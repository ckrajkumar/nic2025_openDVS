* Extracted by KLayout with SKY130 LVS runset on : 10/07/2026 03:15

* cell BiasBuffers
* pin BIT0
* pin BiasDisabled
* pin BufferNBias
* pin SplitterOutput
* pin PowerDown
* pin VBiasOut
* pin PadBias
* pin NBiasEnabled
* pin PBiasEnabled
* pin VddA18
* pin BufferPBias
* pin GND
.SUBCKT BiasBuffers BIT0 BiasDisabled BufferNBias SplitterOutput PowerDown
+ VBiasOut PadBias NBiasEnabled PBiasEnabled VddA18 BufferPBias GND
* device instance $1 r0 *1 67.965,21.47 sky130_fd_pr__pfet_01v8
XM$1 \$32 \$27 \$17 VddA18 sky130_fd_pr__pfet_01v8 L=380000 W=1000000
+ AS=532500000000 AD=265000000000 PS=3600000 PD=2530000
* device instance $2 r0 *1 52.815,21.55 sky130_fd_pr__pfet_01v8
XM$2 \$31 \$27 \$6 VddA18 sky130_fd_pr__pfet_01v8 L=380000 W=1000000
+ AS=265000000000 AD=777500000000 PS=2530000 PD=4760000
* device instance $3 r0 *1 56.335,21.55 sky130_fd_pr__pfet_01v8
XM$3 \$17 \$33 \$28 VddA18 sky130_fd_pr__pfet_01v8 L=380000 W=1000000
+ AS=837500000000 AD=1.136e+12 PS=4880000 PD=6330000
* device instance $4 r0 *1 53.955,23.05 sky130_fd_pr__pfet_01v8
XM$4 \$6 PBiasEnabled \$16 VddA18 sky130_fd_pr__pfet_01v8 L=380000 W=4000000
+ AS=777500000000 AD=1.48e+12 PS=4760000 PD=4740000
* device instance $5 r0 *1 55.075,23.05 sky130_fd_pr__pfet_01v8
XM$5 \$16 NBiasEnabled \$17 VddA18 sky130_fd_pr__pfet_01v8 L=380000 W=4000000
+ AS=1.48e+12 AD=837500000000 PS=4740000 PD=4880000
* device instance $6 r0 *1 45.745,24.05 sky130_fd_pr__pfet_01v8
XM$6 VddA18 \$17 \$39 VddA18 sky130_fd_pr__pfet_01v8 L=3000000 W=12000000
+ AS=3.81e+12 AD=3.81e+12 PS=19270000 PD=19270000
* device instance $8 r0 *1 38.29,21.55 sky130_fd_pr__pfet_01v8
XM$8 \$6 \$33 \$26 VddA18 sky130_fd_pr__pfet_01v8 L=380000 W=1000000
+ AS=265000000000 AD=265000000000 PS=2530000 PD=2530000
* device instance $9 r0 *1 41.975,23.05 sky130_fd_pr__pfet_01v8
XM$9 VBiasOut \$34 PadBias VddA18 sky130_fd_pr__pfet_01v8 L=380000 W=4000000
+ AS=1.06e+12 AD=1.06e+12 PS=8530000 PD=8530000
* device instance $10 r0 *1 36.715,21.55 sky130_fd_pr__pfet_01v8
XM$10 \$25 \$9 VddA18 VddA18 sky130_fd_pr__pfet_01v8 L=150000 W=1000000
+ AS=265000000000 AD=265000000000 PS=2530000 PD=2530000
* device instance $11 r0 *1 40.795,23.05 sky130_fd_pr__pfet_01v8
XM$11 \$16 PowerDown VBiasOut VddA18 sky130_fd_pr__pfet_01v8 L=380000 W=4000000
+ AS=1.06e+12 AD=1.06e+12 PS=8530000 PD=8530000
* device instance $12 r0 *1 53.965,29.64 sky130_fd_pr__pfet_01v8_lvt
XM$12 VddA18 BufferPBias \$17 VddA18 sky130_fd_pr__pfet_01v8_lvt L=3000000
+ W=12000000 AS=3.81e+12 AD=3.81e+12 PS=19270000 PD=19270000
* device instance $14 r0 *1 57.48,22.25 sky130_fd_pr__pfet_01v8_lvt
XM$14 \$28 \$39 \$41 VddA18 sky130_fd_pr__pfet_01v8_lvt L=380000 W=14400000
+ AS=5.576e+12 AD=5.076e+12 PS=22030000 PD=21030000
* device instance $20 r0 *1 65.775,21.3 sky130_fd_pr__pfet_01v8_lvt
XM$20 \$32 \$39 \$41 VddA18 sky130_fd_pr__pfet_01v8_lvt L=2400000 W=500000
+ AS=532500000000 AD=307500000000 PS=3600000 PD=2230000
* device instance $21 r0 *1 52.695,12.72 sky130_fd_pr__nfet_01v8
XM$21 \$31 \$33 \$6 GND sky130_fd_pr__nfet_01v8 L=150000 W=1000000
+ AS=502500000000 AD=265000000000 PS=3480000 PD=2530000
* device instance $22 r0 *1 41.385,6.385 sky130_fd_pr__nfet_01v8
XM$22 SplitterOutput \$6 GND GND sky130_fd_pr__nfet_01v8 L=6000000 W=6000000
+ AS=1.59e+12 AD=1.59e+12 PS=12530000 PD=12530000
* device instance $23 r0 *1 38.175,12.87 sky130_fd_pr__nfet_01v8
XM$23 \$6 \$27 \$26 GND sky130_fd_pr__nfet_01v8 L=150000 W=1000000
+ AS=265000000000 AD=265000000000 PS=2530000 PD=2530000
* device instance $24 r0 *1 67.965,12.72 sky130_fd_pr__nfet_01v8
XM$24 \$32 \$33 \$17 GND sky130_fd_pr__nfet_01v8 L=150000 W=1000000
+ AS=380000000000 AD=380000000000 PS=2760000 PD=2760000
* device instance $25 r0 *1 64.855,13.94 sky130_fd_pr__nfet_01v8
XM$25 \$41 \$10 GND GND sky130_fd_pr__nfet_01v8 L=150000 W=1000000
+ AS=265000000000 AD=265000000000 PS=2530000 PD=2530000
* device instance $26 r0 *1 56.25,11.52 sky130_fd_pr__nfet_01v8
XM$26 \$17 \$27 \$28 GND sky130_fd_pr__nfet_01v8 L=150000 W=1000000
+ AS=380000000000 AD=380000000000 PS=2760000 PD=2760000
* device instance $27 r0 *1 57.945,11.9 sky130_fd_pr__nfet_01v8
XM$27 \$16 \$34 VBiasOut GND sky130_fd_pr__nfet_01v8 L=150000 W=4000000
+ AS=1.06e+12 AD=1.48e+12 PS=8530000 PD=4740000
* device instance $28 r0 *1 58.835,11.9 sky130_fd_pr__nfet_01v8
XM$28 VBiasOut PowerDown PadBias GND sky130_fd_pr__nfet_01v8 L=150000 W=4000000
+ AS=1.48e+12 AD=1.06e+12 PS=4740000 PD=8530000
* device instance $29 r0 *1 54.07,10.02 sky130_fd_pr__nfet_01v8
XM$29 \$6 NBiasEnabled \$16 GND sky130_fd_pr__nfet_01v8 L=150000 W=4000000
+ AS=1.06e+12 AD=1.48e+12 PS=8530000 PD=4740000
* device instance $30 r0 *1 54.96,10.02 sky130_fd_pr__nfet_01v8
XM$30 \$16 PBiasEnabled \$17 GND sky130_fd_pr__nfet_01v8 L=150000 W=4000000
+ AS=1.48e+12 AD=1.06e+12 PS=4740000 PD=8530000
* device instance $31 r0 *1 48.865,6.385 sky130_fd_pr__nfet_01v8
XM$31 GND \$6 \$39 GND sky130_fd_pr__nfet_01v8 L=6000000 W=6000000 AS=1.59e+12
+ AD=1.59e+12 PS=12530000 PD=12530000
* device instance $32 r0 *1 27.43,20.785 sky130_fd_pr__nfet_01v8_lvt
XM$32 \$6 BufferNBias GND GND sky130_fd_pr__nfet_01v8_lvt L=6000000 W=96000000
+ AS=2.544e+13 AD=2.544e+13 PS=200480000 PD=200480000
* device instance $42 r0 *1 39.8,12.02 sky130_fd_pr__nfet_01v8_lvt
XM$42 \$25 SplitterOutput \$26 GND sky130_fd_pr__nfet_01v8_lvt L=240000
+ W=24000000 AS=8.628e+12 AD=8.42875e+12 PS=33590000 PD=31400000
* device instance $52 r0 *1 50.68,12.97 sky130_fd_pr__nfet_01v8_lvt
XM$52 \$25 SplitterOutput \$31 GND sky130_fd_pr__nfet_01v8_lvt L=2400000
+ W=500000 AS=436750000000 AD=502500000000 PS=3140000 PD=3480000
* device instance $59 r90 *1 62.9,3.48 sky130_fd_pr__pfet_01v8_hvt
XM$59 VddA18 \$4 \$I128 VddA18 sky130_fd_pr__pfet_01v8_hvt L=150000 W=420000
+ AS=117600000000 AD=56700000000 PS=1400000 PD=690000
* device instance $60 r90 *1 62.9,3.9 sky130_fd_pr__pfet_01v8_hvt
XM$60 VddA18 PBiasEnabled \$I128 VddA18 sky130_fd_pr__pfet_01v8_hvt L=150000
+ W=420000 AS=166550000000 AD=56700000000 PS=1390000 PD=690000
* device instance $61 r90 *1 62.98,4.44 sky130_fd_pr__pfet_01v8_hvt
XM$61 VddA18 \$I128 \$10 VddA18 sky130_fd_pr__pfet_01v8_hvt L=150000 W=1000000
+ AS=166550000000 AD=475000000000 PS=1390000 PD=2950000
* device instance $62 r90 *1 64.38,3.48 sky130_fd_pr__nfet_01v8
XM$62 \$I128 \$4 \$I129 GND sky130_fd_pr__nfet_01v8 L=150000 W=420000
+ AS=117600000000 AD=56700000000 PS=1400000 PD=690000
* device instance $63 r90 *1 64.38,3.9 sky130_fd_pr__nfet_01v8
XM$63 GND PBiasEnabled \$I129 GND sky130_fd_pr__nfet_01v8 L=150000 W=420000
+ AS=111800000000 AD=56700000000 PS=1040000 PD=690000
* device instance $64 r90 *1 64.405,4.44 sky130_fd_pr__nfet_01v8
XM$64 GND \$I128 \$10 GND sky130_fd_pr__nfet_01v8 L=150000 W=650000
+ AS=111800000000 AD=182000000000 PS=1040000 PD=1860000
* device instance $65 m45 *1 56.07,3.505 sky130_fd_pr__pfet_01v8_hvt
XM$65 VddA18 BIT0 \$27 VddA18 sky130_fd_pr__pfet_01v8_hvt L=150000 W=1000000
+ AS=260000000000 AD=260000000000 PS=2520000 PD=2520000
* device instance $66 m45 *1 54.645,3.505 sky130_fd_pr__nfet_01v8
XM$66 GND BIT0 \$27 GND sky130_fd_pr__nfet_01v8 L=150000 W=650000
+ AS=169000000000 AD=169000000000 PS=1820000 PD=1820000
* device instance $67 m45 *1 61.51,4.425 sky130_fd_pr__pfet_01v8_hvt
XM$67 VddA18 \$4 \$9 VddA18 sky130_fd_pr__pfet_01v8_hvt L=150000 W=1000000
+ AS=260000000000 AD=260000000000 PS=2520000 PD=2520000
* device instance $68 m45 *1 60.085,4.425 sky130_fd_pr__nfet_01v8
XM$68 GND \$4 \$9 GND sky130_fd_pr__nfet_01v8 L=150000 W=650000 AS=169000000000
+ AD=169000000000 PS=1820000 PD=1820000
* device instance $69 r90 *1 57.54,4.885 sky130_fd_pr__pfet_01v8_hvt
XM$69 VddA18 PowerDown \$34 VddA18 sky130_fd_pr__pfet_01v8_hvt L=150000
+ W=1000000 AS=260000000000 AD=260000000000 PS=2520000 PD=2520000
* device instance $70 r90 *1 58.965,4.885 sky130_fd_pr__nfet_01v8
XM$70 GND PowerDown \$34 GND sky130_fd_pr__nfet_01v8 L=150000 W=650000
+ AS=169000000000 AD=169000000000 PS=1820000 PD=1820000
* device instance $71 m45 *1 56.07,4.885 sky130_fd_pr__pfet_01v8_hvt
XM$71 VddA18 \$27 \$33 VddA18 sky130_fd_pr__pfet_01v8_hvt L=150000 W=1000000
+ AS=260000000000 AD=260000000000 PS=2520000 PD=2520000
* device instance $72 m45 *1 54.645,4.885 sky130_fd_pr__nfet_01v8
XM$72 GND \$27 \$33 GND sky130_fd_pr__nfet_01v8 L=150000 W=650000
+ AS=169000000000 AD=169000000000 PS=1820000 PD=1820000
* device instance $73 r90 *1 57.54,3.3 sky130_fd_pr__pfet_01v8_hvt
XM$73 \$4 BiasDisabled \$I130 VddA18 sky130_fd_pr__pfet_01v8_hvt L=150000
+ W=1000000 AS=260000000000 AD=105000000000 PS=2520000 PD=1210000
* device instance $74 r90 *1 57.54,3.66 sky130_fd_pr__pfet_01v8_hvt
XM$74 \$I130 PowerDown VddA18 VddA18 sky130_fd_pr__pfet_01v8_hvt L=150000
+ W=1000000 AS=105000000000 AD=260000000000 PS=1210000 PD=2520000
* device instance $75 r90 *1 58.965,3.3 sky130_fd_pr__nfet_01v8
XM$75 GND BiasDisabled \$4 GND sky130_fd_pr__nfet_01v8 L=150000 W=650000
+ AS=169000000000 AD=87750000000 PS=1820000 PD=920000
* device instance $76 r90 *1 58.965,3.72 sky130_fd_pr__nfet_01v8
XM$76 \$4 PowerDown GND GND sky130_fd_pr__nfet_01v8 L=150000 W=650000
+ AS=87750000000 AD=169000000000 PS=920000 PD=1820000
.ENDS BiasBuffers
