* Extracted by KLayout with SKY130 LVS runset on : 10/07/2026 03:03

* cell BiasCoarseFineInterface
* pin IIn
* pin LowBiasEn
* pin VddA18
* pin IOut
* pin nLowBiasEn
* pin GndA
.SUBCKT BiasCoarseFineInterface IIn LowBiasEn VddA18 IOut nLowBiasEn GndA
* device instance $1 r0 *1 -11.015,-1.585 sky130_fd_pr__pfet_01v8
XM$1 \$4 LowBiasEn \$13 VddA18 sky130_fd_pr__pfet_01v8 L=500000 W=550000
+ AS=145750000000 AD=145750000000 PS=1630000 PD=1630000
* device instance $2 r0 *1 -27.34,0.615 sky130_fd_pr__pfet_01v8
XM$2 VddA18 \$13 \$4 VddA18 sky130_fd_pr__pfet_01v8 L=500000 W=512000000
+ AS=7.968e+13 AD=7.968e+13 PS=580980000 PD=580980000
* device instance $18 r0 *1 26.33,6.075 sky130_fd_pr__pfet_01v8
XM$18 \$19 \$15 \$15 VddA18 sky130_fd_pr__pfet_01v8 L=2000000 W=8000000
+ AS=1.62e+12 AD=1.12e+12 PS=12810000 PD=8560000
* device instance $20 r0 *1 26.33,10.635 sky130_fd_pr__pfet_01v8
XM$20 \$19 \$15 VddA18 VddA18 sky130_fd_pr__pfet_01v8 L=2000000 W=8000000
+ AS=1.12e+12 AD=1.62e+12 PS=8560000 PD=12810000
* device instance $22 r0 *1 30.63,6.075 sky130_fd_pr__pfet_01v8
XM$22 \$20 \$15 \$16 VddA18 sky130_fd_pr__pfet_01v8 L=2000000 W=8000000
+ AS=1.62e+12 AD=1.12e+12 PS=12810000 PD=8560000
* device instance $24 r0 *1 30.63,10.635 sky130_fd_pr__pfet_01v8
XM$24 \$20 \$15 VddA18 VddA18 sky130_fd_pr__pfet_01v8 L=2000000 W=8000000
+ AS=1.12e+12 AD=1.62e+12 PS=8560000 PD=12810000
* device instance $26 r0 *1 -27.34,7.7 sky130_fd_pr__pfet_01v8
XM$26 VddA18 \$13 \$6 VddA18 sky130_fd_pr__pfet_01v8 L=500000 W=512000000
+ AS=7.968e+13 AD=7.968e+13 PS=580980000 PD=580980000
* device instance $42 r0 *1 22.045,14.295 sky130_fd_pr__pfet_01v8
XM$42 \$13 nLowBiasEn VddA18 VddA18 sky130_fd_pr__pfet_01v8 L=150000 W=550000
+ AS=145750000000 AD=145750000000 PS=1630000 PD=1630000
* device instance $43 r0 *1 26.33,0.515 sky130_fd_pr__pfet_01v8_lvt
XM$43 \$15 nLowBiasEn \$7 VddA18 sky130_fd_pr__pfet_01v8_lvt L=2000000
+ W=8000000 AS=1.62e+12 AD=1.62e+12 PS=12810000 PD=12810000
* device instance $45 r0 *1 30.63,0.515 sky130_fd_pr__pfet_01v8_lvt
XM$45 \$16 nLowBiasEn IOut VddA18 sky130_fd_pr__pfet_01v8_lvt L=2000000
+ W=8000000 AS=1.62e+12 AD=1.62e+12 PS=12810000 PD=12810000
* device instance $47 r0 *1 -6.405,-10.525 sky130_fd_pr__pfet_01v8_lvt
XM$47 IIn IIn \$7 VddA18 sky130_fd_pr__pfet_01v8_lvt L=1000000 W=18000000
+ AS=4.77e+12 AD=4.77e+12 PS=37060000 PD=37060000
* device instance $49 r0 *1 -29.615,-6.795 sky130_fd_pr__pfet_01v8_hvt
XM$49 \$4 LowBiasEn \$7 VddA18 sky130_fd_pr__pfet_01v8_hvt L=500000 W=256000000
+ AS=3.984e+13 AD=3.984e+13 PS=290490000 PD=290490000
* device instance $57 r0 *1 7.585,-6.795 sky130_fd_pr__pfet_01v8_hvt
XM$57 \$6 LowBiasEn IOut VddA18 sky130_fd_pr__pfet_01v8_hvt L=500000
+ W=256000000 AS=3.984e+13 AD=3.984e+13 PS=290490000 PD=290490000
* device instance $65 r0 *1 -47.22,-1.425 sky130_fd_pr__nfet_01v8
XM$65 GndA LowBiasEn \$4 GndA sky130_fd_pr__nfet_01v8 L=150000 W=420000
+ AS=111300000000 AD=111300000000 PS=1370000 PD=1370000
* device instance $66 r0 *1 25.525,-4.755 sky130_fd_pr__nfet_01v8
XM$66 GndA LowBiasEn \$6 GndA sky130_fd_pr__nfet_01v8 L=150000 W=420000
+ AS=111300000000 AD=111300000000 PS=1370000 PD=1370000
.ENDS BiasCoarseFineInterface
