** LVS-only netlist: use ONLY if layout ground port is labeled GND (legacy).
** Current layout uses GndA (matches xschem); use ~/.xschem/simulations/BiasBuffers.spice instead.
** sch_path: /home/alienfalcon/Projects/skywater/open_dvs_py312/open_dvs/git_dvs/nic2025_openDVS/analog/xschem/BiasBuffers.sch
.subckt BiasBuffers VddA18 GND NBiasEnabled PBiasEnabled BiasDisabled BIT0 BufferNBias BufferPBias SplitterOutput VBiasOut
+ PadBias PowerDown
*.PININFO GND:B VddA18:B VBiasOut:O NBiasEnabled:I PBiasEnabled:I BiasDisabled:I BufferNBias:I BufferPBias:I SplitterOutput:B
*+ BIT0:I PadBias:B PowerDown:I
XMnDio SplitterOutput NBias GND GND sky130_fd_pr__nfet_01v8 L=6 W=6 nf=1
XMnswnMirrnB0 net1 nB0 NBias GND sky130_fd_pr__nfet_01v8 L=0.15 W=1 nf=1
XMpswnMirrnB0 NBias B0 net1 VddA18 sky130_fd_pr__pfet_01v8 L=0.38 W=1 nf=1
XMnMirrBuffB0 nMirrBuffDrain SplitterOutput net2 GND sky130_fd_pr__nfet_01v8_lvt L=2.4 W=0.5 nf=1
XMpnMirrEnable nMirrBuffDrain disable VddA18 VddA18 sky130_fd_pr__pfet_01v8 L=0.15 W=1 nf=1
XMnswnMirrB0 net2 B0 NBias GND sky130_fd_pr__nfet_01v8 L=0.15 W=1 nf=1
XMpswnMirrB0 NBias nB0 net2 VddA18 sky130_fd_pr__pfet_01v8 L=0.38 W=1 nf=1
XMnMirr nCopy NBias GND GND sky130_fd_pr__nfet_01v8 L=6 W=6 nf=1
XMnMirrBuffBias NBias BufferNBias GND GND sky130_fd_pr__nfet_01v8_lvt L=6 W=6 nf=1 m=16
XMpDio nCopy PBias VddA18 VddA18 sky130_fd_pr__pfet_01v8 L=3 W=6 nf=1 m=2
XMnswpMirrnB0 PBias nB0 net3 GND sky130_fd_pr__nfet_01v8 L=0.15 W=1 nf=1
XMpswpMirrnB0 net3 B0 PBias VddA18 sky130_fd_pr__pfet_01v8 L=0.38 W=1 nf=1
XMnswpMirrB0 PBias B0 net4 GND sky130_fd_pr__nfet_01v8 L=0.15 W=1 nf=1
XMpswpMirrB0 net4 nB0 PBias VddA18 sky130_fd_pr__pfet_01v8 L=0.38 W=1 nf=1
XMpMirrBuffnB0 net3 nCopy pMirrBuffDrain VddA18 sky130_fd_pr__pfet_01v8_lvt L=0.38 W=2.4 nf=1 m=6
XMpMirrBuffB0 net4 nCopy pMirrBuffDrain VddA18 sky130_fd_pr__pfet_01v8_lvt L=2.4 W=0.5 nf=1
XMnpMirrEnable pMirrBuffDrain net6 GND GND sky130_fd_pr__nfet_01v8 L=0.15 W=1 nf=1
XMpMirrBuffBias PBias BufferPBias VddA18 VddA18 sky130_fd_pr__pfet_01v8_lvt L=3 W=6 nf=1 m=2
XMnswNBias NBias NBiasEnabled net5 GND sky130_fd_pr__nfet_01v8 L=0.15 W=4 nf=1
XMpswNBias net5 PBiasEnabled NBias VddA18 sky130_fd_pr__pfet_01v8 L=0.38 W=4 nf=1
XMnswPBias net5 PBiasEnabled PBias GND sky130_fd_pr__nfet_01v8 L=0.15 W=4 nf=1
XMpswPBias PBias NBiasEnabled net5 VddA18 sky130_fd_pr__pfet_01v8 L=0.38 W=4 nf=1
XMnswBias net5 nPowerDown VBiasOut GND sky130_fd_pr__nfet_01v8 L=0.15 W=4 nf=1
XMpswBias VBiasOut PowerDown net5 VddA18 sky130_fd_pr__pfet_01v8 L=0.38 W=4 nf=1
XMnswRail VBiasOut PowerDown PadBias GND sky130_fd_pr__nfet_01v8 L=0.15 W=4 nf=1
XMpswRail PadBias nPowerDown VBiasOut VddA18 sky130_fd_pr__pfet_01v8 L=0.38 W=4 nf=1
XMnMirrBuffnB0 nMirrBuffDrain SplitterOutput net1 GND sky130_fd_pr__nfet_01v8_lvt L=0.24 W=2.4 nf=1 m=10
x6 PowerDown BiasDisabled ndisable VddA18 VddA18 GND GND sky130_fd_sc_hd__nor2_1
x1 ndisable PBiasEnabled VddA18 VddA18 GND GND net6 sky130_fd_sc_hd__and2_1
x2 BIT0 nB0 VddA18 VddA18 GND GND sky130_fd_sc_hd__inv_1
x3 nB0 B0 VddA18 VddA18 GND GND sky130_fd_sc_hd__inv_1
x4 PowerDown nPowerDown VddA18 VddA18 GND GND sky130_fd_sc_hd__inv_1
x5 ndisable disable VddA18 VddA18 GND GND sky130_fd_sc_hd__inv_1
.ends
