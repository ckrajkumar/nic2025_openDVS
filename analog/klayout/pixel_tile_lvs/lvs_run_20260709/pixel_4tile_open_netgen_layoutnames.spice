* converted by convert_pdk_netlist.py (target=open, format=lvs)
* LVS source for netgen; no include needed
* ============================================================================
* NETGEN LVS SOURCE  (pixel_4tile_s130_7_9_26_netgen_layoutnames.cdl)
* For Magic/Netgen LVS only — do NOT use for Calibre (use *_lvsfix.cdl).
* ----------------------------------------------------------------------------
* Derived from : pixel_4tile_s130_7_9_26_lvsfix.cdl
* Port names+order from: lvs_run_20260709/netgen/pixel_4tile_netgen_v2.report
*   Layout pin names (left column); schematic nets renamed to match layout.
* Bus notation : [n]
* Grounding    : vssc1 = tile GndD; vssa1 = column periphery
* Regenerate   : python3 open_src_spice_pixel_4tile/make_netgen_cdl_layoutnames.py
* ============================================================================
* [dropped] .INCLUDE $PDK_HOME/PV/Calibre/LVS/source.cdl
.subckt pixel_4tile vssc1 array_col_bot_left[55] array_col_bot_left[14] array_col_bot_left[29] array_col_bot_left[13] array_col_bot_left[2] array_col_bot_left[49] array_col_bot_left[28] array_col_bot_left[1] array_col_bot_left[17] array_col_bot_left[46] array_col_bot_left[45] array_col_bot_left[4] array_col_bot_left[48] array_col_bot_left[16] array_col_bot_left[43] array_col_bot_left[5] array_col_bot_left[39] array_col_bot_left[34] array_col_bot_left[33] array_col_bot_left[59] array_col_bot_left[38] array_col_bot_left[63] array_col_bot_left[22] array_col_bot_left[21] array_col_bot_left[58] array_col_bot_left[54] array_col_bot_left[53] array_col_bot_left[47] array_col_bot_left[15] array_col_bot_left[0] array_col_bot_left[3] array_col_bot_left[42] array_col_bot_left[37] array_col_bot_left[41] array_col_bot_left[36] array_col_bot_left[62] array_col_bot_left[61] array_col_bot_left[20] array_col_bot_left[19] array_col_bot_left[35] array_col_bot_left[40] array_col_bot_left[23] array_col_bot_left[18] array_col_bot_left[60] array_col_bot_left[57] array_col_bot_left[56] array_col_bot_left[44] array_col_bot_left[50] array_col_bot_left[51] array_col_bot_left[52] array_col_bot_left[24] array_col_bot_left[25] array_col_bot_left[26] array_col_bot_left[27] array_col_bot_left[30] array_col_bot_left[31] array_col_bot_left[32] array_col_bot_left[6] array_col_bot_left[7] array_col_bot_left[8] array_col_bot_left[9] array_col_bot_left[10] array_col_bot_left[11] array_col_bot_left[12] array_col_bot_right[55] array_col_bot_right[14] array_col_bot_right[29] array_col_bot_right[13] array_col_bot_right[2] array_col_bot_right[49] array_col_bot_right[28] array_col_bot_right[1] array_col_bot_right[17] array_col_bot_right[46] array_col_bot_right[45] array_col_bot_right[4] array_col_bot_right[48] array_col_bot_right[16] array_col_bot_right[43] array_col_bot_right[5] array_col_bot_right[39] array_col_bot_right[34] array_col_bot_right[33] array_col_bot_right[59] array_col_bot_right[38] array_col_bot_right[63] array_col_bot_right[22] array_col_bot_right[21] array_col_bot_right[58] array_col_bot_right[54] array_col_bot_right[53] array_col_bot_right[47] array_col_bot_right[15] array_col_bot_right[0] array_col_bot_right[3] array_col_bot_right[42] array_col_bot_right[37] array_col_bot_right[41] array_col_bot_right[36] array_col_bot_right[62] array_col_bot_right[61] array_col_bot_right[20] array_col_bot_right[19] array_col_bot_right[35] array_col_bot_right[40] array_col_bot_right[23] array_col_bot_right[18] array_col_bot_right[60] array_col_bot_right[57] array_col_bot_right[56] array_col_bot_right[44] array_col_bot_right[50] array_col_bot_right[51] array_col_bot_right[52] array_col_bot_right[24] array_col_bot_right[25] array_col_bot_right[26] array_col_bot_right[27] array_col_bot_right[30] array_col_bot_right[31] array_col_bot_right[32] array_col_bot_right[6] array_col_bot_right[7] array_col_bot_right[8] array_col_bot_right[9] array_col_bot_right[10] array_col_bot_right[11] array_col_bot_right[12] dac_config_0 dac_config_5 dac_config_3 dac_config_4 dac_config_1 dac_config_2 detect_pulse_global_bot_left detect_pulse_global_top_left row_off_detect_bot[2] row_off_detect_bot[3] row_off_detect_bot[7] row_off_detect_bot[8] row_off_detect_bot[9] row_off_detect_bot[10] row_off_detect_bot[11] row_off_detect_bot[12] row_off_detect_bot[13] row_off_detect_bot[14] row_off_detect_bot[23] row_off_detect_bot[24] row_off_detect_bot[26] row_off_detect_bot[27] row_off_detect_bot[30] row_off_detect_bot[31] row_off_detect_bot[44] row_off_detect_bot[45] row_off_detect_bot[46] row_off_detect_bot[47] row_off_detect_bot[51] row_off_detect_bot[54] row_off_detect_bot[55] row_off_detect_bot[56] row_off_detect_bot[57] row_off_detect_bot[60] row_off_detect_bot[61] row_off_detect_bot[42] row_off_detect_bot[43] row_off_detect_bot[18] row_off_detect_bot[19] row_off_detect_bot[38] row_off_detect_bot[39] row_off_detect_bot[6] row_off_detect_bot[15] row_off_detect_bot[34] row_off_detect_bot[35] row_off_detect_bot[0] row_off_detect_bot[1] row_off_detect_bot[52] row_off_detect_bot[53] row_off_detect_bot[40] row_off_detect_bot[62] row_off_detect_bot[32] row_off_detect_bot[41] row_off_detect_bot[63] row_off_detect_bot[17] row_off_detect_bot[33] row_off_detect_bot[37] row_off_detect_bot[28] row_off_detect_bot[4] row_off_detect_bot[20] row_off_detect_bot[58] row_off_detect_bot[29] row_off_detect_bot[48] row_off_detect_bot[5] row_off_detect_bot[22] row_off_detect_bot[21] row_off_detect_bot[59] row_off_detect_bot[36] row_off_detect_bot[49] row_off_detect_bot[25] row_off_detect_bot[16] row_off_detect_bot[50] row_off_detect_top[0] row_off_detect_top[1] row_off_detect_top[4] row_off_detect_top[5] row_off_detect_top[6] row_off_detect_top[7] row_off_detect_top[10] row_off_detect_top[11] row_off_detect_top[12] row_off_detect_top[13] row_off_detect_top[14] row_off_detect_top[15] row_off_detect_top[16] row_off_detect_top[17] row_off_detect_top[18] row_off_detect_top[19] row_off_detect_top[22] row_off_detect_top[23] row_off_detect_top[26] row_off_detect_top[27] row_off_detect_top[31] row_off_detect_top[32] row_off_detect_top[33] row_off_detect_top[34] row_off_detect_top[35] row_off_detect_top[36] row_off_detect_top[37] row_off_detect_top[38] row_off_detect_top[39] row_off_detect_top[42] row_off_detect_top[43] row_off_detect_top[46] row_off_detect_top[47] row_off_detect_top[50] row_off_detect_top[51] row_off_detect_top[52] row_off_detect_top[53] row_off_detect_top[54] row_off_detect_top[55] row_off_detect_top[56] row_off_detect_top[63] row_off_detect_top[59] row_off_detect_top[60] row_off_detect_top[61] row_off_detect_top[40] row_off_detect_top[41] row_off_detect_top[20] row_off_detect_top[21] row_off_detect_top[2] row_off_detect_top[58] row_off_detect_top[3] row_off_detect_top[44] row_off_detect_top[45] row_off_detect_top[30] row_off_detect_top[24] row_off_detect_top[25] row_off_detect_top[48] row_off_detect_top[49] row_off_detect_top[28] row_off_detect_top[57] row_off_detect_top[29] row_off_detect_top[8] row_off_detect_top[9] row_off_detect_top[62] pre_charge_global_bot_left pre_charge_global_top_left ndetect_pulse_global_bot_left ndetect_pulse_global_top_left dac_config_6 row_on_detect_bot[0] row_on_detect_bot[1] row_on_detect_bot[10] row_on_detect_bot[11] row_on_detect_bot[14] row_on_detect_bot[15] row_on_detect_bot[16] row_on_detect_bot[17] row_on_detect_bot[18] row_on_detect_bot[19] row_on_detect_bot[20] row_on_detect_bot[21] row_on_detect_bot[22] row_on_detect_bot[23] row_on_detect_bot[24] row_on_detect_bot[34] row_on_detect_bot[35] row_on_detect_bot[36] row_on_detect_bot[37] row_on_detect_bot[40] row_on_detect_bot[62] row_on_detect_bot[63] row_on_detect_bot[28] row_on_detect_bot[25] row_on_detect_bot[29] row_on_detect_bot[12] row_on_detect_bot[13] row_on_detect_bot[46] row_on_detect_bot[26] row_on_detect_bot[50] row_on_detect_bot[47] row_on_detect_bot[27] row_on_detect_bot[51] row_on_detect_bot[6] row_on_detect_bot[7] row_on_detect_bot[41] row_on_detect_bot[30] row_on_detect_bot[31] row_on_detect_bot[44] row_on_detect_bot[45] row_on_detect_bot[58] row_on_detect_bot[54] row_on_detect_bot[59] row_on_detect_bot[55] row_on_detect_bot[38] row_on_detect_bot[39] row_on_detect_bot[48] row_on_detect_bot[52] row_on_detect_bot[49] row_on_detect_bot[32] row_on_detect_bot[4] row_on_detect_bot[53] row_on_detect_bot[33] row_on_detect_bot[8] row_on_detect_bot[5] row_on_detect_bot[42] row_on_detect_bot[3] row_on_detect_bot[9] row_on_detect_bot[43] row_on_detect_bot[60] row_on_detect_bot[56] row_on_detect_bot[61] row_on_detect_bot[2] row_on_detect_bot[57] row_on_detect_top[0] row_on_detect_top[1] row_on_detect_top[6] row_on_detect_top[7] row_on_detect_top[21] row_on_detect_top[26] row_on_detect_top[27] row_on_detect_top[28] row_on_detect_top[29] row_on_detect_top[30] row_on_detect_top[31] row_on_detect_top[40] row_on_detect_top[41] row_on_detect_top[44] row_on_detect_top[45] row_on_detect_top[46] row_on_detect_top[47] row_on_detect_top[56] row_on_detect_top[57] row_on_detect_top[60] row_on_detect_top[61] row_on_detect_top[12] row_on_detect_top[13] row_on_detect_top[52] row_on_detect_top[53] row_on_detect_top[38] row_on_detect_top[34] row_on_detect_top[39] row_on_detect_top[35] row_on_detect_top[4] row_on_detect_top[5] row_on_detect_top[50] row_on_detect_top[51] row_on_detect_top[16] row_on_detect_top[17] row_on_detect_top[22] row_on_detect_top[36] row_on_detect_top[23] row_on_detect_top[32] row_on_detect_top[37] row_on_detect_top[33] row_on_detect_top[42] row_on_detect_top[43] row_on_detect_top[8] row_on_detect_top[2] row_on_detect_top[9] row_on_detect_top[3] row_on_detect_top[18] row_on_detect_top[48] row_on_detect_top[14] row_on_detect_top[19] row_on_detect_top[62] row_on_detect_top[49] row_on_detect_top[10] row_on_detect_top[15] row_on_detect_top[63] row_on_detect_top[58] row_on_detect_top[24] row_on_detect_top[11] row_on_detect_top[54] row_on_detect_top[59] row_on_detect_top[20] row_on_detect_top[25] row_on_detect_top[55] col_event_rst_bot_right[0] col_event_rst_bot_right[4] col_event_rst_bot_right[5] col_event_rst_bot_right[6] col_event_rst_bot_right[7] col_event_rst_bot_right[8] col_event_rst_bot_right[11] col_event_rst_bot_right[24] col_event_rst_bot_right[25] col_event_rst_bot_right[26] col_event_rst_bot_right[27] col_event_rst_bot_right[32] col_event_rst_bot_right[33] col_event_rst_bot_right[34] col_event_rst_bot_right[53] col_event_rst_bot_right[48] col_event_rst_bot_right[45] col_event_rst_bot_right[44] col_event_rst_bot_right[63] col_event_rst_bot_right[58] col_event_rst_bot_right[57] col_event_rst_bot_right[56] col_event_rst_bot_right[55] col_event_rst_bot_right[54] col_event_rst_bot_right[42] col_event_rst_bot_right[43] col_event_rst_bot_right[1] col_event_rst_bot_right[35] col_event_rst_bot_right[41] col_event_rst_bot_right[22] col_event_rst_bot_right[14] col_event_rst_bot_right[23] col_event_rst_bot_right[15] col_event_rst_bot_right[16] col_event_rst_bot_right[38] col_event_rst_bot_right[31] col_event_rst_bot_right[49] col_event_rst_bot_right[50] col_event_rst_bot_right[12] col_event_rst_bot_right[21] col_event_rst_bot_right[46] col_event_rst_bot_right[2] col_event_rst_bot_right[13] col_event_rst_bot_right[17] col_event_rst_bot_right[47] col_event_rst_bot_right[59] col_event_rst_bot_right[3] col_event_rst_bot_right[30] col_event_rst_bot_right[39] col_event_rst_bot_right[40] col_event_rst_bot_right[36] col_event_rst_bot_right[9] col_event_rst_bot_right[51] col_event_rst_bot_right[28] col_event_rst_bot_right[37] col_event_rst_bot_right[60] col_event_rst_bot_right[18] col_event_rst_bot_right[29] col_event_rst_bot_right[52] col_event_rst_bot_right[20] col_event_rst_bot_right[61] col_event_rst_bot_right[10] col_event_rst_bot_right[19] col_event_rst_bot_right[62] col_event_rst_bot_left[0] col_event_rst_bot_left[4] col_event_rst_bot_left[5] col_event_rst_bot_left[6] col_event_rst_bot_left[7] col_event_rst_bot_left[8] col_event_rst_bot_left[11] col_event_rst_bot_left[24] col_event_rst_bot_left[25] col_event_rst_bot_left[26] col_event_rst_bot_left[27] col_event_rst_bot_left[32] col_event_rst_bot_left[33] col_event_rst_bot_left[34] col_event_rst_bot_left[53] col_event_rst_bot_left[48] col_event_rst_bot_left[45] col_event_rst_bot_left[44] col_event_rst_bot_left[63] col_event_rst_bot_left[58] col_event_rst_bot_left[57] col_event_rst_bot_left[56] col_event_rst_bot_left[55] col_event_rst_bot_left[54] col_event_rst_bot_left[42] col_event_rst_bot_left[43] col_event_rst_bot_left[1] col_event_rst_bot_left[35] col_event_rst_bot_left[41] col_event_rst_bot_left[22] col_event_rst_bot_left[14] col_event_rst_bot_left[23] col_event_rst_bot_left[15] col_event_rst_bot_left[16] col_event_rst_bot_left[38] col_event_rst_bot_left[31] col_event_rst_bot_left[49] col_event_rst_bot_left[50] col_event_rst_bot_left[12] col_event_rst_bot_left[21] col_event_rst_bot_left[46] col_event_rst_bot_left[2] col_event_rst_bot_left[13] col_event_rst_bot_left[17] col_event_rst_bot_left[47] col_event_rst_bot_left[59] col_event_rst_bot_left[3] col_event_rst_bot_left[30] col_event_rst_bot_left[39] col_event_rst_bot_left[40] col_event_rst_bot_left[36] col_event_rst_bot_left[9] col_event_rst_bot_left[51] col_event_rst_bot_left[28] col_event_rst_bot_left[37] col_event_rst_bot_left[60] col_event_rst_bot_left[18] col_event_rst_bot_left[29] col_event_rst_bot_left[52] col_event_rst_bot_left[20] col_event_rst_bot_left[61] col_event_rst_bot_left[10] col_event_rst_bot_left[19] col_event_rst_bot_left[62] vssa1 vdda1

*.iopin vssa1
*.iopin vssc1
*.iopin vdda1
*.iopin ndetect_pulse_global_top_left
*.iopin detect_pulse_global_top_left
*.iopin pre_charge_global_top_left
*.iopin detect_pulse_global_top_left
*.iopin ndetect_pulse_global_top_left
*.iopin dac_config_6
*.iopin dac_config_0
*.iopin dac_config_1
*.iopin dac_config_4
*.iopin dac_config_3
*.iopin dac_config_5
*.iopin dac_config_2
*.iopin
*+ row_off_detect_top[4],row_on_detect_bot[57],row_off_detect_top[10],row_off_detect_top[11],row_off_detect_top[12],row_off_detect_top[13],row_off_detect_top[14],row_off_detect_top[15],row_off_detect_top[16],row_off_detect_top[17],row_off_detect_top[33],row_off_detect_top[34],row_off_detect_top[36],row_off_detect_top[37],row_off_detect_top[42],row_off_detect_top[43],row_off_detect_top[61],row_off_detect_top[40],row_off_detect_top[41],row_off_detect_top[20],row_off_detect_bot[49],row_off_detect_top[30],row_off_detect_top[24],row_off_detect_top[25],row_off_detect_top[48],row_off_detect_top[57],row_off_detect_top[29],row_off_detect_top[59],row_off_detect_top[60],row_off_detect_top[23],row_off_detect_top[26],row_off_detect_top[54],row_off_detect_top[55],row_off_detect_top[7],row_off_detect_top[18],row_off_detect_top[50],row_off_detect_top[51],row_off_detect_top[0],row_off_detect_top[1],row_off_detect_top[44],row_off_detect_top[45],row_off_detect_top[56],row_off_detect_top[6],row_off_detect_top[46],row_off_detect_top[63],row_off_detect_bot[48],row_off_detect_top[22],row_off_detect_top[47],row_off_detect_top[53],row_off_detect_top[38],row_off_detect_top[5],row_off_detect_top[27],row_off_detect_top[49],row_off_detect_top[39],row_off_detect_bot[48],row_off_detect_top[6],row_off_detect_bot[22],row_off_detect_bot[21],row_off_detect_bot[59],row_off_detect_bot[36],row_off_detect_bot[49],row_off_detect_bot[25],row_off_detect_bot[16],row_off_detect_bot[50]
*+ row_on_detect_top[1],row_on_detect_top[6],row_on_detect_top[31],row_on_detect_top[40],row_on_detect_top[45],row_on_detect_top[46],row_on_detect_top[47],row_on_detect_top[56],row_on_detect_top[57],row_on_detect_top[60],row_on_detect_top[61],row_on_detect_top[12],row_on_detect_top[13],row_on_detect_top[52],row_on_detect_top[53],row_on_detect_top[17],row_on_detect_top[22],row_on_detect_top[36],row_on_detect_top[23],row_on_detect_top[33],row_on_detect_top[25],row_on_detect_top[55],row_on_detect_top[35],row_on_detect_top[38],row_on_detect_bot[60],row_on_detect_top[41],row_on_detect_top[44],row_on_detect_bot[56],row_on_detect_top[34],row_on_detect_top[19],row_on_detect_top[18],row_on_detect_top[39],row_on_detect_top[62],row_on_detect_top[27],row_on_detect_top[28],row_on_detect_top[42],row_on_detect_bot[43],row_on_detect_top[50],row_on_detect_bot[61],row_on_detect_top[26],row_on_detect_top[11],row_on_detect_top[15],row_on_detect_top[54],row_on_detect_top[63],row_on_detect_top[32],row_on_detect_top[37],row_on_detect_top[48],row_on_detect_top[49],row_on_detect_top[14],row_on_detect_top[51],row_on_detect_top[21],row_on_detect_top[10],row_on_detect_top[16],row_on_detect_top[29],row_on_detect_top[26],row_on_detect_bot[42],row_on_detect_bot[3],row_on_detect_top[30],row_on_detect_bot[43],row_on_detect_bot[60],row_on_detect_bot[56],row_on_detect_bot[61],row_on_detect_top[7],row_on_detect_bot[57]
*+ row_off_detect_top[0],row_off_detect_top[1],row_off_detect_top[4],row_on_detect_bot[57],row_off_detect_top[5],row_off_detect_top[6],row_off_detect_top[7],row_off_detect_top[10],row_off_detect_top[11],row_off_detect_top[12],row_off_detect_top[13],row_off_detect_top[14],row_off_detect_top[15],row_off_detect_top[16],row_off_detect_top[17],row_off_detect_top[18],row_off_detect_top[19],row_off_detect_top[22],row_off_detect_top[23],row_off_detect_top[26],row_off_detect_top[27],row_off_detect_top[31],row_off_detect_top[32],row_off_detect_top[33],row_off_detect_top[34],row_off_detect_top[35],row_off_detect_top[36],row_off_detect_top[37],row_off_detect_top[38],row_off_detect_top[39],row_off_detect_top[42],row_off_detect_top[43],row_off_detect_top[46],row_off_detect_top[47],row_off_detect_top[50],row_off_detect_top[51],row_off_detect_top[52],row_off_detect_top[53],row_off_detect_top[54],row_off_detect_top[55],row_off_detect_top[56],row_off_detect_top[63],row_off_detect_top[59],row_off_detect_top[60],row_off_detect_top[61],row_off_detect_top[40],row_off_detect_top[41],row_off_detect_top[20],row_off_detect_top[21],row_off_detect_bot[25],row_off_detect_top[58],row_off_detect_bot[49],row_off_detect_top[44],row_off_detect_top[45],row_off_detect_top[30],row_off_detect_top[24],row_off_detect_top[25],row_off_detect_top[48],row_off_detect_top[49],row_off_detect_top[28],row_off_detect_top[57],row_off_detect_top[29],row_off_detect_top[6],row_off_detect_bot[48]
*+ row_on_detect_top[1],row_on_detect_top[6],row_on_detect_top[7],row_off_detect_top[62],row_on_detect_top[21],row_on_detect_top[26],row_on_detect_top[27],row_on_detect_top[28],row_on_detect_top[29],row_on_detect_top[30],row_on_detect_top[31],row_on_detect_top[40],row_on_detect_top[41],row_on_detect_top[44],row_on_detect_top[45],row_on_detect_top[46],row_on_detect_top[47],row_on_detect_top[56],row_on_detect_top[57],row_on_detect_top[60],row_on_detect_top[61],row_on_detect_top[12],row_on_detect_top[13],row_on_detect_top[52],row_on_detect_top[53],row_on_detect_top[38],row_on_detect_top[34],row_on_detect_top[39],row_on_detect_top[35],row_on_detect_bot[60],row_on_detect_bot[43],row_on_detect_top[50],row_on_detect_top[51],row_on_detect_top[16],row_on_detect_top[17],row_on_detect_top[22],row_on_detect_top[36],row_on_detect_top[23],row_on_detect_top[32],row_on_detect_top[37],row_on_detect_top[33],row_on_detect_top[42],row_on_detect_top[43],row_on_detect_bot[42],row_on_detect_bot[61],row_on_detect_top[26],row_on_detect_bot[56],row_on_detect_top[18],row_on_detect_top[48],row_on_detect_top[14],row_on_detect_top[19],row_on_detect_top[62],row_on_detect_top[49],row_on_detect_top[10],row_on_detect_top[15],row_on_detect_top[63],row_on_detect_top[58],row_on_detect_top[24],row_on_detect_top[11],row_on_detect_top[54],row_on_detect_top[59],row_on_detect_top[20],row_on_detect_top[25],row_on_detect_top[55]
*+ array_col_bot_right[12],array_col_bot_right[11],array_col_bot_right[10],array_col_bot_right[9],array_col_bot_right[8],array_col_bot_right[7],array_col_bot_right[6],array_col_bot_right[32],array_col_bot_right[31],array_col_bot_right[30],array_col_bot_right[27],array_col_bot_right[26],array_col_bot_right[25],array_col_bot_right[24],array_col_bot_right[52],array_col_bot_right[51],array_col_bot_right[50],array_col_bot_right[44],array_col_bot_right[56],array_col_bot_right[57],array_col_bot_right[60],array_col_bot_right[18],array_col_bot_right[23],array_col_bot_right[40],array_col_bot_right[35],array_col_bot_right[19],array_col_bot_right[20],array_col_bot_right[61],array_col_bot_right[62],array_col_bot_right[36],array_col_bot_right[41],array_col_bot_right[37],array_col_bot_right[42],array_col_bot_right[3],array_col_bot_right[0],array_col_bot_right[15],array_col_bot_right[47],array_col_bot_right[53],array_col_bot_right[54],array_col_bot_right[58],array_col_bot_right[21],array_col_bot_right[22],array_col_bot_right[63],array_col_bot_right[38],array_col_bot_right[59],array_col_bot_right[33],array_col_bot_right[34],array_col_bot_right[39],array_col_bot_right[5],array_col_bot_right[43],array_col_bot_right[16],array_col_bot_right[48],array_col_bot_right[4],array_col_bot_right[45],array_col_bot_right[46],array_col_bot_right[17],array_col_bot_right[1],array_col_bot_right[28],array_col_bot_right[49],array_col_bot_right[2],array_col_bot_right[13],array_col_bot_right[29],array_col_bot_right[14],array_col_bot_right[55]
*+ array_col_bot_left[12],array_col_bot_left[11],array_col_bot_left[10],array_col_bot_left[9],array_col_bot_left[8],array_col_bot_left[7],array_col_bot_left[6],array_col_bot_left[32],array_col_bot_left[31],array_col_bot_left[30],array_col_bot_left[27],array_col_bot_left[26],array_col_bot_left[25],array_col_bot_left[24],array_col_bot_left[52],array_col_bot_left[51],array_col_bot_left[50],array_col_bot_left[44],array_col_bot_left[56],array_col_bot_left[57],array_col_bot_left[60],array_col_bot_left[18],array_col_bot_left[23],array_col_bot_left[40],array_col_bot_left[35],array_col_bot_left[19],array_col_bot_left[20],array_col_bot_left[61],array_col_bot_left[62],array_col_bot_left[36],array_col_bot_left[41],array_col_bot_left[37],array_col_bot_left[42],array_col_bot_left[3],array_col_bot_left[0],array_col_bot_left[15],array_col_bot_left[47],array_col_bot_left[53],array_col_bot_left[54],array_col_bot_left[58],array_col_bot_left[21],array_col_bot_left[22],array_col_bot_left[63],array_col_bot_left[38],array_col_bot_left[59],array_col_bot_left[33],array_col_bot_left[34],array_col_bot_left[39],array_col_bot_left[5],array_col_bot_left[43],array_col_bot_left[16],array_col_bot_left[48],array_col_bot_left[4],array_col_bot_left[45],array_col_bot_left[46],array_col_bot_left[17],array_col_bot_left[1],array_col_bot_left[28],array_col_bot_left[49],array_col_bot_left[2],array_col_bot_left[13],array_col_bot_left[29],array_col_bot_left[14],array_col_bot_left[55]
*+ array_col_bot_left[0],array_col_bot_left[1],array_col_bot_left[2],array_col_bot_left[3],array_col_bot_left[4],array_col_bot_left[5],array_col_bot_left[6],array_col_bot_left[7],array_col_bot_left[8],array_col_bot_left[9],array_col_bot_left[10],array_col_bot_left[11],array_col_bot_left[12],array_col_bot_left[13],array_col_bot_left[14],array_col_bot_left[15],array_col_bot_left[16],array_col_bot_left[17],array_col_bot_left[18],array_col_bot_left[19],array_col_bot_left[20],array_col_bot_left[21],array_col_bot_left[22],array_col_bot_left[23],array_col_bot_left[24],array_col_bot_left[25],array_col_bot_left[26],array_col_bot_left[27],array_col_bot_left[28],array_col_bot_left[29],array_col_bot_left[30],array_col_bot_left[31],array_col_bot_left[32],array_col_bot_left[33],array_col_bot_left[34],array_col_bot_left[35],array_col_bot_left[36],array_col_bot_left[37],array_col_bot_left[38],array_col_bot_left[39],array_col_bot_left[40],array_col_bot_left[41],array_col_bot_left[42],array_col_bot_left[43],array_col_bot_left[44],array_col_bot_left[45],array_col_bot_left[46],array_col_bot_left[47],array_col_bot_left[48],array_col_bot_left[49],array_col_bot_left[50],array_col_bot_left[51],array_col_bot_left[52],array_col_bot_left[53],array_col_bot_left[54],array_col_bot_left[55],array_col_bot_left[56],array_col_bot_left[57],array_col_bot_left[58],array_col_bot_left[59],array_col_bot_left[60],array_col_bot_left[61],array_col_bot_left[62],array_col_bot_left[63]
*+ array_col_bot_right[0],array_col_bot_right[1],array_col_bot_right[2],array_col_bot_right[3],array_col_bot_right[4],array_col_bot_right[5],array_col_bot_right[6],array_col_bot_right[7],array_col_bot_right[8],array_col_bot_right[9],array_col_bot_right[10],array_col_bot_right[11],array_col_bot_right[12],array_col_bot_right[13],array_col_bot_right[14],array_col_bot_right[15],array_col_bot_right[16],array_col_bot_right[17],array_col_bot_right[18],array_col_bot_right[19],array_col_bot_right[20],array_col_bot_right[21],array_col_bot_right[22],array_col_bot_right[23],array_col_bot_right[24],array_col_bot_right[25],array_col_bot_right[26],array_col_bot_right[27],array_col_bot_right[28],array_col_bot_right[29],array_col_bot_right[30],array_col_bot_right[31],array_col_bot_right[32],array_col_bot_right[33],array_col_bot_right[34],array_col_bot_right[35],array_col_bot_right[36],array_col_bot_right[37],array_col_bot_right[38],array_col_bot_right[39],array_col_bot_right[40],array_col_bot_right[41],array_col_bot_right[42],array_col_bot_right[43],array_col_bot_right[44],array_col_bot_right[45],array_col_bot_right[46],array_col_bot_right[47],array_col_bot_right[48],array_col_bot_right[49],array_col_bot_right[50],array_col_bot_right[51],array_col_bot_right[52],array_col_bot_right[53],array_col_bot_right[54],array_col_bot_right[55],array_col_bot_right[56],array_col_bot_right[57],array_col_bot_right[58],array_col_bot_right[59],array_col_bot_right[60],array_col_bot_right[61],array_col_bot_right[62],array_col_bot_right[63]
*+ col_event_rst_bot_right[0],col_event_rst_bot_right[4],col_event_rst_bot_right[5],col_event_rst_bot_right[6],col_event_rst_bot_right[7],col_event_rst_bot_right[8],col_event_rst_bot_right[11],col_event_rst_bot_right[24],col_event_rst_bot_right[25],col_event_rst_bot_right[26],col_event_rst_bot_right[27],col_event_rst_bot_right[32],col_event_rst_bot_right[33],col_event_rst_bot_right[34],col_event_rst_bot_right[53],col_event_rst_bot_right[48],col_event_rst_bot_right[45],col_event_rst_bot_right[44],col_event_rst_bot_right[63],col_event_rst_bot_right[58],col_event_rst_bot_right[57],col_event_rst_bot_right[56],col_event_rst_bot_right[55],col_event_rst_bot_right[54],col_event_rst_bot_right[42],col_event_rst_bot_right[43],col_event_rst_bot_right[1],col_event_rst_bot_right[35],col_event_rst_bot_right[41],col_event_rst_bot_right[22],col_event_rst_bot_right[14],col_event_rst_bot_right[23],col_event_rst_bot_right[15],col_event_rst_bot_right[16],col_event_rst_bot_right[38],col_event_rst_bot_right[31],col_event_rst_bot_right[49],col_event_rst_bot_right[50],col_event_rst_bot_right[12],col_event_rst_bot_right[21],col_event_rst_bot_right[46],col_event_rst_bot_right[2],col_event_rst_bot_right[13],col_event_rst_bot_right[17],col_event_rst_bot_right[47],col_event_rst_bot_right[59],col_event_rst_bot_right[3],col_event_rst_bot_right[30],col_event_rst_bot_right[39],col_event_rst_bot_right[40],col_event_rst_bot_right[36],col_event_rst_bot_right[9],col_event_rst_bot_right[51],col_event_rst_bot_right[28],col_event_rst_bot_right[37],col_event_rst_bot_right[60],col_event_rst_bot_right[18],col_event_rst_bot_right[29],col_event_rst_bot_right[52],col_event_rst_bot_right[20],col_event_rst_bot_right[61],col_event_rst_bot_right[10],col_event_rst_bot_right[19],col_event_rst_bot_right[62]
*+ col_event_rst_bot_left[0],col_event_rst_bot_left[4],col_event_rst_bot_left[5],col_event_rst_bot_left[6],col_event_rst_bot_left[7],col_event_rst_bot_left[8],col_event_rst_bot_left[11],col_event_rst_bot_left[24],col_event_rst_bot_left[25],col_event_rst_bot_left[26],col_event_rst_bot_left[27],col_event_rst_bot_left[32],col_event_rst_bot_left[33],col_event_rst_bot_left[34],col_event_rst_bot_left[53],col_event_rst_bot_left[48],col_event_rst_bot_left[45],col_event_rst_bot_left[44],col_event_rst_bot_left[63],col_event_rst_bot_left[58],col_event_rst_bot_left[57],col_event_rst_bot_left[56],col_event_rst_bot_left[55],col_event_rst_bot_left[54],col_event_rst_bot_left[42],col_event_rst_bot_left[43],col_event_rst_bot_left[1],col_event_rst_bot_left[35],col_event_rst_bot_left[41],col_event_rst_bot_left[22],col_event_rst_bot_left[14],col_event_rst_bot_left[23],col_event_rst_bot_left[15],col_event_rst_bot_left[16],col_event_rst_bot_left[38],col_event_rst_bot_left[31],col_event_rst_bot_left[49],col_event_rst_bot_left[50],col_event_rst_bot_left[12],col_event_rst_bot_left[21],col_event_rst_bot_left[46],col_event_rst_bot_left[2],col_event_rst_bot_left[13],col_event_rst_bot_left[17],col_event_rst_bot_left[47],col_event_rst_bot_left[59],col_event_rst_bot_left[3],col_event_rst_bot_left[30],col_event_rst_bot_left[39],col_event_rst_bot_left[40],col_event_rst_bot_left[36],col_event_rst_bot_left[9],col_event_rst_bot_left[51],col_event_rst_bot_left[28],col_event_rst_bot_left[37],col_event_rst_bot_left[60],col_event_rst_bot_left[18],col_event_rst_bot_left[29],col_event_rst_bot_left[52],col_event_rst_bot_left[20],col_event_rst_bot_left[61],col_event_rst_bot_left[10],col_event_rst_bot_left[19],col_event_rst_bot_left[62]
*+ col_event_rst_bot_left[0],col_event_rst_bot_left[1],col_event_rst_bot_left[2],col_event_rst_bot_left[3],col_event_rst_bot_left[4],col_event_rst_bot_left[5],col_event_rst_bot_left[6],col_event_rst_bot_left[7],col_event_rst_bot_left[8],col_event_rst_bot_left[9],col_event_rst_bot_left[10],col_event_rst_bot_left[11],col_event_rst_bot_left[12],col_event_rst_bot_left[13],col_event_rst_bot_left[14],col_event_rst_bot_left[15],col_event_rst_bot_left[16],col_event_rst_bot_left[17],col_event_rst_bot_left[18],col_event_rst_bot_left[19],col_event_rst_bot_left[20],col_event_rst_bot_left[21],col_event_rst_bot_left[22],col_event_rst_bot_left[23],col_event_rst_bot_left[24],col_event_rst_bot_left[25],col_event_rst_bot_left[26],col_event_rst_bot_left[27],col_event_rst_bot_left[28],col_event_rst_bot_left[29],col_event_rst_bot_left[30],col_event_rst_bot_left[31],col_event_rst_bot_left[32],col_event_rst_bot_left[33],col_event_rst_bot_left[34],col_event_rst_bot_left[35],col_event_rst_bot_left[36],col_event_rst_bot_left[37],col_event_rst_bot_left[38],col_event_rst_bot_left[39],col_event_rst_bot_left[40],col_event_rst_bot_left[41],col_event_rst_bot_left[42],col_event_rst_bot_left[43],col_event_rst_bot_left[44],col_event_rst_bot_left[45],col_event_rst_bot_left[46],col_event_rst_bot_left[47],col_event_rst_bot_left[48],col_event_rst_bot_left[49],col_event_rst_bot_left[50],col_event_rst_bot_left[51],col_event_rst_bot_left[52],col_event_rst_bot_left[53],col_event_rst_bot_left[54],col_event_rst_bot_left[55],col_event_rst_bot_left[56],col_event_rst_bot_left[57],col_event_rst_bot_left[58],col_event_rst_bot_left[59],col_event_rst_bot_left[60],col_event_rst_bot_left[61],col_event_rst_bot_left[62],col_event_rst_bot_left[63]
*+ col_event_rst_bot_right[0],col_event_rst_bot_right[1],col_event_rst_bot_right[2],col_event_rst_bot_right[3],col_event_rst_bot_right[4],col_event_rst_bot_right[5],col_event_rst_bot_right[6],col_event_rst_bot_right[7],col_event_rst_bot_right[8],col_event_rst_bot_right[9],col_event_rst_bot_right[10],col_event_rst_bot_right[11],col_event_rst_bot_right[12],col_event_rst_bot_right[13],col_event_rst_bot_right[14],col_event_rst_bot_right[15],col_event_rst_bot_right[16],col_event_rst_bot_right[17],col_event_rst_bot_right[18],col_event_rst_bot_right[19],col_event_rst_bot_right[20],col_event_rst_bot_right[21],col_event_rst_bot_right[22],col_event_rst_bot_right[23],col_event_rst_bot_right[24],col_event_rst_bot_right[25],col_event_rst_bot_right[26],col_event_rst_bot_right[27],col_event_rst_bot_right[28],col_event_rst_bot_right[29],col_event_rst_bot_right[30],col_event_rst_bot_right[31],col_event_rst_bot_right[32],col_event_rst_bot_right[33],col_event_rst_bot_right[34],col_event_rst_bot_right[35],col_event_rst_bot_right[36],col_event_rst_bot_right[37],col_event_rst_bot_right[38],col_event_rst_bot_right[39],col_event_rst_bot_right[40],col_event_rst_bot_right[41],col_event_rst_bot_right[42],col_event_rst_bot_right[43],col_event_rst_bot_right[44],col_event_rst_bot_right[45],col_event_rst_bot_right[46],col_event_rst_bot_right[47],col_event_rst_bot_right[48],col_event_rst_bot_right[49],col_event_rst_bot_right[50],col_event_rst_bot_right[51],col_event_rst_bot_right[52],col_event_rst_bot_right[53],col_event_rst_bot_right[54],col_event_rst_bot_right[55],col_event_rst_bot_right[56],col_event_rst_bot_right[57],col_event_rst_bot_right[58],col_event_rst_bot_right[59],col_event_rst_bot_right[60],col_event_rst_bot_right[61],col_event_rst_bot_right[62],col_event_rst_bot_right[63]
x1 dac_config_0 dac_config_5 dac_config_3 vssa1 dac_config_4 dac_config_1 vdda1 dac_config_2
+ dac_config_6 pre_charge_global_top_left row_off_detect_top[4] row_on_detect_bot[57]
+ row_off_detect_top[10] row_off_detect_top[11] row_off_detect_top[12] row_off_detect_top[13]
+ row_off_detect_top[14] row_off_detect_top[15] row_off_detect_top[16] row_off_detect_top[17]
+ row_off_detect_top[33] row_off_detect_top[34] row_off_detect_top[36] row_off_detect_top[37]
+ row_off_detect_top[42] row_off_detect_top[43] row_off_detect_top[61] row_off_detect_top[40]
+ row_off_detect_top[41] row_off_detect_top[20] row_off_detect_bot[49] row_off_detect_top[30]
+ row_off_detect_top[24] row_off_detect_top[25] row_off_detect_top[48] row_off_detect_top[57]
+ row_off_detect_top[29] row_off_detect_top[59] row_off_detect_top[60] row_off_detect_top[23]
+ row_off_detect_top[26] row_off_detect_top[54] row_off_detect_top[55] row_off_detect_top[7]
+ row_off_detect_top[18] row_off_detect_top[50] row_off_detect_top[51] row_off_detect_top[0]
+ row_off_detect_top[1] row_off_detect_top[44] row_off_detect_top[45] row_off_detect_top[56]
+ row_off_detect_top[6] row_off_detect_top[46] row_off_detect_top[63] row_off_detect_bot[48]
+ row_off_detect_top[22] row_off_detect_top[47] row_off_detect_top[53] row_off_detect_top[38]
+ row_off_detect_top[5] row_off_detect_top[27] row_off_detect_top[49] row_off_detect_top[39]
+ row_off_detect_bot[48] row_off_detect_top[6] row_off_detect_bot[22] row_off_detect_bot[21]
+ row_off_detect_bot[59] row_off_detect_bot[36] row_off_detect_bot[49] row_off_detect_bot[25]
+ row_off_detect_bot[16] row_off_detect_bot[50] row_on_detect_top[1] row_on_detect_top[6]
+ row_on_detect_top[31] row_on_detect_top[40] row_on_detect_top[45] row_on_detect_top[46]
+ row_on_detect_top[47] row_on_detect_top[56] row_on_detect_top[57] row_on_detect_top[60]
+ row_on_detect_top[61] row_on_detect_top[12] row_on_detect_top[13] row_on_detect_top[52]
+ row_on_detect_top[53] row_on_detect_top[17] row_on_detect_top[22] row_on_detect_top[36]
+ row_on_detect_top[23] row_on_detect_top[33] row_on_detect_top[25] row_on_detect_top[55]
+ row_on_detect_top[35] row_on_detect_top[38] row_on_detect_bot[60] row_on_detect_top[41]
+ row_on_detect_top[44] row_on_detect_bot[56] row_on_detect_top[34] row_on_detect_top[19]
+ row_on_detect_top[18] row_on_detect_top[39] row_on_detect_top[62] row_on_detect_top[27]
+ row_on_detect_top[28] row_on_detect_top[42] row_on_detect_bot[43] row_on_detect_top[50]
+ row_on_detect_bot[61] row_on_detect_top[26] row_on_detect_top[11] row_on_detect_top[15]
+ row_on_detect_top[54] row_on_detect_top[63] row_on_detect_top[32] row_on_detect_top[37]
+ row_on_detect_top[48] row_on_detect_top[49] row_on_detect_top[14] row_on_detect_top[51]
+ row_on_detect_top[21] row_on_detect_top[10] row_on_detect_top[16] row_on_detect_top[29]
+ row_on_detect_top[26] row_on_detect_bot[42] row_on_detect_bot[3] row_on_detect_top[30]
+ row_on_detect_bot[43] row_on_detect_bot[60] row_on_detect_bot[56] row_on_detect_bot[61]
+ row_on_detect_top[7] row_on_detect_bot[57] detect_pulse_global_top_left col_event_rst_bot_right[0]
+ col_event_rst_bot_right[4] col_event_rst_bot_right[5] col_event_rst_bot_right[6]
+ col_event_rst_bot_right[7] col_event_rst_bot_right[8] col_event_rst_bot_right[11]
+ col_event_rst_bot_right[24] col_event_rst_bot_right[25] col_event_rst_bot_right[26]
+ col_event_rst_bot_right[27] col_event_rst_bot_right[32] col_event_rst_bot_right[33]
+ col_event_rst_bot_right[34] col_event_rst_bot_right[53] col_event_rst_bot_right[48]
+ col_event_rst_bot_right[45] col_event_rst_bot_right[44] col_event_rst_bot_right[63]
+ col_event_rst_bot_right[58] col_event_rst_bot_right[57] col_event_rst_bot_right[56]
+ col_event_rst_bot_right[55] col_event_rst_bot_right[54] col_event_rst_bot_right[42]
+ col_event_rst_bot_right[43] col_event_rst_bot_right[1] col_event_rst_bot_right[35]
+ col_event_rst_bot_right[41] col_event_rst_bot_right[22] col_event_rst_bot_right[14]
+ col_event_rst_bot_right[23] col_event_rst_bot_right[15] col_event_rst_bot_right[16]
+ col_event_rst_bot_right[38] col_event_rst_bot_right[31] col_event_rst_bot_right[49]
+ col_event_rst_bot_right[50] col_event_rst_bot_right[12] col_event_rst_bot_right[21]
+ col_event_rst_bot_right[46] col_event_rst_bot_right[2] col_event_rst_bot_right[13]
+ col_event_rst_bot_right[17] col_event_rst_bot_right[47] col_event_rst_bot_right[59]
+ col_event_rst_bot_right[3] col_event_rst_bot_right[30] col_event_rst_bot_right[39]
+ col_event_rst_bot_right[40] col_event_rst_bot_right[36] col_event_rst_bot_right[9]
+ col_event_rst_bot_right[51] col_event_rst_bot_right[28] col_event_rst_bot_right[37]
+ col_event_rst_bot_right[60] col_event_rst_bot_right[18] col_event_rst_bot_right[29]
+ col_event_rst_bot_right[52] col_event_rst_bot_right[20] col_event_rst_bot_right[61]
+ col_event_rst_bot_right[10] col_event_rst_bot_right[19] col_event_rst_bot_right[62]
+ array_col_bot_right[12] array_col_bot_right[11] array_col_bot_right[10] array_col_bot_right[9]
+ array_col_bot_right[8] array_col_bot_right[7] array_col_bot_right[6] array_col_bot_right[32]
+ array_col_bot_right[31] array_col_bot_right[30] array_col_bot_right[27] array_col_bot_right[26]
+ array_col_bot_right[25] array_col_bot_right[24] array_col_bot_right[52] array_col_bot_right[51]
+ array_col_bot_right[50] array_col_bot_right[44] array_col_bot_right[56] array_col_bot_right[57]
+ array_col_bot_right[60] array_col_bot_right[18] array_col_bot_right[23] array_col_bot_right[40]
+ array_col_bot_right[35] array_col_bot_right[19] array_col_bot_right[20] array_col_bot_right[61]
+ array_col_bot_right[62] array_col_bot_right[36] array_col_bot_right[41] array_col_bot_right[37]
+ array_col_bot_right[42] array_col_bot_right[3] array_col_bot_right[0] array_col_bot_right[15]
+ array_col_bot_right[47] array_col_bot_right[53] array_col_bot_right[54] array_col_bot_right[58]
+ array_col_bot_right[21] array_col_bot_right[22] array_col_bot_right[63] array_col_bot_right[38]
+ array_col_bot_right[59] array_col_bot_right[33] array_col_bot_right[34] array_col_bot_right[39]
+ array_col_bot_right[5] array_col_bot_right[43] array_col_bot_right[16] array_col_bot_right[48]
+ array_col_bot_right[4] array_col_bot_right[45] array_col_bot_right[46] array_col_bot_right[17]
+ array_col_bot_right[1] array_col_bot_right[28] array_col_bot_right[49] array_col_bot_right[2]
+ array_col_bot_right[13] array_col_bot_right[29] array_col_bot_right[14] array_col_bot_right[55]
+ ndetect_pulse_global_top_left vssc1 pixel_layout_tile
x2 dac_config_0 dac_config_5 dac_config_3 vssa1 dac_config_4 dac_config_1 vdda1 dac_config_2
+ dac_config_6 pre_charge_global_top_left row_off_detect_top[4] row_on_detect_bot[57]
+ row_off_detect_top[10] row_off_detect_top[11] row_off_detect_top[12] row_off_detect_top[13]
+ row_off_detect_top[14] row_off_detect_top[15] row_off_detect_top[16] row_off_detect_top[17]
+ row_off_detect_top[33] row_off_detect_top[34] row_off_detect_top[36] row_off_detect_top[37]
+ row_off_detect_top[42] row_off_detect_top[43] row_off_detect_top[61] row_off_detect_top[40]
+ row_off_detect_top[41] row_off_detect_top[20] row_off_detect_bot[49] row_off_detect_top[30]
+ row_off_detect_top[24] row_off_detect_top[25] row_off_detect_top[48] row_off_detect_top[57]
+ row_off_detect_top[29] row_off_detect_top[59] row_off_detect_top[60] row_off_detect_top[23]
+ row_off_detect_top[26] row_off_detect_top[54] row_off_detect_top[55] row_off_detect_top[7]
+ row_off_detect_top[18] row_off_detect_top[50] row_off_detect_top[51] row_off_detect_top[0]
+ row_off_detect_top[1] row_off_detect_top[44] row_off_detect_top[45] row_off_detect_top[56]
+ row_off_detect_top[6] row_off_detect_top[46] row_off_detect_top[63] row_off_detect_bot[48]
+ row_off_detect_top[22] row_off_detect_top[47] row_off_detect_top[53] row_off_detect_top[38]
+ row_off_detect_top[5] row_off_detect_top[27] row_off_detect_top[49] row_off_detect_top[39]
+ row_off_detect_bot[48] row_off_detect_top[6] row_off_detect_bot[22] row_off_detect_bot[21]
+ row_off_detect_bot[59] row_off_detect_bot[36] row_off_detect_bot[49] row_off_detect_bot[25]
+ row_off_detect_bot[16] row_off_detect_bot[50] row_on_detect_top[1] row_on_detect_top[6]
+ row_on_detect_top[31] row_on_detect_top[40] row_on_detect_top[45] row_on_detect_top[46]
+ row_on_detect_top[47] row_on_detect_top[56] row_on_detect_top[57] row_on_detect_top[60]
+ row_on_detect_top[61] row_on_detect_top[12] row_on_detect_top[13] row_on_detect_top[52]
+ row_on_detect_top[53] row_on_detect_top[17] row_on_detect_top[22] row_on_detect_top[36]
+ row_on_detect_top[23] row_on_detect_top[33] row_on_detect_top[25] row_on_detect_top[55]
+ row_on_detect_top[35] row_on_detect_top[38] row_on_detect_bot[60] row_on_detect_top[41]
+ row_on_detect_top[44] row_on_detect_bot[56] row_on_detect_top[34] row_on_detect_top[19]
+ row_on_detect_top[18] row_on_detect_top[39] row_on_detect_top[62] row_on_detect_top[27]
+ row_on_detect_top[28] row_on_detect_top[42] row_on_detect_bot[43] row_on_detect_top[50]
+ row_on_detect_bot[61] row_on_detect_top[26] row_on_detect_top[11] row_on_detect_top[15]
+ row_on_detect_top[54] row_on_detect_top[63] row_on_detect_top[32] row_on_detect_top[37]
+ row_on_detect_top[48] row_on_detect_top[49] row_on_detect_top[14] row_on_detect_top[51]
+ row_on_detect_top[21] row_on_detect_top[10] row_on_detect_top[16] row_on_detect_top[29]
+ row_on_detect_top[26] row_on_detect_bot[42] row_on_detect_bot[3] row_on_detect_top[30]
+ row_on_detect_bot[43] row_on_detect_bot[60] row_on_detect_bot[56] row_on_detect_bot[61]
+ row_on_detect_top[7] row_on_detect_bot[57] detect_pulse_global_top_left col_event_rst_bot_left[0]
+ col_event_rst_bot_left[4] col_event_rst_bot_left[5] col_event_rst_bot_left[6]
+ col_event_rst_bot_left[7] col_event_rst_bot_left[8] col_event_rst_bot_left[11]
+ col_event_rst_bot_left[24] col_event_rst_bot_left[25] col_event_rst_bot_left[26]
+ col_event_rst_bot_left[27] col_event_rst_bot_left[32] col_event_rst_bot_left[33]
+ col_event_rst_bot_left[34] col_event_rst_bot_left[53] col_event_rst_bot_left[48]
+ col_event_rst_bot_left[45] col_event_rst_bot_left[44] col_event_rst_bot_left[63]
+ col_event_rst_bot_left[58] col_event_rst_bot_left[57] col_event_rst_bot_left[56]
+ col_event_rst_bot_left[55] col_event_rst_bot_left[54] col_event_rst_bot_left[42]
+ col_event_rst_bot_left[43] col_event_rst_bot_left[1] col_event_rst_bot_left[35]
+ col_event_rst_bot_left[41] col_event_rst_bot_left[22] col_event_rst_bot_left[14]
+ col_event_rst_bot_left[23] col_event_rst_bot_left[15] col_event_rst_bot_left[16]
+ col_event_rst_bot_left[38] col_event_rst_bot_left[31] col_event_rst_bot_left[49]
+ col_event_rst_bot_left[50] col_event_rst_bot_left[12] col_event_rst_bot_left[21]
+ col_event_rst_bot_left[46] col_event_rst_bot_left[2] col_event_rst_bot_left[13]
+ col_event_rst_bot_left[17] col_event_rst_bot_left[47] col_event_rst_bot_left[59]
+ col_event_rst_bot_left[3] col_event_rst_bot_left[30] col_event_rst_bot_left[39]
+ col_event_rst_bot_left[40] col_event_rst_bot_left[36] col_event_rst_bot_left[9]
+ col_event_rst_bot_left[51] col_event_rst_bot_left[28] col_event_rst_bot_left[37]
+ col_event_rst_bot_left[60] col_event_rst_bot_left[18] col_event_rst_bot_left[29]
+ col_event_rst_bot_left[52] col_event_rst_bot_left[20] col_event_rst_bot_left[61]
+ col_event_rst_bot_left[10] col_event_rst_bot_left[19] col_event_rst_bot_left[62]
+ array_col_bot_left[12] array_col_bot_left[11] array_col_bot_left[10] array_col_bot_left[9]
+ array_col_bot_left[8] array_col_bot_left[7] array_col_bot_left[6] array_col_bot_left[32]
+ array_col_bot_left[31] array_col_bot_left[30] array_col_bot_left[27] array_col_bot_left[26]
+ array_col_bot_left[25] array_col_bot_left[24] array_col_bot_left[52] array_col_bot_left[51]
+ array_col_bot_left[50] array_col_bot_left[44] array_col_bot_left[56] array_col_bot_left[57]
+ array_col_bot_left[60] array_col_bot_left[18] array_col_bot_left[23] array_col_bot_left[40]
+ array_col_bot_left[35] array_col_bot_left[19] array_col_bot_left[20] array_col_bot_left[61]
+ array_col_bot_left[62] array_col_bot_left[36] array_col_bot_left[41] array_col_bot_left[37]
+ array_col_bot_left[42] array_col_bot_left[3] array_col_bot_left[0] array_col_bot_left[15]
+ array_col_bot_left[47] array_col_bot_left[53] array_col_bot_left[54] array_col_bot_left[58]
+ array_col_bot_left[21] array_col_bot_left[22] array_col_bot_left[63] array_col_bot_left[38]
+ array_col_bot_left[59] array_col_bot_left[33] array_col_bot_left[34] array_col_bot_left[39]
+ array_col_bot_left[5] array_col_bot_left[43] array_col_bot_left[16] array_col_bot_left[48]
+ array_col_bot_left[4] array_col_bot_left[45] array_col_bot_left[46] array_col_bot_left[17]
+ array_col_bot_left[1] array_col_bot_left[28] array_col_bot_left[49] array_col_bot_left[2]
+ array_col_bot_left[13] array_col_bot_left[29] array_col_bot_left[14] array_col_bot_left[55]
+ ndetect_pulse_global_top_left vssc1 pixel_layout_tile
x3 dac_config_0 dac_config_5 dac_config_3 vssa1 dac_config_4 dac_config_1 vdda1 dac_config_2
+ dac_config_6 pre_charge_global_top_left row_off_detect_top[0] row_off_detect_top[1]
+ row_off_detect_top[4] row_on_detect_bot[57] row_off_detect_top[5] row_off_detect_top[6]
+ row_off_detect_top[7] row_off_detect_top[10] row_off_detect_top[11] row_off_detect_top[12]
+ row_off_detect_top[13] row_off_detect_top[14] row_off_detect_top[15] row_off_detect_top[16]
+ row_off_detect_top[17] row_off_detect_top[18] row_off_detect_top[19] row_off_detect_top[22]
+ row_off_detect_top[23] row_off_detect_top[26] row_off_detect_top[27] row_off_detect_top[31]
+ row_off_detect_top[32] row_off_detect_top[33] row_off_detect_top[34] row_off_detect_top[35]
+ row_off_detect_top[36] row_off_detect_top[37] row_off_detect_top[38] row_off_detect_top[39]
+ row_off_detect_top[42] row_off_detect_top[43] row_off_detect_top[46] row_off_detect_top[47]
+ row_off_detect_top[50] row_off_detect_top[51] row_off_detect_top[52] row_off_detect_top[53]
+ row_off_detect_top[54] row_off_detect_top[55] row_off_detect_top[56] row_off_detect_top[63]
+ row_off_detect_top[59] row_off_detect_top[60] row_off_detect_top[61] row_off_detect_top[40]
+ row_off_detect_top[41] row_off_detect_top[20] row_off_detect_top[21] row_off_detect_bot[25]
+ row_off_detect_top[58] row_off_detect_bot[49] row_off_detect_top[44] row_off_detect_top[45]
+ row_off_detect_top[30] row_off_detect_top[24] row_off_detect_top[25] row_off_detect_top[48]
+ row_off_detect_top[49] row_off_detect_top[28] row_off_detect_top[57] row_off_detect_top[29]
+ row_off_detect_top[6] row_off_detect_bot[48] row_on_detect_top[1] row_on_detect_top[6]
+ row_on_detect_top[7] row_off_detect_top[62] row_on_detect_top[21] row_on_detect_top[26]
+ row_on_detect_top[27] row_on_detect_top[28] row_on_detect_top[29] row_on_detect_top[30]
+ row_on_detect_top[31] row_on_detect_top[40] row_on_detect_top[41] row_on_detect_top[44]
+ row_on_detect_top[45] row_on_detect_top[46] row_on_detect_top[47] row_on_detect_top[56]
+ row_on_detect_top[57] row_on_detect_top[60] row_on_detect_top[61] row_on_detect_top[12]
+ row_on_detect_top[13] row_on_detect_top[52] row_on_detect_top[53] row_on_detect_top[38]
+ row_on_detect_top[34] row_on_detect_top[39] row_on_detect_top[35] row_on_detect_bot[60]
+ row_on_detect_bot[43] row_on_detect_top[50] row_on_detect_top[51] row_on_detect_top[16]
+ row_on_detect_top[17] row_on_detect_top[22] row_on_detect_top[36] row_on_detect_top[23]
+ row_on_detect_top[32] row_on_detect_top[37] row_on_detect_top[33] row_on_detect_top[42]
+ row_on_detect_top[43] row_on_detect_bot[42] row_on_detect_bot[61] row_on_detect_top[26]
+ row_on_detect_bot[56] row_on_detect_top[18] row_on_detect_top[48] row_on_detect_top[14]
+ row_on_detect_top[19] row_on_detect_top[62] row_on_detect_top[49] row_on_detect_top[10]
+ row_on_detect_top[15] row_on_detect_top[63] row_on_detect_top[58] row_on_detect_top[24]
+ row_on_detect_top[11] row_on_detect_top[54] row_on_detect_top[59] row_on_detect_top[20]
+ row_on_detect_top[25] row_on_detect_top[55] detect_pulse_global_top_left array_col_bot_left[0]
+ array_col_bot_left[1] array_col_bot_left[2] array_col_bot_left[3] array_col_bot_left[4]
+ array_col_bot_left[5] array_col_bot_left[6] array_col_bot_left[7] array_col_bot_left[8]
+ array_col_bot_left[9] array_col_bot_left[10] array_col_bot_left[11] array_col_bot_left[12]
+ array_col_bot_left[13] array_col_bot_left[14] array_col_bot_left[15] array_col_bot_left[16]
+ array_col_bot_left[17] array_col_bot_left[18] array_col_bot_left[19] array_col_bot_left[20]
+ array_col_bot_left[21] array_col_bot_left[22] array_col_bot_left[23] array_col_bot_left[24]
+ array_col_bot_left[25] array_col_bot_left[26] array_col_bot_left[27] array_col_bot_left[28]
+ array_col_bot_left[29] array_col_bot_left[30] array_col_bot_left[31] array_col_bot_left[32]
+ array_col_bot_left[33] array_col_bot_left[34] array_col_bot_left[35] array_col_bot_left[36]
+ array_col_bot_left[37] array_col_bot_left[38] array_col_bot_left[39] array_col_bot_left[40]
+ array_col_bot_left[41] array_col_bot_left[42] array_col_bot_left[43] array_col_bot_left[44]
+ array_col_bot_left[45] array_col_bot_left[46] array_col_bot_left[47] array_col_bot_left[48]
+ array_col_bot_left[49] array_col_bot_left[50] array_col_bot_left[51] array_col_bot_left[52]
+ array_col_bot_left[53] array_col_bot_left[54] array_col_bot_left[55] array_col_bot_left[56]
+ array_col_bot_left[57] array_col_bot_left[58] array_col_bot_left[59] array_col_bot_left[60]
+ array_col_bot_left[61] array_col_bot_left[62] array_col_bot_left[63] col_event_rst_bot_left[0]
+ col_event_rst_bot_left[1] col_event_rst_bot_left[2] col_event_rst_bot_left[3]
+ col_event_rst_bot_left[4] col_event_rst_bot_left[5] col_event_rst_bot_left[6]
+ col_event_rst_bot_left[7] col_event_rst_bot_left[8] col_event_rst_bot_left[9]
+ col_event_rst_bot_left[10] col_event_rst_bot_left[11] col_event_rst_bot_left[12]
+ col_event_rst_bot_left[13] col_event_rst_bot_left[14] col_event_rst_bot_left[15]
+ col_event_rst_bot_left[16] col_event_rst_bot_left[17] col_event_rst_bot_left[18]
+ col_event_rst_bot_left[19] col_event_rst_bot_left[20] col_event_rst_bot_left[21]
+ col_event_rst_bot_left[22] col_event_rst_bot_left[23] col_event_rst_bot_left[24]
+ col_event_rst_bot_left[25] col_event_rst_bot_left[26] col_event_rst_bot_left[27]
+ col_event_rst_bot_left[28] col_event_rst_bot_left[29] col_event_rst_bot_left[30]
+ col_event_rst_bot_left[31] col_event_rst_bot_left[32] col_event_rst_bot_left[33]
+ col_event_rst_bot_left[34] col_event_rst_bot_left[35] col_event_rst_bot_left[36]
+ col_event_rst_bot_left[37] col_event_rst_bot_left[38] col_event_rst_bot_left[39]
+ col_event_rst_bot_left[40] col_event_rst_bot_left[41] col_event_rst_bot_left[42]
+ col_event_rst_bot_left[43] col_event_rst_bot_left[44] col_event_rst_bot_left[45]
+ col_event_rst_bot_left[46] col_event_rst_bot_left[47] col_event_rst_bot_left[48]
+ col_event_rst_bot_left[49] col_event_rst_bot_left[50] col_event_rst_bot_left[51]
+ col_event_rst_bot_left[52] col_event_rst_bot_left[53] col_event_rst_bot_left[54]
+ col_event_rst_bot_left[55] col_event_rst_bot_left[56] col_event_rst_bot_left[57]
+ col_event_rst_bot_left[58] col_event_rst_bot_left[59] col_event_rst_bot_left[60]
+ col_event_rst_bot_left[61] col_event_rst_bot_left[62] col_event_rst_bot_left[63]
+ ndetect_pulse_global_top_left vssc1 pixel_layout_tile_bot
x4 dac_config_0 dac_config_5 dac_config_3 vssa1 dac_config_4 dac_config_1 vdda1 dac_config_2
+ dac_config_6 pre_charge_global_top_left row_off_detect_top[0] row_off_detect_top[1]
+ row_off_detect_top[4] row_on_detect_bot[57] row_off_detect_top[5] row_off_detect_top[6]
+ row_off_detect_top[7] row_off_detect_top[10] row_off_detect_top[11] row_off_detect_top[12]
+ row_off_detect_top[13] row_off_detect_top[14] row_off_detect_top[15] row_off_detect_top[16]
+ row_off_detect_top[17] row_off_detect_top[18] row_off_detect_top[19] row_off_detect_top[22]
+ row_off_detect_top[23] row_off_detect_top[26] row_off_detect_top[27] row_off_detect_top[31]
+ row_off_detect_top[32] row_off_detect_top[33] row_off_detect_top[34] row_off_detect_top[35]
+ row_off_detect_top[36] row_off_detect_top[37] row_off_detect_top[38] row_off_detect_top[39]
+ row_off_detect_top[42] row_off_detect_top[43] row_off_detect_top[46] row_off_detect_top[47]
+ row_off_detect_top[50] row_off_detect_top[51] row_off_detect_top[52] row_off_detect_top[53]
+ row_off_detect_top[54] row_off_detect_top[55] row_off_detect_top[56] row_off_detect_top[63]
+ row_off_detect_top[59] row_off_detect_top[60] row_off_detect_top[61] row_off_detect_top[40]
+ row_off_detect_top[41] row_off_detect_top[20] row_off_detect_top[21] row_off_detect_bot[25]
+ row_off_detect_top[58] row_off_detect_bot[49] row_off_detect_top[44] row_off_detect_top[45]
+ row_off_detect_top[30] row_off_detect_top[24] row_off_detect_top[25] row_off_detect_top[48]
+ row_off_detect_top[49] row_off_detect_top[28] row_off_detect_top[57] row_off_detect_top[29]
+ row_off_detect_top[6] row_off_detect_bot[48] row_on_detect_top[1] row_on_detect_top[6]
+ row_on_detect_top[7] row_off_detect_top[62] row_on_detect_top[21] row_on_detect_top[26]
+ row_on_detect_top[27] row_on_detect_top[28] row_on_detect_top[29] row_on_detect_top[30]
+ row_on_detect_top[31] row_on_detect_top[40] row_on_detect_top[41] row_on_detect_top[44]
+ row_on_detect_top[45] row_on_detect_top[46] row_on_detect_top[47] row_on_detect_top[56]
+ row_on_detect_top[57] row_on_detect_top[60] row_on_detect_top[61] row_on_detect_top[12]
+ row_on_detect_top[13] row_on_detect_top[52] row_on_detect_top[53] row_on_detect_top[38]
+ row_on_detect_top[34] row_on_detect_top[39] row_on_detect_top[35] row_on_detect_bot[60]
+ row_on_detect_bot[43] row_on_detect_top[50] row_on_detect_top[51] row_on_detect_top[16]
+ row_on_detect_top[17] row_on_detect_top[22] row_on_detect_top[36] row_on_detect_top[23]
+ row_on_detect_top[32] row_on_detect_top[37] row_on_detect_top[33] row_on_detect_top[42]
+ row_on_detect_top[43] row_on_detect_bot[42] row_on_detect_bot[61] row_on_detect_top[26]
+ row_on_detect_bot[56] row_on_detect_top[18] row_on_detect_top[48] row_on_detect_top[14]
+ row_on_detect_top[19] row_on_detect_top[62] row_on_detect_top[49] row_on_detect_top[10]
+ row_on_detect_top[15] row_on_detect_top[63] row_on_detect_top[58] row_on_detect_top[24]
+ row_on_detect_top[11] row_on_detect_top[54] row_on_detect_top[59] row_on_detect_top[20]
+ row_on_detect_top[25] row_on_detect_top[55] detect_pulse_global_top_left array_col_bot_right[0]
+ array_col_bot_right[1] array_col_bot_right[2] array_col_bot_right[3] array_col_bot_right[4]
+ array_col_bot_right[5] array_col_bot_right[6] array_col_bot_right[7] array_col_bot_right[8]
+ array_col_bot_right[9] array_col_bot_right[10] array_col_bot_right[11] array_col_bot_right[12]
+ array_col_bot_right[13] array_col_bot_right[14] array_col_bot_right[15] array_col_bot_right[16]
+ array_col_bot_right[17] array_col_bot_right[18] array_col_bot_right[19] array_col_bot_right[20]
+ array_col_bot_right[21] array_col_bot_right[22] array_col_bot_right[23] array_col_bot_right[24]
+ array_col_bot_right[25] array_col_bot_right[26] array_col_bot_right[27] array_col_bot_right[28]
+ array_col_bot_right[29] array_col_bot_right[30] array_col_bot_right[31] array_col_bot_right[32]
+ array_col_bot_right[33] array_col_bot_right[34] array_col_bot_right[35] array_col_bot_right[36]
+ array_col_bot_right[37] array_col_bot_right[38] array_col_bot_right[39] array_col_bot_right[40]
+ array_col_bot_right[41] array_col_bot_right[42] array_col_bot_right[43] array_col_bot_right[44]
+ array_col_bot_right[45] array_col_bot_right[46] array_col_bot_right[47] array_col_bot_right[48]
+ array_col_bot_right[49] array_col_bot_right[50] array_col_bot_right[51] array_col_bot_right[52]
+ array_col_bot_right[53] array_col_bot_right[54] array_col_bot_right[55] array_col_bot_right[56]
+ array_col_bot_right[57] array_col_bot_right[58] array_col_bot_right[59] array_col_bot_right[60]
+ array_col_bot_right[61] array_col_bot_right[62] array_col_bot_right[63] col_event_rst_bot_right[0]
+ col_event_rst_bot_right[1] col_event_rst_bot_right[2] col_event_rst_bot_right[3]
+ col_event_rst_bot_right[4] col_event_rst_bot_right[5] col_event_rst_bot_right[6]
+ col_event_rst_bot_right[7] col_event_rst_bot_right[8] col_event_rst_bot_right[9]
+ col_event_rst_bot_right[10] col_event_rst_bot_right[11] col_event_rst_bot_right[12]
+ col_event_rst_bot_right[13] col_event_rst_bot_right[14] col_event_rst_bot_right[15]
+ col_event_rst_bot_right[16] col_event_rst_bot_right[17] col_event_rst_bot_right[18]
+ col_event_rst_bot_right[19] col_event_rst_bot_right[20] col_event_rst_bot_right[21]
+ col_event_rst_bot_right[22] col_event_rst_bot_right[23] col_event_rst_bot_right[24]
+ col_event_rst_bot_right[25] col_event_rst_bot_right[26] col_event_rst_bot_right[27]
+ col_event_rst_bot_right[28] col_event_rst_bot_right[29] col_event_rst_bot_right[30]
+ col_event_rst_bot_right[31] col_event_rst_bot_right[32] col_event_rst_bot_right[33]
+ col_event_rst_bot_right[34] col_event_rst_bot_right[35] col_event_rst_bot_right[36]
+ col_event_rst_bot_right[37] col_event_rst_bot_right[38] col_event_rst_bot_right[39]
+ col_event_rst_bot_right[40] col_event_rst_bot_right[41] col_event_rst_bot_right[42]
+ col_event_rst_bot_right[43] col_event_rst_bot_right[44] col_event_rst_bot_right[45]
+ col_event_rst_bot_right[46] col_event_rst_bot_right[47] col_event_rst_bot_right[48]
+ col_event_rst_bot_right[49] col_event_rst_bot_right[50] col_event_rst_bot_right[51]
+ col_event_rst_bot_right[52] col_event_rst_bot_right[53] col_event_rst_bot_right[54]
+ col_event_rst_bot_right[55] col_event_rst_bot_right[56] col_event_rst_bot_right[57]
+ col_event_rst_bot_right[58] col_event_rst_bot_right[59] col_event_rst_bot_right[60]
+ col_event_rst_bot_right[61] col_event_rst_bot_right[62] col_event_rst_bot_right[63]
+ ndetect_pulse_global_top_left vssc1 pixel_layout_tile_bot
.ends

* expanding   symbol:  pixel_layout_tile.sym # of pins=35
** sym_path: /home/alienfalcon/Projects/skywater/open_dvs_py312/open_dvs/git_dvs/nic2025_openDVS/analog/xschem/pixel_layout_tile.sym
** sch_path: /home/alienfalcon/Projects/skywater/open_dvs_py312/open_dvs/git_dvs/nic2025_openDVS/analog/xschem/pixel_layout_tile.sch
.subckt pixel_layout_tile DiffBn RefrBp PrBp GndA PrSFBp OffBn VDD OnBn VTHRESH nCHARGE rowReadOFF[63] rowReadOFF[62] rowReadOFF[61] rowReadOFF[60] rowReadOFF[59] rowReadOFF[58] rowReadOFF[57] rowReadOFF[56] rowReadOFF[55] rowReadOFF[54] rowReadOFF[53] rowReadOFF[52] rowReadOFF[51] rowReadOFF[50] rowReadOFF[49] rowReadOFF[48] rowReadOFF[47] rowReadOFF[46] rowReadOFF[45] rowReadOFF[44] rowReadOFF[43] rowReadOFF[42] rowReadOFF[41] rowReadOFF[40] rowReadOFF[39] rowReadOFF[38] rowReadOFF[37] rowReadOFF[36] rowReadOFF[35] rowReadOFF[34] rowReadOFF[33] rowReadOFF[32] rowReadOFF[31] rowReadOFF[30] rowReadOFF[29] rowReadOFF[28] rowReadOFF[27] rowReadOFF[26] rowReadOFF[25] rowReadOFF[24] rowReadOFF[23] rowReadOFF[22] rowReadOFF[21] rowReadOFF[20] rowReadOFF[19] rowReadOFF[18] rowReadOFF[17] rowReadOFF[16] rowReadOFF[15] rowReadOFF[14] rowReadOFF[13] rowReadOFF[12] rowReadOFF[11] rowReadOFF[10] rowReadOFF[9] rowReadOFF[8] rowReadOFF[7] rowReadOFF[6] rowReadOFF[5] rowReadOFF[4] rowReadOFF[3] rowReadOFF[2] rowReadOFF[1] rowReadOFF[0] rowReadON[63] rowReadON[62] rowReadON[61] rowReadON[60] rowReadON[59] rowReadON[58] rowReadON[57] rowReadON[56] rowReadON[55] rowReadON[54] rowReadON[53] rowReadON[52] rowReadON[51] rowReadON[50] rowReadON[49] rowReadON[48] rowReadON[47] rowReadON[46] rowReadON[45] rowReadON[44] rowReadON[43] rowReadON[42] rowReadON[41] rowReadON[40] rowReadON[39] rowReadON[38] rowReadON[37] rowReadON[36] rowReadON[35] rowReadON[34] rowReadON[33] rowReadON[32] rowReadON[31] rowReadON[30] rowReadON[29] rowReadON[28] rowReadON[27] rowReadON[26] rowReadON[25] rowReadON[24] rowReadON[23] rowReadON[22] rowReadON[21] rowReadON[20] rowReadON[19] rowReadON[18] rowReadON[17] rowReadON[16] rowReadON[15] rowReadON[14] rowReadON[13] rowReadON[12] rowReadON[11] rowReadON[10] rowReadON[9] rowReadON[8] rowReadON[7] rowReadON[6] rowReadON[5] rowReadON[4] rowReadON[3] rowReadON[2] rowReadON[1] rowReadON[0] DETECT pixRst[63] pixRst[62] pixRst[61] pixRst[60] pixRst[59] pixRst[58] pixRst[57] pixRst[56] pixRst[55] pixRst[54] pixRst[53] pixRst[52] pixRst[51] pixRst[50] pixRst[49] pixRst[48] pixRst[47] pixRst[46] pixRst[45] pixRst[44] pixRst[43] pixRst[42] pixRst[41] pixRst[40] pixRst[39] pixRst[38] pixRst[37] pixRst[36] pixRst[35] pixRst[34] pixRst[33] pixRst[32] pixRst[31] pixRst[30] pixRst[29] pixRst[28] pixRst[27] pixRst[26] pixRst[25] pixRst[24] pixRst[23] pixRst[22] pixRst[21] pixRst[20] pixRst[19] pixRst[18] pixRst[17] pixRst[16] pixRst[15] pixRst[14] pixRst[13] pixRst[12] pixRst[11] pixRst[10] pixRst[9] pixRst[8] pixRst[7] pixRst[6] pixRst[5] pixRst[4] pixRst[3] pixRst[2] pixRst[1] pixRst[0] voutn[63] voutn[62] voutn[61] voutn[60] voutn[59] voutn[58] voutn[57] voutn[56] voutn[55] voutn[54] voutn[53] voutn[52] voutn[51] voutn[50] voutn[49] voutn[48] voutn[47] voutn[46] voutn[45] voutn[44] voutn[43] voutn[42] voutn[41] voutn[40] voutn[39] voutn[38] voutn[37] voutn[36] voutn[35] voutn[34] voutn[33] voutn[32] voutn[31] voutn[30] voutn[29] voutn[28] voutn[27] voutn[26] voutn[25] voutn[24] voutn[23] voutn[22] voutn[21] voutn[20] voutn[19] voutn[18] voutn[17] voutn[16] voutn[15] voutn[14] voutn[13] voutn[12] voutn[11] voutn[10] voutn[9] voutn[8] voutn[7] voutn[6] voutn[5] voutn[4] voutn[3] voutn[2] voutn[1] voutn[0] nDETECT GndD
*.iopin GndA
*.iopin VDD
*.iopin OffBn
*.iopin OnBn
*.iopin DiffBn
*.iopin RefrBp
*.iopin PrSFBp
*.iopin PrBp
*.iopin nCHARGE
*.iopin VTHRESH
*.iopin nDETECT
*.iopin DETECT
*.iopin
*+ rowReadON[63],rowReadON[62],rowReadON[61],rowReadON[60],rowReadON[59],rowReadON[58],rowReadON[57],rowReadON[56],rowReadON[55],rowReadON[54],rowReadON[53],rowReadON[52],rowReadON[51],rowReadON[50],rowReadON[49],rowReadON[48],rowReadON[47],rowReadON[46],rowReadON[45],rowReadON[44],rowReadON[43],rowReadON[42],rowReadON[41],rowReadON[40],rowReadON[39],rowReadON[38],rowReadON[37],rowReadON[36],rowReadON[35],rowReadON[34],rowReadON[33],rowReadON[32],rowReadON[31],rowReadON[30],rowReadON[29],rowReadON[28],rowReadON[27],rowReadON[26],rowReadON[25],rowReadON[24],rowReadON[23],rowReadON[22],rowReadON[21],rowReadON[20],rowReadON[19],rowReadON[18],rowReadON[17],rowReadON[16],rowReadON[15],rowReadON[14],rowReadON[13],rowReadON[12],rowReadON[11],rowReadON[10],rowReadON[9],rowReadON[8],rowReadON[7],rowReadON[6],rowReadON[5],rowReadON[4],rowReadON[3],rowReadON[2],rowReadON[1],rowReadON[0]
*.iopin
*+ rowReadOFF[63],rowReadOFF[62],rowReadOFF[61],rowReadOFF[60],rowReadOFF[59],rowReadOFF[58],rowReadOFF[57],rowReadOFF[56],rowReadOFF[55],rowReadOFF[54],rowReadOFF[53],rowReadOFF[52],rowReadOFF[51],rowReadOFF[50],rowReadOFF[49],rowReadOFF[48],rowReadOFF[47],rowReadOFF[46],rowReadOFF[45],rowReadOFF[44],rowReadOFF[43],rowReadOFF[42],rowReadOFF[41],rowReadOFF[40],rowReadOFF[39],rowReadOFF[38],rowReadOFF[37],rowReadOFF[36],rowReadOFF[35],rowReadOFF[34],rowReadOFF[33],rowReadOFF[32],rowReadOFF[31],rowReadOFF[30],rowReadOFF[29],rowReadOFF[28],rowReadOFF[27],rowReadOFF[26],rowReadOFF[25],rowReadOFF[24],rowReadOFF[23],rowReadOFF[22],rowReadOFF[21],rowReadOFF[20],rowReadOFF[19],rowReadOFF[18],rowReadOFF[17],rowReadOFF[16],rowReadOFF[15],rowReadOFF[14],rowReadOFF[13],rowReadOFF[12],rowReadOFF[11],rowReadOFF[10],rowReadOFF[9],rowReadOFF[8],rowReadOFF[7],rowReadOFF[6],rowReadOFF[5],rowReadOFF[4],rowReadOFF[3],rowReadOFF[2],rowReadOFF[1],rowReadOFF[0]
*.iopin
*+ pixRst[63],pixRst[62],pixRst[61],pixRst[60],pixRst[59],pixRst[58],pixRst[57],pixRst[56],pixRst[55],pixRst[54],pixRst[53],pixRst[52],pixRst[51],pixRst[50],pixRst[49],pixRst[48],pixRst[47],pixRst[46],pixRst[45],pixRst[44],pixRst[43],pixRst[42],pixRst[41],pixRst[40],pixRst[39],pixRst[38],pixRst[37],pixRst[36],pixRst[35],pixRst[34],pixRst[33],pixRst[32],pixRst[31],pixRst[30],pixRst[29],pixRst[28],pixRst[27],pixRst[26],pixRst[25],pixRst[24],pixRst[23],pixRst[22],pixRst[21],pixRst[20],pixRst[19],pixRst[18],pixRst[17],pixRst[16],pixRst[15],pixRst[14],pixRst[13],pixRst[12],pixRst[11],pixRst[10],pixRst[9],pixRst[8],pixRst[7],pixRst[6],pixRst[5],pixRst[4],pixRst[3],pixRst[2],pixRst[1],pixRst[0]
*.iopin
*+ voutn[63],voutn[62],voutn[61],voutn[60],voutn[59],voutn[58],voutn[57],voutn[56],voutn[55],voutn[54],voutn[53],voutn[52],voutn[51],voutn[50],voutn[49],voutn[48],voutn[47],voutn[46],voutn[45],voutn[44],voutn[43],voutn[42],voutn[41],voutn[40],voutn[39],voutn[38],voutn[37],voutn[36],voutn[35],voutn[34],voutn[33],voutn[32],voutn[31],voutn[30],voutn[29],voutn[28],voutn[27],voutn[26],voutn[25],voutn[24],voutn[23],voutn[22],voutn[21],voutn[20],voutn[19],voutn[18],voutn[17],voutn[16],voutn[15],voutn[14],voutn[13],voutn[12],voutn[11],voutn[10],voutn[9],voutn[8],voutn[7],voutn[6],voutn[5],voutn[4],voutn[3],voutn[2],voutn[1],voutn[0]
*.iopin GndD
x0 DiffBn VDD RefrBp GndD GndA PrSFBp OffBn PrBp OnBn pixRst[0] net1 net2 pixRst[1] rowReadON[1]
+ rowReadON[0] rowReadOFF[1] rowReadOFF[0] openDVS_pixel2x2
x1 DiffBn VDD RefrBp GndD GndA PrSFBp OffBn PrBp OnBn pixRst[2] net5 net6 pixRst[3] rowReadON[1]
+ rowReadON[0] rowReadOFF[1] rowReadOFF[0] openDVS_pixel2x2
x2 DiffBn VDD RefrBp GndD GndA PrSFBp OffBn PrBp OnBn pixRst[4] net9 net10 pixRst[5] rowReadON[1]
+ rowReadON[0] rowReadOFF[1] rowReadOFF[0] openDVS_pixel2x2
x3 DiffBn VDD RefrBp GndD GndA PrSFBp OffBn PrBp OnBn pixRst[6] net13 net14 pixRst[7] rowReadON[1]
+ rowReadON[0] rowReadOFF[1] rowReadOFF[0] openDVS_pixel2x2
x4 DiffBn VDD RefrBp GndD GndA PrSFBp OffBn PrBp OnBn pixRst[8] net17 net18 pixRst[9] rowReadON[1]
+ rowReadON[0] rowReadOFF[1] rowReadOFF[0] openDVS_pixel2x2
x5 DiffBn VDD RefrBp GndD GndA PrSFBp OffBn PrBp OnBn pixRst[10] net21 net22 pixRst[11] rowReadON[1]
+ rowReadON[0] rowReadOFF[1] rowReadOFF[0] openDVS_pixel2x2
x6 DiffBn VDD RefrBp GndD GndA PrSFBp OffBn PrBp OnBn pixRst[12] net25 net26 pixRst[13] rowReadON[1]
+ rowReadON[0] rowReadOFF[1] rowReadOFF[0] openDVS_pixel2x2
x7 DiffBn VDD RefrBp GndD GndA PrSFBp OffBn PrBp OnBn pixRst[14] net29 net30 pixRst[15] rowReadON[1]
+ rowReadON[0] rowReadOFF[1] rowReadOFF[0] openDVS_pixel2x2
x8 DiffBn VDD RefrBp GndD GndA PrSFBp OffBn PrBp OnBn pixRst[16] net33 net34 pixRst[17] rowReadON[1]
+ rowReadON[0] rowReadOFF[1] rowReadOFF[0] openDVS_pixel2x2
x9 DiffBn VDD RefrBp GndD GndA PrSFBp OffBn PrBp OnBn pixRst[18] net37 net38 pixRst[19] rowReadON[1]
+ rowReadON[0] rowReadOFF[1] rowReadOFF[0] openDVS_pixel2x2
x10 DiffBn VDD RefrBp GndD GndA PrSFBp OffBn PrBp OnBn pixRst[20] net41 net42 pixRst[21]
+ rowReadON[1] rowReadON[0] rowReadOFF[1] rowReadOFF[0] openDVS_pixel2x2
x11 DiffBn VDD RefrBp GndD GndA PrSFBp OffBn PrBp OnBn pixRst[22] net45 net46 pixRst[23]
+ rowReadON[1] rowReadON[0] rowReadOFF[1] rowReadOFF[0] openDVS_pixel2x2
x12 DiffBn VDD RefrBp GndD GndA PrSFBp OffBn PrBp OnBn pixRst[24] net49 net50 pixRst[25]
+ rowReadON[1] rowReadON[0] rowReadOFF[1] rowReadOFF[0] openDVS_pixel2x2
x13 DiffBn VDD RefrBp GndD GndA PrSFBp OffBn PrBp OnBn pixRst[26] net53 net54 pixRst[27]
+ rowReadON[1] rowReadON[0] rowReadOFF[1] rowReadOFF[0] openDVS_pixel2x2
x14 DiffBn VDD RefrBp GndD GndA PrSFBp OffBn PrBp OnBn pixRst[28] net57 net58 pixRst[29]
+ rowReadON[1] rowReadON[0] rowReadOFF[1] rowReadOFF[0] openDVS_pixel2x2
x15 DiffBn VDD RefrBp GndD GndA PrSFBp OffBn PrBp OnBn pixRst[30] net61 net62 pixRst[31]
+ rowReadON[1] rowReadON[0] rowReadOFF[1] rowReadOFF[0] openDVS_pixel2x2
x16 DiffBn VDD RefrBp GndD GndA PrSFBp OffBn PrBp OnBn pixRst[32] net65 net66 pixRst[33]
+ rowReadON[1] rowReadON[0] rowReadOFF[1] rowReadOFF[0] openDVS_pixel2x2
x17 DiffBn VDD RefrBp GndD GndA PrSFBp OffBn PrBp OnBn pixRst[34] net69 net70 pixRst[35]
+ rowReadON[1] rowReadON[0] rowReadOFF[1] rowReadOFF[0] openDVS_pixel2x2
x18 DiffBn VDD RefrBp GndD GndA PrSFBp OffBn PrBp OnBn pixRst[36] net73 net74 pixRst[37]
+ rowReadON[1] rowReadON[0] rowReadOFF[1] rowReadOFF[0] openDVS_pixel2x2
x19 DiffBn VDD RefrBp GndD GndA PrSFBp OffBn PrBp OnBn pixRst[38] net77 net78 pixRst[39]
+ rowReadON[1] rowReadON[0] rowReadOFF[1] rowReadOFF[0] openDVS_pixel2x2
x20 DiffBn VDD RefrBp GndD GndA PrSFBp OffBn PrBp OnBn pixRst[40] net81 net82 pixRst[41]
+ rowReadON[1] rowReadON[0] rowReadOFF[1] rowReadOFF[0] openDVS_pixel2x2
x21 DiffBn VDD RefrBp GndD GndA PrSFBp OffBn PrBp OnBn pixRst[42] net85 net86 pixRst[43]
+ rowReadON[1] rowReadON[0] rowReadOFF[1] rowReadOFF[0] openDVS_pixel2x2
x22 DiffBn VDD RefrBp GndD GndA PrSFBp OffBn PrBp OnBn pixRst[44] net89 net90 pixRst[45]
+ rowReadON[1] rowReadON[0] rowReadOFF[1] rowReadOFF[0] openDVS_pixel2x2
x23 DiffBn VDD RefrBp GndD GndA PrSFBp OffBn PrBp OnBn pixRst[46] net93 net94 pixRst[47]
+ rowReadON[1] rowReadON[0] rowReadOFF[1] rowReadOFF[0] openDVS_pixel2x2
x24 DiffBn VDD RefrBp GndD GndA PrSFBp OffBn PrBp OnBn pixRst[48] net97 net98 pixRst[49]
+ rowReadON[1] rowReadON[0] rowReadOFF[1] rowReadOFF[0] openDVS_pixel2x2
x25 DiffBn VDD RefrBp GndD GndA PrSFBp OffBn PrBp OnBn pixRst[50] net101 net102 pixRst[51]
+ rowReadON[1] rowReadON[0] rowReadOFF[1] rowReadOFF[0] openDVS_pixel2x2
x26 DiffBn VDD RefrBp GndD GndA PrSFBp OffBn PrBp OnBn pixRst[52] net105 net106 pixRst[53]
+ rowReadON[1] rowReadON[0] rowReadOFF[1] rowReadOFF[0] openDVS_pixel2x2
x27 DiffBn VDD RefrBp GndD GndA PrSFBp OffBn PrBp OnBn pixRst[54] net109 net110 pixRst[55]
+ rowReadON[1] rowReadON[0] rowReadOFF[1] rowReadOFF[0] openDVS_pixel2x2
x28 DiffBn VDD RefrBp GndD GndA PrSFBp OffBn PrBp OnBn pixRst[56] net113 net114 pixRst[57]
+ rowReadON[1] rowReadON[0] rowReadOFF[1] rowReadOFF[0] openDVS_pixel2x2
x29 DiffBn VDD RefrBp GndD GndA PrSFBp OffBn PrBp OnBn pixRst[58] net117 net118 pixRst[59]
+ rowReadON[1] rowReadON[0] rowReadOFF[1] rowReadOFF[0] openDVS_pixel2x2
x30 DiffBn VDD RefrBp GndD GndA PrSFBp OffBn PrBp OnBn pixRst[60] net121 net122 pixRst[61]
+ rowReadON[1] rowReadON[0] rowReadOFF[1] rowReadOFF[0] openDVS_pixel2x2
x31 DiffBn VDD RefrBp GndD GndA PrSFBp OffBn PrBp OnBn pixRst[62] net125 net126 pixRst[63]
+ rowReadON[1] rowReadON[0] rowReadOFF[1] rowReadOFF[0] openDVS_pixel2x2
x32 DiffBn VDD RefrBp GndD GndA PrSFBp OffBn PrBp OnBn pixRst[0] net3 net4 pixRst[1] rowReadON[3]
+ rowReadON[2] rowReadOFF[3] rowReadOFF[2] openDVS_pixel2x2
x33 DiffBn VDD RefrBp GndD GndA PrSFBp OffBn PrBp OnBn pixRst[2] net7 net8 pixRst[3] rowReadON[3]
+ rowReadON[2] rowReadOFF[3] rowReadOFF[2] openDVS_pixel2x2
x34 DiffBn VDD RefrBp GndD GndA PrSFBp OffBn PrBp OnBn pixRst[4] net11 net12 pixRst[5] rowReadON[3]
+ rowReadON[2] rowReadOFF[3] rowReadOFF[2] openDVS_pixel2x2
x35 DiffBn VDD RefrBp GndD GndA PrSFBp OffBn PrBp OnBn pixRst[6] net15 net16 pixRst[7] rowReadON[3]
+ rowReadON[2] rowReadOFF[3] rowReadOFF[2] openDVS_pixel2x2
x36 DiffBn VDD RefrBp GndD GndA PrSFBp OffBn PrBp OnBn pixRst[8] net19 net20 pixRst[9] rowReadON[3]
+ rowReadON[2] rowReadOFF[3] rowReadOFF[2] openDVS_pixel2x2
x37 DiffBn VDD RefrBp GndD GndA PrSFBp OffBn PrBp OnBn pixRst[10] net23 net24 pixRst[11]
+ rowReadON[3] rowReadON[2] rowReadOFF[3] rowReadOFF[2] openDVS_pixel2x2
x38 DiffBn VDD RefrBp GndD GndA PrSFBp OffBn PrBp OnBn pixRst[12] net27 net28 pixRst[13]
+ rowReadON[3] rowReadON[2] rowReadOFF[3] rowReadOFF[2] openDVS_pixel2x2
x39 DiffBn VDD RefrBp GndD GndA PrSFBp OffBn PrBp OnBn pixRst[14] net31 net32 pixRst[15]
+ rowReadON[3] rowReadON[2] rowReadOFF[3] rowReadOFF[2] openDVS_pixel2x2
x40 DiffBn VDD RefrBp GndD GndA PrSFBp OffBn PrBp OnBn pixRst[16] net35 net36 pixRst[17]
+ rowReadON[3] rowReadON[2] rowReadOFF[3] rowReadOFF[2] openDVS_pixel2x2
x41 DiffBn VDD RefrBp GndD GndA PrSFBp OffBn PrBp OnBn pixRst[18] net39 net40 pixRst[19]
+ rowReadON[3] rowReadON[2] rowReadOFF[3] rowReadOFF[2] openDVS_pixel2x2
x42 DiffBn VDD RefrBp GndD GndA PrSFBp OffBn PrBp OnBn pixRst[20] net43 net44 pixRst[21]
+ rowReadON[3] rowReadON[2] rowReadOFF[3] rowReadOFF[2] openDVS_pixel2x2
x43 DiffBn VDD RefrBp GndD GndA PrSFBp OffBn PrBp OnBn pixRst[22] net47 net48 pixRst[23]
+ rowReadON[3] rowReadON[2] rowReadOFF[3] rowReadOFF[2] openDVS_pixel2x2
x44 DiffBn VDD RefrBp GndD GndA PrSFBp OffBn PrBp OnBn pixRst[24] net51 net52 pixRst[25]
+ rowReadON[3] rowReadON[2] rowReadOFF[3] rowReadOFF[2] openDVS_pixel2x2
x45 DiffBn VDD RefrBp GndD GndA PrSFBp OffBn PrBp OnBn pixRst[26] net55 net56 pixRst[27]
+ rowReadON[3] rowReadON[2] rowReadOFF[3] rowReadOFF[2] openDVS_pixel2x2
x46 DiffBn VDD RefrBp GndD GndA PrSFBp OffBn PrBp OnBn pixRst[28] net59 net60 pixRst[29]
+ rowReadON[3] rowReadON[2] rowReadOFF[3] rowReadOFF[2] openDVS_pixel2x2
x47 DiffBn VDD RefrBp GndD GndA PrSFBp OffBn PrBp OnBn pixRst[30] net63 net64 pixRst[31]
+ rowReadON[3] rowReadON[2] rowReadOFF[3] rowReadOFF[2] openDVS_pixel2x2
x48 DiffBn VDD RefrBp GndD GndA PrSFBp OffBn PrBp OnBn pixRst[32] net67 net68 pixRst[33]
+ rowReadON[3] rowReadON[2] rowReadOFF[3] rowReadOFF[2] openDVS_pixel2x2
x49 DiffBn VDD RefrBp GndD GndA PrSFBp OffBn PrBp OnBn pixRst[34] net71 net72 pixRst[35]
+ rowReadON[3] rowReadON[2] rowReadOFF[3] rowReadOFF[2] openDVS_pixel2x2
x50 DiffBn VDD RefrBp GndD GndA PrSFBp OffBn PrBp OnBn pixRst[36] net75 net76 pixRst[37]
+ rowReadON[3] rowReadON[2] rowReadOFF[3] rowReadOFF[2] openDVS_pixel2x2
x51 DiffBn VDD RefrBp GndD GndA PrSFBp OffBn PrBp OnBn pixRst[38] net79 net80 pixRst[39]
+ rowReadON[3] rowReadON[2] rowReadOFF[3] rowReadOFF[2] openDVS_pixel2x2
x52 DiffBn VDD RefrBp GndD GndA PrSFBp OffBn PrBp OnBn pixRst[40] net83 net84 pixRst[41]
+ rowReadON[3] rowReadON[2] rowReadOFF[3] rowReadOFF[2] openDVS_pixel2x2
x53 DiffBn VDD RefrBp GndD GndA PrSFBp OffBn PrBp OnBn pixRst[42] net87 net88 pixRst[43]
+ rowReadON[3] rowReadON[2] rowReadOFF[3] rowReadOFF[2] openDVS_pixel2x2
x54 DiffBn VDD RefrBp GndD GndA PrSFBp OffBn PrBp OnBn pixRst[44] net91 net92 pixRst[45]
+ rowReadON[3] rowReadON[2] rowReadOFF[3] rowReadOFF[2] openDVS_pixel2x2
x55 DiffBn VDD RefrBp GndD GndA PrSFBp OffBn PrBp OnBn pixRst[46] net95 net96 pixRst[47]
+ rowReadON[3] rowReadON[2] rowReadOFF[3] rowReadOFF[2] openDVS_pixel2x2
x56 DiffBn VDD RefrBp GndD GndA PrSFBp OffBn PrBp OnBn pixRst[48] net99 net100 pixRst[49]
+ rowReadON[3] rowReadON[2] rowReadOFF[3] rowReadOFF[2] openDVS_pixel2x2
x57 DiffBn VDD RefrBp GndD GndA PrSFBp OffBn PrBp OnBn pixRst[50] net103 net104 pixRst[51]
+ rowReadON[3] rowReadON[2] rowReadOFF[3] rowReadOFF[2] openDVS_pixel2x2
x58 DiffBn VDD RefrBp GndD GndA PrSFBp OffBn PrBp OnBn pixRst[52] net107 net108 pixRst[53]
+ rowReadON[3] rowReadON[2] rowReadOFF[3] rowReadOFF[2] openDVS_pixel2x2
x59 DiffBn VDD RefrBp GndD GndA PrSFBp OffBn PrBp OnBn pixRst[54] net111 net112 pixRst[55]
+ rowReadON[3] rowReadON[2] rowReadOFF[3] rowReadOFF[2] openDVS_pixel2x2
x60 DiffBn VDD RefrBp GndD GndA PrSFBp OffBn PrBp OnBn pixRst[56] net115 net116 pixRst[57]
+ rowReadON[3] rowReadON[2] rowReadOFF[3] rowReadOFF[2] openDVS_pixel2x2
x61 DiffBn VDD RefrBp GndD GndA PrSFBp OffBn PrBp OnBn pixRst[58] net119 net120 pixRst[59]
+ rowReadON[3] rowReadON[2] rowReadOFF[3] rowReadOFF[2] openDVS_pixel2x2
x62 DiffBn VDD RefrBp GndD GndA PrSFBp OffBn PrBp OnBn pixRst[60] net123 net124 pixRst[61]
+ rowReadON[3] rowReadON[2] rowReadOFF[3] rowReadOFF[2] openDVS_pixel2x2
x63 DiffBn VDD RefrBp GndD GndA PrSFBp OffBn PrBp OnBn pixRst[62] net127 net128 pixRst[63]
+ rowReadON[3] rowReadON[2] rowReadOFF[3] rowReadOFF[2] openDVS_pixel2x2
x64 DiffBn VDD RefrBp GndD GndA PrSFBp OffBn PrBp OnBn pixRst[0] net3 net4 pixRst[1] rowReadON[5]
+ rowReadON[4] rowReadOFF[5] rowReadOFF[4] openDVS_pixel2x2
x65 DiffBn VDD RefrBp GndD GndA PrSFBp OffBn PrBp OnBn pixRst[2] net7 net8 pixRst[3] rowReadON[5]
+ rowReadON[4] rowReadOFF[5] rowReadOFF[4] openDVS_pixel2x2
x66 DiffBn VDD RefrBp GndD GndA PrSFBp OffBn PrBp OnBn pixRst[4] net11 net12 pixRst[5] rowReadON[5]
+ rowReadON[4] rowReadOFF[5] rowReadOFF[4] openDVS_pixel2x2
x67 DiffBn VDD RefrBp GndD GndA PrSFBp OffBn PrBp OnBn pixRst[6] net15 net16 pixRst[7] rowReadON[5]
+ rowReadON[4] rowReadOFF[5] rowReadOFF[4] openDVS_pixel2x2
x68 DiffBn VDD RefrBp GndD GndA PrSFBp OffBn PrBp OnBn pixRst[8] net19 net20 pixRst[9] rowReadON[5]
+ rowReadON[4] rowReadOFF[5] rowReadOFF[4] openDVS_pixel2x2
x69 DiffBn VDD RefrBp GndD GndA PrSFBp OffBn PrBp OnBn pixRst[10] net23 net24 pixRst[11]
+ rowReadON[5] rowReadON[4] rowReadOFF[5] rowReadOFF[4] openDVS_pixel2x2
x70 DiffBn VDD RefrBp GndD GndA PrSFBp OffBn PrBp OnBn pixRst[12] net27 net28 pixRst[13]
+ rowReadON[5] rowReadON[4] rowReadOFF[5] rowReadOFF[4] openDVS_pixel2x2
x71 DiffBn VDD RefrBp GndD GndA PrSFBp OffBn PrBp OnBn pixRst[14] net31 net32 pixRst[15]
+ rowReadON[5] rowReadON[4] rowReadOFF[5] rowReadOFF[4] openDVS_pixel2x2
x72 DiffBn VDD RefrBp GndD GndA PrSFBp OffBn PrBp OnBn pixRst[16] net35 net36 pixRst[17]
+ rowReadON[5] rowReadON[4] rowReadOFF[5] rowReadOFF[4] openDVS_pixel2x2
x73 DiffBn VDD RefrBp GndD GndA PrSFBp OffBn PrBp OnBn pixRst[18] net39 net40 pixRst[19]
+ rowReadON[5] rowReadON[4] rowReadOFF[5] rowReadOFF[4] openDVS_pixel2x2
x74 DiffBn VDD RefrBp GndD GndA PrSFBp OffBn PrBp OnBn pixRst[20] net43 net44 pixRst[21]
+ rowReadON[5] rowReadON[4] rowReadOFF[5] rowReadOFF[4] openDVS_pixel2x2
x75 DiffBn VDD RefrBp GndD GndA PrSFBp OffBn PrBp OnBn pixRst[22] net47 net48 pixRst[23]
+ rowReadON[5] rowReadON[4] rowReadOFF[5] rowReadOFF[4] openDVS_pixel2x2
x76 DiffBn VDD RefrBp GndD GndA PrSFBp OffBn PrBp OnBn pixRst[24] net51 net52 pixRst[25]
+ rowReadON[5] rowReadON[4] rowReadOFF[5] rowReadOFF[4] openDVS_pixel2x2
x77 DiffBn VDD RefrBp GndD GndA PrSFBp OffBn PrBp OnBn pixRst[26] net55 net56 pixRst[27]
+ rowReadON[5] rowReadON[4] rowReadOFF[5] rowReadOFF[4] openDVS_pixel2x2
x78 DiffBn VDD RefrBp GndD GndA PrSFBp OffBn PrBp OnBn pixRst[28] net59 net60 pixRst[29]
+ rowReadON[5] rowReadON[4] rowReadOFF[5] rowReadOFF[4] openDVS_pixel2x2
x79 DiffBn VDD RefrBp GndD GndA PrSFBp OffBn PrBp OnBn pixRst[30] net63 net64 pixRst[31]
+ rowReadON[5] rowReadON[4] rowReadOFF[5] rowReadOFF[4] openDVS_pixel2x2
x80 DiffBn VDD RefrBp GndD GndA PrSFBp OffBn PrBp OnBn pixRst[32] net67 net68 pixRst[33]
+ rowReadON[5] rowReadON[4] rowReadOFF[5] rowReadOFF[4] openDVS_pixel2x2
x81 DiffBn VDD RefrBp GndD GndA PrSFBp OffBn PrBp OnBn pixRst[34] net71 net72 pixRst[35]
+ rowReadON[5] rowReadON[4] rowReadOFF[5] rowReadOFF[4] openDVS_pixel2x2
x82 DiffBn VDD RefrBp GndD GndA PrSFBp OffBn PrBp OnBn pixRst[36] net75 net76 pixRst[37]
+ rowReadON[5] rowReadON[4] rowReadOFF[5] rowReadOFF[4] openDVS_pixel2x2
x83 DiffBn VDD RefrBp GndD GndA PrSFBp OffBn PrBp OnBn pixRst[38] net79 net80 pixRst[39]
+ rowReadON[5] rowReadON[4] rowReadOFF[5] rowReadOFF[4] openDVS_pixel2x2
x84 DiffBn VDD RefrBp GndD GndA PrSFBp OffBn PrBp OnBn pixRst[40] net83 net84 pixRst[41]
+ rowReadON[5] rowReadON[4] rowReadOFF[5] rowReadOFF[4] openDVS_pixel2x2
x85 DiffBn VDD RefrBp GndD GndA PrSFBp OffBn PrBp OnBn pixRst[42] net87 net88 pixRst[43]
+ rowReadON[5] rowReadON[4] rowReadOFF[5] rowReadOFF[4] openDVS_pixel2x2
x86 DiffBn VDD RefrBp GndD GndA PrSFBp OffBn PrBp OnBn pixRst[44] net91 net92 pixRst[45]
+ rowReadON[5] rowReadON[4] rowReadOFF[5] rowReadOFF[4] openDVS_pixel2x2
x87 DiffBn VDD RefrBp GndD GndA PrSFBp OffBn PrBp OnBn pixRst[46] net95 net96 pixRst[47]
+ rowReadON[5] rowReadON[4] rowReadOFF[5] rowReadOFF[4] openDVS_pixel2x2
x88 DiffBn VDD RefrBp GndD GndA PrSFBp OffBn PrBp OnBn pixRst[48] net99 net100 pixRst[49]
+ rowReadON[5] rowReadON[4] rowReadOFF[5] rowReadOFF[4] openDVS_pixel2x2
x89 DiffBn VDD RefrBp GndD GndA PrSFBp OffBn PrBp OnBn pixRst[50] net103 net104 pixRst[51]
+ rowReadON[5] rowReadON[4] rowReadOFF[5] rowReadOFF[4] openDVS_pixel2x2
x90 DiffBn VDD RefrBp GndD GndA PrSFBp OffBn PrBp OnBn pixRst[52] net107 net108 pixRst[53]
+ rowReadON[5] rowReadON[4] rowReadOFF[5] rowReadOFF[4] openDVS_pixel2x2
x91 DiffBn VDD RefrBp GndD GndA PrSFBp OffBn PrBp OnBn pixRst[54] net111 net112 pixRst[55]
+ rowReadON[5] rowReadON[4] rowReadOFF[5] rowReadOFF[4] openDVS_pixel2x2
x92 DiffBn VDD RefrBp GndD GndA PrSFBp OffBn PrBp OnBn pixRst[56] net115 net116 pixRst[57]
+ rowReadON[5] rowReadON[4] rowReadOFF[5] rowReadOFF[4] openDVS_pixel2x2
x93 DiffBn VDD RefrBp GndD GndA PrSFBp OffBn PrBp OnBn pixRst[58] net119 net120 pixRst[59]
+ rowReadON[5] rowReadON[4] rowReadOFF[5] rowReadOFF[4] openDVS_pixel2x2
x94 DiffBn VDD RefrBp GndD GndA PrSFBp OffBn PrBp OnBn pixRst[60] net123 net124 pixRst[61]
+ rowReadON[5] rowReadON[4] rowReadOFF[5] rowReadOFF[4] openDVS_pixel2x2
x95 DiffBn VDD RefrBp GndD GndA PrSFBp OffBn PrBp OnBn pixRst[62] net127 net128 pixRst[63]
+ rowReadON[5] rowReadON[4] rowReadOFF[5] rowReadOFF[4] openDVS_pixel2x2
x96 DiffBn VDD RefrBp GndD GndA PrSFBp OffBn PrBp OnBn pixRst[0] net3 net4 pixRst[1] rowReadON[7]
+ rowReadON[6] rowReadOFF[7] rowReadOFF[6] openDVS_pixel2x2
x97 DiffBn VDD RefrBp GndD GndA PrSFBp OffBn PrBp OnBn pixRst[2] net7 net8 pixRst[3] rowReadON[7]
+ rowReadON[6] rowReadOFF[7] rowReadOFF[6] openDVS_pixel2x2
x98 DiffBn VDD RefrBp GndD GndA PrSFBp OffBn PrBp OnBn pixRst[4] net11 net12 pixRst[5] rowReadON[7]
+ rowReadON[6] rowReadOFF[7] rowReadOFF[6] openDVS_pixel2x2
x99 DiffBn VDD RefrBp GndD GndA PrSFBp OffBn PrBp OnBn pixRst[6] net15 net16 pixRst[7] rowReadON[7]
+ rowReadON[6] rowReadOFF[7] rowReadOFF[6] openDVS_pixel2x2
x100 DiffBn VDD RefrBp GndD GndA PrSFBp OffBn PrBp OnBn pixRst[8] net19 net20 pixRst[9] rowReadON[7]
+ rowReadON[6] rowReadOFF[7] rowReadOFF[6] openDVS_pixel2x2
x101 DiffBn VDD RefrBp GndD GndA PrSFBp OffBn PrBp OnBn pixRst[10] net23 net24 pixRst[11]
+ rowReadON[7] rowReadON[6] rowReadOFF[7] rowReadOFF[6] openDVS_pixel2x2
x102 DiffBn VDD RefrBp GndD GndA PrSFBp OffBn PrBp OnBn pixRst[12] net27 net28 pixRst[13]
+ rowReadON[7] rowReadON[6] rowReadOFF[7] rowReadOFF[6] openDVS_pixel2x2
x103 DiffBn VDD RefrBp GndD GndA PrSFBp OffBn PrBp OnBn pixRst[14] net31 net32 pixRst[15]
+ rowReadON[7] rowReadON[6] rowReadOFF[7] rowReadOFF[6] openDVS_pixel2x2
x104 DiffBn VDD RefrBp GndD GndA PrSFBp OffBn PrBp OnBn pixRst[16] net35 net36 pixRst[17]
+ rowReadON[7] rowReadON[6] rowReadOFF[7] rowReadOFF[6] openDVS_pixel2x2
x105 DiffBn VDD RefrBp GndD GndA PrSFBp OffBn PrBp OnBn pixRst[18] net39 net40 pixRst[19]
+ rowReadON[7] rowReadON[6] rowReadOFF[7] rowReadOFF[6] openDVS_pixel2x2
x106 DiffBn VDD RefrBp GndD GndA PrSFBp OffBn PrBp OnBn pixRst[20] net43 net44 pixRst[21]
+ rowReadON[7] rowReadON[6] rowReadOFF[7] rowReadOFF[6] openDVS_pixel2x2
x107 DiffBn VDD RefrBp GndD GndA PrSFBp OffBn PrBp OnBn pixRst[22] net47 net48 pixRst[23]
+ rowReadON[7] rowReadON[6] rowReadOFF[7] rowReadOFF[6] openDVS_pixel2x2
x108 DiffBn VDD RefrBp GndD GndA PrSFBp OffBn PrBp OnBn pixRst[24] net51 net52 pixRst[25]
+ rowReadON[7] rowReadON[6] rowReadOFF[7] rowReadOFF[6] openDVS_pixel2x2
x109 DiffBn VDD RefrBp GndD GndA PrSFBp OffBn PrBp OnBn pixRst[26] net55 net56 pixRst[27]
+ rowReadON[7] rowReadON[6] rowReadOFF[7] rowReadOFF[6] openDVS_pixel2x2
x110 DiffBn VDD RefrBp GndD GndA PrSFBp OffBn PrBp OnBn pixRst[28] net59 net60 pixRst[29]
+ rowReadON[7] rowReadON[6] rowReadOFF[7] rowReadOFF[6] openDVS_pixel2x2
x111 DiffBn VDD RefrBp GndD GndA PrSFBp OffBn PrBp OnBn pixRst[30] net63 net64 pixRst[31]
+ rowReadON[7] rowReadON[6] rowReadOFF[7] rowReadOFF[6] openDVS_pixel2x2
x112 DiffBn VDD RefrBp GndD GndA PrSFBp OffBn PrBp OnBn pixRst[32] net67 net68 pixRst[33]
+ rowReadON[7] rowReadON[6] rowReadOFF[7] rowReadOFF[6] openDVS_pixel2x2
x113 DiffBn VDD RefrBp GndD GndA PrSFBp OffBn PrBp OnBn pixRst[34] net71 net72 pixRst[35]
+ rowReadON[7] rowReadON[6] rowReadOFF[7] rowReadOFF[6] openDVS_pixel2x2
x114 DiffBn VDD RefrBp GndD GndA PrSFBp OffBn PrBp OnBn pixRst[36] net75 net76 pixRst[37]
+ rowReadON[7] rowReadON[6] rowReadOFF[7] rowReadOFF[6] openDVS_pixel2x2
x115 DiffBn VDD RefrBp GndD GndA PrSFBp OffBn PrBp OnBn pixRst[38] net79 net80 pixRst[39]
+ rowReadON[7] rowReadON[6] rowReadOFF[7] rowReadOFF[6] openDVS_pixel2x2
x116 DiffBn VDD RefrBp GndD GndA PrSFBp OffBn PrBp OnBn pixRst[40] net83 net84 pixRst[41]
+ rowReadON[7] rowReadON[6] rowReadOFF[7] rowReadOFF[6] openDVS_pixel2x2
x117 DiffBn VDD RefrBp GndD GndA PrSFBp OffBn PrBp OnBn pixRst[42] net87 net88 pixRst[43]
+ rowReadON[7] rowReadON[6] rowReadOFF[7] rowReadOFF[6] openDVS_pixel2x2
x118 DiffBn VDD RefrBp GndD GndA PrSFBp OffBn PrBp OnBn pixRst[44] net91 net92 pixRst[45]
+ rowReadON[7] rowReadON[6] rowReadOFF[7] rowReadOFF[6] openDVS_pixel2x2
x119 DiffBn VDD RefrBp GndD GndA PrSFBp OffBn PrBp OnBn pixRst[46] net95 net96 pixRst[47]
+ rowReadON[7] rowReadON[6] rowReadOFF[7] rowReadOFF[6] openDVS_pixel2x2
x120 DiffBn VDD RefrBp GndD GndA PrSFBp OffBn PrBp OnBn pixRst[48] net99 net100 pixRst[49]
+ rowReadON[7] rowReadON[6] rowReadOFF[7] rowReadOFF[6] openDVS_pixel2x2
x121 DiffBn VDD RefrBp GndD GndA PrSFBp OffBn PrBp OnBn pixRst[50] net103 net104 pixRst[51]
+ rowReadON[7] rowReadON[6] rowReadOFF[7] rowReadOFF[6] openDVS_pixel2x2
x122 DiffBn VDD RefrBp GndD GndA PrSFBp OffBn PrBp OnBn pixRst[52] net107 net108 pixRst[53]
+ rowReadON[7] rowReadON[6] rowReadOFF[7] rowReadOFF[6] openDVS_pixel2x2
x123 DiffBn VDD RefrBp GndD GndA PrSFBp OffBn PrBp OnBn pixRst[54] net111 net112 pixRst[55]
+ rowReadON[7] rowReadON[6] rowReadOFF[7] rowReadOFF[6] openDVS_pixel2x2
x124 DiffBn VDD RefrBp GndD GndA PrSFBp OffBn PrBp OnBn pixRst[56] net115 net116 pixRst[57]
+ rowReadON[7] rowReadON[6] rowReadOFF[7] rowReadOFF[6] openDVS_pixel2x2
x125 DiffBn VDD RefrBp GndD GndA PrSFBp OffBn PrBp OnBn pixRst[58] net119 net120 pixRst[59]
+ rowReadON[7] rowReadON[6] rowReadOFF[7] rowReadOFF[6] openDVS_pixel2x2
x126 DiffBn VDD RefrBp GndD GndA PrSFBp OffBn PrBp OnBn pixRst[60] net123 net124 pixRst[61]
+ rowReadON[7] rowReadON[6] rowReadOFF[7] rowReadOFF[6] openDVS_pixel2x2
x127 DiffBn VDD RefrBp GndD GndA PrSFBp OffBn PrBp OnBn pixRst[62] net127 net128 pixRst[63]
+ rowReadON[7] rowReadON[6] rowReadOFF[7] rowReadOFF[6] openDVS_pixel2x2
x128 DiffBn VDD RefrBp GndD GndA PrSFBp OffBn PrBp OnBn pixRst[0] net3 net4 pixRst[1] rowReadON[9]
+ rowReadON[8] rowReadOFF[9] rowReadOFF[8] openDVS_pixel2x2
x129 DiffBn VDD RefrBp GndD GndA PrSFBp OffBn PrBp OnBn pixRst[2] net7 net8 pixRst[3] rowReadON[9]
+ rowReadON[8] rowReadOFF[9] rowReadOFF[8] openDVS_pixel2x2
x130 DiffBn VDD RefrBp GndD GndA PrSFBp OffBn PrBp OnBn pixRst[4] net11 net12 pixRst[5] rowReadON[9]
+ rowReadON[8] rowReadOFF[9] rowReadOFF[8] openDVS_pixel2x2
x131 DiffBn VDD RefrBp GndD GndA PrSFBp OffBn PrBp OnBn pixRst[6] net15 net16 pixRst[7] rowReadON[9]
+ rowReadON[8] rowReadOFF[9] rowReadOFF[8] openDVS_pixel2x2
x132 DiffBn VDD RefrBp GndD GndA PrSFBp OffBn PrBp OnBn pixRst[8] net19 net20 pixRst[9] rowReadON[9]
+ rowReadON[8] rowReadOFF[9] rowReadOFF[8] openDVS_pixel2x2
x133 DiffBn VDD RefrBp GndD GndA PrSFBp OffBn PrBp OnBn pixRst[10] net23 net24 pixRst[11]
+ rowReadON[9] rowReadON[8] rowReadOFF[9] rowReadOFF[8] openDVS_pixel2x2
x134 DiffBn VDD RefrBp GndD GndA PrSFBp OffBn PrBp OnBn pixRst[12] net27 net28 pixRst[13]
+ rowReadON[9] rowReadON[8] rowReadOFF[9] rowReadOFF[8] openDVS_pixel2x2
x135 DiffBn VDD RefrBp GndD GndA PrSFBp OffBn PrBp OnBn pixRst[14] net31 net32 pixRst[15]
+ rowReadON[9] rowReadON[8] rowReadOFF[9] rowReadOFF[8] openDVS_pixel2x2
x136 DiffBn VDD RefrBp GndD GndA PrSFBp OffBn PrBp OnBn pixRst[16] net35 net36 pixRst[17]
+ rowReadON[9] rowReadON[8] rowReadOFF[9] rowReadOFF[8] openDVS_pixel2x2
x137 DiffBn VDD RefrBp GndD GndA PrSFBp OffBn PrBp OnBn pixRst[18] net39 net40 pixRst[19]
+ rowReadON[9] rowReadON[8] rowReadOFF[9] rowReadOFF[8] openDVS_pixel2x2
x138 DiffBn VDD RefrBp GndD GndA PrSFBp OffBn PrBp OnBn pixRst[20] net43 net44 pixRst[21]
+ rowReadON[9] rowReadON[8] rowReadOFF[9] rowReadOFF[8] openDVS_pixel2x2
x139 DiffBn VDD RefrBp GndD GndA PrSFBp OffBn PrBp OnBn pixRst[22] net47 net48 pixRst[23]
+ rowReadON[9] rowReadON[8] rowReadOFF[9] rowReadOFF[8] openDVS_pixel2x2
x140 DiffBn VDD RefrBp GndD GndA PrSFBp OffBn PrBp OnBn pixRst[24] net51 net52 pixRst[25]
+ rowReadON[9] rowReadON[8] rowReadOFF[9] rowReadOFF[8] openDVS_pixel2x2
x141 DiffBn VDD RefrBp GndD GndA PrSFBp OffBn PrBp OnBn pixRst[26] net55 net56 pixRst[27]
+ rowReadON[9] rowReadON[8] rowReadOFF[9] rowReadOFF[8] openDVS_pixel2x2
x142 DiffBn VDD RefrBp GndD GndA PrSFBp OffBn PrBp OnBn pixRst[28] net59 net60 pixRst[29]
+ rowReadON[9] rowReadON[8] rowReadOFF[9] rowReadOFF[8] openDVS_pixel2x2
x143 DiffBn VDD RefrBp GndD GndA PrSFBp OffBn PrBp OnBn pixRst[30] net63 net64 pixRst[31]
+ rowReadON[9] rowReadON[8] rowReadOFF[9] rowReadOFF[8] openDVS_pixel2x2
x144 DiffBn VDD RefrBp GndD GndA PrSFBp OffBn PrBp OnBn pixRst[32] net67 net68 pixRst[33]
+ rowReadON[9] rowReadON[8] rowReadOFF[9] rowReadOFF[8] openDVS_pixel2x2
x145 DiffBn VDD RefrBp GndD GndA PrSFBp OffBn PrBp OnBn pixRst[34] net71 net72 pixRst[35]
+ rowReadON[9] rowReadON[8] rowReadOFF[9] rowReadOFF[8] openDVS_pixel2x2
x146 DiffBn VDD RefrBp GndD GndA PrSFBp OffBn PrBp OnBn pixRst[36] net75 net76 pixRst[37]
+ rowReadON[9] rowReadON[8] rowReadOFF[9] rowReadOFF[8] openDVS_pixel2x2
x147 DiffBn VDD RefrBp GndD GndA PrSFBp OffBn PrBp OnBn pixRst[38] net79 net80 pixRst[39]
+ rowReadON[9] rowReadON[8] rowReadOFF[9] rowReadOFF[8] openDVS_pixel2x2
x148 DiffBn VDD RefrBp GndD GndA PrSFBp OffBn PrBp OnBn pixRst[40] net83 net84 pixRst[41]
+ rowReadON[9] rowReadON[8] rowReadOFF[9] rowReadOFF[8] openDVS_pixel2x2
x149 DiffBn VDD RefrBp GndD GndA PrSFBp OffBn PrBp OnBn pixRst[42] net87 net88 pixRst[43]
+ rowReadON[9] rowReadON[8] rowReadOFF[9] rowReadOFF[8] openDVS_pixel2x2
x150 DiffBn VDD RefrBp GndD GndA PrSFBp OffBn PrBp OnBn pixRst[44] net91 net92 pixRst[45]
+ rowReadON[9] rowReadON[8] rowReadOFF[9] rowReadOFF[8] openDVS_pixel2x2
x151 DiffBn VDD RefrBp GndD GndA PrSFBp OffBn PrBp OnBn pixRst[46] net95 net96 pixRst[47]
+ rowReadON[9] rowReadON[8] rowReadOFF[9] rowReadOFF[8] openDVS_pixel2x2
x152 DiffBn VDD RefrBp GndD GndA PrSFBp OffBn PrBp OnBn pixRst[48] net99 net100 pixRst[49]
+ rowReadON[9] rowReadON[8] rowReadOFF[9] rowReadOFF[8] openDVS_pixel2x2
x153 DiffBn VDD RefrBp GndD GndA PrSFBp OffBn PrBp OnBn pixRst[50] net103 net104 pixRst[51]
+ rowReadON[9] rowReadON[8] rowReadOFF[9] rowReadOFF[8] openDVS_pixel2x2
x154 DiffBn VDD RefrBp GndD GndA PrSFBp OffBn PrBp OnBn pixRst[52] net107 net108 pixRst[53]
+ rowReadON[9] rowReadON[8] rowReadOFF[9] rowReadOFF[8] openDVS_pixel2x2
x155 DiffBn VDD RefrBp GndD GndA PrSFBp OffBn PrBp OnBn pixRst[54] net111 net112 pixRst[55]
+ rowReadON[9] rowReadON[8] rowReadOFF[9] rowReadOFF[8] openDVS_pixel2x2
x156 DiffBn VDD RefrBp GndD GndA PrSFBp OffBn PrBp OnBn pixRst[56] net115 net116 pixRst[57]
+ rowReadON[9] rowReadON[8] rowReadOFF[9] rowReadOFF[8] openDVS_pixel2x2
x157 DiffBn VDD RefrBp GndD GndA PrSFBp OffBn PrBp OnBn pixRst[58] net119 net120 pixRst[59]
+ rowReadON[9] rowReadON[8] rowReadOFF[9] rowReadOFF[8] openDVS_pixel2x2
x158 DiffBn VDD RefrBp GndD GndA PrSFBp OffBn PrBp OnBn pixRst[60] net123 net124 pixRst[61]
+ rowReadON[9] rowReadON[8] rowReadOFF[9] rowReadOFF[8] openDVS_pixel2x2
x159 DiffBn VDD RefrBp GndD GndA PrSFBp OffBn PrBp OnBn pixRst[62] net127 net128 pixRst[63]
+ rowReadON[9] rowReadON[8] rowReadOFF[9] rowReadOFF[8] openDVS_pixel2x2
x160 DiffBn VDD RefrBp GndD GndA PrSFBp OffBn PrBp OnBn pixRst[0] net3 net4 pixRst[1] rowReadON[11]
+ rowReadON[10] rowReadOFF[11] rowReadOFF[10] openDVS_pixel2x2
x161 DiffBn VDD RefrBp GndD GndA PrSFBp OffBn PrBp OnBn pixRst[2] net7 net8 pixRst[3] rowReadON[11]
+ rowReadON[10] rowReadOFF[11] rowReadOFF[10] openDVS_pixel2x2
x162 DiffBn VDD RefrBp GndD GndA PrSFBp OffBn PrBp OnBn pixRst[4] net11 net12 pixRst[5]
+ rowReadON[11] rowReadON[10] rowReadOFF[11] rowReadOFF[10] openDVS_pixel2x2
x163 DiffBn VDD RefrBp GndD GndA PrSFBp OffBn PrBp OnBn pixRst[6] net15 net16 pixRst[7]
+ rowReadON[11] rowReadON[10] rowReadOFF[11] rowReadOFF[10] openDVS_pixel2x2
x164 DiffBn VDD RefrBp GndD GndA PrSFBp OffBn PrBp OnBn pixRst[8] net19 net20 pixRst[9]
+ rowReadON[11] rowReadON[10] rowReadOFF[11] rowReadOFF[10] openDVS_pixel2x2
x165 DiffBn VDD RefrBp GndD GndA PrSFBp OffBn PrBp OnBn pixRst[10] net23 net24 pixRst[11]
+ rowReadON[11] rowReadON[10] rowReadOFF[11] rowReadOFF[10] openDVS_pixel2x2
x166 DiffBn VDD RefrBp GndD GndA PrSFBp OffBn PrBp OnBn pixRst[12] net27 net28 pixRst[13]
+ rowReadON[11] rowReadON[10] rowReadOFF[11] rowReadOFF[10] openDVS_pixel2x2
x167 DiffBn VDD RefrBp GndD GndA PrSFBp OffBn PrBp OnBn pixRst[14] net31 net32 pixRst[15]
+ rowReadON[11] rowReadON[10] rowReadOFF[11] rowReadOFF[10] openDVS_pixel2x2
x168 DiffBn VDD RefrBp GndD GndA PrSFBp OffBn PrBp OnBn pixRst[16] net35 net36 pixRst[17]
+ rowReadON[11] rowReadON[10] rowReadOFF[11] rowReadOFF[10] openDVS_pixel2x2
x169 DiffBn VDD RefrBp GndD GndA PrSFBp OffBn PrBp OnBn pixRst[18] net39 net40 pixRst[19]
+ rowReadON[11] rowReadON[10] rowReadOFF[11] rowReadOFF[10] openDVS_pixel2x2
x170 DiffBn VDD RefrBp GndD GndA PrSFBp OffBn PrBp OnBn pixRst[20] net43 net44 pixRst[21]
+ rowReadON[11] rowReadON[10] rowReadOFF[11] rowReadOFF[10] openDVS_pixel2x2
x171 DiffBn VDD RefrBp GndD GndA PrSFBp OffBn PrBp OnBn pixRst[22] net47 net48 pixRst[23]
+ rowReadON[11] rowReadON[10] rowReadOFF[11] rowReadOFF[10] openDVS_pixel2x2
x172 DiffBn VDD RefrBp GndD GndA PrSFBp OffBn PrBp OnBn pixRst[24] net51 net52 pixRst[25]
+ rowReadON[11] rowReadON[10] rowReadOFF[11] rowReadOFF[10] openDVS_pixel2x2
x173 DiffBn VDD RefrBp GndD GndA PrSFBp OffBn PrBp OnBn pixRst[26] net55 net56 pixRst[27]
+ rowReadON[11] rowReadON[10] rowReadOFF[11] rowReadOFF[10] openDVS_pixel2x2
x174 DiffBn VDD RefrBp GndD GndA PrSFBp OffBn PrBp OnBn pixRst[28] net59 net60 pixRst[29]
+ rowReadON[11] rowReadON[10] rowReadOFF[11] rowReadOFF[10] openDVS_pixel2x2
x175 DiffBn VDD RefrBp GndD GndA PrSFBp OffBn PrBp OnBn pixRst[30] net63 net64 pixRst[31]
+ rowReadON[11] rowReadON[10] rowReadOFF[11] rowReadOFF[10] openDVS_pixel2x2
x176 DiffBn VDD RefrBp GndD GndA PrSFBp OffBn PrBp OnBn pixRst[32] net67 net68 pixRst[33]
+ rowReadON[11] rowReadON[10] rowReadOFF[11] rowReadOFF[10] openDVS_pixel2x2
x177 DiffBn VDD RefrBp GndD GndA PrSFBp OffBn PrBp OnBn pixRst[34] net71 net72 pixRst[35]
+ rowReadON[11] rowReadON[10] rowReadOFF[11] rowReadOFF[10] openDVS_pixel2x2
x178 DiffBn VDD RefrBp GndD GndA PrSFBp OffBn PrBp OnBn pixRst[36] net75 net76 pixRst[37]
+ rowReadON[11] rowReadON[10] rowReadOFF[11] rowReadOFF[10] openDVS_pixel2x2
x179 DiffBn VDD RefrBp GndD GndA PrSFBp OffBn PrBp OnBn pixRst[38] net79 net80 pixRst[39]
+ rowReadON[11] rowReadON[10] rowReadOFF[11] rowReadOFF[10] openDVS_pixel2x2
x180 DiffBn VDD RefrBp GndD GndA PrSFBp OffBn PrBp OnBn pixRst[40] net83 net84 pixRst[41]
+ rowReadON[11] rowReadON[10] rowReadOFF[11] rowReadOFF[10] openDVS_pixel2x2
x181 DiffBn VDD RefrBp GndD GndA PrSFBp OffBn PrBp OnBn pixRst[42] net87 net88 pixRst[43]
+ rowReadON[11] rowReadON[10] rowReadOFF[11] rowReadOFF[10] openDVS_pixel2x2
x182 DiffBn VDD RefrBp GndD GndA PrSFBp OffBn PrBp OnBn pixRst[44] net91 net92 pixRst[45]
+ rowReadON[11] rowReadON[10] rowReadOFF[11] rowReadOFF[10] openDVS_pixel2x2
x183 DiffBn VDD RefrBp GndD GndA PrSFBp OffBn PrBp OnBn pixRst[46] net95 net96 pixRst[47]
+ rowReadON[11] rowReadON[10] rowReadOFF[11] rowReadOFF[10] openDVS_pixel2x2
x184 DiffBn VDD RefrBp GndD GndA PrSFBp OffBn PrBp OnBn pixRst[48] net99 net100 pixRst[49]
+ rowReadON[11] rowReadON[10] rowReadOFF[11] rowReadOFF[10] openDVS_pixel2x2
x185 DiffBn VDD RefrBp GndD GndA PrSFBp OffBn PrBp OnBn pixRst[50] net103 net104 pixRst[51]
+ rowReadON[11] rowReadON[10] rowReadOFF[11] rowReadOFF[10] openDVS_pixel2x2
x186 DiffBn VDD RefrBp GndD GndA PrSFBp OffBn PrBp OnBn pixRst[52] net107 net108 pixRst[53]
+ rowReadON[11] rowReadON[10] rowReadOFF[11] rowReadOFF[10] openDVS_pixel2x2
x187 DiffBn VDD RefrBp GndD GndA PrSFBp OffBn PrBp OnBn pixRst[54] net111 net112 pixRst[55]
+ rowReadON[11] rowReadON[10] rowReadOFF[11] rowReadOFF[10] openDVS_pixel2x2
x188 DiffBn VDD RefrBp GndD GndA PrSFBp OffBn PrBp OnBn pixRst[56] net115 net116 pixRst[57]
+ rowReadON[11] rowReadON[10] rowReadOFF[11] rowReadOFF[10] openDVS_pixel2x2
x189 DiffBn VDD RefrBp GndD GndA PrSFBp OffBn PrBp OnBn pixRst[58] net119 net120 pixRst[59]
+ rowReadON[11] rowReadON[10] rowReadOFF[11] rowReadOFF[10] openDVS_pixel2x2
x190 DiffBn VDD RefrBp GndD GndA PrSFBp OffBn PrBp OnBn pixRst[60] net123 net124 pixRst[61]
+ rowReadON[11] rowReadON[10] rowReadOFF[11] rowReadOFF[10] openDVS_pixel2x2
x191 DiffBn VDD RefrBp GndD GndA PrSFBp OffBn PrBp OnBn pixRst[62] net127 net128 pixRst[63]
+ rowReadON[11] rowReadON[10] rowReadOFF[11] rowReadOFF[10] openDVS_pixel2x2
x192 DiffBn VDD RefrBp GndD GndA PrSFBp OffBn PrBp OnBn pixRst[0] net3 net4 pixRst[1] rowReadON[13]
+ rowReadON[12] rowReadOFF[13] rowReadOFF[12] openDVS_pixel2x2
x193 DiffBn VDD RefrBp GndD GndA PrSFBp OffBn PrBp OnBn pixRst[2] net7 net8 pixRst[3] rowReadON[13]
+ rowReadON[12] rowReadOFF[13] rowReadOFF[12] openDVS_pixel2x2
x194 DiffBn VDD RefrBp GndD GndA PrSFBp OffBn PrBp OnBn pixRst[4] net11 net12 pixRst[5]
+ rowReadON[13] rowReadON[12] rowReadOFF[13] rowReadOFF[12] openDVS_pixel2x2
x195 DiffBn VDD RefrBp GndD GndA PrSFBp OffBn PrBp OnBn pixRst[6] net15 net16 pixRst[7]
+ rowReadON[13] rowReadON[12] rowReadOFF[13] rowReadOFF[12] openDVS_pixel2x2
x196 DiffBn VDD RefrBp GndD GndA PrSFBp OffBn PrBp OnBn pixRst[8] net19 net20 pixRst[9]
+ rowReadON[13] rowReadON[12] rowReadOFF[13] rowReadOFF[12] openDVS_pixel2x2
x197 DiffBn VDD RefrBp GndD GndA PrSFBp OffBn PrBp OnBn pixRst[10] net23 net24 pixRst[11]
+ rowReadON[13] rowReadON[12] rowReadOFF[13] rowReadOFF[12] openDVS_pixel2x2
x198 DiffBn VDD RefrBp GndD GndA PrSFBp OffBn PrBp OnBn pixRst[12] net27 net28 pixRst[13]
+ rowReadON[13] rowReadON[12] rowReadOFF[13] rowReadOFF[12] openDVS_pixel2x2
x199 DiffBn VDD RefrBp GndD GndA PrSFBp OffBn PrBp OnBn pixRst[14] net31 net32 pixRst[15]
+ rowReadON[13] rowReadON[12] rowReadOFF[13] rowReadOFF[12] openDVS_pixel2x2
x200 DiffBn VDD RefrBp GndD GndA PrSFBp OffBn PrBp OnBn pixRst[16] net35 net36 pixRst[17]
+ rowReadON[13] rowReadON[12] rowReadOFF[13] rowReadOFF[12] openDVS_pixel2x2
x201 DiffBn VDD RefrBp GndD GndA PrSFBp OffBn PrBp OnBn pixRst[18] net39 net40 pixRst[19]
+ rowReadON[13] rowReadON[12] rowReadOFF[13] rowReadOFF[12] openDVS_pixel2x2
x202 DiffBn VDD RefrBp GndD GndA PrSFBp OffBn PrBp OnBn pixRst[20] net43 net44 pixRst[21]
+ rowReadON[13] rowReadON[12] rowReadOFF[13] rowReadOFF[12] openDVS_pixel2x2
x203 DiffBn VDD RefrBp GndD GndA PrSFBp OffBn PrBp OnBn pixRst[22] net47 net48 pixRst[23]
+ rowReadON[13] rowReadON[12] rowReadOFF[13] rowReadOFF[12] openDVS_pixel2x2
x204 DiffBn VDD RefrBp GndD GndA PrSFBp OffBn PrBp OnBn pixRst[24] net51 net52 pixRst[25]
+ rowReadON[13] rowReadON[12] rowReadOFF[13] rowReadOFF[12] openDVS_pixel2x2
x205 DiffBn VDD RefrBp GndD GndA PrSFBp OffBn PrBp OnBn pixRst[26] net55 net56 pixRst[27]
+ rowReadON[13] rowReadON[12] rowReadOFF[13] rowReadOFF[12] openDVS_pixel2x2
x206 DiffBn VDD RefrBp GndD GndA PrSFBp OffBn PrBp OnBn pixRst[28] net59 net60 pixRst[29]
+ rowReadON[13] rowReadON[12] rowReadOFF[13] rowReadOFF[12] openDVS_pixel2x2
x207 DiffBn VDD RefrBp GndD GndA PrSFBp OffBn PrBp OnBn pixRst[30] net63 net64 pixRst[31]
+ rowReadON[13] rowReadON[12] rowReadOFF[13] rowReadOFF[12] openDVS_pixel2x2
x208 DiffBn VDD RefrBp GndD GndA PrSFBp OffBn PrBp OnBn pixRst[32] net67 net68 pixRst[33]
+ rowReadON[13] rowReadON[12] rowReadOFF[13] rowReadOFF[12] openDVS_pixel2x2
x209 DiffBn VDD RefrBp GndD GndA PrSFBp OffBn PrBp OnBn pixRst[34] net71 net72 pixRst[35]
+ rowReadON[13] rowReadON[12] rowReadOFF[13] rowReadOFF[12] openDVS_pixel2x2
x210 DiffBn VDD RefrBp GndD GndA PrSFBp OffBn PrBp OnBn pixRst[36] net75 net76 pixRst[37]
+ rowReadON[13] rowReadON[12] rowReadOFF[13] rowReadOFF[12] openDVS_pixel2x2
x211 DiffBn VDD RefrBp GndD GndA PrSFBp OffBn PrBp OnBn pixRst[38] net79 net80 pixRst[39]
+ rowReadON[13] rowReadON[12] rowReadOFF[13] rowReadOFF[12] openDVS_pixel2x2
x212 DiffBn VDD RefrBp GndD GndA PrSFBp OffBn PrBp OnBn pixRst[40] net83 net84 pixRst[41]
+ rowReadON[13] rowReadON[12] rowReadOFF[13] rowReadOFF[12] openDVS_pixel2x2
x213 DiffBn VDD RefrBp GndD GndA PrSFBp OffBn PrBp OnBn pixRst[42] net87 net88 pixRst[43]
+ rowReadON[13] rowReadON[12] rowReadOFF[13] rowReadOFF[12] openDVS_pixel2x2
x214 DiffBn VDD RefrBp GndD GndA PrSFBp OffBn PrBp OnBn pixRst[44] net91 net92 pixRst[45]
+ rowReadON[13] rowReadON[12] rowReadOFF[13] rowReadOFF[12] openDVS_pixel2x2
x215 DiffBn VDD RefrBp GndD GndA PrSFBp OffBn PrBp OnBn pixRst[46] net95 net96 pixRst[47]
+ rowReadON[13] rowReadON[12] rowReadOFF[13] rowReadOFF[12] openDVS_pixel2x2
x216 DiffBn VDD RefrBp GndD GndA PrSFBp OffBn PrBp OnBn pixRst[48] net99 net100 pixRst[49]
+ rowReadON[13] rowReadON[12] rowReadOFF[13] rowReadOFF[12] openDVS_pixel2x2
x217 DiffBn VDD RefrBp GndD GndA PrSFBp OffBn PrBp OnBn pixRst[50] net103 net104 pixRst[51]
+ rowReadON[13] rowReadON[12] rowReadOFF[13] rowReadOFF[12] openDVS_pixel2x2
x218 DiffBn VDD RefrBp GndD GndA PrSFBp OffBn PrBp OnBn pixRst[52] net107 net108 pixRst[53]
+ rowReadON[13] rowReadON[12] rowReadOFF[13] rowReadOFF[12] openDVS_pixel2x2
x219 DiffBn VDD RefrBp GndD GndA PrSFBp OffBn PrBp OnBn pixRst[54] net111 net112 pixRst[55]
+ rowReadON[13] rowReadON[12] rowReadOFF[13] rowReadOFF[12] openDVS_pixel2x2
x220 DiffBn VDD RefrBp GndD GndA PrSFBp OffBn PrBp OnBn pixRst[56] net115 net116 pixRst[57]
+ rowReadON[13] rowReadON[12] rowReadOFF[13] rowReadOFF[12] openDVS_pixel2x2
x221 DiffBn VDD RefrBp GndD GndA PrSFBp OffBn PrBp OnBn pixRst[58] net119 net120 pixRst[59]
+ rowReadON[13] rowReadON[12] rowReadOFF[13] rowReadOFF[12] openDVS_pixel2x2
x222 DiffBn VDD RefrBp GndD GndA PrSFBp OffBn PrBp OnBn pixRst[60] net123 net124 pixRst[61]
+ rowReadON[13] rowReadON[12] rowReadOFF[13] rowReadOFF[12] openDVS_pixel2x2
x223 DiffBn VDD RefrBp GndD GndA PrSFBp OffBn PrBp OnBn pixRst[62] net127 net128 pixRst[63]
+ rowReadON[13] rowReadON[12] rowReadOFF[13] rowReadOFF[12] openDVS_pixel2x2
x224 DiffBn VDD RefrBp GndD GndA PrSFBp OffBn PrBp OnBn pixRst[0] net3 net4 pixRst[1] rowReadON[15]
+ rowReadON[14] rowReadOFF[15] rowReadOFF[14] openDVS_pixel2x2
x225 DiffBn VDD RefrBp GndD GndA PrSFBp OffBn PrBp OnBn pixRst[2] net7 net8 pixRst[3] rowReadON[15]
+ rowReadON[14] rowReadOFF[15] rowReadOFF[14] openDVS_pixel2x2
x226 DiffBn VDD RefrBp GndD GndA PrSFBp OffBn PrBp OnBn pixRst[4] net11 net12 pixRst[5]
+ rowReadON[15] rowReadON[14] rowReadOFF[15] rowReadOFF[14] openDVS_pixel2x2
x227 DiffBn VDD RefrBp GndD GndA PrSFBp OffBn PrBp OnBn pixRst[6] net15 net16 pixRst[7]
+ rowReadON[15] rowReadON[14] rowReadOFF[15] rowReadOFF[14] openDVS_pixel2x2
x228 DiffBn VDD RefrBp GndD GndA PrSFBp OffBn PrBp OnBn pixRst[8] net19 net20 pixRst[9]
+ rowReadON[15] rowReadON[14] rowReadOFF[15] rowReadOFF[14] openDVS_pixel2x2
x229 DiffBn VDD RefrBp GndD GndA PrSFBp OffBn PrBp OnBn pixRst[10] net23 net24 pixRst[11]
+ rowReadON[15] rowReadON[14] rowReadOFF[15] rowReadOFF[14] openDVS_pixel2x2
x230 DiffBn VDD RefrBp GndD GndA PrSFBp OffBn PrBp OnBn pixRst[12] net27 net28 pixRst[13]
+ rowReadON[15] rowReadON[14] rowReadOFF[15] rowReadOFF[14] openDVS_pixel2x2
x231 DiffBn VDD RefrBp GndD GndA PrSFBp OffBn PrBp OnBn pixRst[14] net31 net32 pixRst[15]
+ rowReadON[15] rowReadON[14] rowReadOFF[15] rowReadOFF[14] openDVS_pixel2x2
x232 DiffBn VDD RefrBp GndD GndA PrSFBp OffBn PrBp OnBn pixRst[16] net35 net36 pixRst[17]
+ rowReadON[15] rowReadON[14] rowReadOFF[15] rowReadOFF[14] openDVS_pixel2x2
x233 DiffBn VDD RefrBp GndD GndA PrSFBp OffBn PrBp OnBn pixRst[18] net39 net40 pixRst[19]
+ rowReadON[15] rowReadON[14] rowReadOFF[15] rowReadOFF[14] openDVS_pixel2x2
x234 DiffBn VDD RefrBp GndD GndA PrSFBp OffBn PrBp OnBn pixRst[20] net43 net44 pixRst[21]
+ rowReadON[15] rowReadON[14] rowReadOFF[15] rowReadOFF[14] openDVS_pixel2x2
x235 DiffBn VDD RefrBp GndD GndA PrSFBp OffBn PrBp OnBn pixRst[22] net47 net48 pixRst[23]
+ rowReadON[15] rowReadON[14] rowReadOFF[15] rowReadOFF[14] openDVS_pixel2x2
x236 DiffBn VDD RefrBp GndD GndA PrSFBp OffBn PrBp OnBn pixRst[24] net51 net52 pixRst[25]
+ rowReadON[15] rowReadON[14] rowReadOFF[15] rowReadOFF[14] openDVS_pixel2x2
x237 DiffBn VDD RefrBp GndD GndA PrSFBp OffBn PrBp OnBn pixRst[26] net55 net56 pixRst[27]
+ rowReadON[15] rowReadON[14] rowReadOFF[15] rowReadOFF[14] openDVS_pixel2x2
x238 DiffBn VDD RefrBp GndD GndA PrSFBp OffBn PrBp OnBn pixRst[28] net59 net60 pixRst[29]
+ rowReadON[15] rowReadON[14] rowReadOFF[15] rowReadOFF[14] openDVS_pixel2x2
x239 DiffBn VDD RefrBp GndD GndA PrSFBp OffBn PrBp OnBn pixRst[30] net63 net64 pixRst[31]
+ rowReadON[15] rowReadON[14] rowReadOFF[15] rowReadOFF[14] openDVS_pixel2x2
x240 DiffBn VDD RefrBp GndD GndA PrSFBp OffBn PrBp OnBn pixRst[32] net67 net68 pixRst[33]
+ rowReadON[15] rowReadON[14] rowReadOFF[15] rowReadOFF[14] openDVS_pixel2x2
x241 DiffBn VDD RefrBp GndD GndA PrSFBp OffBn PrBp OnBn pixRst[34] net71 net72 pixRst[35]
+ rowReadON[15] rowReadON[14] rowReadOFF[15] rowReadOFF[14] openDVS_pixel2x2
x242 DiffBn VDD RefrBp GndD GndA PrSFBp OffBn PrBp OnBn pixRst[36] net75 net76 pixRst[37]
+ rowReadON[15] rowReadON[14] rowReadOFF[15] rowReadOFF[14] openDVS_pixel2x2
x243 DiffBn VDD RefrBp GndD GndA PrSFBp OffBn PrBp OnBn pixRst[38] net79 net80 pixRst[39]
+ rowReadON[15] rowReadON[14] rowReadOFF[15] rowReadOFF[14] openDVS_pixel2x2
x244 DiffBn VDD RefrBp GndD GndA PrSFBp OffBn PrBp OnBn pixRst[40] net83 net84 pixRst[41]
+ rowReadON[15] rowReadON[14] rowReadOFF[15] rowReadOFF[14] openDVS_pixel2x2
x245 DiffBn VDD RefrBp GndD GndA PrSFBp OffBn PrBp OnBn pixRst[42] net87 net88 pixRst[43]
+ rowReadON[15] rowReadON[14] rowReadOFF[15] rowReadOFF[14] openDVS_pixel2x2
x246 DiffBn VDD RefrBp GndD GndA PrSFBp OffBn PrBp OnBn pixRst[44] net91 net92 pixRst[45]
+ rowReadON[15] rowReadON[14] rowReadOFF[15] rowReadOFF[14] openDVS_pixel2x2
x247 DiffBn VDD RefrBp GndD GndA PrSFBp OffBn PrBp OnBn pixRst[46] net95 net96 pixRst[47]
+ rowReadON[15] rowReadON[14] rowReadOFF[15] rowReadOFF[14] openDVS_pixel2x2
x248 DiffBn VDD RefrBp GndD GndA PrSFBp OffBn PrBp OnBn pixRst[48] net99 net100 pixRst[49]
+ rowReadON[15] rowReadON[14] rowReadOFF[15] rowReadOFF[14] openDVS_pixel2x2
x249 DiffBn VDD RefrBp GndD GndA PrSFBp OffBn PrBp OnBn pixRst[50] net103 net104 pixRst[51]
+ rowReadON[15] rowReadON[14] rowReadOFF[15] rowReadOFF[14] openDVS_pixel2x2
x250 DiffBn VDD RefrBp GndD GndA PrSFBp OffBn PrBp OnBn pixRst[52] net107 net108 pixRst[53]
+ rowReadON[15] rowReadON[14] rowReadOFF[15] rowReadOFF[14] openDVS_pixel2x2
x251 DiffBn VDD RefrBp GndD GndA PrSFBp OffBn PrBp OnBn pixRst[54] net111 net112 pixRst[55]
+ rowReadON[15] rowReadON[14] rowReadOFF[15] rowReadOFF[14] openDVS_pixel2x2
x252 DiffBn VDD RefrBp GndD GndA PrSFBp OffBn PrBp OnBn pixRst[56] net115 net116 pixRst[57]
+ rowReadON[15] rowReadON[14] rowReadOFF[15] rowReadOFF[14] openDVS_pixel2x2
x253 DiffBn VDD RefrBp GndD GndA PrSFBp OffBn PrBp OnBn pixRst[58] net119 net120 pixRst[59]
+ rowReadON[15] rowReadON[14] rowReadOFF[15] rowReadOFF[14] openDVS_pixel2x2
x254 DiffBn VDD RefrBp GndD GndA PrSFBp OffBn PrBp OnBn pixRst[60] net123 net124 pixRst[61]
+ rowReadON[15] rowReadON[14] rowReadOFF[15] rowReadOFF[14] openDVS_pixel2x2
x255 DiffBn VDD RefrBp GndD GndA PrSFBp OffBn PrBp OnBn pixRst[62] net127 net128 pixRst[63]
+ rowReadON[15] rowReadON[14] rowReadOFF[15] rowReadOFF[14] openDVS_pixel2x2
x256 DiffBn VDD RefrBp GndD GndA PrSFBp OffBn PrBp OnBn pixRst[0] net3 net4 pixRst[1] rowReadON[17]
+ rowReadON[16] rowReadOFF[17] rowReadOFF[16] openDVS_pixel2x2
x257 DiffBn VDD RefrBp GndD GndA PrSFBp OffBn PrBp OnBn pixRst[2] net7 net8 pixRst[3] rowReadON[17]
+ rowReadON[16] rowReadOFF[17] rowReadOFF[16] openDVS_pixel2x2
x258 DiffBn VDD RefrBp GndD GndA PrSFBp OffBn PrBp OnBn pixRst[4] net11 net12 pixRst[5]
+ rowReadON[17] rowReadON[16] rowReadOFF[17] rowReadOFF[16] openDVS_pixel2x2
x259 DiffBn VDD RefrBp GndD GndA PrSFBp OffBn PrBp OnBn pixRst[6] net15 net16 pixRst[7]
+ rowReadON[17] rowReadON[16] rowReadOFF[17] rowReadOFF[16] openDVS_pixel2x2
x260 DiffBn VDD RefrBp GndD GndA PrSFBp OffBn PrBp OnBn pixRst[8] net19 net20 pixRst[9]
+ rowReadON[17] rowReadON[16] rowReadOFF[17] rowReadOFF[16] openDVS_pixel2x2
x261 DiffBn VDD RefrBp GndD GndA PrSFBp OffBn PrBp OnBn pixRst[10] net23 net24 pixRst[11]
+ rowReadON[17] rowReadON[16] rowReadOFF[17] rowReadOFF[16] openDVS_pixel2x2
x262 DiffBn VDD RefrBp GndD GndA PrSFBp OffBn PrBp OnBn pixRst[12] net27 net28 pixRst[13]
+ rowReadON[17] rowReadON[16] rowReadOFF[17] rowReadOFF[16] openDVS_pixel2x2
x263 DiffBn VDD RefrBp GndD GndA PrSFBp OffBn PrBp OnBn pixRst[14] net31 net32 pixRst[15]
+ rowReadON[17] rowReadON[16] rowReadOFF[17] rowReadOFF[16] openDVS_pixel2x2
x264 DiffBn VDD RefrBp GndD GndA PrSFBp OffBn PrBp OnBn pixRst[16] net35 net36 pixRst[17]
+ rowReadON[17] rowReadON[16] rowReadOFF[17] rowReadOFF[16] openDVS_pixel2x2
x265 DiffBn VDD RefrBp GndD GndA PrSFBp OffBn PrBp OnBn pixRst[18] net39 net40 pixRst[19]
+ rowReadON[17] rowReadON[16] rowReadOFF[17] rowReadOFF[16] openDVS_pixel2x2
x266 DiffBn VDD RefrBp GndD GndA PrSFBp OffBn PrBp OnBn pixRst[20] net43 net44 pixRst[21]
+ rowReadON[17] rowReadON[16] rowReadOFF[17] rowReadOFF[16] openDVS_pixel2x2
x267 DiffBn VDD RefrBp GndD GndA PrSFBp OffBn PrBp OnBn pixRst[22] net47 net48 pixRst[23]
+ rowReadON[17] rowReadON[16] rowReadOFF[17] rowReadOFF[16] openDVS_pixel2x2
x268 DiffBn VDD RefrBp GndD GndA PrSFBp OffBn PrBp OnBn pixRst[24] net51 net52 pixRst[25]
+ rowReadON[17] rowReadON[16] rowReadOFF[17] rowReadOFF[16] openDVS_pixel2x2
x269 DiffBn VDD RefrBp GndD GndA PrSFBp OffBn PrBp OnBn pixRst[26] net55 net56 pixRst[27]
+ rowReadON[17] rowReadON[16] rowReadOFF[17] rowReadOFF[16] openDVS_pixel2x2
x270 DiffBn VDD RefrBp GndD GndA PrSFBp OffBn PrBp OnBn pixRst[28] net59 net60 pixRst[29]
+ rowReadON[17] rowReadON[16] rowReadOFF[17] rowReadOFF[16] openDVS_pixel2x2
x271 DiffBn VDD RefrBp GndD GndA PrSFBp OffBn PrBp OnBn pixRst[30] net63 net64 pixRst[31]
+ rowReadON[17] rowReadON[16] rowReadOFF[17] rowReadOFF[16] openDVS_pixel2x2
x272 DiffBn VDD RefrBp GndD GndA PrSFBp OffBn PrBp OnBn pixRst[32] net67 net68 pixRst[33]
+ rowReadON[17] rowReadON[16] rowReadOFF[17] rowReadOFF[16] openDVS_pixel2x2
x273 DiffBn VDD RefrBp GndD GndA PrSFBp OffBn PrBp OnBn pixRst[34] net71 net72 pixRst[35]
+ rowReadON[17] rowReadON[16] rowReadOFF[17] rowReadOFF[16] openDVS_pixel2x2
x274 DiffBn VDD RefrBp GndD GndA PrSFBp OffBn PrBp OnBn pixRst[36] net75 net76 pixRst[37]
+ rowReadON[17] rowReadON[16] rowReadOFF[17] rowReadOFF[16] openDVS_pixel2x2
x275 DiffBn VDD RefrBp GndD GndA PrSFBp OffBn PrBp OnBn pixRst[38] net79 net80 pixRst[39]
+ rowReadON[17] rowReadON[16] rowReadOFF[17] rowReadOFF[16] openDVS_pixel2x2
x276 DiffBn VDD RefrBp GndD GndA PrSFBp OffBn PrBp OnBn pixRst[40] net83 net84 pixRst[41]
+ rowReadON[17] rowReadON[16] rowReadOFF[17] rowReadOFF[16] openDVS_pixel2x2
x277 DiffBn VDD RefrBp GndD GndA PrSFBp OffBn PrBp OnBn pixRst[42] net87 net88 pixRst[43]
+ rowReadON[17] rowReadON[16] rowReadOFF[17] rowReadOFF[16] openDVS_pixel2x2
x278 DiffBn VDD RefrBp GndD GndA PrSFBp OffBn PrBp OnBn pixRst[44] net91 net92 pixRst[45]
+ rowReadON[17] rowReadON[16] rowReadOFF[17] rowReadOFF[16] openDVS_pixel2x2
x279 DiffBn VDD RefrBp GndD GndA PrSFBp OffBn PrBp OnBn pixRst[46] net95 net96 pixRst[47]
+ rowReadON[17] rowReadON[16] rowReadOFF[17] rowReadOFF[16] openDVS_pixel2x2
x280 DiffBn VDD RefrBp GndD GndA PrSFBp OffBn PrBp OnBn pixRst[48] net99 net100 pixRst[49]
+ rowReadON[17] rowReadON[16] rowReadOFF[17] rowReadOFF[16] openDVS_pixel2x2
x281 DiffBn VDD RefrBp GndD GndA PrSFBp OffBn PrBp OnBn pixRst[50] net103 net104 pixRst[51]
+ rowReadON[17] rowReadON[16] rowReadOFF[17] rowReadOFF[16] openDVS_pixel2x2
x282 DiffBn VDD RefrBp GndD GndA PrSFBp OffBn PrBp OnBn pixRst[52] net107 net108 pixRst[53]
+ rowReadON[17] rowReadON[16] rowReadOFF[17] rowReadOFF[16] openDVS_pixel2x2
x283 DiffBn VDD RefrBp GndD GndA PrSFBp OffBn PrBp OnBn pixRst[54] net111 net112 pixRst[55]
+ rowReadON[17] rowReadON[16] rowReadOFF[17] rowReadOFF[16] openDVS_pixel2x2
x284 DiffBn VDD RefrBp GndD GndA PrSFBp OffBn PrBp OnBn pixRst[56] net115 net116 pixRst[57]
+ rowReadON[17] rowReadON[16] rowReadOFF[17] rowReadOFF[16] openDVS_pixel2x2
x285 DiffBn VDD RefrBp GndD GndA PrSFBp OffBn PrBp OnBn pixRst[58] net119 net120 pixRst[59]
+ rowReadON[17] rowReadON[16] rowReadOFF[17] rowReadOFF[16] openDVS_pixel2x2
x286 DiffBn VDD RefrBp GndD GndA PrSFBp OffBn PrBp OnBn pixRst[60] net123 net124 pixRst[61]
+ rowReadON[17] rowReadON[16] rowReadOFF[17] rowReadOFF[16] openDVS_pixel2x2
x287 DiffBn VDD RefrBp GndD GndA PrSFBp OffBn PrBp OnBn pixRst[62] net127 net128 pixRst[63]
+ rowReadON[17] rowReadON[16] rowReadOFF[17] rowReadOFF[16] openDVS_pixel2x2
x288 DiffBn VDD RefrBp GndD GndA PrSFBp OffBn PrBp OnBn pixRst[0] net3 net4 pixRst[1] rowReadON[19]
+ rowReadON[18] rowReadOFF[19] rowReadOFF[18] openDVS_pixel2x2
x289 DiffBn VDD RefrBp GndD GndA PrSFBp OffBn PrBp OnBn pixRst[2] net7 net8 pixRst[3] rowReadON[19]
+ rowReadON[18] rowReadOFF[19] rowReadOFF[18] openDVS_pixel2x2
x290 DiffBn VDD RefrBp GndD GndA PrSFBp OffBn PrBp OnBn pixRst[4] net11 net12 pixRst[5]
+ rowReadON[19] rowReadON[18] rowReadOFF[19] rowReadOFF[18] openDVS_pixel2x2
x291 DiffBn VDD RefrBp GndD GndA PrSFBp OffBn PrBp OnBn pixRst[6] net15 net16 pixRst[7]
+ rowReadON[19] rowReadON[18] rowReadOFF[19] rowReadOFF[18] openDVS_pixel2x2
x292 DiffBn VDD RefrBp GndD GndA PrSFBp OffBn PrBp OnBn pixRst[8] net19 net20 pixRst[9]
+ rowReadON[19] rowReadON[18] rowReadOFF[19] rowReadOFF[18] openDVS_pixel2x2
x293 DiffBn VDD RefrBp GndD GndA PrSFBp OffBn PrBp OnBn pixRst[10] net23 net24 pixRst[11]
+ rowReadON[19] rowReadON[18] rowReadOFF[19] rowReadOFF[18] openDVS_pixel2x2
x294 DiffBn VDD RefrBp GndD GndA PrSFBp OffBn PrBp OnBn pixRst[12] net27 net28 pixRst[13]
+ rowReadON[19] rowReadON[18] rowReadOFF[19] rowReadOFF[18] openDVS_pixel2x2
x295 DiffBn VDD RefrBp GndD GndA PrSFBp OffBn PrBp OnBn pixRst[14] net31 net32 pixRst[15]
+ rowReadON[19] rowReadON[18] rowReadOFF[19] rowReadOFF[18] openDVS_pixel2x2
x296 DiffBn VDD RefrBp GndD GndA PrSFBp OffBn PrBp OnBn pixRst[16] net35 net36 pixRst[17]
+ rowReadON[19] rowReadON[18] rowReadOFF[19] rowReadOFF[18] openDVS_pixel2x2
x297 DiffBn VDD RefrBp GndD GndA PrSFBp OffBn PrBp OnBn pixRst[18] net39 net40 pixRst[19]
+ rowReadON[19] rowReadON[18] rowReadOFF[19] rowReadOFF[18] openDVS_pixel2x2
x298 DiffBn VDD RefrBp GndD GndA PrSFBp OffBn PrBp OnBn pixRst[20] net43 net44 pixRst[21]
+ rowReadON[19] rowReadON[18] rowReadOFF[19] rowReadOFF[18] openDVS_pixel2x2
x299 DiffBn VDD RefrBp GndD GndA PrSFBp OffBn PrBp OnBn pixRst[22] net47 net48 pixRst[23]
+ rowReadON[19] rowReadON[18] rowReadOFF[19] rowReadOFF[18] openDVS_pixel2x2
x300 DiffBn VDD RefrBp GndD GndA PrSFBp OffBn PrBp OnBn pixRst[24] net51 net52 pixRst[25]
+ rowReadON[19] rowReadON[18] rowReadOFF[19] rowReadOFF[18] openDVS_pixel2x2
x301 DiffBn VDD RefrBp GndD GndA PrSFBp OffBn PrBp OnBn pixRst[26] net55 net56 pixRst[27]
+ rowReadON[19] rowReadON[18] rowReadOFF[19] rowReadOFF[18] openDVS_pixel2x2
x302 DiffBn VDD RefrBp GndD GndA PrSFBp OffBn PrBp OnBn pixRst[28] net59 net60 pixRst[29]
+ rowReadON[19] rowReadON[18] rowReadOFF[19] rowReadOFF[18] openDVS_pixel2x2
x303 DiffBn VDD RefrBp GndD GndA PrSFBp OffBn PrBp OnBn pixRst[30] net63 net64 pixRst[31]
+ rowReadON[19] rowReadON[18] rowReadOFF[19] rowReadOFF[18] openDVS_pixel2x2
x304 DiffBn VDD RefrBp GndD GndA PrSFBp OffBn PrBp OnBn pixRst[32] net67 net68 pixRst[33]
+ rowReadON[19] rowReadON[18] rowReadOFF[19] rowReadOFF[18] openDVS_pixel2x2
x305 DiffBn VDD RefrBp GndD GndA PrSFBp OffBn PrBp OnBn pixRst[34] net71 net72 pixRst[35]
+ rowReadON[19] rowReadON[18] rowReadOFF[19] rowReadOFF[18] openDVS_pixel2x2
x306 DiffBn VDD RefrBp GndD GndA PrSFBp OffBn PrBp OnBn pixRst[36] net75 net76 pixRst[37]
+ rowReadON[19] rowReadON[18] rowReadOFF[19] rowReadOFF[18] openDVS_pixel2x2
x307 DiffBn VDD RefrBp GndD GndA PrSFBp OffBn PrBp OnBn pixRst[38] net79 net80 pixRst[39]
+ rowReadON[19] rowReadON[18] rowReadOFF[19] rowReadOFF[18] openDVS_pixel2x2
x308 DiffBn VDD RefrBp GndD GndA PrSFBp OffBn PrBp OnBn pixRst[40] net83 net84 pixRst[41]
+ rowReadON[19] rowReadON[18] rowReadOFF[19] rowReadOFF[18] openDVS_pixel2x2
x309 DiffBn VDD RefrBp GndD GndA PrSFBp OffBn PrBp OnBn pixRst[42] net87 net88 pixRst[43]
+ rowReadON[19] rowReadON[18] rowReadOFF[19] rowReadOFF[18] openDVS_pixel2x2
x310 DiffBn VDD RefrBp GndD GndA PrSFBp OffBn PrBp OnBn pixRst[44] net91 net92 pixRst[45]
+ rowReadON[19] rowReadON[18] rowReadOFF[19] rowReadOFF[18] openDVS_pixel2x2
x311 DiffBn VDD RefrBp GndD GndA PrSFBp OffBn PrBp OnBn pixRst[46] net95 net96 pixRst[47]
+ rowReadON[19] rowReadON[18] rowReadOFF[19] rowReadOFF[18] openDVS_pixel2x2
x312 DiffBn VDD RefrBp GndD GndA PrSFBp OffBn PrBp OnBn pixRst[48] net99 net100 pixRst[49]
+ rowReadON[19] rowReadON[18] rowReadOFF[19] rowReadOFF[18] openDVS_pixel2x2
x313 DiffBn VDD RefrBp GndD GndA PrSFBp OffBn PrBp OnBn pixRst[50] net103 net104 pixRst[51]
+ rowReadON[19] rowReadON[18] rowReadOFF[19] rowReadOFF[18] openDVS_pixel2x2
x314 DiffBn VDD RefrBp GndD GndA PrSFBp OffBn PrBp OnBn pixRst[52] net107 net108 pixRst[53]
+ rowReadON[19] rowReadON[18] rowReadOFF[19] rowReadOFF[18] openDVS_pixel2x2
x315 DiffBn VDD RefrBp GndD GndA PrSFBp OffBn PrBp OnBn pixRst[54] net111 net112 pixRst[55]
+ rowReadON[19] rowReadON[18] rowReadOFF[19] rowReadOFF[18] openDVS_pixel2x2
x316 DiffBn VDD RefrBp GndD GndA PrSFBp OffBn PrBp OnBn pixRst[56] net115 net116 pixRst[57]
+ rowReadON[19] rowReadON[18] rowReadOFF[19] rowReadOFF[18] openDVS_pixel2x2
x317 DiffBn VDD RefrBp GndD GndA PrSFBp OffBn PrBp OnBn pixRst[58] net119 net120 pixRst[59]
+ rowReadON[19] rowReadON[18] rowReadOFF[19] rowReadOFF[18] openDVS_pixel2x2
x318 DiffBn VDD RefrBp GndD GndA PrSFBp OffBn PrBp OnBn pixRst[60] net123 net124 pixRst[61]
+ rowReadON[19] rowReadON[18] rowReadOFF[19] rowReadOFF[18] openDVS_pixel2x2
x319 DiffBn VDD RefrBp GndD GndA PrSFBp OffBn PrBp OnBn pixRst[62] net127 net128 pixRst[63]
+ rowReadON[19] rowReadON[18] rowReadOFF[19] rowReadOFF[18] openDVS_pixel2x2
x320 DiffBn VDD RefrBp GndD GndA PrSFBp OffBn PrBp OnBn pixRst[0] net3 net4 pixRst[1] rowReadON[21]
+ rowReadON[20] rowReadOFF[21] rowReadOFF[20] openDVS_pixel2x2
x321 DiffBn VDD RefrBp GndD GndA PrSFBp OffBn PrBp OnBn pixRst[2] net7 net8 pixRst[3] rowReadON[21]
+ rowReadON[20] rowReadOFF[21] rowReadOFF[20] openDVS_pixel2x2
x322 DiffBn VDD RefrBp GndD GndA PrSFBp OffBn PrBp OnBn pixRst[4] net11 net12 pixRst[5]
+ rowReadON[21] rowReadON[20] rowReadOFF[21] rowReadOFF[20] openDVS_pixel2x2
x323 DiffBn VDD RefrBp GndD GndA PrSFBp OffBn PrBp OnBn pixRst[6] net15 net16 pixRst[7]
+ rowReadON[21] rowReadON[20] rowReadOFF[21] rowReadOFF[20] openDVS_pixel2x2
x324 DiffBn VDD RefrBp GndD GndA PrSFBp OffBn PrBp OnBn pixRst[8] net19 net20 pixRst[9]
+ rowReadON[21] rowReadON[20] rowReadOFF[21] rowReadOFF[20] openDVS_pixel2x2
x325 DiffBn VDD RefrBp GndD GndA PrSFBp OffBn PrBp OnBn pixRst[10] net23 net24 pixRst[11]
+ rowReadON[21] rowReadON[20] rowReadOFF[21] rowReadOFF[20] openDVS_pixel2x2
x326 DiffBn VDD RefrBp GndD GndA PrSFBp OffBn PrBp OnBn pixRst[12] net27 net28 pixRst[13]
+ rowReadON[21] rowReadON[20] rowReadOFF[21] rowReadOFF[20] openDVS_pixel2x2
x327 DiffBn VDD RefrBp GndD GndA PrSFBp OffBn PrBp OnBn pixRst[14] net31 net32 pixRst[15]
+ rowReadON[21] rowReadON[20] rowReadOFF[21] rowReadOFF[20] openDVS_pixel2x2
x328 DiffBn VDD RefrBp GndD GndA PrSFBp OffBn PrBp OnBn pixRst[16] net35 net36 pixRst[17]
+ rowReadON[21] rowReadON[20] rowReadOFF[21] rowReadOFF[20] openDVS_pixel2x2
x329 DiffBn VDD RefrBp GndD GndA PrSFBp OffBn PrBp OnBn pixRst[18] net39 net40 pixRst[19]
+ rowReadON[21] rowReadON[20] rowReadOFF[21] rowReadOFF[20] openDVS_pixel2x2
x330 DiffBn VDD RefrBp GndD GndA PrSFBp OffBn PrBp OnBn pixRst[20] net43 net44 pixRst[21]
+ rowReadON[21] rowReadON[20] rowReadOFF[21] rowReadOFF[20] openDVS_pixel2x2
x331 DiffBn VDD RefrBp GndD GndA PrSFBp OffBn PrBp OnBn pixRst[22] net47 net48 pixRst[23]
+ rowReadON[21] rowReadON[20] rowReadOFF[21] rowReadOFF[20] openDVS_pixel2x2
x332 DiffBn VDD RefrBp GndD GndA PrSFBp OffBn PrBp OnBn pixRst[24] net51 net52 pixRst[25]
+ rowReadON[21] rowReadON[20] rowReadOFF[21] rowReadOFF[20] openDVS_pixel2x2
x333 DiffBn VDD RefrBp GndD GndA PrSFBp OffBn PrBp OnBn pixRst[26] net55 net56 pixRst[27]
+ rowReadON[21] rowReadON[20] rowReadOFF[21] rowReadOFF[20] openDVS_pixel2x2
x334 DiffBn VDD RefrBp GndD GndA PrSFBp OffBn PrBp OnBn pixRst[28] net59 net60 pixRst[29]
+ rowReadON[21] rowReadON[20] rowReadOFF[21] rowReadOFF[20] openDVS_pixel2x2
x335 DiffBn VDD RefrBp GndD GndA PrSFBp OffBn PrBp OnBn pixRst[30] net63 net64 pixRst[31]
+ rowReadON[21] rowReadON[20] rowReadOFF[21] rowReadOFF[20] openDVS_pixel2x2
x336 DiffBn VDD RefrBp GndD GndA PrSFBp OffBn PrBp OnBn pixRst[32] net67 net68 pixRst[33]
+ rowReadON[21] rowReadON[20] rowReadOFF[21] rowReadOFF[20] openDVS_pixel2x2
x337 DiffBn VDD RefrBp GndD GndA PrSFBp OffBn PrBp OnBn pixRst[34] net71 net72 pixRst[35]
+ rowReadON[21] rowReadON[20] rowReadOFF[21] rowReadOFF[20] openDVS_pixel2x2
x338 DiffBn VDD RefrBp GndD GndA PrSFBp OffBn PrBp OnBn pixRst[36] net75 net76 pixRst[37]
+ rowReadON[21] rowReadON[20] rowReadOFF[21] rowReadOFF[20] openDVS_pixel2x2
x339 DiffBn VDD RefrBp GndD GndA PrSFBp OffBn PrBp OnBn pixRst[38] net79 net80 pixRst[39]
+ rowReadON[21] rowReadON[20] rowReadOFF[21] rowReadOFF[20] openDVS_pixel2x2
x340 DiffBn VDD RefrBp GndD GndA PrSFBp OffBn PrBp OnBn pixRst[40] net83 net84 pixRst[41]
+ rowReadON[21] rowReadON[20] rowReadOFF[21] rowReadOFF[20] openDVS_pixel2x2
x341 DiffBn VDD RefrBp GndD GndA PrSFBp OffBn PrBp OnBn pixRst[42] net87 net88 pixRst[43]
+ rowReadON[21] rowReadON[20] rowReadOFF[21] rowReadOFF[20] openDVS_pixel2x2
x342 DiffBn VDD RefrBp GndD GndA PrSFBp OffBn PrBp OnBn pixRst[44] net91 net92 pixRst[45]
+ rowReadON[21] rowReadON[20] rowReadOFF[21] rowReadOFF[20] openDVS_pixel2x2
x343 DiffBn VDD RefrBp GndD GndA PrSFBp OffBn PrBp OnBn pixRst[46] net95 net96 pixRst[47]
+ rowReadON[21] rowReadON[20] rowReadOFF[21] rowReadOFF[20] openDVS_pixel2x2
x344 DiffBn VDD RefrBp GndD GndA PrSFBp OffBn PrBp OnBn pixRst[48] net99 net100 pixRst[49]
+ rowReadON[21] rowReadON[20] rowReadOFF[21] rowReadOFF[20] openDVS_pixel2x2
x345 DiffBn VDD RefrBp GndD GndA PrSFBp OffBn PrBp OnBn pixRst[50] net103 net104 pixRst[51]
+ rowReadON[21] rowReadON[20] rowReadOFF[21] rowReadOFF[20] openDVS_pixel2x2
x346 DiffBn VDD RefrBp GndD GndA PrSFBp OffBn PrBp OnBn pixRst[52] net107 net108 pixRst[53]
+ rowReadON[21] rowReadON[20] rowReadOFF[21] rowReadOFF[20] openDVS_pixel2x2
x347 DiffBn VDD RefrBp GndD GndA PrSFBp OffBn PrBp OnBn pixRst[54] net111 net112 pixRst[55]
+ rowReadON[21] rowReadON[20] rowReadOFF[21] rowReadOFF[20] openDVS_pixel2x2
x348 DiffBn VDD RefrBp GndD GndA PrSFBp OffBn PrBp OnBn pixRst[56] net115 net116 pixRst[57]
+ rowReadON[21] rowReadON[20] rowReadOFF[21] rowReadOFF[20] openDVS_pixel2x2
x349 DiffBn VDD RefrBp GndD GndA PrSFBp OffBn PrBp OnBn pixRst[58] net119 net120 pixRst[59]
+ rowReadON[21] rowReadON[20] rowReadOFF[21] rowReadOFF[20] openDVS_pixel2x2
x350 DiffBn VDD RefrBp GndD GndA PrSFBp OffBn PrBp OnBn pixRst[60] net123 net124 pixRst[61]
+ rowReadON[21] rowReadON[20] rowReadOFF[21] rowReadOFF[20] openDVS_pixel2x2
x351 DiffBn VDD RefrBp GndD GndA PrSFBp OffBn PrBp OnBn pixRst[62] net127 net128 pixRst[63]
+ rowReadON[21] rowReadON[20] rowReadOFF[21] rowReadOFF[20] openDVS_pixel2x2
x352 DiffBn VDD RefrBp GndD GndA PrSFBp OffBn PrBp OnBn pixRst[0] net3 net4 pixRst[1] rowReadON[23]
+ rowReadON[22] rowReadOFF[23] rowReadOFF[22] openDVS_pixel2x2
x353 DiffBn VDD RefrBp GndD GndA PrSFBp OffBn PrBp OnBn pixRst[2] net7 net8 pixRst[3] rowReadON[23]
+ rowReadON[22] rowReadOFF[23] rowReadOFF[22] openDVS_pixel2x2
x354 DiffBn VDD RefrBp GndD GndA PrSFBp OffBn PrBp OnBn pixRst[4] net11 net12 pixRst[5]
+ rowReadON[23] rowReadON[22] rowReadOFF[23] rowReadOFF[22] openDVS_pixel2x2
x355 DiffBn VDD RefrBp GndD GndA PrSFBp OffBn PrBp OnBn pixRst[6] net15 net16 pixRst[7]
+ rowReadON[23] rowReadON[22] rowReadOFF[23] rowReadOFF[22] openDVS_pixel2x2
x356 DiffBn VDD RefrBp GndD GndA PrSFBp OffBn PrBp OnBn pixRst[8] net19 net20 pixRst[9]
+ rowReadON[23] rowReadON[22] rowReadOFF[23] rowReadOFF[22] openDVS_pixel2x2
x357 DiffBn VDD RefrBp GndD GndA PrSFBp OffBn PrBp OnBn pixRst[10] net23 net24 pixRst[11]
+ rowReadON[23] rowReadON[22] rowReadOFF[23] rowReadOFF[22] openDVS_pixel2x2
x358 DiffBn VDD RefrBp GndD GndA PrSFBp OffBn PrBp OnBn pixRst[12] net27 net28 pixRst[13]
+ rowReadON[23] rowReadON[22] rowReadOFF[23] rowReadOFF[22] openDVS_pixel2x2
x359 DiffBn VDD RefrBp GndD GndA PrSFBp OffBn PrBp OnBn pixRst[14] net31 net32 pixRst[15]
+ rowReadON[23] rowReadON[22] rowReadOFF[23] rowReadOFF[22] openDVS_pixel2x2
x360 DiffBn VDD RefrBp GndD GndA PrSFBp OffBn PrBp OnBn pixRst[16] net35 net36 pixRst[17]
+ rowReadON[23] rowReadON[22] rowReadOFF[23] rowReadOFF[22] openDVS_pixel2x2
x361 DiffBn VDD RefrBp GndD GndA PrSFBp OffBn PrBp OnBn pixRst[18] net39 net40 pixRst[19]
+ rowReadON[23] rowReadON[22] rowReadOFF[23] rowReadOFF[22] openDVS_pixel2x2
x362 DiffBn VDD RefrBp GndD GndA PrSFBp OffBn PrBp OnBn pixRst[20] net43 net44 pixRst[21]
+ rowReadON[23] rowReadON[22] rowReadOFF[23] rowReadOFF[22] openDVS_pixel2x2
x363 DiffBn VDD RefrBp GndD GndA PrSFBp OffBn PrBp OnBn pixRst[22] net47 net48 pixRst[23]
+ rowReadON[23] rowReadON[22] rowReadOFF[23] rowReadOFF[22] openDVS_pixel2x2
x364 DiffBn VDD RefrBp GndD GndA PrSFBp OffBn PrBp OnBn pixRst[24] net51 net52 pixRst[25]
+ rowReadON[23] rowReadON[22] rowReadOFF[23] rowReadOFF[22] openDVS_pixel2x2
x365 DiffBn VDD RefrBp GndD GndA PrSFBp OffBn PrBp OnBn pixRst[26] net55 net56 pixRst[27]
+ rowReadON[23] rowReadON[22] rowReadOFF[23] rowReadOFF[22] openDVS_pixel2x2
x366 DiffBn VDD RefrBp GndD GndA PrSFBp OffBn PrBp OnBn pixRst[28] net59 net60 pixRst[29]
+ rowReadON[23] rowReadON[22] rowReadOFF[23] rowReadOFF[22] openDVS_pixel2x2
x367 DiffBn VDD RefrBp GndD GndA PrSFBp OffBn PrBp OnBn pixRst[30] net63 net64 pixRst[31]
+ rowReadON[23] rowReadON[22] rowReadOFF[23] rowReadOFF[22] openDVS_pixel2x2
x368 DiffBn VDD RefrBp GndD GndA PrSFBp OffBn PrBp OnBn pixRst[32] net67 net68 pixRst[33]
+ rowReadON[23] rowReadON[22] rowReadOFF[23] rowReadOFF[22] openDVS_pixel2x2
x369 DiffBn VDD RefrBp GndD GndA PrSFBp OffBn PrBp OnBn pixRst[34] net71 net72 pixRst[35]
+ rowReadON[23] rowReadON[22] rowReadOFF[23] rowReadOFF[22] openDVS_pixel2x2
x370 DiffBn VDD RefrBp GndD GndA PrSFBp OffBn PrBp OnBn pixRst[36] net75 net76 pixRst[37]
+ rowReadON[23] rowReadON[22] rowReadOFF[23] rowReadOFF[22] openDVS_pixel2x2
x371 DiffBn VDD RefrBp GndD GndA PrSFBp OffBn PrBp OnBn pixRst[38] net79 net80 pixRst[39]
+ rowReadON[23] rowReadON[22] rowReadOFF[23] rowReadOFF[22] openDVS_pixel2x2
x372 DiffBn VDD RefrBp GndD GndA PrSFBp OffBn PrBp OnBn pixRst[40] net83 net84 pixRst[41]
+ rowReadON[23] rowReadON[22] rowReadOFF[23] rowReadOFF[22] openDVS_pixel2x2
x373 DiffBn VDD RefrBp GndD GndA PrSFBp OffBn PrBp OnBn pixRst[42] net87 net88 pixRst[43]
+ rowReadON[23] rowReadON[22] rowReadOFF[23] rowReadOFF[22] openDVS_pixel2x2
x374 DiffBn VDD RefrBp GndD GndA PrSFBp OffBn PrBp OnBn pixRst[44] net91 net92 pixRst[45]
+ rowReadON[23] rowReadON[22] rowReadOFF[23] rowReadOFF[22] openDVS_pixel2x2
x375 DiffBn VDD RefrBp GndD GndA PrSFBp OffBn PrBp OnBn pixRst[46] net95 net96 pixRst[47]
+ rowReadON[23] rowReadON[22] rowReadOFF[23] rowReadOFF[22] openDVS_pixel2x2
x376 DiffBn VDD RefrBp GndD GndA PrSFBp OffBn PrBp OnBn pixRst[48] net99 net100 pixRst[49]
+ rowReadON[23] rowReadON[22] rowReadOFF[23] rowReadOFF[22] openDVS_pixel2x2
x377 DiffBn VDD RefrBp GndD GndA PrSFBp OffBn PrBp OnBn pixRst[50] net103 net104 pixRst[51]
+ rowReadON[23] rowReadON[22] rowReadOFF[23] rowReadOFF[22] openDVS_pixel2x2
x378 DiffBn VDD RefrBp GndD GndA PrSFBp OffBn PrBp OnBn pixRst[52] net107 net108 pixRst[53]
+ rowReadON[23] rowReadON[22] rowReadOFF[23] rowReadOFF[22] openDVS_pixel2x2
x379 DiffBn VDD RefrBp GndD GndA PrSFBp OffBn PrBp OnBn pixRst[54] net111 net112 pixRst[55]
+ rowReadON[23] rowReadON[22] rowReadOFF[23] rowReadOFF[22] openDVS_pixel2x2
x380 DiffBn VDD RefrBp GndD GndA PrSFBp OffBn PrBp OnBn pixRst[56] net115 net116 pixRst[57]
+ rowReadON[23] rowReadON[22] rowReadOFF[23] rowReadOFF[22] openDVS_pixel2x2
x381 DiffBn VDD RefrBp GndD GndA PrSFBp OffBn PrBp OnBn pixRst[58] net119 net120 pixRst[59]
+ rowReadON[23] rowReadON[22] rowReadOFF[23] rowReadOFF[22] openDVS_pixel2x2
x382 DiffBn VDD RefrBp GndD GndA PrSFBp OffBn PrBp OnBn pixRst[60] net123 net124 pixRst[61]
+ rowReadON[23] rowReadON[22] rowReadOFF[23] rowReadOFF[22] openDVS_pixel2x2
x383 DiffBn VDD RefrBp GndD GndA PrSFBp OffBn PrBp OnBn pixRst[62] net127 net128 pixRst[63]
+ rowReadON[23] rowReadON[22] rowReadOFF[23] rowReadOFF[22] openDVS_pixel2x2
x384 DiffBn VDD RefrBp GndD GndA PrSFBp OffBn PrBp OnBn pixRst[0] net3 net4 pixRst[1] rowReadON[25]
+ rowReadON[24] rowReadOFF[25] rowReadOFF[24] openDVS_pixel2x2
x385 DiffBn VDD RefrBp GndD GndA PrSFBp OffBn PrBp OnBn pixRst[2] net7 net8 pixRst[3] rowReadON[25]
+ rowReadON[24] rowReadOFF[25] rowReadOFF[24] openDVS_pixel2x2
x386 DiffBn VDD RefrBp GndD GndA PrSFBp OffBn PrBp OnBn pixRst[4] net11 net12 pixRst[5]
+ rowReadON[25] rowReadON[24] rowReadOFF[25] rowReadOFF[24] openDVS_pixel2x2
x387 DiffBn VDD RefrBp GndD GndA PrSFBp OffBn PrBp OnBn pixRst[6] net15 net16 pixRst[7]
+ rowReadON[25] rowReadON[24] rowReadOFF[25] rowReadOFF[24] openDVS_pixel2x2
x388 DiffBn VDD RefrBp GndD GndA PrSFBp OffBn PrBp OnBn pixRst[8] net19 net20 pixRst[9]
+ rowReadON[25] rowReadON[24] rowReadOFF[25] rowReadOFF[24] openDVS_pixel2x2
x389 DiffBn VDD RefrBp GndD GndA PrSFBp OffBn PrBp OnBn pixRst[10] net23 net24 pixRst[11]
+ rowReadON[25] rowReadON[24] rowReadOFF[25] rowReadOFF[24] openDVS_pixel2x2
x390 DiffBn VDD RefrBp GndD GndA PrSFBp OffBn PrBp OnBn pixRst[12] net27 net28 pixRst[13]
+ rowReadON[25] rowReadON[24] rowReadOFF[25] rowReadOFF[24] openDVS_pixel2x2
x391 DiffBn VDD RefrBp GndD GndA PrSFBp OffBn PrBp OnBn pixRst[14] net31 net32 pixRst[15]
+ rowReadON[25] rowReadON[24] rowReadOFF[25] rowReadOFF[24] openDVS_pixel2x2
x392 DiffBn VDD RefrBp GndD GndA PrSFBp OffBn PrBp OnBn pixRst[16] net35 net36 pixRst[17]
+ rowReadON[25] rowReadON[24] rowReadOFF[25] rowReadOFF[24] openDVS_pixel2x2
x393 DiffBn VDD RefrBp GndD GndA PrSFBp OffBn PrBp OnBn pixRst[18] net39 net40 pixRst[19]
+ rowReadON[25] rowReadON[24] rowReadOFF[25] rowReadOFF[24] openDVS_pixel2x2
x394 DiffBn VDD RefrBp GndD GndA PrSFBp OffBn PrBp OnBn pixRst[20] net43 net44 pixRst[21]
+ rowReadON[25] rowReadON[24] rowReadOFF[25] rowReadOFF[24] openDVS_pixel2x2
x395 DiffBn VDD RefrBp GndD GndA PrSFBp OffBn PrBp OnBn pixRst[22] net47 net48 pixRst[23]
+ rowReadON[25] rowReadON[24] rowReadOFF[25] rowReadOFF[24] openDVS_pixel2x2
x396 DiffBn VDD RefrBp GndD GndA PrSFBp OffBn PrBp OnBn pixRst[24] net51 net52 pixRst[25]
+ rowReadON[25] rowReadON[24] rowReadOFF[25] rowReadOFF[24] openDVS_pixel2x2
x397 DiffBn VDD RefrBp GndD GndA PrSFBp OffBn PrBp OnBn pixRst[26] net55 net56 pixRst[27]
+ rowReadON[25] rowReadON[24] rowReadOFF[25] rowReadOFF[24] openDVS_pixel2x2
x398 DiffBn VDD RefrBp GndD GndA PrSFBp OffBn PrBp OnBn pixRst[28] net59 net60 pixRst[29]
+ rowReadON[25] rowReadON[24] rowReadOFF[25] rowReadOFF[24] openDVS_pixel2x2
x399 DiffBn VDD RefrBp GndD GndA PrSFBp OffBn PrBp OnBn pixRst[30] net63 net64 pixRst[31]
+ rowReadON[25] rowReadON[24] rowReadOFF[25] rowReadOFF[24] openDVS_pixel2x2
x400 DiffBn VDD RefrBp GndD GndA PrSFBp OffBn PrBp OnBn pixRst[32] net67 net68 pixRst[33]
+ rowReadON[25] rowReadON[24] rowReadOFF[25] rowReadOFF[24] openDVS_pixel2x2
x401 DiffBn VDD RefrBp GndD GndA PrSFBp OffBn PrBp OnBn pixRst[34] net71 net72 pixRst[35]
+ rowReadON[25] rowReadON[24] rowReadOFF[25] rowReadOFF[24] openDVS_pixel2x2
x402 DiffBn VDD RefrBp GndD GndA PrSFBp OffBn PrBp OnBn pixRst[36] net75 net76 pixRst[37]
+ rowReadON[25] rowReadON[24] rowReadOFF[25] rowReadOFF[24] openDVS_pixel2x2
x403 DiffBn VDD RefrBp GndD GndA PrSFBp OffBn PrBp OnBn pixRst[38] net79 net80 pixRst[39]
+ rowReadON[25] rowReadON[24] rowReadOFF[25] rowReadOFF[24] openDVS_pixel2x2
x404 DiffBn VDD RefrBp GndD GndA PrSFBp OffBn PrBp OnBn pixRst[40] net83 net84 pixRst[41]
+ rowReadON[25] rowReadON[24] rowReadOFF[25] rowReadOFF[24] openDVS_pixel2x2
x405 DiffBn VDD RefrBp GndD GndA PrSFBp OffBn PrBp OnBn pixRst[42] net87 net88 pixRst[43]
+ rowReadON[25] rowReadON[24] rowReadOFF[25] rowReadOFF[24] openDVS_pixel2x2
x406 DiffBn VDD RefrBp GndD GndA PrSFBp OffBn PrBp OnBn pixRst[44] net91 net92 pixRst[45]
+ rowReadON[25] rowReadON[24] rowReadOFF[25] rowReadOFF[24] openDVS_pixel2x2
x407 DiffBn VDD RefrBp GndD GndA PrSFBp OffBn PrBp OnBn pixRst[46] net95 net96 pixRst[47]
+ rowReadON[25] rowReadON[24] rowReadOFF[25] rowReadOFF[24] openDVS_pixel2x2
x408 DiffBn VDD RefrBp GndD GndA PrSFBp OffBn PrBp OnBn pixRst[48] net99 net100 pixRst[49]
+ rowReadON[25] rowReadON[24] rowReadOFF[25] rowReadOFF[24] openDVS_pixel2x2
x409 DiffBn VDD RefrBp GndD GndA PrSFBp OffBn PrBp OnBn pixRst[50] net103 net104 pixRst[51]
+ rowReadON[25] rowReadON[24] rowReadOFF[25] rowReadOFF[24] openDVS_pixel2x2
x410 DiffBn VDD RefrBp GndD GndA PrSFBp OffBn PrBp OnBn pixRst[52] net107 net108 pixRst[53]
+ rowReadON[25] rowReadON[24] rowReadOFF[25] rowReadOFF[24] openDVS_pixel2x2
x411 DiffBn VDD RefrBp GndD GndA PrSFBp OffBn PrBp OnBn pixRst[54] net111 net112 pixRst[55]
+ rowReadON[25] rowReadON[24] rowReadOFF[25] rowReadOFF[24] openDVS_pixel2x2
x412 DiffBn VDD RefrBp GndD GndA PrSFBp OffBn PrBp OnBn pixRst[56] net115 net116 pixRst[57]
+ rowReadON[25] rowReadON[24] rowReadOFF[25] rowReadOFF[24] openDVS_pixel2x2
x413 DiffBn VDD RefrBp GndD GndA PrSFBp OffBn PrBp OnBn pixRst[58] net119 net120 pixRst[59]
+ rowReadON[25] rowReadON[24] rowReadOFF[25] rowReadOFF[24] openDVS_pixel2x2
x414 DiffBn VDD RefrBp GndD GndA PrSFBp OffBn PrBp OnBn pixRst[60] net123 net124 pixRst[61]
+ rowReadON[25] rowReadON[24] rowReadOFF[25] rowReadOFF[24] openDVS_pixel2x2
x415 DiffBn VDD RefrBp GndD GndA PrSFBp OffBn PrBp OnBn pixRst[62] net127 net128 pixRst[63]
+ rowReadON[25] rowReadON[24] rowReadOFF[25] rowReadOFF[24] openDVS_pixel2x2
x416 DiffBn VDD RefrBp GndD GndA PrSFBp OffBn PrBp OnBn pixRst[0] net3 net4 pixRst[1] rowReadON[27]
+ rowReadON[26] rowReadOFF[27] rowReadOFF[26] openDVS_pixel2x2
x417 DiffBn VDD RefrBp GndD GndA PrSFBp OffBn PrBp OnBn pixRst[2] net7 net8 pixRst[3] rowReadON[27]
+ rowReadON[26] rowReadOFF[27] rowReadOFF[26] openDVS_pixel2x2
x418 DiffBn VDD RefrBp GndD GndA PrSFBp OffBn PrBp OnBn pixRst[4] net11 net12 pixRst[5]
+ rowReadON[27] rowReadON[26] rowReadOFF[27] rowReadOFF[26] openDVS_pixel2x2
x419 DiffBn VDD RefrBp GndD GndA PrSFBp OffBn PrBp OnBn pixRst[6] net15 net16 pixRst[7]
+ rowReadON[27] rowReadON[26] rowReadOFF[27] rowReadOFF[26] openDVS_pixel2x2
x420 DiffBn VDD RefrBp GndD GndA PrSFBp OffBn PrBp OnBn pixRst[8] net19 net20 pixRst[9]
+ rowReadON[27] rowReadON[26] rowReadOFF[27] rowReadOFF[26] openDVS_pixel2x2
x421 DiffBn VDD RefrBp GndD GndA PrSFBp OffBn PrBp OnBn pixRst[10] net23 net24 pixRst[11]
+ rowReadON[27] rowReadON[26] rowReadOFF[27] rowReadOFF[26] openDVS_pixel2x2
x422 DiffBn VDD RefrBp GndD GndA PrSFBp OffBn PrBp OnBn pixRst[12] net27 net28 pixRst[13]
+ rowReadON[27] rowReadON[26] rowReadOFF[27] rowReadOFF[26] openDVS_pixel2x2
x423 DiffBn VDD RefrBp GndD GndA PrSFBp OffBn PrBp OnBn pixRst[14] net31 net32 pixRst[15]
+ rowReadON[27] rowReadON[26] rowReadOFF[27] rowReadOFF[26] openDVS_pixel2x2
x424 DiffBn VDD RefrBp GndD GndA PrSFBp OffBn PrBp OnBn pixRst[16] net35 net36 pixRst[17]
+ rowReadON[27] rowReadON[26] rowReadOFF[27] rowReadOFF[26] openDVS_pixel2x2
x425 DiffBn VDD RefrBp GndD GndA PrSFBp OffBn PrBp OnBn pixRst[18] net39 net40 pixRst[19]
+ rowReadON[27] rowReadON[26] rowReadOFF[27] rowReadOFF[26] openDVS_pixel2x2
x426 DiffBn VDD RefrBp GndD GndA PrSFBp OffBn PrBp OnBn pixRst[20] net43 net44 pixRst[21]
+ rowReadON[27] rowReadON[26] rowReadOFF[27] rowReadOFF[26] openDVS_pixel2x2
x427 DiffBn VDD RefrBp GndD GndA PrSFBp OffBn PrBp OnBn pixRst[22] net47 net48 pixRst[23]
+ rowReadON[27] rowReadON[26] rowReadOFF[27] rowReadOFF[26] openDVS_pixel2x2
x428 DiffBn VDD RefrBp GndD GndA PrSFBp OffBn PrBp OnBn pixRst[24] net51 net52 pixRst[25]
+ rowReadON[27] rowReadON[26] rowReadOFF[27] rowReadOFF[26] openDVS_pixel2x2
x429 DiffBn VDD RefrBp GndD GndA PrSFBp OffBn PrBp OnBn pixRst[26] net55 net56 pixRst[27]
+ rowReadON[27] rowReadON[26] rowReadOFF[27] rowReadOFF[26] openDVS_pixel2x2
x430 DiffBn VDD RefrBp GndD GndA PrSFBp OffBn PrBp OnBn pixRst[28] net59 net60 pixRst[29]
+ rowReadON[27] rowReadON[26] rowReadOFF[27] rowReadOFF[26] openDVS_pixel2x2
x431 DiffBn VDD RefrBp GndD GndA PrSFBp OffBn PrBp OnBn pixRst[30] net63 net64 pixRst[31]
+ rowReadON[27] rowReadON[26] rowReadOFF[27] rowReadOFF[26] openDVS_pixel2x2
x432 DiffBn VDD RefrBp GndD GndA PrSFBp OffBn PrBp OnBn pixRst[32] net67 net68 pixRst[33]
+ rowReadON[27] rowReadON[26] rowReadOFF[27] rowReadOFF[26] openDVS_pixel2x2
x433 DiffBn VDD RefrBp GndD GndA PrSFBp OffBn PrBp OnBn pixRst[34] net71 net72 pixRst[35]
+ rowReadON[27] rowReadON[26] rowReadOFF[27] rowReadOFF[26] openDVS_pixel2x2
x434 DiffBn VDD RefrBp GndD GndA PrSFBp OffBn PrBp OnBn pixRst[36] net75 net76 pixRst[37]
+ rowReadON[27] rowReadON[26] rowReadOFF[27] rowReadOFF[26] openDVS_pixel2x2
x435 DiffBn VDD RefrBp GndD GndA PrSFBp OffBn PrBp OnBn pixRst[38] net79 net80 pixRst[39]
+ rowReadON[27] rowReadON[26] rowReadOFF[27] rowReadOFF[26] openDVS_pixel2x2
x436 DiffBn VDD RefrBp GndD GndA PrSFBp OffBn PrBp OnBn pixRst[40] net83 net84 pixRst[41]
+ rowReadON[27] rowReadON[26] rowReadOFF[27] rowReadOFF[26] openDVS_pixel2x2
x437 DiffBn VDD RefrBp GndD GndA PrSFBp OffBn PrBp OnBn pixRst[42] net87 net88 pixRst[43]
+ rowReadON[27] rowReadON[26] rowReadOFF[27] rowReadOFF[26] openDVS_pixel2x2
x438 DiffBn VDD RefrBp GndD GndA PrSFBp OffBn PrBp OnBn pixRst[44] net91 net92 pixRst[45]
+ rowReadON[27] rowReadON[26] rowReadOFF[27] rowReadOFF[26] openDVS_pixel2x2
x439 DiffBn VDD RefrBp GndD GndA PrSFBp OffBn PrBp OnBn pixRst[46] net95 net96 pixRst[47]
+ rowReadON[27] rowReadON[26] rowReadOFF[27] rowReadOFF[26] openDVS_pixel2x2
x440 DiffBn VDD RefrBp GndD GndA PrSFBp OffBn PrBp OnBn pixRst[48] net99 net100 pixRst[49]
+ rowReadON[27] rowReadON[26] rowReadOFF[27] rowReadOFF[26] openDVS_pixel2x2
x441 DiffBn VDD RefrBp GndD GndA PrSFBp OffBn PrBp OnBn pixRst[50] net103 net104 pixRst[51]
+ rowReadON[27] rowReadON[26] rowReadOFF[27] rowReadOFF[26] openDVS_pixel2x2
x442 DiffBn VDD RefrBp GndD GndA PrSFBp OffBn PrBp OnBn pixRst[52] net107 net108 pixRst[53]
+ rowReadON[27] rowReadON[26] rowReadOFF[27] rowReadOFF[26] openDVS_pixel2x2
x443 DiffBn VDD RefrBp GndD GndA PrSFBp OffBn PrBp OnBn pixRst[54] net111 net112 pixRst[55]
+ rowReadON[27] rowReadON[26] rowReadOFF[27] rowReadOFF[26] openDVS_pixel2x2
x444 DiffBn VDD RefrBp GndD GndA PrSFBp OffBn PrBp OnBn pixRst[56] net115 net116 pixRst[57]
+ rowReadON[27] rowReadON[26] rowReadOFF[27] rowReadOFF[26] openDVS_pixel2x2
x445 DiffBn VDD RefrBp GndD GndA PrSFBp OffBn PrBp OnBn pixRst[58] net119 net120 pixRst[59]
+ rowReadON[27] rowReadON[26] rowReadOFF[27] rowReadOFF[26] openDVS_pixel2x2
x446 DiffBn VDD RefrBp GndD GndA PrSFBp OffBn PrBp OnBn pixRst[60] net123 net124 pixRst[61]
+ rowReadON[27] rowReadON[26] rowReadOFF[27] rowReadOFF[26] openDVS_pixel2x2
x447 DiffBn VDD RefrBp GndD GndA PrSFBp OffBn PrBp OnBn pixRst[62] net127 net128 pixRst[63]
+ rowReadON[27] rowReadON[26] rowReadOFF[27] rowReadOFF[26] openDVS_pixel2x2
x448 DiffBn VDD RefrBp GndD GndA PrSFBp OffBn PrBp OnBn pixRst[0] net3 net4 pixRst[1] rowReadON[29]
+ rowReadON[28] rowReadOFF[29] rowReadOFF[28] openDVS_pixel2x2
x449 DiffBn VDD RefrBp GndD GndA PrSFBp OffBn PrBp OnBn pixRst[2] net7 net8 pixRst[3] rowReadON[29]
+ rowReadON[28] rowReadOFF[29] rowReadOFF[28] openDVS_pixel2x2
x450 DiffBn VDD RefrBp GndD GndA PrSFBp OffBn PrBp OnBn pixRst[4] net11 net12 pixRst[5]
+ rowReadON[29] rowReadON[28] rowReadOFF[29] rowReadOFF[28] openDVS_pixel2x2
x451 DiffBn VDD RefrBp GndD GndA PrSFBp OffBn PrBp OnBn pixRst[6] net15 net16 pixRst[7]
+ rowReadON[29] rowReadON[28] rowReadOFF[29] rowReadOFF[28] openDVS_pixel2x2
x452 DiffBn VDD RefrBp GndD GndA PrSFBp OffBn PrBp OnBn pixRst[8] net19 net20 pixRst[9]
+ rowReadON[29] rowReadON[28] rowReadOFF[29] rowReadOFF[28] openDVS_pixel2x2
x453 DiffBn VDD RefrBp GndD GndA PrSFBp OffBn PrBp OnBn pixRst[10] net23 net24 pixRst[11]
+ rowReadON[29] rowReadON[28] rowReadOFF[29] rowReadOFF[28] openDVS_pixel2x2
x454 DiffBn VDD RefrBp GndD GndA PrSFBp OffBn PrBp OnBn pixRst[12] net27 net28 pixRst[13]
+ rowReadON[29] rowReadON[28] rowReadOFF[29] rowReadOFF[28] openDVS_pixel2x2
x455 DiffBn VDD RefrBp GndD GndA PrSFBp OffBn PrBp OnBn pixRst[14] net31 net32 pixRst[15]
+ rowReadON[29] rowReadON[28] rowReadOFF[29] rowReadOFF[28] openDVS_pixel2x2
x456 DiffBn VDD RefrBp GndD GndA PrSFBp OffBn PrBp OnBn pixRst[16] net35 net36 pixRst[17]
+ rowReadON[29] rowReadON[28] rowReadOFF[29] rowReadOFF[28] openDVS_pixel2x2
x457 DiffBn VDD RefrBp GndD GndA PrSFBp OffBn PrBp OnBn pixRst[18] net39 net40 pixRst[19]
+ rowReadON[29] rowReadON[28] rowReadOFF[29] rowReadOFF[28] openDVS_pixel2x2
x458 DiffBn VDD RefrBp GndD GndA PrSFBp OffBn PrBp OnBn pixRst[20] net43 net44 pixRst[21]
+ rowReadON[29] rowReadON[28] rowReadOFF[29] rowReadOFF[28] openDVS_pixel2x2
x459 DiffBn VDD RefrBp GndD GndA PrSFBp OffBn PrBp OnBn pixRst[22] net47 net48 pixRst[23]
+ rowReadON[29] rowReadON[28] rowReadOFF[29] rowReadOFF[28] openDVS_pixel2x2
x460 DiffBn VDD RefrBp GndD GndA PrSFBp OffBn PrBp OnBn pixRst[24] net51 net52 pixRst[25]
+ rowReadON[29] rowReadON[28] rowReadOFF[29] rowReadOFF[28] openDVS_pixel2x2
x461 DiffBn VDD RefrBp GndD GndA PrSFBp OffBn PrBp OnBn pixRst[26] net55 net56 pixRst[27]
+ rowReadON[29] rowReadON[28] rowReadOFF[29] rowReadOFF[28] openDVS_pixel2x2
x462 DiffBn VDD RefrBp GndD GndA PrSFBp OffBn PrBp OnBn pixRst[28] net59 net60 pixRst[29]
+ rowReadON[29] rowReadON[28] rowReadOFF[29] rowReadOFF[28] openDVS_pixel2x2
x463 DiffBn VDD RefrBp GndD GndA PrSFBp OffBn PrBp OnBn pixRst[30] net63 net64 pixRst[31]
+ rowReadON[29] rowReadON[28] rowReadOFF[29] rowReadOFF[28] openDVS_pixel2x2
x464 DiffBn VDD RefrBp GndD GndA PrSFBp OffBn PrBp OnBn pixRst[32] net67 net68 pixRst[33]
+ rowReadON[29] rowReadON[28] rowReadOFF[29] rowReadOFF[28] openDVS_pixel2x2
x465 DiffBn VDD RefrBp GndD GndA PrSFBp OffBn PrBp OnBn pixRst[34] net71 net72 pixRst[35]
+ rowReadON[29] rowReadON[28] rowReadOFF[29] rowReadOFF[28] openDVS_pixel2x2
x466 DiffBn VDD RefrBp GndD GndA PrSFBp OffBn PrBp OnBn pixRst[36] net75 net76 pixRst[37]
+ rowReadON[29] rowReadON[28] rowReadOFF[29] rowReadOFF[28] openDVS_pixel2x2
x467 DiffBn VDD RefrBp GndD GndA PrSFBp OffBn PrBp OnBn pixRst[38] net79 net80 pixRst[39]
+ rowReadON[29] rowReadON[28] rowReadOFF[29] rowReadOFF[28] openDVS_pixel2x2
x468 DiffBn VDD RefrBp GndD GndA PrSFBp OffBn PrBp OnBn pixRst[40] net83 net84 pixRst[41]
+ rowReadON[29] rowReadON[28] rowReadOFF[29] rowReadOFF[28] openDVS_pixel2x2
x469 DiffBn VDD RefrBp GndD GndA PrSFBp OffBn PrBp OnBn pixRst[42] net87 net88 pixRst[43]
+ rowReadON[29] rowReadON[28] rowReadOFF[29] rowReadOFF[28] openDVS_pixel2x2
x470 DiffBn VDD RefrBp GndD GndA PrSFBp OffBn PrBp OnBn pixRst[44] net91 net92 pixRst[45]
+ rowReadON[29] rowReadON[28] rowReadOFF[29] rowReadOFF[28] openDVS_pixel2x2
x471 DiffBn VDD RefrBp GndD GndA PrSFBp OffBn PrBp OnBn pixRst[46] net95 net96 pixRst[47]
+ rowReadON[29] rowReadON[28] rowReadOFF[29] rowReadOFF[28] openDVS_pixel2x2
x472 DiffBn VDD RefrBp GndD GndA PrSFBp OffBn PrBp OnBn pixRst[48] net99 net100 pixRst[49]
+ rowReadON[29] rowReadON[28] rowReadOFF[29] rowReadOFF[28] openDVS_pixel2x2
x473 DiffBn VDD RefrBp GndD GndA PrSFBp OffBn PrBp OnBn pixRst[50] net103 net104 pixRst[51]
+ rowReadON[29] rowReadON[28] rowReadOFF[29] rowReadOFF[28] openDVS_pixel2x2
x474 DiffBn VDD RefrBp GndD GndA PrSFBp OffBn PrBp OnBn pixRst[52] net107 net108 pixRst[53]
+ rowReadON[29] rowReadON[28] rowReadOFF[29] rowReadOFF[28] openDVS_pixel2x2
x475 DiffBn VDD RefrBp GndD GndA PrSFBp OffBn PrBp OnBn pixRst[54] net111 net112 pixRst[55]
+ rowReadON[29] rowReadON[28] rowReadOFF[29] rowReadOFF[28] openDVS_pixel2x2
x476 DiffBn VDD RefrBp GndD GndA PrSFBp OffBn PrBp OnBn pixRst[56] net115 net116 pixRst[57]
+ rowReadON[29] rowReadON[28] rowReadOFF[29] rowReadOFF[28] openDVS_pixel2x2
x477 DiffBn VDD RefrBp GndD GndA PrSFBp OffBn PrBp OnBn pixRst[58] net119 net120 pixRst[59]
+ rowReadON[29] rowReadON[28] rowReadOFF[29] rowReadOFF[28] openDVS_pixel2x2
x478 DiffBn VDD RefrBp GndD GndA PrSFBp OffBn PrBp OnBn pixRst[60] net123 net124 pixRst[61]
+ rowReadON[29] rowReadON[28] rowReadOFF[29] rowReadOFF[28] openDVS_pixel2x2
x479 DiffBn VDD RefrBp GndD GndA PrSFBp OffBn PrBp OnBn pixRst[62] net127 net128 pixRst[63]
+ rowReadON[29] rowReadON[28] rowReadOFF[29] rowReadOFF[28] openDVS_pixel2x2
x480 DiffBn VDD RefrBp GndD GndA PrSFBp OffBn PrBp OnBn pixRst[0] net3 net4 pixRst[1] rowReadON[31]
+ rowReadON[30] rowReadOFF[31] rowReadOFF[30] openDVS_pixel2x2
x481 DiffBn VDD RefrBp GndD GndA PrSFBp OffBn PrBp OnBn pixRst[2] net7 net8 pixRst[3] rowReadON[31]
+ rowReadON[30] rowReadOFF[31] rowReadOFF[30] openDVS_pixel2x2
x482 DiffBn VDD RefrBp GndD GndA PrSFBp OffBn PrBp OnBn pixRst[4] net11 net12 pixRst[5]
+ rowReadON[31] rowReadON[30] rowReadOFF[31] rowReadOFF[30] openDVS_pixel2x2
x483 DiffBn VDD RefrBp GndD GndA PrSFBp OffBn PrBp OnBn pixRst[6] net15 net16 pixRst[7]
+ rowReadON[31] rowReadON[30] rowReadOFF[31] rowReadOFF[30] openDVS_pixel2x2
x484 DiffBn VDD RefrBp GndD GndA PrSFBp OffBn PrBp OnBn pixRst[8] net19 net20 pixRst[9]
+ rowReadON[31] rowReadON[30] rowReadOFF[31] rowReadOFF[30] openDVS_pixel2x2
x485 DiffBn VDD RefrBp GndD GndA PrSFBp OffBn PrBp OnBn pixRst[10] net23 net24 pixRst[11]
+ rowReadON[31] rowReadON[30] rowReadOFF[31] rowReadOFF[30] openDVS_pixel2x2
x486 DiffBn VDD RefrBp GndD GndA PrSFBp OffBn PrBp OnBn pixRst[12] net27 net28 pixRst[13]
+ rowReadON[31] rowReadON[30] rowReadOFF[31] rowReadOFF[30] openDVS_pixel2x2
x487 DiffBn VDD RefrBp GndD GndA PrSFBp OffBn PrBp OnBn pixRst[14] net31 net32 pixRst[15]
+ rowReadON[31] rowReadON[30] rowReadOFF[31] rowReadOFF[30] openDVS_pixel2x2
x488 DiffBn VDD RefrBp GndD GndA PrSFBp OffBn PrBp OnBn pixRst[16] net35 net36 pixRst[17]
+ rowReadON[31] rowReadON[30] rowReadOFF[31] rowReadOFF[30] openDVS_pixel2x2
x489 DiffBn VDD RefrBp GndD GndA PrSFBp OffBn PrBp OnBn pixRst[18] net39 net40 pixRst[19]
+ rowReadON[31] rowReadON[30] rowReadOFF[31] rowReadOFF[30] openDVS_pixel2x2
x490 DiffBn VDD RefrBp GndD GndA PrSFBp OffBn PrBp OnBn pixRst[20] net43 net44 pixRst[21]
+ rowReadON[31] rowReadON[30] rowReadOFF[31] rowReadOFF[30] openDVS_pixel2x2
x491 DiffBn VDD RefrBp GndD GndA PrSFBp OffBn PrBp OnBn pixRst[22] net47 net48 pixRst[23]
+ rowReadON[31] rowReadON[30] rowReadOFF[31] rowReadOFF[30] openDVS_pixel2x2
x492 DiffBn VDD RefrBp GndD GndA PrSFBp OffBn PrBp OnBn pixRst[24] net51 net52 pixRst[25]
+ rowReadON[31] rowReadON[30] rowReadOFF[31] rowReadOFF[30] openDVS_pixel2x2
x493 DiffBn VDD RefrBp GndD GndA PrSFBp OffBn PrBp OnBn pixRst[26] net55 net56 pixRst[27]
+ rowReadON[31] rowReadON[30] rowReadOFF[31] rowReadOFF[30] openDVS_pixel2x2
x494 DiffBn VDD RefrBp GndD GndA PrSFBp OffBn PrBp OnBn pixRst[28] net59 net60 pixRst[29]
+ rowReadON[31] rowReadON[30] rowReadOFF[31] rowReadOFF[30] openDVS_pixel2x2
x495 DiffBn VDD RefrBp GndD GndA PrSFBp OffBn PrBp OnBn pixRst[30] net63 net64 pixRst[31]
+ rowReadON[31] rowReadON[30] rowReadOFF[31] rowReadOFF[30] openDVS_pixel2x2
x496 DiffBn VDD RefrBp GndD GndA PrSFBp OffBn PrBp OnBn pixRst[32] net67 net68 pixRst[33]
+ rowReadON[31] rowReadON[30] rowReadOFF[31] rowReadOFF[30] openDVS_pixel2x2
x497 DiffBn VDD RefrBp GndD GndA PrSFBp OffBn PrBp OnBn pixRst[34] net71 net72 pixRst[35]
+ rowReadON[31] rowReadON[30] rowReadOFF[31] rowReadOFF[30] openDVS_pixel2x2
x498 DiffBn VDD RefrBp GndD GndA PrSFBp OffBn PrBp OnBn pixRst[36] net75 net76 pixRst[37]
+ rowReadON[31] rowReadON[30] rowReadOFF[31] rowReadOFF[30] openDVS_pixel2x2
x499 DiffBn VDD RefrBp GndD GndA PrSFBp OffBn PrBp OnBn pixRst[38] net79 net80 pixRst[39]
+ rowReadON[31] rowReadON[30] rowReadOFF[31] rowReadOFF[30] openDVS_pixel2x2
x500 DiffBn VDD RefrBp GndD GndA PrSFBp OffBn PrBp OnBn pixRst[40] net83 net84 pixRst[41]
+ rowReadON[31] rowReadON[30] rowReadOFF[31] rowReadOFF[30] openDVS_pixel2x2
x501 DiffBn VDD RefrBp GndD GndA PrSFBp OffBn PrBp OnBn pixRst[42] net87 net88 pixRst[43]
+ rowReadON[31] rowReadON[30] rowReadOFF[31] rowReadOFF[30] openDVS_pixel2x2
x502 DiffBn VDD RefrBp GndD GndA PrSFBp OffBn PrBp OnBn pixRst[44] net91 net92 pixRst[45]
+ rowReadON[31] rowReadON[30] rowReadOFF[31] rowReadOFF[30] openDVS_pixel2x2
x503 DiffBn VDD RefrBp GndD GndA PrSFBp OffBn PrBp OnBn pixRst[46] net95 net96 pixRst[47]
+ rowReadON[31] rowReadON[30] rowReadOFF[31] rowReadOFF[30] openDVS_pixel2x2
x504 DiffBn VDD RefrBp GndD GndA PrSFBp OffBn PrBp OnBn pixRst[48] net99 net100 pixRst[49]
+ rowReadON[31] rowReadON[30] rowReadOFF[31] rowReadOFF[30] openDVS_pixel2x2
x505 DiffBn VDD RefrBp GndD GndA PrSFBp OffBn PrBp OnBn pixRst[50] net103 net104 pixRst[51]
+ rowReadON[31] rowReadON[30] rowReadOFF[31] rowReadOFF[30] openDVS_pixel2x2
x506 DiffBn VDD RefrBp GndD GndA PrSFBp OffBn PrBp OnBn pixRst[52] net107 net108 pixRst[53]
+ rowReadON[31] rowReadON[30] rowReadOFF[31] rowReadOFF[30] openDVS_pixel2x2
x507 DiffBn VDD RefrBp GndD GndA PrSFBp OffBn PrBp OnBn pixRst[54] net111 net112 pixRst[55]
+ rowReadON[31] rowReadON[30] rowReadOFF[31] rowReadOFF[30] openDVS_pixel2x2
x508 DiffBn VDD RefrBp GndD GndA PrSFBp OffBn PrBp OnBn pixRst[56] net115 net116 pixRst[57]
+ rowReadON[31] rowReadON[30] rowReadOFF[31] rowReadOFF[30] openDVS_pixel2x2
x509 DiffBn VDD RefrBp GndD GndA PrSFBp OffBn PrBp OnBn pixRst[58] net119 net120 pixRst[59]
+ rowReadON[31] rowReadON[30] rowReadOFF[31] rowReadOFF[30] openDVS_pixel2x2
x510 DiffBn VDD RefrBp GndD GndA PrSFBp OffBn PrBp OnBn pixRst[60] net123 net124 pixRst[61]
+ rowReadON[31] rowReadON[30] rowReadOFF[31] rowReadOFF[30] openDVS_pixel2x2
x511 DiffBn VDD RefrBp GndD GndA PrSFBp OffBn PrBp OnBn pixRst[62] net127 net128 pixRst[63]
+ rowReadON[31] rowReadON[30] rowReadOFF[31] rowReadOFF[30] openDVS_pixel2x2
x512 DiffBn VDD RefrBp GndD GndA PrSFBp OffBn PrBp OnBn pixRst[0] net3 net4 pixRst[1] rowReadON[33]
+ rowReadON[32] rowReadOFF[33] rowReadOFF[32] openDVS_pixel2x2
x513 DiffBn VDD RefrBp GndD GndA PrSFBp OffBn PrBp OnBn pixRst[2] net7 net8 pixRst[3] rowReadON[33]
+ rowReadON[32] rowReadOFF[33] rowReadOFF[32] openDVS_pixel2x2
x514 DiffBn VDD RefrBp GndD GndA PrSFBp OffBn PrBp OnBn pixRst[4] net11 net12 pixRst[5]
+ rowReadON[33] rowReadON[32] rowReadOFF[33] rowReadOFF[32] openDVS_pixel2x2
x515 DiffBn VDD RefrBp GndD GndA PrSFBp OffBn PrBp OnBn pixRst[6] net15 net16 pixRst[7]
+ rowReadON[33] rowReadON[32] rowReadOFF[33] rowReadOFF[32] openDVS_pixel2x2
x516 DiffBn VDD RefrBp GndD GndA PrSFBp OffBn PrBp OnBn pixRst[8] net19 net20 pixRst[9]
+ rowReadON[33] rowReadON[32] rowReadOFF[33] rowReadOFF[32] openDVS_pixel2x2
x517 DiffBn VDD RefrBp GndD GndA PrSFBp OffBn PrBp OnBn pixRst[10] net23 net24 pixRst[11]
+ rowReadON[33] rowReadON[32] rowReadOFF[33] rowReadOFF[32] openDVS_pixel2x2
x518 DiffBn VDD RefrBp GndD GndA PrSFBp OffBn PrBp OnBn pixRst[12] net27 net28 pixRst[13]
+ rowReadON[33] rowReadON[32] rowReadOFF[33] rowReadOFF[32] openDVS_pixel2x2
x519 DiffBn VDD RefrBp GndD GndA PrSFBp OffBn PrBp OnBn pixRst[14] net31 net32 pixRst[15]
+ rowReadON[33] rowReadON[32] rowReadOFF[33] rowReadOFF[32] openDVS_pixel2x2
x520 DiffBn VDD RefrBp GndD GndA PrSFBp OffBn PrBp OnBn pixRst[16] net35 net36 pixRst[17]
+ rowReadON[33] rowReadON[32] rowReadOFF[33] rowReadOFF[32] openDVS_pixel2x2
x521 DiffBn VDD RefrBp GndD GndA PrSFBp OffBn PrBp OnBn pixRst[18] net39 net40 pixRst[19]
+ rowReadON[33] rowReadON[32] rowReadOFF[33] rowReadOFF[32] openDVS_pixel2x2
x522 DiffBn VDD RefrBp GndD GndA PrSFBp OffBn PrBp OnBn pixRst[20] net43 net44 pixRst[21]
+ rowReadON[33] rowReadON[32] rowReadOFF[33] rowReadOFF[32] openDVS_pixel2x2
x523 DiffBn VDD RefrBp GndD GndA PrSFBp OffBn PrBp OnBn pixRst[22] net47 net48 pixRst[23]
+ rowReadON[33] rowReadON[32] rowReadOFF[33] rowReadOFF[32] openDVS_pixel2x2
x524 DiffBn VDD RefrBp GndD GndA PrSFBp OffBn PrBp OnBn pixRst[24] net51 net52 pixRst[25]
+ rowReadON[33] rowReadON[32] rowReadOFF[33] rowReadOFF[32] openDVS_pixel2x2
x525 DiffBn VDD RefrBp GndD GndA PrSFBp OffBn PrBp OnBn pixRst[26] net55 net56 pixRst[27]
+ rowReadON[33] rowReadON[32] rowReadOFF[33] rowReadOFF[32] openDVS_pixel2x2
x526 DiffBn VDD RefrBp GndD GndA PrSFBp OffBn PrBp OnBn pixRst[28] net59 net60 pixRst[29]
+ rowReadON[33] rowReadON[32] rowReadOFF[33] rowReadOFF[32] openDVS_pixel2x2
x527 DiffBn VDD RefrBp GndD GndA PrSFBp OffBn PrBp OnBn pixRst[30] net63 net64 pixRst[31]
+ rowReadON[33] rowReadON[32] rowReadOFF[33] rowReadOFF[32] openDVS_pixel2x2
x528 DiffBn VDD RefrBp GndD GndA PrSFBp OffBn PrBp OnBn pixRst[32] net67 net68 pixRst[33]
+ rowReadON[33] rowReadON[32] rowReadOFF[33] rowReadOFF[32] openDVS_pixel2x2
x529 DiffBn VDD RefrBp GndD GndA PrSFBp OffBn PrBp OnBn pixRst[34] net71 net72 pixRst[35]
+ rowReadON[33] rowReadON[32] rowReadOFF[33] rowReadOFF[32] openDVS_pixel2x2
x530 DiffBn VDD RefrBp GndD GndA PrSFBp OffBn PrBp OnBn pixRst[36] net75 net76 pixRst[37]
+ rowReadON[33] rowReadON[32] rowReadOFF[33] rowReadOFF[32] openDVS_pixel2x2
x531 DiffBn VDD RefrBp GndD GndA PrSFBp OffBn PrBp OnBn pixRst[38] net79 net80 pixRst[39]
+ rowReadON[33] rowReadON[32] rowReadOFF[33] rowReadOFF[32] openDVS_pixel2x2
x532 DiffBn VDD RefrBp GndD GndA PrSFBp OffBn PrBp OnBn pixRst[40] net83 net84 pixRst[41]
+ rowReadON[33] rowReadON[32] rowReadOFF[33] rowReadOFF[32] openDVS_pixel2x2
x533 DiffBn VDD RefrBp GndD GndA PrSFBp OffBn PrBp OnBn pixRst[42] net87 net88 pixRst[43]
+ rowReadON[33] rowReadON[32] rowReadOFF[33] rowReadOFF[32] openDVS_pixel2x2
x534 DiffBn VDD RefrBp GndD GndA PrSFBp OffBn PrBp OnBn pixRst[44] net91 net92 pixRst[45]
+ rowReadON[33] rowReadON[32] rowReadOFF[33] rowReadOFF[32] openDVS_pixel2x2
x535 DiffBn VDD RefrBp GndD GndA PrSFBp OffBn PrBp OnBn pixRst[46] net95 net96 pixRst[47]
+ rowReadON[33] rowReadON[32] rowReadOFF[33] rowReadOFF[32] openDVS_pixel2x2
x536 DiffBn VDD RefrBp GndD GndA PrSFBp OffBn PrBp OnBn pixRst[48] net99 net100 pixRst[49]
+ rowReadON[33] rowReadON[32] rowReadOFF[33] rowReadOFF[32] openDVS_pixel2x2
x537 DiffBn VDD RefrBp GndD GndA PrSFBp OffBn PrBp OnBn pixRst[50] net103 net104 pixRst[51]
+ rowReadON[33] rowReadON[32] rowReadOFF[33] rowReadOFF[32] openDVS_pixel2x2
x538 DiffBn VDD RefrBp GndD GndA PrSFBp OffBn PrBp OnBn pixRst[52] net107 net108 pixRst[53]
+ rowReadON[33] rowReadON[32] rowReadOFF[33] rowReadOFF[32] openDVS_pixel2x2
x539 DiffBn VDD RefrBp GndD GndA PrSFBp OffBn PrBp OnBn pixRst[54] net111 net112 pixRst[55]
+ rowReadON[33] rowReadON[32] rowReadOFF[33] rowReadOFF[32] openDVS_pixel2x2
x540 DiffBn VDD RefrBp GndD GndA PrSFBp OffBn PrBp OnBn pixRst[56] net115 net116 pixRst[57]
+ rowReadON[33] rowReadON[32] rowReadOFF[33] rowReadOFF[32] openDVS_pixel2x2
x541 DiffBn VDD RefrBp GndD GndA PrSFBp OffBn PrBp OnBn pixRst[58] net119 net120 pixRst[59]
+ rowReadON[33] rowReadON[32] rowReadOFF[33] rowReadOFF[32] openDVS_pixel2x2
x542 DiffBn VDD RefrBp GndD GndA PrSFBp OffBn PrBp OnBn pixRst[60] net123 net124 pixRst[61]
+ rowReadON[33] rowReadON[32] rowReadOFF[33] rowReadOFF[32] openDVS_pixel2x2
x543 DiffBn VDD RefrBp GndD GndA PrSFBp OffBn PrBp OnBn pixRst[62] net127 net128 pixRst[63]
+ rowReadON[33] rowReadON[32] rowReadOFF[33] rowReadOFF[32] openDVS_pixel2x2
x544 DiffBn VDD RefrBp GndD GndA PrSFBp OffBn PrBp OnBn pixRst[0] net3 net4 pixRst[1] rowReadON[35]
+ rowReadON[34] rowReadOFF[35] rowReadOFF[34] openDVS_pixel2x2
x545 DiffBn VDD RefrBp GndD GndA PrSFBp OffBn PrBp OnBn pixRst[2] net7 net8 pixRst[3] rowReadON[35]
+ rowReadON[34] rowReadOFF[35] rowReadOFF[34] openDVS_pixel2x2
x546 DiffBn VDD RefrBp GndD GndA PrSFBp OffBn PrBp OnBn pixRst[4] net11 net12 pixRst[5]
+ rowReadON[35] rowReadON[34] rowReadOFF[35] rowReadOFF[34] openDVS_pixel2x2
x547 DiffBn VDD RefrBp GndD GndA PrSFBp OffBn PrBp OnBn pixRst[6] net15 net16 pixRst[7]
+ rowReadON[35] rowReadON[34] rowReadOFF[35] rowReadOFF[34] openDVS_pixel2x2
x548 DiffBn VDD RefrBp GndD GndA PrSFBp OffBn PrBp OnBn pixRst[8] net19 net20 pixRst[9]
+ rowReadON[35] rowReadON[34] rowReadOFF[35] rowReadOFF[34] openDVS_pixel2x2
x549 DiffBn VDD RefrBp GndD GndA PrSFBp OffBn PrBp OnBn pixRst[10] net23 net24 pixRst[11]
+ rowReadON[35] rowReadON[34] rowReadOFF[35] rowReadOFF[34] openDVS_pixel2x2
x550 DiffBn VDD RefrBp GndD GndA PrSFBp OffBn PrBp OnBn pixRst[12] net27 net28 pixRst[13]
+ rowReadON[35] rowReadON[34] rowReadOFF[35] rowReadOFF[34] openDVS_pixel2x2
x551 DiffBn VDD RefrBp GndD GndA PrSFBp OffBn PrBp OnBn pixRst[14] net31 net32 pixRst[15]
+ rowReadON[35] rowReadON[34] rowReadOFF[35] rowReadOFF[34] openDVS_pixel2x2
x552 DiffBn VDD RefrBp GndD GndA PrSFBp OffBn PrBp OnBn pixRst[16] net35 net36 pixRst[17]
+ rowReadON[35] rowReadON[34] rowReadOFF[35] rowReadOFF[34] openDVS_pixel2x2
x553 DiffBn VDD RefrBp GndD GndA PrSFBp OffBn PrBp OnBn pixRst[18] net39 net40 pixRst[19]
+ rowReadON[35] rowReadON[34] rowReadOFF[35] rowReadOFF[34] openDVS_pixel2x2
x554 DiffBn VDD RefrBp GndD GndA PrSFBp OffBn PrBp OnBn pixRst[20] net43 net44 pixRst[21]
+ rowReadON[35] rowReadON[34] rowReadOFF[35] rowReadOFF[34] openDVS_pixel2x2
x555 DiffBn VDD RefrBp GndD GndA PrSFBp OffBn PrBp OnBn pixRst[22] net47 net48 pixRst[23]
+ rowReadON[35] rowReadON[34] rowReadOFF[35] rowReadOFF[34] openDVS_pixel2x2
x556 DiffBn VDD RefrBp GndD GndA PrSFBp OffBn PrBp OnBn pixRst[24] net51 net52 pixRst[25]
+ rowReadON[35] rowReadON[34] rowReadOFF[35] rowReadOFF[34] openDVS_pixel2x2
x557 DiffBn VDD RefrBp GndD GndA PrSFBp OffBn PrBp OnBn pixRst[26] net55 net56 pixRst[27]
+ rowReadON[35] rowReadON[34] rowReadOFF[35] rowReadOFF[34] openDVS_pixel2x2
x558 DiffBn VDD RefrBp GndD GndA PrSFBp OffBn PrBp OnBn pixRst[28] net59 net60 pixRst[29]
+ rowReadON[35] rowReadON[34] rowReadOFF[35] rowReadOFF[34] openDVS_pixel2x2
x559 DiffBn VDD RefrBp GndD GndA PrSFBp OffBn PrBp OnBn pixRst[30] net63 net64 pixRst[31]
+ rowReadON[35] rowReadON[34] rowReadOFF[35] rowReadOFF[34] openDVS_pixel2x2
x560 DiffBn VDD RefrBp GndD GndA PrSFBp OffBn PrBp OnBn pixRst[32] net67 net68 pixRst[33]
+ rowReadON[35] rowReadON[34] rowReadOFF[35] rowReadOFF[34] openDVS_pixel2x2
x561 DiffBn VDD RefrBp GndD GndA PrSFBp OffBn PrBp OnBn pixRst[34] net71 net72 pixRst[35]
+ rowReadON[35] rowReadON[34] rowReadOFF[35] rowReadOFF[34] openDVS_pixel2x2
x562 DiffBn VDD RefrBp GndD GndA PrSFBp OffBn PrBp OnBn pixRst[36] net75 net76 pixRst[37]
+ rowReadON[35] rowReadON[34] rowReadOFF[35] rowReadOFF[34] openDVS_pixel2x2
x563 DiffBn VDD RefrBp GndD GndA PrSFBp OffBn PrBp OnBn pixRst[38] net79 net80 pixRst[39]
+ rowReadON[35] rowReadON[34] rowReadOFF[35] rowReadOFF[34] openDVS_pixel2x2
x564 DiffBn VDD RefrBp GndD GndA PrSFBp OffBn PrBp OnBn pixRst[40] net83 net84 pixRst[41]
+ rowReadON[35] rowReadON[34] rowReadOFF[35] rowReadOFF[34] openDVS_pixel2x2
x565 DiffBn VDD RefrBp GndD GndA PrSFBp OffBn PrBp OnBn pixRst[42] net87 net88 pixRst[43]
+ rowReadON[35] rowReadON[34] rowReadOFF[35] rowReadOFF[34] openDVS_pixel2x2
x566 DiffBn VDD RefrBp GndD GndA PrSFBp OffBn PrBp OnBn pixRst[44] net91 net92 pixRst[45]
+ rowReadON[35] rowReadON[34] rowReadOFF[35] rowReadOFF[34] openDVS_pixel2x2
x567 DiffBn VDD RefrBp GndD GndA PrSFBp OffBn PrBp OnBn pixRst[46] net95 net96 pixRst[47]
+ rowReadON[35] rowReadON[34] rowReadOFF[35] rowReadOFF[34] openDVS_pixel2x2
x568 DiffBn VDD RefrBp GndD GndA PrSFBp OffBn PrBp OnBn pixRst[48] net99 net100 pixRst[49]
+ rowReadON[35] rowReadON[34] rowReadOFF[35] rowReadOFF[34] openDVS_pixel2x2
x569 DiffBn VDD RefrBp GndD GndA PrSFBp OffBn PrBp OnBn pixRst[50] net103 net104 pixRst[51]
+ rowReadON[35] rowReadON[34] rowReadOFF[35] rowReadOFF[34] openDVS_pixel2x2
x570 DiffBn VDD RefrBp GndD GndA PrSFBp OffBn PrBp OnBn pixRst[52] net107 net108 pixRst[53]
+ rowReadON[35] rowReadON[34] rowReadOFF[35] rowReadOFF[34] openDVS_pixel2x2
x571 DiffBn VDD RefrBp GndD GndA PrSFBp OffBn PrBp OnBn pixRst[54] net111 net112 pixRst[55]
+ rowReadON[35] rowReadON[34] rowReadOFF[35] rowReadOFF[34] openDVS_pixel2x2
x572 DiffBn VDD RefrBp GndD GndA PrSFBp OffBn PrBp OnBn pixRst[56] net115 net116 pixRst[57]
+ rowReadON[35] rowReadON[34] rowReadOFF[35] rowReadOFF[34] openDVS_pixel2x2
x573 DiffBn VDD RefrBp GndD GndA PrSFBp OffBn PrBp OnBn pixRst[58] net119 net120 pixRst[59]
+ rowReadON[35] rowReadON[34] rowReadOFF[35] rowReadOFF[34] openDVS_pixel2x2
x574 DiffBn VDD RefrBp GndD GndA PrSFBp OffBn PrBp OnBn pixRst[60] net123 net124 pixRst[61]
+ rowReadON[35] rowReadON[34] rowReadOFF[35] rowReadOFF[34] openDVS_pixel2x2
x575 DiffBn VDD RefrBp GndD GndA PrSFBp OffBn PrBp OnBn pixRst[62] net127 net128 pixRst[63]
+ rowReadON[35] rowReadON[34] rowReadOFF[35] rowReadOFF[34] openDVS_pixel2x2
x576 DiffBn VDD RefrBp GndD GndA PrSFBp OffBn PrBp OnBn pixRst[0] net3 net4 pixRst[1] rowReadON[37]
+ rowReadON[36] rowReadOFF[37] rowReadOFF[36] openDVS_pixel2x2
x577 DiffBn VDD RefrBp GndD GndA PrSFBp OffBn PrBp OnBn pixRst[2] net7 net8 pixRst[3] rowReadON[37]
+ rowReadON[36] rowReadOFF[37] rowReadOFF[36] openDVS_pixel2x2
x578 DiffBn VDD RefrBp GndD GndA PrSFBp OffBn PrBp OnBn pixRst[4] net11 net12 pixRst[5]
+ rowReadON[37] rowReadON[36] rowReadOFF[37] rowReadOFF[36] openDVS_pixel2x2
x579 DiffBn VDD RefrBp GndD GndA PrSFBp OffBn PrBp OnBn pixRst[6] net15 net16 pixRst[7]
+ rowReadON[37] rowReadON[36] rowReadOFF[37] rowReadOFF[36] openDVS_pixel2x2
x580 DiffBn VDD RefrBp GndD GndA PrSFBp OffBn PrBp OnBn pixRst[8] net19 net20 pixRst[9]
+ rowReadON[37] rowReadON[36] rowReadOFF[37] rowReadOFF[36] openDVS_pixel2x2
x581 DiffBn VDD RefrBp GndD GndA PrSFBp OffBn PrBp OnBn pixRst[10] net23 net24 pixRst[11]
+ rowReadON[37] rowReadON[36] rowReadOFF[37] rowReadOFF[36] openDVS_pixel2x2
x582 DiffBn VDD RefrBp GndD GndA PrSFBp OffBn PrBp OnBn pixRst[12] net27 net28 pixRst[13]
+ rowReadON[37] rowReadON[36] rowReadOFF[37] rowReadOFF[36] openDVS_pixel2x2
x583 DiffBn VDD RefrBp GndD GndA PrSFBp OffBn PrBp OnBn pixRst[14] net31 net32 pixRst[15]
+ rowReadON[37] rowReadON[36] rowReadOFF[37] rowReadOFF[36] openDVS_pixel2x2
x584 DiffBn VDD RefrBp GndD GndA PrSFBp OffBn PrBp OnBn pixRst[16] net35 net36 pixRst[17]
+ rowReadON[37] rowReadON[36] rowReadOFF[37] rowReadOFF[36] openDVS_pixel2x2
x585 DiffBn VDD RefrBp GndD GndA PrSFBp OffBn PrBp OnBn pixRst[18] net39 net40 pixRst[19]
+ rowReadON[37] rowReadON[36] rowReadOFF[37] rowReadOFF[36] openDVS_pixel2x2
x586 DiffBn VDD RefrBp GndD GndA PrSFBp OffBn PrBp OnBn pixRst[20] net43 net44 pixRst[21]
+ rowReadON[37] rowReadON[36] rowReadOFF[37] rowReadOFF[36] openDVS_pixel2x2
x587 DiffBn VDD RefrBp GndD GndA PrSFBp OffBn PrBp OnBn pixRst[22] net47 net48 pixRst[23]
+ rowReadON[37] rowReadON[36] rowReadOFF[37] rowReadOFF[36] openDVS_pixel2x2
x588 DiffBn VDD RefrBp GndD GndA PrSFBp OffBn PrBp OnBn pixRst[24] net51 net52 pixRst[25]
+ rowReadON[37] rowReadON[36] rowReadOFF[37] rowReadOFF[36] openDVS_pixel2x2
x589 DiffBn VDD RefrBp GndD GndA PrSFBp OffBn PrBp OnBn pixRst[26] net55 net56 pixRst[27]
+ rowReadON[37] rowReadON[36] rowReadOFF[37] rowReadOFF[36] openDVS_pixel2x2
x590 DiffBn VDD RefrBp GndD GndA PrSFBp OffBn PrBp OnBn pixRst[28] net59 net60 pixRst[29]
+ rowReadON[37] rowReadON[36] rowReadOFF[37] rowReadOFF[36] openDVS_pixel2x2
x591 DiffBn VDD RefrBp GndD GndA PrSFBp OffBn PrBp OnBn pixRst[30] net63 net64 pixRst[31]
+ rowReadON[37] rowReadON[36] rowReadOFF[37] rowReadOFF[36] openDVS_pixel2x2
x592 DiffBn VDD RefrBp GndD GndA PrSFBp OffBn PrBp OnBn pixRst[32] net67 net68 pixRst[33]
+ rowReadON[37] rowReadON[36] rowReadOFF[37] rowReadOFF[36] openDVS_pixel2x2
x593 DiffBn VDD RefrBp GndD GndA PrSFBp OffBn PrBp OnBn pixRst[34] net71 net72 pixRst[35]
+ rowReadON[37] rowReadON[36] rowReadOFF[37] rowReadOFF[36] openDVS_pixel2x2
x594 DiffBn VDD RefrBp GndD GndA PrSFBp OffBn PrBp OnBn pixRst[36] net75 net76 pixRst[37]
+ rowReadON[37] rowReadON[36] rowReadOFF[37] rowReadOFF[36] openDVS_pixel2x2
x595 DiffBn VDD RefrBp GndD GndA PrSFBp OffBn PrBp OnBn pixRst[38] net79 net80 pixRst[39]
+ rowReadON[37] rowReadON[36] rowReadOFF[37] rowReadOFF[36] openDVS_pixel2x2
x596 DiffBn VDD RefrBp GndD GndA PrSFBp OffBn PrBp OnBn pixRst[40] net83 net84 pixRst[41]
+ rowReadON[37] rowReadON[36] rowReadOFF[37] rowReadOFF[36] openDVS_pixel2x2
x597 DiffBn VDD RefrBp GndD GndA PrSFBp OffBn PrBp OnBn pixRst[42] net87 net88 pixRst[43]
+ rowReadON[37] rowReadON[36] rowReadOFF[37] rowReadOFF[36] openDVS_pixel2x2
x598 DiffBn VDD RefrBp GndD GndA PrSFBp OffBn PrBp OnBn pixRst[44] net91 net92 pixRst[45]
+ rowReadON[37] rowReadON[36] rowReadOFF[37] rowReadOFF[36] openDVS_pixel2x2
x599 DiffBn VDD RefrBp GndD GndA PrSFBp OffBn PrBp OnBn pixRst[46] net95 net96 pixRst[47]
+ rowReadON[37] rowReadON[36] rowReadOFF[37] rowReadOFF[36] openDVS_pixel2x2
x600 DiffBn VDD RefrBp GndD GndA PrSFBp OffBn PrBp OnBn pixRst[48] net99 net100 pixRst[49]
+ rowReadON[37] rowReadON[36] rowReadOFF[37] rowReadOFF[36] openDVS_pixel2x2
x601 DiffBn VDD RefrBp GndD GndA PrSFBp OffBn PrBp OnBn pixRst[50] net103 net104 pixRst[51]
+ rowReadON[37] rowReadON[36] rowReadOFF[37] rowReadOFF[36] openDVS_pixel2x2
x602 DiffBn VDD RefrBp GndD GndA PrSFBp OffBn PrBp OnBn pixRst[52] net107 net108 pixRst[53]
+ rowReadON[37] rowReadON[36] rowReadOFF[37] rowReadOFF[36] openDVS_pixel2x2
x603 DiffBn VDD RefrBp GndD GndA PrSFBp OffBn PrBp OnBn pixRst[54] net111 net112 pixRst[55]
+ rowReadON[37] rowReadON[36] rowReadOFF[37] rowReadOFF[36] openDVS_pixel2x2
x604 DiffBn VDD RefrBp GndD GndA PrSFBp OffBn PrBp OnBn pixRst[56] net115 net116 pixRst[57]
+ rowReadON[37] rowReadON[36] rowReadOFF[37] rowReadOFF[36] openDVS_pixel2x2
x605 DiffBn VDD RefrBp GndD GndA PrSFBp OffBn PrBp OnBn pixRst[58] net119 net120 pixRst[59]
+ rowReadON[37] rowReadON[36] rowReadOFF[37] rowReadOFF[36] openDVS_pixel2x2
x606 DiffBn VDD RefrBp GndD GndA PrSFBp OffBn PrBp OnBn pixRst[60] net123 net124 pixRst[61]
+ rowReadON[37] rowReadON[36] rowReadOFF[37] rowReadOFF[36] openDVS_pixel2x2
x607 DiffBn VDD RefrBp GndD GndA PrSFBp OffBn PrBp OnBn pixRst[62] net127 net128 pixRst[63]
+ rowReadON[37] rowReadON[36] rowReadOFF[37] rowReadOFF[36] openDVS_pixel2x2
x608 DiffBn VDD RefrBp GndD GndA PrSFBp OffBn PrBp OnBn pixRst[0] net3 net4 pixRst[1] rowReadON[39]
+ rowReadON[38] rowReadOFF[39] rowReadOFF[38] openDVS_pixel2x2
x609 DiffBn VDD RefrBp GndD GndA PrSFBp OffBn PrBp OnBn pixRst[2] net7 net8 pixRst[3] rowReadON[39]
+ rowReadON[38] rowReadOFF[39] rowReadOFF[38] openDVS_pixel2x2
x610 DiffBn VDD RefrBp GndD GndA PrSFBp OffBn PrBp OnBn pixRst[4] net11 net12 pixRst[5]
+ rowReadON[39] rowReadON[38] rowReadOFF[39] rowReadOFF[38] openDVS_pixel2x2
x611 DiffBn VDD RefrBp GndD GndA PrSFBp OffBn PrBp OnBn pixRst[6] net15 net16 pixRst[7]
+ rowReadON[39] rowReadON[38] rowReadOFF[39] rowReadOFF[38] openDVS_pixel2x2
x612 DiffBn VDD RefrBp GndD GndA PrSFBp OffBn PrBp OnBn pixRst[8] net19 net20 pixRst[9]
+ rowReadON[39] rowReadON[38] rowReadOFF[39] rowReadOFF[38] openDVS_pixel2x2
x613 DiffBn VDD RefrBp GndD GndA PrSFBp OffBn PrBp OnBn pixRst[10] net23 net24 pixRst[11]
+ rowReadON[39] rowReadON[38] rowReadOFF[39] rowReadOFF[38] openDVS_pixel2x2
x614 DiffBn VDD RefrBp GndD GndA PrSFBp OffBn PrBp OnBn pixRst[12] net27 net28 pixRst[13]
+ rowReadON[39] rowReadON[38] rowReadOFF[39] rowReadOFF[38] openDVS_pixel2x2
x615 DiffBn VDD RefrBp GndD GndA PrSFBp OffBn PrBp OnBn pixRst[14] net31 net32 pixRst[15]
+ rowReadON[39] rowReadON[38] rowReadOFF[39] rowReadOFF[38] openDVS_pixel2x2
x616 DiffBn VDD RefrBp GndD GndA PrSFBp OffBn PrBp OnBn pixRst[16] net35 net36 pixRst[17]
+ rowReadON[39] rowReadON[38] rowReadOFF[39] rowReadOFF[38] openDVS_pixel2x2
x617 DiffBn VDD RefrBp GndD GndA PrSFBp OffBn PrBp OnBn pixRst[18] net39 net40 pixRst[19]
+ rowReadON[39] rowReadON[38] rowReadOFF[39] rowReadOFF[38] openDVS_pixel2x2
x618 DiffBn VDD RefrBp GndD GndA PrSFBp OffBn PrBp OnBn pixRst[20] net43 net44 pixRst[21]
+ rowReadON[39] rowReadON[38] rowReadOFF[39] rowReadOFF[38] openDVS_pixel2x2
x619 DiffBn VDD RefrBp GndD GndA PrSFBp OffBn PrBp OnBn pixRst[22] net47 net48 pixRst[23]
+ rowReadON[39] rowReadON[38] rowReadOFF[39] rowReadOFF[38] openDVS_pixel2x2
x620 DiffBn VDD RefrBp GndD GndA PrSFBp OffBn PrBp OnBn pixRst[24] net51 net52 pixRst[25]
+ rowReadON[39] rowReadON[38] rowReadOFF[39] rowReadOFF[38] openDVS_pixel2x2
x621 DiffBn VDD RefrBp GndD GndA PrSFBp OffBn PrBp OnBn pixRst[26] net55 net56 pixRst[27]
+ rowReadON[39] rowReadON[38] rowReadOFF[39] rowReadOFF[38] openDVS_pixel2x2
x622 DiffBn VDD RefrBp GndD GndA PrSFBp OffBn PrBp OnBn pixRst[28] net59 net60 pixRst[29]
+ rowReadON[39] rowReadON[38] rowReadOFF[39] rowReadOFF[38] openDVS_pixel2x2
x623 DiffBn VDD RefrBp GndD GndA PrSFBp OffBn PrBp OnBn pixRst[30] net63 net64 pixRst[31]
+ rowReadON[39] rowReadON[38] rowReadOFF[39] rowReadOFF[38] openDVS_pixel2x2
x624 DiffBn VDD RefrBp GndD GndA PrSFBp OffBn PrBp OnBn pixRst[32] net67 net68 pixRst[33]
+ rowReadON[39] rowReadON[38] rowReadOFF[39] rowReadOFF[38] openDVS_pixel2x2
x625 DiffBn VDD RefrBp GndD GndA PrSFBp OffBn PrBp OnBn pixRst[34] net71 net72 pixRst[35]
+ rowReadON[39] rowReadON[38] rowReadOFF[39] rowReadOFF[38] openDVS_pixel2x2
x626 DiffBn VDD RefrBp GndD GndA PrSFBp OffBn PrBp OnBn pixRst[36] net75 net76 pixRst[37]
+ rowReadON[39] rowReadON[38] rowReadOFF[39] rowReadOFF[38] openDVS_pixel2x2
x627 DiffBn VDD RefrBp GndD GndA PrSFBp OffBn PrBp OnBn pixRst[38] net79 net80 pixRst[39]
+ rowReadON[39] rowReadON[38] rowReadOFF[39] rowReadOFF[38] openDVS_pixel2x2
x628 DiffBn VDD RefrBp GndD GndA PrSFBp OffBn PrBp OnBn pixRst[40] net83 net84 pixRst[41]
+ rowReadON[39] rowReadON[38] rowReadOFF[39] rowReadOFF[38] openDVS_pixel2x2
x629 DiffBn VDD RefrBp GndD GndA PrSFBp OffBn PrBp OnBn pixRst[42] net87 net88 pixRst[43]
+ rowReadON[39] rowReadON[38] rowReadOFF[39] rowReadOFF[38] openDVS_pixel2x2
x630 DiffBn VDD RefrBp GndD GndA PrSFBp OffBn PrBp OnBn pixRst[44] net91 net92 pixRst[45]
+ rowReadON[39] rowReadON[38] rowReadOFF[39] rowReadOFF[38] openDVS_pixel2x2
x631 DiffBn VDD RefrBp GndD GndA PrSFBp OffBn PrBp OnBn pixRst[46] net95 net96 pixRst[47]
+ rowReadON[39] rowReadON[38] rowReadOFF[39] rowReadOFF[38] openDVS_pixel2x2
x632 DiffBn VDD RefrBp GndD GndA PrSFBp OffBn PrBp OnBn pixRst[48] net99 net100 pixRst[49]
+ rowReadON[39] rowReadON[38] rowReadOFF[39] rowReadOFF[38] openDVS_pixel2x2
x633 DiffBn VDD RefrBp GndD GndA PrSFBp OffBn PrBp OnBn pixRst[50] net103 net104 pixRst[51]
+ rowReadON[39] rowReadON[38] rowReadOFF[39] rowReadOFF[38] openDVS_pixel2x2
x634 DiffBn VDD RefrBp GndD GndA PrSFBp OffBn PrBp OnBn pixRst[52] net107 net108 pixRst[53]
+ rowReadON[39] rowReadON[38] rowReadOFF[39] rowReadOFF[38] openDVS_pixel2x2
x635 DiffBn VDD RefrBp GndD GndA PrSFBp OffBn PrBp OnBn pixRst[54] net111 net112 pixRst[55]
+ rowReadON[39] rowReadON[38] rowReadOFF[39] rowReadOFF[38] openDVS_pixel2x2
x636 DiffBn VDD RefrBp GndD GndA PrSFBp OffBn PrBp OnBn pixRst[56] net115 net116 pixRst[57]
+ rowReadON[39] rowReadON[38] rowReadOFF[39] rowReadOFF[38] openDVS_pixel2x2
x637 DiffBn VDD RefrBp GndD GndA PrSFBp OffBn PrBp OnBn pixRst[58] net119 net120 pixRst[59]
+ rowReadON[39] rowReadON[38] rowReadOFF[39] rowReadOFF[38] openDVS_pixel2x2
x638 DiffBn VDD RefrBp GndD GndA PrSFBp OffBn PrBp OnBn pixRst[60] net123 net124 pixRst[61]
+ rowReadON[39] rowReadON[38] rowReadOFF[39] rowReadOFF[38] openDVS_pixel2x2
x639 DiffBn VDD RefrBp GndD GndA PrSFBp OffBn PrBp OnBn pixRst[62] net127 net128 pixRst[63]
+ rowReadON[39] rowReadON[38] rowReadOFF[39] rowReadOFF[38] openDVS_pixel2x2
x640 DiffBn VDD RefrBp GndD GndA PrSFBp OffBn PrBp OnBn pixRst[0] net3 net4 pixRst[1] rowReadON[41]
+ rowReadON[40] rowReadOFF[41] rowReadOFF[40] openDVS_pixel2x2
x641 DiffBn VDD RefrBp GndD GndA PrSFBp OffBn PrBp OnBn pixRst[2] net7 net8 pixRst[3] rowReadON[41]
+ rowReadON[40] rowReadOFF[41] rowReadOFF[40] openDVS_pixel2x2
x642 DiffBn VDD RefrBp GndD GndA PrSFBp OffBn PrBp OnBn pixRst[4] net11 net12 pixRst[5]
+ rowReadON[41] rowReadON[40] rowReadOFF[41] rowReadOFF[40] openDVS_pixel2x2
x643 DiffBn VDD RefrBp GndD GndA PrSFBp OffBn PrBp OnBn pixRst[6] net15 net16 pixRst[7]
+ rowReadON[41] rowReadON[40] rowReadOFF[41] rowReadOFF[40] openDVS_pixel2x2
x644 DiffBn VDD RefrBp GndD GndA PrSFBp OffBn PrBp OnBn pixRst[8] net19 net20 pixRst[9]
+ rowReadON[41] rowReadON[40] rowReadOFF[41] rowReadOFF[40] openDVS_pixel2x2
x645 DiffBn VDD RefrBp GndD GndA PrSFBp OffBn PrBp OnBn pixRst[10] net23 net24 pixRst[11]
+ rowReadON[41] rowReadON[40] rowReadOFF[41] rowReadOFF[40] openDVS_pixel2x2
x646 DiffBn VDD RefrBp GndD GndA PrSFBp OffBn PrBp OnBn pixRst[12] net27 net28 pixRst[13]
+ rowReadON[41] rowReadON[40] rowReadOFF[41] rowReadOFF[40] openDVS_pixel2x2
x647 DiffBn VDD RefrBp GndD GndA PrSFBp OffBn PrBp OnBn pixRst[14] net31 net32 pixRst[15]
+ rowReadON[41] rowReadON[40] rowReadOFF[41] rowReadOFF[40] openDVS_pixel2x2
x648 DiffBn VDD RefrBp GndD GndA PrSFBp OffBn PrBp OnBn pixRst[16] net35 net36 pixRst[17]
+ rowReadON[41] rowReadON[40] rowReadOFF[41] rowReadOFF[40] openDVS_pixel2x2
x649 DiffBn VDD RefrBp GndD GndA PrSFBp OffBn PrBp OnBn pixRst[18] net39 net40 pixRst[19]
+ rowReadON[41] rowReadON[40] rowReadOFF[41] rowReadOFF[40] openDVS_pixel2x2
x650 DiffBn VDD RefrBp GndD GndA PrSFBp OffBn PrBp OnBn pixRst[20] net43 net44 pixRst[21]
+ rowReadON[41] rowReadON[40] rowReadOFF[41] rowReadOFF[40] openDVS_pixel2x2
x651 DiffBn VDD RefrBp GndD GndA PrSFBp OffBn PrBp OnBn pixRst[22] net47 net48 pixRst[23]
+ rowReadON[41] rowReadON[40] rowReadOFF[41] rowReadOFF[40] openDVS_pixel2x2
x652 DiffBn VDD RefrBp GndD GndA PrSFBp OffBn PrBp OnBn pixRst[24] net51 net52 pixRst[25]
+ rowReadON[41] rowReadON[40] rowReadOFF[41] rowReadOFF[40] openDVS_pixel2x2
x653 DiffBn VDD RefrBp GndD GndA PrSFBp OffBn PrBp OnBn pixRst[26] net55 net56 pixRst[27]
+ rowReadON[41] rowReadON[40] rowReadOFF[41] rowReadOFF[40] openDVS_pixel2x2
x654 DiffBn VDD RefrBp GndD GndA PrSFBp OffBn PrBp OnBn pixRst[28] net59 net60 pixRst[29]
+ rowReadON[41] rowReadON[40] rowReadOFF[41] rowReadOFF[40] openDVS_pixel2x2
x655 DiffBn VDD RefrBp GndD GndA PrSFBp OffBn PrBp OnBn pixRst[30] net63 net64 pixRst[31]
+ rowReadON[41] rowReadON[40] rowReadOFF[41] rowReadOFF[40] openDVS_pixel2x2
x656 DiffBn VDD RefrBp GndD GndA PrSFBp OffBn PrBp OnBn pixRst[32] net67 net68 pixRst[33]
+ rowReadON[41] rowReadON[40] rowReadOFF[41] rowReadOFF[40] openDVS_pixel2x2
x657 DiffBn VDD RefrBp GndD GndA PrSFBp OffBn PrBp OnBn pixRst[34] net71 net72 pixRst[35]
+ rowReadON[41] rowReadON[40] rowReadOFF[41] rowReadOFF[40] openDVS_pixel2x2
x658 DiffBn VDD RefrBp GndD GndA PrSFBp OffBn PrBp OnBn pixRst[36] net75 net76 pixRst[37]
+ rowReadON[41] rowReadON[40] rowReadOFF[41] rowReadOFF[40] openDVS_pixel2x2
x659 DiffBn VDD RefrBp GndD GndA PrSFBp OffBn PrBp OnBn pixRst[38] net79 net80 pixRst[39]
+ rowReadON[41] rowReadON[40] rowReadOFF[41] rowReadOFF[40] openDVS_pixel2x2
x660 DiffBn VDD RefrBp GndD GndA PrSFBp OffBn PrBp OnBn pixRst[40] net83 net84 pixRst[41]
+ rowReadON[41] rowReadON[40] rowReadOFF[41] rowReadOFF[40] openDVS_pixel2x2
x661 DiffBn VDD RefrBp GndD GndA PrSFBp OffBn PrBp OnBn pixRst[42] net87 net88 pixRst[43]
+ rowReadON[41] rowReadON[40] rowReadOFF[41] rowReadOFF[40] openDVS_pixel2x2
x662 DiffBn VDD RefrBp GndD GndA PrSFBp OffBn PrBp OnBn pixRst[44] net91 net92 pixRst[45]
+ rowReadON[41] rowReadON[40] rowReadOFF[41] rowReadOFF[40] openDVS_pixel2x2
x663 DiffBn VDD RefrBp GndD GndA PrSFBp OffBn PrBp OnBn pixRst[46] net95 net96 pixRst[47]
+ rowReadON[41] rowReadON[40] rowReadOFF[41] rowReadOFF[40] openDVS_pixel2x2
x664 DiffBn VDD RefrBp GndD GndA PrSFBp OffBn PrBp OnBn pixRst[48] net99 net100 pixRst[49]
+ rowReadON[41] rowReadON[40] rowReadOFF[41] rowReadOFF[40] openDVS_pixel2x2
x665 DiffBn VDD RefrBp GndD GndA PrSFBp OffBn PrBp OnBn pixRst[50] net103 net104 pixRst[51]
+ rowReadON[41] rowReadON[40] rowReadOFF[41] rowReadOFF[40] openDVS_pixel2x2
x666 DiffBn VDD RefrBp GndD GndA PrSFBp OffBn PrBp OnBn pixRst[52] net107 net108 pixRst[53]
+ rowReadON[41] rowReadON[40] rowReadOFF[41] rowReadOFF[40] openDVS_pixel2x2
x667 DiffBn VDD RefrBp GndD GndA PrSFBp OffBn PrBp OnBn pixRst[54] net111 net112 pixRst[55]
+ rowReadON[41] rowReadON[40] rowReadOFF[41] rowReadOFF[40] openDVS_pixel2x2
x668 DiffBn VDD RefrBp GndD GndA PrSFBp OffBn PrBp OnBn pixRst[56] net115 net116 pixRst[57]
+ rowReadON[41] rowReadON[40] rowReadOFF[41] rowReadOFF[40] openDVS_pixel2x2
x669 DiffBn VDD RefrBp GndD GndA PrSFBp OffBn PrBp OnBn pixRst[58] net119 net120 pixRst[59]
+ rowReadON[41] rowReadON[40] rowReadOFF[41] rowReadOFF[40] openDVS_pixel2x2
x670 DiffBn VDD RefrBp GndD GndA PrSFBp OffBn PrBp OnBn pixRst[60] net123 net124 pixRst[61]
+ rowReadON[41] rowReadON[40] rowReadOFF[41] rowReadOFF[40] openDVS_pixel2x2
x671 DiffBn VDD RefrBp GndD GndA PrSFBp OffBn PrBp OnBn pixRst[62] net127 net128 pixRst[63]
+ rowReadON[41] rowReadON[40] rowReadOFF[41] rowReadOFF[40] openDVS_pixel2x2
x672 DiffBn VDD RefrBp GndD GndA PrSFBp OffBn PrBp OnBn pixRst[0] net3 net4 pixRst[1] rowReadON[43]
+ rowReadON[42] rowReadOFF[43] rowReadOFF[42] openDVS_pixel2x2
x673 DiffBn VDD RefrBp GndD GndA PrSFBp OffBn PrBp OnBn pixRst[2] net7 net8 pixRst[3] rowReadON[43]
+ rowReadON[42] rowReadOFF[43] rowReadOFF[42] openDVS_pixel2x2
x674 DiffBn VDD RefrBp GndD GndA PrSFBp OffBn PrBp OnBn pixRst[4] net11 net12 pixRst[5]
+ rowReadON[43] rowReadON[42] rowReadOFF[43] rowReadOFF[42] openDVS_pixel2x2
x675 DiffBn VDD RefrBp GndD GndA PrSFBp OffBn PrBp OnBn pixRst[6] net15 net16 pixRst[7]
+ rowReadON[43] rowReadON[42] rowReadOFF[43] rowReadOFF[42] openDVS_pixel2x2
x676 DiffBn VDD RefrBp GndD GndA PrSFBp OffBn PrBp OnBn pixRst[8] net19 net20 pixRst[9]
+ rowReadON[43] rowReadON[42] rowReadOFF[43] rowReadOFF[42] openDVS_pixel2x2
x677 DiffBn VDD RefrBp GndD GndA PrSFBp OffBn PrBp OnBn pixRst[10] net23 net24 pixRst[11]
+ rowReadON[43] rowReadON[42] rowReadOFF[43] rowReadOFF[42] openDVS_pixel2x2
x678 DiffBn VDD RefrBp GndD GndA PrSFBp OffBn PrBp OnBn pixRst[12] net27 net28 pixRst[13]
+ rowReadON[43] rowReadON[42] rowReadOFF[43] rowReadOFF[42] openDVS_pixel2x2
x679 DiffBn VDD RefrBp GndD GndA PrSFBp OffBn PrBp OnBn pixRst[14] net31 net32 pixRst[15]
+ rowReadON[43] rowReadON[42] rowReadOFF[43] rowReadOFF[42] openDVS_pixel2x2
x680 DiffBn VDD RefrBp GndD GndA PrSFBp OffBn PrBp OnBn pixRst[16] net35 net36 pixRst[17]
+ rowReadON[43] rowReadON[42] rowReadOFF[43] rowReadOFF[42] openDVS_pixel2x2
x681 DiffBn VDD RefrBp GndD GndA PrSFBp OffBn PrBp OnBn pixRst[18] net39 net40 pixRst[19]
+ rowReadON[43] rowReadON[42] rowReadOFF[43] rowReadOFF[42] openDVS_pixel2x2
x682 DiffBn VDD RefrBp GndD GndA PrSFBp OffBn PrBp OnBn pixRst[20] net43 net44 pixRst[21]
+ rowReadON[43] rowReadON[42] rowReadOFF[43] rowReadOFF[42] openDVS_pixel2x2
x683 DiffBn VDD RefrBp GndD GndA PrSFBp OffBn PrBp OnBn pixRst[22] net47 net48 pixRst[23]
+ rowReadON[43] rowReadON[42] rowReadOFF[43] rowReadOFF[42] openDVS_pixel2x2
x684 DiffBn VDD RefrBp GndD GndA PrSFBp OffBn PrBp OnBn pixRst[24] net51 net52 pixRst[25]
+ rowReadON[43] rowReadON[42] rowReadOFF[43] rowReadOFF[42] openDVS_pixel2x2
x685 DiffBn VDD RefrBp GndD GndA PrSFBp OffBn PrBp OnBn pixRst[26] net55 net56 pixRst[27]
+ rowReadON[43] rowReadON[42] rowReadOFF[43] rowReadOFF[42] openDVS_pixel2x2
x686 DiffBn VDD RefrBp GndD GndA PrSFBp OffBn PrBp OnBn pixRst[28] net59 net60 pixRst[29]
+ rowReadON[43] rowReadON[42] rowReadOFF[43] rowReadOFF[42] openDVS_pixel2x2
x687 DiffBn VDD RefrBp GndD GndA PrSFBp OffBn PrBp OnBn pixRst[30] net63 net64 pixRst[31]
+ rowReadON[43] rowReadON[42] rowReadOFF[43] rowReadOFF[42] openDVS_pixel2x2
x688 DiffBn VDD RefrBp GndD GndA PrSFBp OffBn PrBp OnBn pixRst[32] net67 net68 pixRst[33]
+ rowReadON[43] rowReadON[42] rowReadOFF[43] rowReadOFF[42] openDVS_pixel2x2
x689 DiffBn VDD RefrBp GndD GndA PrSFBp OffBn PrBp OnBn pixRst[34] net71 net72 pixRst[35]
+ rowReadON[43] rowReadON[42] rowReadOFF[43] rowReadOFF[42] openDVS_pixel2x2
x690 DiffBn VDD RefrBp GndD GndA PrSFBp OffBn PrBp OnBn pixRst[36] net75 net76 pixRst[37]
+ rowReadON[43] rowReadON[42] rowReadOFF[43] rowReadOFF[42] openDVS_pixel2x2
x691 DiffBn VDD RefrBp GndD GndA PrSFBp OffBn PrBp OnBn pixRst[38] net79 net80 pixRst[39]
+ rowReadON[43] rowReadON[42] rowReadOFF[43] rowReadOFF[42] openDVS_pixel2x2
x692 DiffBn VDD RefrBp GndD GndA PrSFBp OffBn PrBp OnBn pixRst[40] net83 net84 pixRst[41]
+ rowReadON[43] rowReadON[42] rowReadOFF[43] rowReadOFF[42] openDVS_pixel2x2
x693 DiffBn VDD RefrBp GndD GndA PrSFBp OffBn PrBp OnBn pixRst[42] net87 net88 pixRst[43]
+ rowReadON[43] rowReadON[42] rowReadOFF[43] rowReadOFF[42] openDVS_pixel2x2
x694 DiffBn VDD RefrBp GndD GndA PrSFBp OffBn PrBp OnBn pixRst[44] net91 net92 pixRst[45]
+ rowReadON[43] rowReadON[42] rowReadOFF[43] rowReadOFF[42] openDVS_pixel2x2
x695 DiffBn VDD RefrBp GndD GndA PrSFBp OffBn PrBp OnBn pixRst[46] net95 net96 pixRst[47]
+ rowReadON[43] rowReadON[42] rowReadOFF[43] rowReadOFF[42] openDVS_pixel2x2
x696 DiffBn VDD RefrBp GndD GndA PrSFBp OffBn PrBp OnBn pixRst[48] net99 net100 pixRst[49]
+ rowReadON[43] rowReadON[42] rowReadOFF[43] rowReadOFF[42] openDVS_pixel2x2
x697 DiffBn VDD RefrBp GndD GndA PrSFBp OffBn PrBp OnBn pixRst[50] net103 net104 pixRst[51]
+ rowReadON[43] rowReadON[42] rowReadOFF[43] rowReadOFF[42] openDVS_pixel2x2
x698 DiffBn VDD RefrBp GndD GndA PrSFBp OffBn PrBp OnBn pixRst[52] net107 net108 pixRst[53]
+ rowReadON[43] rowReadON[42] rowReadOFF[43] rowReadOFF[42] openDVS_pixel2x2
x699 DiffBn VDD RefrBp GndD GndA PrSFBp OffBn PrBp OnBn pixRst[54] net111 net112 pixRst[55]
+ rowReadON[43] rowReadON[42] rowReadOFF[43] rowReadOFF[42] openDVS_pixel2x2
x700 DiffBn VDD RefrBp GndD GndA PrSFBp OffBn PrBp OnBn pixRst[56] net115 net116 pixRst[57]
+ rowReadON[43] rowReadON[42] rowReadOFF[43] rowReadOFF[42] openDVS_pixel2x2
x701 DiffBn VDD RefrBp GndD GndA PrSFBp OffBn PrBp OnBn pixRst[58] net119 net120 pixRst[59]
+ rowReadON[43] rowReadON[42] rowReadOFF[43] rowReadOFF[42] openDVS_pixel2x2
x702 DiffBn VDD RefrBp GndD GndA PrSFBp OffBn PrBp OnBn pixRst[60] net123 net124 pixRst[61]
+ rowReadON[43] rowReadON[42] rowReadOFF[43] rowReadOFF[42] openDVS_pixel2x2
x703 DiffBn VDD RefrBp GndD GndA PrSFBp OffBn PrBp OnBn pixRst[62] net127 net128 pixRst[63]
+ rowReadON[43] rowReadON[42] rowReadOFF[43] rowReadOFF[42] openDVS_pixel2x2
x704 DiffBn VDD RefrBp GndD GndA PrSFBp OffBn PrBp OnBn pixRst[0] net3 net4 pixRst[1] rowReadON[45]
+ rowReadON[44] rowReadOFF[45] rowReadOFF[44] openDVS_pixel2x2
x705 DiffBn VDD RefrBp GndD GndA PrSFBp OffBn PrBp OnBn pixRst[2] net7 net8 pixRst[3] rowReadON[45]
+ rowReadON[44] rowReadOFF[45] rowReadOFF[44] openDVS_pixel2x2
x706 DiffBn VDD RefrBp GndD GndA PrSFBp OffBn PrBp OnBn pixRst[4] net11 net12 pixRst[5]
+ rowReadON[45] rowReadON[44] rowReadOFF[45] rowReadOFF[44] openDVS_pixel2x2
x707 DiffBn VDD RefrBp GndD GndA PrSFBp OffBn PrBp OnBn pixRst[6] net15 net16 pixRst[7]
+ rowReadON[45] rowReadON[44] rowReadOFF[45] rowReadOFF[44] openDVS_pixel2x2
x708 DiffBn VDD RefrBp GndD GndA PrSFBp OffBn PrBp OnBn pixRst[8] net19 net20 pixRst[9]
+ rowReadON[45] rowReadON[44] rowReadOFF[45] rowReadOFF[44] openDVS_pixel2x2
x709 DiffBn VDD RefrBp GndD GndA PrSFBp OffBn PrBp OnBn pixRst[10] net23 net24 pixRst[11]
+ rowReadON[45] rowReadON[44] rowReadOFF[45] rowReadOFF[44] openDVS_pixel2x2
x710 DiffBn VDD RefrBp GndD GndA PrSFBp OffBn PrBp OnBn pixRst[12] net27 net28 pixRst[13]
+ rowReadON[45] rowReadON[44] rowReadOFF[45] rowReadOFF[44] openDVS_pixel2x2
x711 DiffBn VDD RefrBp GndD GndA PrSFBp OffBn PrBp OnBn pixRst[14] net31 net32 pixRst[15]
+ rowReadON[45] rowReadON[44] rowReadOFF[45] rowReadOFF[44] openDVS_pixel2x2
x712 DiffBn VDD RefrBp GndD GndA PrSFBp OffBn PrBp OnBn pixRst[16] net35 net36 pixRst[17]
+ rowReadON[45] rowReadON[44] rowReadOFF[45] rowReadOFF[44] openDVS_pixel2x2
x713 DiffBn VDD RefrBp GndD GndA PrSFBp OffBn PrBp OnBn pixRst[18] net39 net40 pixRst[19]
+ rowReadON[45] rowReadON[44] rowReadOFF[45] rowReadOFF[44] openDVS_pixel2x2
x714 DiffBn VDD RefrBp GndD GndA PrSFBp OffBn PrBp OnBn pixRst[20] net43 net44 pixRst[21]
+ rowReadON[45] rowReadON[44] rowReadOFF[45] rowReadOFF[44] openDVS_pixel2x2
x715 DiffBn VDD RefrBp GndD GndA PrSFBp OffBn PrBp OnBn pixRst[22] net47 net48 pixRst[23]
+ rowReadON[45] rowReadON[44] rowReadOFF[45] rowReadOFF[44] openDVS_pixel2x2
x716 DiffBn VDD RefrBp GndD GndA PrSFBp OffBn PrBp OnBn pixRst[24] net51 net52 pixRst[25]
+ rowReadON[45] rowReadON[44] rowReadOFF[45] rowReadOFF[44] openDVS_pixel2x2
x717 DiffBn VDD RefrBp GndD GndA PrSFBp OffBn PrBp OnBn pixRst[26] net55 net56 pixRst[27]
+ rowReadON[45] rowReadON[44] rowReadOFF[45] rowReadOFF[44] openDVS_pixel2x2
x718 DiffBn VDD RefrBp GndD GndA PrSFBp OffBn PrBp OnBn pixRst[28] net59 net60 pixRst[29]
+ rowReadON[45] rowReadON[44] rowReadOFF[45] rowReadOFF[44] openDVS_pixel2x2
x719 DiffBn VDD RefrBp GndD GndA PrSFBp OffBn PrBp OnBn pixRst[30] net63 net64 pixRst[31]
+ rowReadON[45] rowReadON[44] rowReadOFF[45] rowReadOFF[44] openDVS_pixel2x2
x720 DiffBn VDD RefrBp GndD GndA PrSFBp OffBn PrBp OnBn pixRst[32] net67 net68 pixRst[33]
+ rowReadON[45] rowReadON[44] rowReadOFF[45] rowReadOFF[44] openDVS_pixel2x2
x721 DiffBn VDD RefrBp GndD GndA PrSFBp OffBn PrBp OnBn pixRst[34] net71 net72 pixRst[35]
+ rowReadON[45] rowReadON[44] rowReadOFF[45] rowReadOFF[44] openDVS_pixel2x2
x722 DiffBn VDD RefrBp GndD GndA PrSFBp OffBn PrBp OnBn pixRst[36] net75 net76 pixRst[37]
+ rowReadON[45] rowReadON[44] rowReadOFF[45] rowReadOFF[44] openDVS_pixel2x2
x723 DiffBn VDD RefrBp GndD GndA PrSFBp OffBn PrBp OnBn pixRst[38] net79 net80 pixRst[39]
+ rowReadON[45] rowReadON[44] rowReadOFF[45] rowReadOFF[44] openDVS_pixel2x2
x724 DiffBn VDD RefrBp GndD GndA PrSFBp OffBn PrBp OnBn pixRst[40] net83 net84 pixRst[41]
+ rowReadON[45] rowReadON[44] rowReadOFF[45] rowReadOFF[44] openDVS_pixel2x2
x725 DiffBn VDD RefrBp GndD GndA PrSFBp OffBn PrBp OnBn pixRst[42] net87 net88 pixRst[43]
+ rowReadON[45] rowReadON[44] rowReadOFF[45] rowReadOFF[44] openDVS_pixel2x2
x726 DiffBn VDD RefrBp GndD GndA PrSFBp OffBn PrBp OnBn pixRst[44] net91 net92 pixRst[45]
+ rowReadON[45] rowReadON[44] rowReadOFF[45] rowReadOFF[44] openDVS_pixel2x2
x727 DiffBn VDD RefrBp GndD GndA PrSFBp OffBn PrBp OnBn pixRst[46] net95 net96 pixRst[47]
+ rowReadON[45] rowReadON[44] rowReadOFF[45] rowReadOFF[44] openDVS_pixel2x2
x728 DiffBn VDD RefrBp GndD GndA PrSFBp OffBn PrBp OnBn pixRst[48] net99 net100 pixRst[49]
+ rowReadON[45] rowReadON[44] rowReadOFF[45] rowReadOFF[44] openDVS_pixel2x2
x729 DiffBn VDD RefrBp GndD GndA PrSFBp OffBn PrBp OnBn pixRst[50] net103 net104 pixRst[51]
+ rowReadON[45] rowReadON[44] rowReadOFF[45] rowReadOFF[44] openDVS_pixel2x2
x730 DiffBn VDD RefrBp GndD GndA PrSFBp OffBn PrBp OnBn pixRst[52] net107 net108 pixRst[53]
+ rowReadON[45] rowReadON[44] rowReadOFF[45] rowReadOFF[44] openDVS_pixel2x2
x731 DiffBn VDD RefrBp GndD GndA PrSFBp OffBn PrBp OnBn pixRst[54] net111 net112 pixRst[55]
+ rowReadON[45] rowReadON[44] rowReadOFF[45] rowReadOFF[44] openDVS_pixel2x2
x732 DiffBn VDD RefrBp GndD GndA PrSFBp OffBn PrBp OnBn pixRst[56] net115 net116 pixRst[57]
+ rowReadON[45] rowReadON[44] rowReadOFF[45] rowReadOFF[44] openDVS_pixel2x2
x733 DiffBn VDD RefrBp GndD GndA PrSFBp OffBn PrBp OnBn pixRst[58] net119 net120 pixRst[59]
+ rowReadON[45] rowReadON[44] rowReadOFF[45] rowReadOFF[44] openDVS_pixel2x2
x734 DiffBn VDD RefrBp GndD GndA PrSFBp OffBn PrBp OnBn pixRst[60] net123 net124 pixRst[61]
+ rowReadON[45] rowReadON[44] rowReadOFF[45] rowReadOFF[44] openDVS_pixel2x2
x735 DiffBn VDD RefrBp GndD GndA PrSFBp OffBn PrBp OnBn pixRst[62] net127 net128 pixRst[63]
+ rowReadON[45] rowReadON[44] rowReadOFF[45] rowReadOFF[44] openDVS_pixel2x2
x736 DiffBn VDD RefrBp GndD GndA PrSFBp OffBn PrBp OnBn pixRst[0] net3 net4 pixRst[1] rowReadON[47]
+ rowReadON[46] rowReadOFF[47] rowReadOFF[46] openDVS_pixel2x2
x737 DiffBn VDD RefrBp GndD GndA PrSFBp OffBn PrBp OnBn pixRst[2] net7 net8 pixRst[3] rowReadON[47]
+ rowReadON[46] rowReadOFF[47] rowReadOFF[46] openDVS_pixel2x2
x738 DiffBn VDD RefrBp GndD GndA PrSFBp OffBn PrBp OnBn pixRst[4] net11 net12 pixRst[5]
+ rowReadON[47] rowReadON[46] rowReadOFF[47] rowReadOFF[46] openDVS_pixel2x2
x739 DiffBn VDD RefrBp GndD GndA PrSFBp OffBn PrBp OnBn pixRst[6] net15 net16 pixRst[7]
+ rowReadON[47] rowReadON[46] rowReadOFF[47] rowReadOFF[46] openDVS_pixel2x2
x740 DiffBn VDD RefrBp GndD GndA PrSFBp OffBn PrBp OnBn pixRst[8] net19 net20 pixRst[9]
+ rowReadON[47] rowReadON[46] rowReadOFF[47] rowReadOFF[46] openDVS_pixel2x2
x741 DiffBn VDD RefrBp GndD GndA PrSFBp OffBn PrBp OnBn pixRst[10] net23 net24 pixRst[11]
+ rowReadON[47] rowReadON[46] rowReadOFF[47] rowReadOFF[46] openDVS_pixel2x2
x742 DiffBn VDD RefrBp GndD GndA PrSFBp OffBn PrBp OnBn pixRst[12] net27 net28 pixRst[13]
+ rowReadON[47] rowReadON[46] rowReadOFF[47] rowReadOFF[46] openDVS_pixel2x2
x743 DiffBn VDD RefrBp GndD GndA PrSFBp OffBn PrBp OnBn pixRst[14] net31 net32 pixRst[15]
+ rowReadON[47] rowReadON[46] rowReadOFF[47] rowReadOFF[46] openDVS_pixel2x2
x744 DiffBn VDD RefrBp GndD GndA PrSFBp OffBn PrBp OnBn pixRst[16] net35 net36 pixRst[17]
+ rowReadON[47] rowReadON[46] rowReadOFF[47] rowReadOFF[46] openDVS_pixel2x2
x745 DiffBn VDD RefrBp GndD GndA PrSFBp OffBn PrBp OnBn pixRst[18] net39 net40 pixRst[19]
+ rowReadON[47] rowReadON[46] rowReadOFF[47] rowReadOFF[46] openDVS_pixel2x2
x746 DiffBn VDD RefrBp GndD GndA PrSFBp OffBn PrBp OnBn pixRst[20] net43 net44 pixRst[21]
+ rowReadON[47] rowReadON[46] rowReadOFF[47] rowReadOFF[46] openDVS_pixel2x2
x747 DiffBn VDD RefrBp GndD GndA PrSFBp OffBn PrBp OnBn pixRst[22] net47 net48 pixRst[23]
+ rowReadON[47] rowReadON[46] rowReadOFF[47] rowReadOFF[46] openDVS_pixel2x2
x748 DiffBn VDD RefrBp GndD GndA PrSFBp OffBn PrBp OnBn pixRst[24] net51 net52 pixRst[25]
+ rowReadON[47] rowReadON[46] rowReadOFF[47] rowReadOFF[46] openDVS_pixel2x2
x749 DiffBn VDD RefrBp GndD GndA PrSFBp OffBn PrBp OnBn pixRst[26] net55 net56 pixRst[27]
+ rowReadON[47] rowReadON[46] rowReadOFF[47] rowReadOFF[46] openDVS_pixel2x2
x750 DiffBn VDD RefrBp GndD GndA PrSFBp OffBn PrBp OnBn pixRst[28] net59 net60 pixRst[29]
+ rowReadON[47] rowReadON[46] rowReadOFF[47] rowReadOFF[46] openDVS_pixel2x2
x751 DiffBn VDD RefrBp GndD GndA PrSFBp OffBn PrBp OnBn pixRst[30] net63 net64 pixRst[31]
+ rowReadON[47] rowReadON[46] rowReadOFF[47] rowReadOFF[46] openDVS_pixel2x2
x752 DiffBn VDD RefrBp GndD GndA PrSFBp OffBn PrBp OnBn pixRst[32] net67 net68 pixRst[33]
+ rowReadON[47] rowReadON[46] rowReadOFF[47] rowReadOFF[46] openDVS_pixel2x2
x753 DiffBn VDD RefrBp GndD GndA PrSFBp OffBn PrBp OnBn pixRst[34] net71 net72 pixRst[35]
+ rowReadON[47] rowReadON[46] rowReadOFF[47] rowReadOFF[46] openDVS_pixel2x2
x754 DiffBn VDD RefrBp GndD GndA PrSFBp OffBn PrBp OnBn pixRst[36] net75 net76 pixRst[37]
+ rowReadON[47] rowReadON[46] rowReadOFF[47] rowReadOFF[46] openDVS_pixel2x2
x755 DiffBn VDD RefrBp GndD GndA PrSFBp OffBn PrBp OnBn pixRst[38] net79 net80 pixRst[39]
+ rowReadON[47] rowReadON[46] rowReadOFF[47] rowReadOFF[46] openDVS_pixel2x2
x756 DiffBn VDD RefrBp GndD GndA PrSFBp OffBn PrBp OnBn pixRst[40] net83 net84 pixRst[41]
+ rowReadON[47] rowReadON[46] rowReadOFF[47] rowReadOFF[46] openDVS_pixel2x2
x757 DiffBn VDD RefrBp GndD GndA PrSFBp OffBn PrBp OnBn pixRst[42] net87 net88 pixRst[43]
+ rowReadON[47] rowReadON[46] rowReadOFF[47] rowReadOFF[46] openDVS_pixel2x2
x758 DiffBn VDD RefrBp GndD GndA PrSFBp OffBn PrBp OnBn pixRst[44] net91 net92 pixRst[45]
+ rowReadON[47] rowReadON[46] rowReadOFF[47] rowReadOFF[46] openDVS_pixel2x2
x759 DiffBn VDD RefrBp GndD GndA PrSFBp OffBn PrBp OnBn pixRst[46] net95 net96 pixRst[47]
+ rowReadON[47] rowReadON[46] rowReadOFF[47] rowReadOFF[46] openDVS_pixel2x2
x760 DiffBn VDD RefrBp GndD GndA PrSFBp OffBn PrBp OnBn pixRst[48] net99 net100 pixRst[49]
+ rowReadON[47] rowReadON[46] rowReadOFF[47] rowReadOFF[46] openDVS_pixel2x2
x761 DiffBn VDD RefrBp GndD GndA PrSFBp OffBn PrBp OnBn pixRst[50] net103 net104 pixRst[51]
+ rowReadON[47] rowReadON[46] rowReadOFF[47] rowReadOFF[46] openDVS_pixel2x2
x762 DiffBn VDD RefrBp GndD GndA PrSFBp OffBn PrBp OnBn pixRst[52] net107 net108 pixRst[53]
+ rowReadON[47] rowReadON[46] rowReadOFF[47] rowReadOFF[46] openDVS_pixel2x2
x763 DiffBn VDD RefrBp GndD GndA PrSFBp OffBn PrBp OnBn pixRst[54] net111 net112 pixRst[55]
+ rowReadON[47] rowReadON[46] rowReadOFF[47] rowReadOFF[46] openDVS_pixel2x2
x764 DiffBn VDD RefrBp GndD GndA PrSFBp OffBn PrBp OnBn pixRst[56] net115 net116 pixRst[57]
+ rowReadON[47] rowReadON[46] rowReadOFF[47] rowReadOFF[46] openDVS_pixel2x2
x765 DiffBn VDD RefrBp GndD GndA PrSFBp OffBn PrBp OnBn pixRst[58] net119 net120 pixRst[59]
+ rowReadON[47] rowReadON[46] rowReadOFF[47] rowReadOFF[46] openDVS_pixel2x2
x766 DiffBn VDD RefrBp GndD GndA PrSFBp OffBn PrBp OnBn pixRst[60] net123 net124 pixRst[61]
+ rowReadON[47] rowReadON[46] rowReadOFF[47] rowReadOFF[46] openDVS_pixel2x2
x767 DiffBn VDD RefrBp GndD GndA PrSFBp OffBn PrBp OnBn pixRst[62] net127 net128 pixRst[63]
+ rowReadON[47] rowReadON[46] rowReadOFF[47] rowReadOFF[46] openDVS_pixel2x2
x768 DiffBn VDD RefrBp GndD GndA PrSFBp OffBn PrBp OnBn pixRst[0] net3 net4 pixRst[1] rowReadON[49]
+ rowReadON[48] rowReadOFF[49] rowReadOFF[48] openDVS_pixel2x2
x769 DiffBn VDD RefrBp GndD GndA PrSFBp OffBn PrBp OnBn pixRst[2] net7 net8 pixRst[3] rowReadON[49]
+ rowReadON[48] rowReadOFF[49] rowReadOFF[48] openDVS_pixel2x2
x770 DiffBn VDD RefrBp GndD GndA PrSFBp OffBn PrBp OnBn pixRst[4] net11 net12 pixRst[5]
+ rowReadON[49] rowReadON[48] rowReadOFF[49] rowReadOFF[48] openDVS_pixel2x2
x771 DiffBn VDD RefrBp GndD GndA PrSFBp OffBn PrBp OnBn pixRst[6] net15 net16 pixRst[7]
+ rowReadON[49] rowReadON[48] rowReadOFF[49] rowReadOFF[48] openDVS_pixel2x2
x772 DiffBn VDD RefrBp GndD GndA PrSFBp OffBn PrBp OnBn pixRst[8] net19 net20 pixRst[9]
+ rowReadON[49] rowReadON[48] rowReadOFF[49] rowReadOFF[48] openDVS_pixel2x2
x773 DiffBn VDD RefrBp GndD GndA PrSFBp OffBn PrBp OnBn pixRst[10] net23 net24 pixRst[11]
+ rowReadON[49] rowReadON[48] rowReadOFF[49] rowReadOFF[48] openDVS_pixel2x2
x774 DiffBn VDD RefrBp GndD GndA PrSFBp OffBn PrBp OnBn pixRst[12] net27 net28 pixRst[13]
+ rowReadON[49] rowReadON[48] rowReadOFF[49] rowReadOFF[48] openDVS_pixel2x2
x775 DiffBn VDD RefrBp GndD GndA PrSFBp OffBn PrBp OnBn pixRst[14] net31 net32 pixRst[15]
+ rowReadON[49] rowReadON[48] rowReadOFF[49] rowReadOFF[48] openDVS_pixel2x2
x776 DiffBn VDD RefrBp GndD GndA PrSFBp OffBn PrBp OnBn pixRst[16] net35 net36 pixRst[17]
+ rowReadON[49] rowReadON[48] rowReadOFF[49] rowReadOFF[48] openDVS_pixel2x2
x777 DiffBn VDD RefrBp GndD GndA PrSFBp OffBn PrBp OnBn pixRst[18] net39 net40 pixRst[19]
+ rowReadON[49] rowReadON[48] rowReadOFF[49] rowReadOFF[48] openDVS_pixel2x2
x778 DiffBn VDD RefrBp GndD GndA PrSFBp OffBn PrBp OnBn pixRst[20] net43 net44 pixRst[21]
+ rowReadON[49] rowReadON[48] rowReadOFF[49] rowReadOFF[48] openDVS_pixel2x2
x779 DiffBn VDD RefrBp GndD GndA PrSFBp OffBn PrBp OnBn pixRst[22] net47 net48 pixRst[23]
+ rowReadON[49] rowReadON[48] rowReadOFF[49] rowReadOFF[48] openDVS_pixel2x2
x780 DiffBn VDD RefrBp GndD GndA PrSFBp OffBn PrBp OnBn pixRst[24] net51 net52 pixRst[25]
+ rowReadON[49] rowReadON[48] rowReadOFF[49] rowReadOFF[48] openDVS_pixel2x2
x781 DiffBn VDD RefrBp GndD GndA PrSFBp OffBn PrBp OnBn pixRst[26] net55 net56 pixRst[27]
+ rowReadON[49] rowReadON[48] rowReadOFF[49] rowReadOFF[48] openDVS_pixel2x2
x782 DiffBn VDD RefrBp GndD GndA PrSFBp OffBn PrBp OnBn pixRst[28] net59 net60 pixRst[29]
+ rowReadON[49] rowReadON[48] rowReadOFF[49] rowReadOFF[48] openDVS_pixel2x2
x783 DiffBn VDD RefrBp GndD GndA PrSFBp OffBn PrBp OnBn pixRst[30] net63 net64 pixRst[31]
+ rowReadON[49] rowReadON[48] rowReadOFF[49] rowReadOFF[48] openDVS_pixel2x2
x784 DiffBn VDD RefrBp GndD GndA PrSFBp OffBn PrBp OnBn pixRst[32] net67 net68 pixRst[33]
+ rowReadON[49] rowReadON[48] rowReadOFF[49] rowReadOFF[48] openDVS_pixel2x2
x785 DiffBn VDD RefrBp GndD GndA PrSFBp OffBn PrBp OnBn pixRst[34] net71 net72 pixRst[35]
+ rowReadON[49] rowReadON[48] rowReadOFF[49] rowReadOFF[48] openDVS_pixel2x2
x786 DiffBn VDD RefrBp GndD GndA PrSFBp OffBn PrBp OnBn pixRst[36] net75 net76 pixRst[37]
+ rowReadON[49] rowReadON[48] rowReadOFF[49] rowReadOFF[48] openDVS_pixel2x2
x787 DiffBn VDD RefrBp GndD GndA PrSFBp OffBn PrBp OnBn pixRst[38] net79 net80 pixRst[39]
+ rowReadON[49] rowReadON[48] rowReadOFF[49] rowReadOFF[48] openDVS_pixel2x2
x788 DiffBn VDD RefrBp GndD GndA PrSFBp OffBn PrBp OnBn pixRst[40] net83 net84 pixRst[41]
+ rowReadON[49] rowReadON[48] rowReadOFF[49] rowReadOFF[48] openDVS_pixel2x2
x789 DiffBn VDD RefrBp GndD GndA PrSFBp OffBn PrBp OnBn pixRst[42] net87 net88 pixRst[43]
+ rowReadON[49] rowReadON[48] rowReadOFF[49] rowReadOFF[48] openDVS_pixel2x2
x790 DiffBn VDD RefrBp GndD GndA PrSFBp OffBn PrBp OnBn pixRst[44] net91 net92 pixRst[45]
+ rowReadON[49] rowReadON[48] rowReadOFF[49] rowReadOFF[48] openDVS_pixel2x2
x791 DiffBn VDD RefrBp GndD GndA PrSFBp OffBn PrBp OnBn pixRst[46] net95 net96 pixRst[47]
+ rowReadON[49] rowReadON[48] rowReadOFF[49] rowReadOFF[48] openDVS_pixel2x2
x792 DiffBn VDD RefrBp GndD GndA PrSFBp OffBn PrBp OnBn pixRst[48] net99 net100 pixRst[49]
+ rowReadON[49] rowReadON[48] rowReadOFF[49] rowReadOFF[48] openDVS_pixel2x2
x793 DiffBn VDD RefrBp GndD GndA PrSFBp OffBn PrBp OnBn pixRst[50] net103 net104 pixRst[51]
+ rowReadON[49] rowReadON[48] rowReadOFF[49] rowReadOFF[48] openDVS_pixel2x2
x794 DiffBn VDD RefrBp GndD GndA PrSFBp OffBn PrBp OnBn pixRst[52] net107 net108 pixRst[53]
+ rowReadON[49] rowReadON[48] rowReadOFF[49] rowReadOFF[48] openDVS_pixel2x2
x795 DiffBn VDD RefrBp GndD GndA PrSFBp OffBn PrBp OnBn pixRst[54] net111 net112 pixRst[55]
+ rowReadON[49] rowReadON[48] rowReadOFF[49] rowReadOFF[48] openDVS_pixel2x2
x796 DiffBn VDD RefrBp GndD GndA PrSFBp OffBn PrBp OnBn pixRst[56] net115 net116 pixRst[57]
+ rowReadON[49] rowReadON[48] rowReadOFF[49] rowReadOFF[48] openDVS_pixel2x2
x797 DiffBn VDD RefrBp GndD GndA PrSFBp OffBn PrBp OnBn pixRst[58] net119 net120 pixRst[59]
+ rowReadON[49] rowReadON[48] rowReadOFF[49] rowReadOFF[48] openDVS_pixel2x2
x798 DiffBn VDD RefrBp GndD GndA PrSFBp OffBn PrBp OnBn pixRst[60] net123 net124 pixRst[61]
+ rowReadON[49] rowReadON[48] rowReadOFF[49] rowReadOFF[48] openDVS_pixel2x2
x799 DiffBn VDD RefrBp GndD GndA PrSFBp OffBn PrBp OnBn pixRst[62] net127 net128 pixRst[63]
+ rowReadON[49] rowReadON[48] rowReadOFF[49] rowReadOFF[48] openDVS_pixel2x2
x800 DiffBn VDD RefrBp GndD GndA PrSFBp OffBn PrBp OnBn pixRst[0] net3 net4 pixRst[1] rowReadON[51]
+ rowReadON[50] rowReadOFF[51] rowReadOFF[50] openDVS_pixel2x2
x801 DiffBn VDD RefrBp GndD GndA PrSFBp OffBn PrBp OnBn pixRst[2] net7 net8 pixRst[3] rowReadON[51]
+ rowReadON[50] rowReadOFF[51] rowReadOFF[50] openDVS_pixel2x2
x802 DiffBn VDD RefrBp GndD GndA PrSFBp OffBn PrBp OnBn pixRst[4] net11 net12 pixRst[5]
+ rowReadON[51] rowReadON[50] rowReadOFF[51] rowReadOFF[50] openDVS_pixel2x2
x803 DiffBn VDD RefrBp GndD GndA PrSFBp OffBn PrBp OnBn pixRst[6] net15 net16 pixRst[7]
+ rowReadON[51] rowReadON[50] rowReadOFF[51] rowReadOFF[50] openDVS_pixel2x2
x804 DiffBn VDD RefrBp GndD GndA PrSFBp OffBn PrBp OnBn pixRst[8] net19 net20 pixRst[9]
+ rowReadON[51] rowReadON[50] rowReadOFF[51] rowReadOFF[50] openDVS_pixel2x2
x805 DiffBn VDD RefrBp GndD GndA PrSFBp OffBn PrBp OnBn pixRst[10] net23 net24 pixRst[11]
+ rowReadON[51] rowReadON[50] rowReadOFF[51] rowReadOFF[50] openDVS_pixel2x2
x806 DiffBn VDD RefrBp GndD GndA PrSFBp OffBn PrBp OnBn pixRst[12] net27 net28 pixRst[13]
+ rowReadON[51] rowReadON[50] rowReadOFF[51] rowReadOFF[50] openDVS_pixel2x2
x807 DiffBn VDD RefrBp GndD GndA PrSFBp OffBn PrBp OnBn pixRst[14] net31 net32 pixRst[15]
+ rowReadON[51] rowReadON[50] rowReadOFF[51] rowReadOFF[50] openDVS_pixel2x2
x808 DiffBn VDD RefrBp GndD GndA PrSFBp OffBn PrBp OnBn pixRst[16] net35 net36 pixRst[17]
+ rowReadON[51] rowReadON[50] rowReadOFF[51] rowReadOFF[50] openDVS_pixel2x2
x809 DiffBn VDD RefrBp GndD GndA PrSFBp OffBn PrBp OnBn pixRst[18] net39 net40 pixRst[19]
+ rowReadON[51] rowReadON[50] rowReadOFF[51] rowReadOFF[50] openDVS_pixel2x2
x810 DiffBn VDD RefrBp GndD GndA PrSFBp OffBn PrBp OnBn pixRst[20] net43 net44 pixRst[21]
+ rowReadON[51] rowReadON[50] rowReadOFF[51] rowReadOFF[50] openDVS_pixel2x2
x811 DiffBn VDD RefrBp GndD GndA PrSFBp OffBn PrBp OnBn pixRst[22] net47 net48 pixRst[23]
+ rowReadON[51] rowReadON[50] rowReadOFF[51] rowReadOFF[50] openDVS_pixel2x2
x812 DiffBn VDD RefrBp GndD GndA PrSFBp OffBn PrBp OnBn pixRst[24] net51 net52 pixRst[25]
+ rowReadON[51] rowReadON[50] rowReadOFF[51] rowReadOFF[50] openDVS_pixel2x2
x813 DiffBn VDD RefrBp GndD GndA PrSFBp OffBn PrBp OnBn pixRst[26] net55 net56 pixRst[27]
+ rowReadON[51] rowReadON[50] rowReadOFF[51] rowReadOFF[50] openDVS_pixel2x2
x814 DiffBn VDD RefrBp GndD GndA PrSFBp OffBn PrBp OnBn pixRst[28] net59 net60 pixRst[29]
+ rowReadON[51] rowReadON[50] rowReadOFF[51] rowReadOFF[50] openDVS_pixel2x2
x815 DiffBn VDD RefrBp GndD GndA PrSFBp OffBn PrBp OnBn pixRst[30] net63 net64 pixRst[31]
+ rowReadON[51] rowReadON[50] rowReadOFF[51] rowReadOFF[50] openDVS_pixel2x2
x816 DiffBn VDD RefrBp GndD GndA PrSFBp OffBn PrBp OnBn pixRst[32] net67 net68 pixRst[33]
+ rowReadON[51] rowReadON[50] rowReadOFF[51] rowReadOFF[50] openDVS_pixel2x2
x817 DiffBn VDD RefrBp GndD GndA PrSFBp OffBn PrBp OnBn pixRst[34] net71 net72 pixRst[35]
+ rowReadON[51] rowReadON[50] rowReadOFF[51] rowReadOFF[50] openDVS_pixel2x2
x818 DiffBn VDD RefrBp GndD GndA PrSFBp OffBn PrBp OnBn pixRst[36] net75 net76 pixRst[37]
+ rowReadON[51] rowReadON[50] rowReadOFF[51] rowReadOFF[50] openDVS_pixel2x2
x819 DiffBn VDD RefrBp GndD GndA PrSFBp OffBn PrBp OnBn pixRst[38] net79 net80 pixRst[39]
+ rowReadON[51] rowReadON[50] rowReadOFF[51] rowReadOFF[50] openDVS_pixel2x2
x820 DiffBn VDD RefrBp GndD GndA PrSFBp OffBn PrBp OnBn pixRst[40] net83 net84 pixRst[41]
+ rowReadON[51] rowReadON[50] rowReadOFF[51] rowReadOFF[50] openDVS_pixel2x2
x821 DiffBn VDD RefrBp GndD GndA PrSFBp OffBn PrBp OnBn pixRst[42] net87 net88 pixRst[43]
+ rowReadON[51] rowReadON[50] rowReadOFF[51] rowReadOFF[50] openDVS_pixel2x2
x822 DiffBn VDD RefrBp GndD GndA PrSFBp OffBn PrBp OnBn pixRst[44] net91 net92 pixRst[45]
+ rowReadON[51] rowReadON[50] rowReadOFF[51] rowReadOFF[50] openDVS_pixel2x2
x823 DiffBn VDD RefrBp GndD GndA PrSFBp OffBn PrBp OnBn pixRst[46] net95 net96 pixRst[47]
+ rowReadON[51] rowReadON[50] rowReadOFF[51] rowReadOFF[50] openDVS_pixel2x2
x824 DiffBn VDD RefrBp GndD GndA PrSFBp OffBn PrBp OnBn pixRst[48] net99 net100 pixRst[49]
+ rowReadON[51] rowReadON[50] rowReadOFF[51] rowReadOFF[50] openDVS_pixel2x2
x825 DiffBn VDD RefrBp GndD GndA PrSFBp OffBn PrBp OnBn pixRst[50] net103 net104 pixRst[51]
+ rowReadON[51] rowReadON[50] rowReadOFF[51] rowReadOFF[50] openDVS_pixel2x2
x826 DiffBn VDD RefrBp GndD GndA PrSFBp OffBn PrBp OnBn pixRst[52] net107 net108 pixRst[53]
+ rowReadON[51] rowReadON[50] rowReadOFF[51] rowReadOFF[50] openDVS_pixel2x2
x827 DiffBn VDD RefrBp GndD GndA PrSFBp OffBn PrBp OnBn pixRst[54] net111 net112 pixRst[55]
+ rowReadON[51] rowReadON[50] rowReadOFF[51] rowReadOFF[50] openDVS_pixel2x2
x828 DiffBn VDD RefrBp GndD GndA PrSFBp OffBn PrBp OnBn pixRst[56] net115 net116 pixRst[57]
+ rowReadON[51] rowReadON[50] rowReadOFF[51] rowReadOFF[50] openDVS_pixel2x2
x829 DiffBn VDD RefrBp GndD GndA PrSFBp OffBn PrBp OnBn pixRst[58] net119 net120 pixRst[59]
+ rowReadON[51] rowReadON[50] rowReadOFF[51] rowReadOFF[50] openDVS_pixel2x2
x830 DiffBn VDD RefrBp GndD GndA PrSFBp OffBn PrBp OnBn pixRst[60] net123 net124 pixRst[61]
+ rowReadON[51] rowReadON[50] rowReadOFF[51] rowReadOFF[50] openDVS_pixel2x2
x831 DiffBn VDD RefrBp GndD GndA PrSFBp OffBn PrBp OnBn pixRst[62] net127 net128 pixRst[63]
+ rowReadON[51] rowReadON[50] rowReadOFF[51] rowReadOFF[50] openDVS_pixel2x2
x832 DiffBn VDD RefrBp GndD GndA PrSFBp OffBn PrBp OnBn pixRst[0] net3 net4 pixRst[1] rowReadON[53]
+ rowReadON[52] rowReadOFF[53] rowReadOFF[52] openDVS_pixel2x2
x833 DiffBn VDD RefrBp GndD GndA PrSFBp OffBn PrBp OnBn pixRst[2] net7 net8 pixRst[3] rowReadON[53]
+ rowReadON[52] rowReadOFF[53] rowReadOFF[52] openDVS_pixel2x2
x834 DiffBn VDD RefrBp GndD GndA PrSFBp OffBn PrBp OnBn pixRst[4] net11 net12 pixRst[5]
+ rowReadON[53] rowReadON[52] rowReadOFF[53] rowReadOFF[52] openDVS_pixel2x2
x835 DiffBn VDD RefrBp GndD GndA PrSFBp OffBn PrBp OnBn pixRst[6] net15 net16 pixRst[7]
+ rowReadON[53] rowReadON[52] rowReadOFF[53] rowReadOFF[52] openDVS_pixel2x2
x836 DiffBn VDD RefrBp GndD GndA PrSFBp OffBn PrBp OnBn pixRst[8] net19 net20 pixRst[9]
+ rowReadON[53] rowReadON[52] rowReadOFF[53] rowReadOFF[52] openDVS_pixel2x2
x837 DiffBn VDD RefrBp GndD GndA PrSFBp OffBn PrBp OnBn pixRst[10] net23 net24 pixRst[11]
+ rowReadON[53] rowReadON[52] rowReadOFF[53] rowReadOFF[52] openDVS_pixel2x2
x838 DiffBn VDD RefrBp GndD GndA PrSFBp OffBn PrBp OnBn pixRst[12] net27 net28 pixRst[13]
+ rowReadON[53] rowReadON[52] rowReadOFF[53] rowReadOFF[52] openDVS_pixel2x2
x839 DiffBn VDD RefrBp GndD GndA PrSFBp OffBn PrBp OnBn pixRst[14] net31 net32 pixRst[15]
+ rowReadON[53] rowReadON[52] rowReadOFF[53] rowReadOFF[52] openDVS_pixel2x2
x840 DiffBn VDD RefrBp GndD GndA PrSFBp OffBn PrBp OnBn pixRst[16] net35 net36 pixRst[17]
+ rowReadON[53] rowReadON[52] rowReadOFF[53] rowReadOFF[52] openDVS_pixel2x2
x841 DiffBn VDD RefrBp GndD GndA PrSFBp OffBn PrBp OnBn pixRst[18] net39 net40 pixRst[19]
+ rowReadON[53] rowReadON[52] rowReadOFF[53] rowReadOFF[52] openDVS_pixel2x2
x842 DiffBn VDD RefrBp GndD GndA PrSFBp OffBn PrBp OnBn pixRst[20] net43 net44 pixRst[21]
+ rowReadON[53] rowReadON[52] rowReadOFF[53] rowReadOFF[52] openDVS_pixel2x2
x843 DiffBn VDD RefrBp GndD GndA PrSFBp OffBn PrBp OnBn pixRst[22] net47 net48 pixRst[23]
+ rowReadON[53] rowReadON[52] rowReadOFF[53] rowReadOFF[52] openDVS_pixel2x2
x844 DiffBn VDD RefrBp GndD GndA PrSFBp OffBn PrBp OnBn pixRst[24] net51 net52 pixRst[25]
+ rowReadON[53] rowReadON[52] rowReadOFF[53] rowReadOFF[52] openDVS_pixel2x2
x845 DiffBn VDD RefrBp GndD GndA PrSFBp OffBn PrBp OnBn pixRst[26] net55 net56 pixRst[27]
+ rowReadON[53] rowReadON[52] rowReadOFF[53] rowReadOFF[52] openDVS_pixel2x2
x846 DiffBn VDD RefrBp GndD GndA PrSFBp OffBn PrBp OnBn pixRst[28] net59 net60 pixRst[29]
+ rowReadON[53] rowReadON[52] rowReadOFF[53] rowReadOFF[52] openDVS_pixel2x2
x847 DiffBn VDD RefrBp GndD GndA PrSFBp OffBn PrBp OnBn pixRst[30] net63 net64 pixRst[31]
+ rowReadON[53] rowReadON[52] rowReadOFF[53] rowReadOFF[52] openDVS_pixel2x2
x848 DiffBn VDD RefrBp GndD GndA PrSFBp OffBn PrBp OnBn pixRst[32] net67 net68 pixRst[33]
+ rowReadON[53] rowReadON[52] rowReadOFF[53] rowReadOFF[52] openDVS_pixel2x2
x849 DiffBn VDD RefrBp GndD GndA PrSFBp OffBn PrBp OnBn pixRst[34] net71 net72 pixRst[35]
+ rowReadON[53] rowReadON[52] rowReadOFF[53] rowReadOFF[52] openDVS_pixel2x2
x850 DiffBn VDD RefrBp GndD GndA PrSFBp OffBn PrBp OnBn pixRst[36] net75 net76 pixRst[37]
+ rowReadON[53] rowReadON[52] rowReadOFF[53] rowReadOFF[52] openDVS_pixel2x2
x851 DiffBn VDD RefrBp GndD GndA PrSFBp OffBn PrBp OnBn pixRst[38] net79 net80 pixRst[39]
+ rowReadON[53] rowReadON[52] rowReadOFF[53] rowReadOFF[52] openDVS_pixel2x2
x852 DiffBn VDD RefrBp GndD GndA PrSFBp OffBn PrBp OnBn pixRst[40] net83 net84 pixRst[41]
+ rowReadON[53] rowReadON[52] rowReadOFF[53] rowReadOFF[52] openDVS_pixel2x2
x853 DiffBn VDD RefrBp GndD GndA PrSFBp OffBn PrBp OnBn pixRst[42] net87 net88 pixRst[43]
+ rowReadON[53] rowReadON[52] rowReadOFF[53] rowReadOFF[52] openDVS_pixel2x2
x854 DiffBn VDD RefrBp GndD GndA PrSFBp OffBn PrBp OnBn pixRst[44] net91 net92 pixRst[45]
+ rowReadON[53] rowReadON[52] rowReadOFF[53] rowReadOFF[52] openDVS_pixel2x2
x855 DiffBn VDD RefrBp GndD GndA PrSFBp OffBn PrBp OnBn pixRst[46] net95 net96 pixRst[47]
+ rowReadON[53] rowReadON[52] rowReadOFF[53] rowReadOFF[52] openDVS_pixel2x2
x856 DiffBn VDD RefrBp GndD GndA PrSFBp OffBn PrBp OnBn pixRst[48] net99 net100 pixRst[49]
+ rowReadON[53] rowReadON[52] rowReadOFF[53] rowReadOFF[52] openDVS_pixel2x2
x857 DiffBn VDD RefrBp GndD GndA PrSFBp OffBn PrBp OnBn pixRst[50] net103 net104 pixRst[51]
+ rowReadON[53] rowReadON[52] rowReadOFF[53] rowReadOFF[52] openDVS_pixel2x2
x858 DiffBn VDD RefrBp GndD GndA PrSFBp OffBn PrBp OnBn pixRst[52] net107 net108 pixRst[53]
+ rowReadON[53] rowReadON[52] rowReadOFF[53] rowReadOFF[52] openDVS_pixel2x2
x859 DiffBn VDD RefrBp GndD GndA PrSFBp OffBn PrBp OnBn pixRst[54] net111 net112 pixRst[55]
+ rowReadON[53] rowReadON[52] rowReadOFF[53] rowReadOFF[52] openDVS_pixel2x2
x860 DiffBn VDD RefrBp GndD GndA PrSFBp OffBn PrBp OnBn pixRst[56] net115 net116 pixRst[57]
+ rowReadON[53] rowReadON[52] rowReadOFF[53] rowReadOFF[52] openDVS_pixel2x2
x861 DiffBn VDD RefrBp GndD GndA PrSFBp OffBn PrBp OnBn pixRst[58] net119 net120 pixRst[59]
+ rowReadON[53] rowReadON[52] rowReadOFF[53] rowReadOFF[52] openDVS_pixel2x2
x862 DiffBn VDD RefrBp GndD GndA PrSFBp OffBn PrBp OnBn pixRst[60] net123 net124 pixRst[61]
+ rowReadON[53] rowReadON[52] rowReadOFF[53] rowReadOFF[52] openDVS_pixel2x2
x863 DiffBn VDD RefrBp GndD GndA PrSFBp OffBn PrBp OnBn pixRst[62] net127 net128 pixRst[63]
+ rowReadON[53] rowReadON[52] rowReadOFF[53] rowReadOFF[52] openDVS_pixel2x2
x864 DiffBn VDD RefrBp GndD GndA PrSFBp OffBn PrBp OnBn pixRst[0] net3 net4 pixRst[1] rowReadON[55]
+ rowReadON[54] rowReadOFF[55] rowReadOFF[54] openDVS_pixel2x2
x865 DiffBn VDD RefrBp GndD GndA PrSFBp OffBn PrBp OnBn pixRst[2] net7 net8 pixRst[3] rowReadON[55]
+ rowReadON[54] rowReadOFF[55] rowReadOFF[54] openDVS_pixel2x2
x866 DiffBn VDD RefrBp GndD GndA PrSFBp OffBn PrBp OnBn pixRst[4] net11 net12 pixRst[5]
+ rowReadON[55] rowReadON[54] rowReadOFF[55] rowReadOFF[54] openDVS_pixel2x2
x867 DiffBn VDD RefrBp GndD GndA PrSFBp OffBn PrBp OnBn pixRst[6] net15 net16 pixRst[7]
+ rowReadON[55] rowReadON[54] rowReadOFF[55] rowReadOFF[54] openDVS_pixel2x2
x868 DiffBn VDD RefrBp GndD GndA PrSFBp OffBn PrBp OnBn pixRst[8] net19 net20 pixRst[9]
+ rowReadON[55] rowReadON[54] rowReadOFF[55] rowReadOFF[54] openDVS_pixel2x2
x869 DiffBn VDD RefrBp GndD GndA PrSFBp OffBn PrBp OnBn pixRst[10] net23 net24 pixRst[11]
+ rowReadON[55] rowReadON[54] rowReadOFF[55] rowReadOFF[54] openDVS_pixel2x2
x870 DiffBn VDD RefrBp GndD GndA PrSFBp OffBn PrBp OnBn pixRst[12] net27 net28 pixRst[13]
+ rowReadON[55] rowReadON[54] rowReadOFF[55] rowReadOFF[54] openDVS_pixel2x2
x871 DiffBn VDD RefrBp GndD GndA PrSFBp OffBn PrBp OnBn pixRst[14] net31 net32 pixRst[15]
+ rowReadON[55] rowReadON[54] rowReadOFF[55] rowReadOFF[54] openDVS_pixel2x2
x872 DiffBn VDD RefrBp GndD GndA PrSFBp OffBn PrBp OnBn pixRst[16] net35 net36 pixRst[17]
+ rowReadON[55] rowReadON[54] rowReadOFF[55] rowReadOFF[54] openDVS_pixel2x2
x873 DiffBn VDD RefrBp GndD GndA PrSFBp OffBn PrBp OnBn pixRst[18] net39 net40 pixRst[19]
+ rowReadON[55] rowReadON[54] rowReadOFF[55] rowReadOFF[54] openDVS_pixel2x2
x874 DiffBn VDD RefrBp GndD GndA PrSFBp OffBn PrBp OnBn pixRst[20] net43 net44 pixRst[21]
+ rowReadON[55] rowReadON[54] rowReadOFF[55] rowReadOFF[54] openDVS_pixel2x2
x875 DiffBn VDD RefrBp GndD GndA PrSFBp OffBn PrBp OnBn pixRst[22] net47 net48 pixRst[23]
+ rowReadON[55] rowReadON[54] rowReadOFF[55] rowReadOFF[54] openDVS_pixel2x2
x876 DiffBn VDD RefrBp GndD GndA PrSFBp OffBn PrBp OnBn pixRst[24] net51 net52 pixRst[25]
+ rowReadON[55] rowReadON[54] rowReadOFF[55] rowReadOFF[54] openDVS_pixel2x2
x877 DiffBn VDD RefrBp GndD GndA PrSFBp OffBn PrBp OnBn pixRst[26] net55 net56 pixRst[27]
+ rowReadON[55] rowReadON[54] rowReadOFF[55] rowReadOFF[54] openDVS_pixel2x2
x878 DiffBn VDD RefrBp GndD GndA PrSFBp OffBn PrBp OnBn pixRst[28] net59 net60 pixRst[29]
+ rowReadON[55] rowReadON[54] rowReadOFF[55] rowReadOFF[54] openDVS_pixel2x2
x879 DiffBn VDD RefrBp GndD GndA PrSFBp OffBn PrBp OnBn pixRst[30] net63 net64 pixRst[31]
+ rowReadON[55] rowReadON[54] rowReadOFF[55] rowReadOFF[54] openDVS_pixel2x2
x880 DiffBn VDD RefrBp GndD GndA PrSFBp OffBn PrBp OnBn pixRst[32] net67 net68 pixRst[33]
+ rowReadON[55] rowReadON[54] rowReadOFF[55] rowReadOFF[54] openDVS_pixel2x2
x881 DiffBn VDD RefrBp GndD GndA PrSFBp OffBn PrBp OnBn pixRst[34] net71 net72 pixRst[35]
+ rowReadON[55] rowReadON[54] rowReadOFF[55] rowReadOFF[54] openDVS_pixel2x2
x882 DiffBn VDD RefrBp GndD GndA PrSFBp OffBn PrBp OnBn pixRst[36] net75 net76 pixRst[37]
+ rowReadON[55] rowReadON[54] rowReadOFF[55] rowReadOFF[54] openDVS_pixel2x2
x883 DiffBn VDD RefrBp GndD GndA PrSFBp OffBn PrBp OnBn pixRst[38] net79 net80 pixRst[39]
+ rowReadON[55] rowReadON[54] rowReadOFF[55] rowReadOFF[54] openDVS_pixel2x2
x884 DiffBn VDD RefrBp GndD GndA PrSFBp OffBn PrBp OnBn pixRst[40] net83 net84 pixRst[41]
+ rowReadON[55] rowReadON[54] rowReadOFF[55] rowReadOFF[54] openDVS_pixel2x2
x885 DiffBn VDD RefrBp GndD GndA PrSFBp OffBn PrBp OnBn pixRst[42] net87 net88 pixRst[43]
+ rowReadON[55] rowReadON[54] rowReadOFF[55] rowReadOFF[54] openDVS_pixel2x2
x886 DiffBn VDD RefrBp GndD GndA PrSFBp OffBn PrBp OnBn pixRst[44] net91 net92 pixRst[45]
+ rowReadON[55] rowReadON[54] rowReadOFF[55] rowReadOFF[54] openDVS_pixel2x2
x887 DiffBn VDD RefrBp GndD GndA PrSFBp OffBn PrBp OnBn pixRst[46] net95 net96 pixRst[47]
+ rowReadON[55] rowReadON[54] rowReadOFF[55] rowReadOFF[54] openDVS_pixel2x2
x888 DiffBn VDD RefrBp GndD GndA PrSFBp OffBn PrBp OnBn pixRst[48] net99 net100 pixRst[49]
+ rowReadON[55] rowReadON[54] rowReadOFF[55] rowReadOFF[54] openDVS_pixel2x2
x889 DiffBn VDD RefrBp GndD GndA PrSFBp OffBn PrBp OnBn pixRst[50] net103 net104 pixRst[51]
+ rowReadON[55] rowReadON[54] rowReadOFF[55] rowReadOFF[54] openDVS_pixel2x2
x890 DiffBn VDD RefrBp GndD GndA PrSFBp OffBn PrBp OnBn pixRst[52] net107 net108 pixRst[53]
+ rowReadON[55] rowReadON[54] rowReadOFF[55] rowReadOFF[54] openDVS_pixel2x2
x891 DiffBn VDD RefrBp GndD GndA PrSFBp OffBn PrBp OnBn pixRst[54] net111 net112 pixRst[55]
+ rowReadON[55] rowReadON[54] rowReadOFF[55] rowReadOFF[54] openDVS_pixel2x2
x892 DiffBn VDD RefrBp GndD GndA PrSFBp OffBn PrBp OnBn pixRst[56] net115 net116 pixRst[57]
+ rowReadON[55] rowReadON[54] rowReadOFF[55] rowReadOFF[54] openDVS_pixel2x2
x893 DiffBn VDD RefrBp GndD GndA PrSFBp OffBn PrBp OnBn pixRst[58] net119 net120 pixRst[59]
+ rowReadON[55] rowReadON[54] rowReadOFF[55] rowReadOFF[54] openDVS_pixel2x2
x894 DiffBn VDD RefrBp GndD GndA PrSFBp OffBn PrBp OnBn pixRst[60] net123 net124 pixRst[61]
+ rowReadON[55] rowReadON[54] rowReadOFF[55] rowReadOFF[54] openDVS_pixel2x2
x895 DiffBn VDD RefrBp GndD GndA PrSFBp OffBn PrBp OnBn pixRst[62] net127 net128 pixRst[63]
+ rowReadON[55] rowReadON[54] rowReadOFF[55] rowReadOFF[54] openDVS_pixel2x2
x896 DiffBn VDD RefrBp GndD GndA PrSFBp OffBn PrBp OnBn pixRst[0] net3 net4 pixRst[1] rowReadON[57]
+ rowReadON[56] rowReadOFF[57] rowReadOFF[56] openDVS_pixel2x2
x897 DiffBn VDD RefrBp GndD GndA PrSFBp OffBn PrBp OnBn pixRst[2] net7 net8 pixRst[3] rowReadON[57]
+ rowReadON[56] rowReadOFF[57] rowReadOFF[56] openDVS_pixel2x2
x898 DiffBn VDD RefrBp GndD GndA PrSFBp OffBn PrBp OnBn pixRst[4] net11 net12 pixRst[5]
+ rowReadON[57] rowReadON[56] rowReadOFF[57] rowReadOFF[56] openDVS_pixel2x2
x899 DiffBn VDD RefrBp GndD GndA PrSFBp OffBn PrBp OnBn pixRst[6] net15 net16 pixRst[7]
+ rowReadON[57] rowReadON[56] rowReadOFF[57] rowReadOFF[56] openDVS_pixel2x2
x900 DiffBn VDD RefrBp GndD GndA PrSFBp OffBn PrBp OnBn pixRst[8] net19 net20 pixRst[9]
+ rowReadON[57] rowReadON[56] rowReadOFF[57] rowReadOFF[56] openDVS_pixel2x2
x901 DiffBn VDD RefrBp GndD GndA PrSFBp OffBn PrBp OnBn pixRst[10] net23 net24 pixRst[11]
+ rowReadON[57] rowReadON[56] rowReadOFF[57] rowReadOFF[56] openDVS_pixel2x2
x902 DiffBn VDD RefrBp GndD GndA PrSFBp OffBn PrBp OnBn pixRst[12] net27 net28 pixRst[13]
+ rowReadON[57] rowReadON[56] rowReadOFF[57] rowReadOFF[56] openDVS_pixel2x2
x903 DiffBn VDD RefrBp GndD GndA PrSFBp OffBn PrBp OnBn pixRst[14] net31 net32 pixRst[15]
+ rowReadON[57] rowReadON[56] rowReadOFF[57] rowReadOFF[56] openDVS_pixel2x2
x904 DiffBn VDD RefrBp GndD GndA PrSFBp OffBn PrBp OnBn pixRst[16] net35 net36 pixRst[17]
+ rowReadON[57] rowReadON[56] rowReadOFF[57] rowReadOFF[56] openDVS_pixel2x2
x905 DiffBn VDD RefrBp GndD GndA PrSFBp OffBn PrBp OnBn pixRst[18] net39 net40 pixRst[19]
+ rowReadON[57] rowReadON[56] rowReadOFF[57] rowReadOFF[56] openDVS_pixel2x2
x906 DiffBn VDD RefrBp GndD GndA PrSFBp OffBn PrBp OnBn pixRst[20] net43 net44 pixRst[21]
+ rowReadON[57] rowReadON[56] rowReadOFF[57] rowReadOFF[56] openDVS_pixel2x2
x907 DiffBn VDD RefrBp GndD GndA PrSFBp OffBn PrBp OnBn pixRst[22] net47 net48 pixRst[23]
+ rowReadON[57] rowReadON[56] rowReadOFF[57] rowReadOFF[56] openDVS_pixel2x2
x908 DiffBn VDD RefrBp GndD GndA PrSFBp OffBn PrBp OnBn pixRst[24] net51 net52 pixRst[25]
+ rowReadON[57] rowReadON[56] rowReadOFF[57] rowReadOFF[56] openDVS_pixel2x2
x909 DiffBn VDD RefrBp GndD GndA PrSFBp OffBn PrBp OnBn pixRst[26] net55 net56 pixRst[27]
+ rowReadON[57] rowReadON[56] rowReadOFF[57] rowReadOFF[56] openDVS_pixel2x2
x910 DiffBn VDD RefrBp GndD GndA PrSFBp OffBn PrBp OnBn pixRst[28] net59 net60 pixRst[29]
+ rowReadON[57] rowReadON[56] rowReadOFF[57] rowReadOFF[56] openDVS_pixel2x2
x911 DiffBn VDD RefrBp GndD GndA PrSFBp OffBn PrBp OnBn pixRst[30] net63 net64 pixRst[31]
+ rowReadON[57] rowReadON[56] rowReadOFF[57] rowReadOFF[56] openDVS_pixel2x2
x912 DiffBn VDD RefrBp GndD GndA PrSFBp OffBn PrBp OnBn pixRst[32] net67 net68 pixRst[33]
+ rowReadON[57] rowReadON[56] rowReadOFF[57] rowReadOFF[56] openDVS_pixel2x2
x913 DiffBn VDD RefrBp GndD GndA PrSFBp OffBn PrBp OnBn pixRst[34] net71 net72 pixRst[35]
+ rowReadON[57] rowReadON[56] rowReadOFF[57] rowReadOFF[56] openDVS_pixel2x2
x914 DiffBn VDD RefrBp GndD GndA PrSFBp OffBn PrBp OnBn pixRst[36] net75 net76 pixRst[37]
+ rowReadON[57] rowReadON[56] rowReadOFF[57] rowReadOFF[56] openDVS_pixel2x2
x915 DiffBn VDD RefrBp GndD GndA PrSFBp OffBn PrBp OnBn pixRst[38] net79 net80 pixRst[39]
+ rowReadON[57] rowReadON[56] rowReadOFF[57] rowReadOFF[56] openDVS_pixel2x2
x916 DiffBn VDD RefrBp GndD GndA PrSFBp OffBn PrBp OnBn pixRst[40] net83 net84 pixRst[41]
+ rowReadON[57] rowReadON[56] rowReadOFF[57] rowReadOFF[56] openDVS_pixel2x2
x917 DiffBn VDD RefrBp GndD GndA PrSFBp OffBn PrBp OnBn pixRst[42] net87 net88 pixRst[43]
+ rowReadON[57] rowReadON[56] rowReadOFF[57] rowReadOFF[56] openDVS_pixel2x2
x918 DiffBn VDD RefrBp GndD GndA PrSFBp OffBn PrBp OnBn pixRst[44] net91 net92 pixRst[45]
+ rowReadON[57] rowReadON[56] rowReadOFF[57] rowReadOFF[56] openDVS_pixel2x2
x919 DiffBn VDD RefrBp GndD GndA PrSFBp OffBn PrBp OnBn pixRst[46] net95 net96 pixRst[47]
+ rowReadON[57] rowReadON[56] rowReadOFF[57] rowReadOFF[56] openDVS_pixel2x2
x920 DiffBn VDD RefrBp GndD GndA PrSFBp OffBn PrBp OnBn pixRst[48] net99 net100 pixRst[49]
+ rowReadON[57] rowReadON[56] rowReadOFF[57] rowReadOFF[56] openDVS_pixel2x2
x921 DiffBn VDD RefrBp GndD GndA PrSFBp OffBn PrBp OnBn pixRst[50] net103 net104 pixRst[51]
+ rowReadON[57] rowReadON[56] rowReadOFF[57] rowReadOFF[56] openDVS_pixel2x2
x922 DiffBn VDD RefrBp GndD GndA PrSFBp OffBn PrBp OnBn pixRst[52] net107 net108 pixRst[53]
+ rowReadON[57] rowReadON[56] rowReadOFF[57] rowReadOFF[56] openDVS_pixel2x2
x923 DiffBn VDD RefrBp GndD GndA PrSFBp OffBn PrBp OnBn pixRst[54] net111 net112 pixRst[55]
+ rowReadON[57] rowReadON[56] rowReadOFF[57] rowReadOFF[56] openDVS_pixel2x2
x924 DiffBn VDD RefrBp GndD GndA PrSFBp OffBn PrBp OnBn pixRst[56] net115 net116 pixRst[57]
+ rowReadON[57] rowReadON[56] rowReadOFF[57] rowReadOFF[56] openDVS_pixel2x2
x925 DiffBn VDD RefrBp GndD GndA PrSFBp OffBn PrBp OnBn pixRst[58] net119 net120 pixRst[59]
+ rowReadON[57] rowReadON[56] rowReadOFF[57] rowReadOFF[56] openDVS_pixel2x2
x926 DiffBn VDD RefrBp GndD GndA PrSFBp OffBn PrBp OnBn pixRst[60] net123 net124 pixRst[61]
+ rowReadON[57] rowReadON[56] rowReadOFF[57] rowReadOFF[56] openDVS_pixel2x2
x927 DiffBn VDD RefrBp GndD GndA PrSFBp OffBn PrBp OnBn pixRst[62] net127 net128 pixRst[63]
+ rowReadON[57] rowReadON[56] rowReadOFF[57] rowReadOFF[56] openDVS_pixel2x2
x928 DiffBn VDD RefrBp GndD GndA PrSFBp OffBn PrBp OnBn pixRst[0] net3 net4 pixRst[1] rowReadON[59]
+ rowReadON[58] rowReadOFF[59] rowReadOFF[58] openDVS_pixel2x2
x929 DiffBn VDD RefrBp GndD GndA PrSFBp OffBn PrBp OnBn pixRst[2] net7 net8 pixRst[3] rowReadON[59]
+ rowReadON[58] rowReadOFF[59] rowReadOFF[58] openDVS_pixel2x2
x930 DiffBn VDD RefrBp GndD GndA PrSFBp OffBn PrBp OnBn pixRst[4] net11 net12 pixRst[5]
+ rowReadON[59] rowReadON[58] rowReadOFF[59] rowReadOFF[58] openDVS_pixel2x2
x931 DiffBn VDD RefrBp GndD GndA PrSFBp OffBn PrBp OnBn pixRst[6] net15 net16 pixRst[7]
+ rowReadON[59] rowReadON[58] rowReadOFF[59] rowReadOFF[58] openDVS_pixel2x2
x932 DiffBn VDD RefrBp GndD GndA PrSFBp OffBn PrBp OnBn pixRst[8] net19 net20 pixRst[9]
+ rowReadON[59] rowReadON[58] rowReadOFF[59] rowReadOFF[58] openDVS_pixel2x2
x933 DiffBn VDD RefrBp GndD GndA PrSFBp OffBn PrBp OnBn pixRst[10] net23 net24 pixRst[11]
+ rowReadON[59] rowReadON[58] rowReadOFF[59] rowReadOFF[58] openDVS_pixel2x2
x934 DiffBn VDD RefrBp GndD GndA PrSFBp OffBn PrBp OnBn pixRst[12] net27 net28 pixRst[13]
+ rowReadON[59] rowReadON[58] rowReadOFF[59] rowReadOFF[58] openDVS_pixel2x2
x935 DiffBn VDD RefrBp GndD GndA PrSFBp OffBn PrBp OnBn pixRst[14] net31 net32 pixRst[15]
+ rowReadON[59] rowReadON[58] rowReadOFF[59] rowReadOFF[58] openDVS_pixel2x2
x936 DiffBn VDD RefrBp GndD GndA PrSFBp OffBn PrBp OnBn pixRst[16] net35 net36 pixRst[17]
+ rowReadON[59] rowReadON[58] rowReadOFF[59] rowReadOFF[58] openDVS_pixel2x2
x937 DiffBn VDD RefrBp GndD GndA PrSFBp OffBn PrBp OnBn pixRst[18] net39 net40 pixRst[19]
+ rowReadON[59] rowReadON[58] rowReadOFF[59] rowReadOFF[58] openDVS_pixel2x2
x938 DiffBn VDD RefrBp GndD GndA PrSFBp OffBn PrBp OnBn pixRst[20] net43 net44 pixRst[21]
+ rowReadON[59] rowReadON[58] rowReadOFF[59] rowReadOFF[58] openDVS_pixel2x2
x939 DiffBn VDD RefrBp GndD GndA PrSFBp OffBn PrBp OnBn pixRst[22] net47 net48 pixRst[23]
+ rowReadON[59] rowReadON[58] rowReadOFF[59] rowReadOFF[58] openDVS_pixel2x2
x940 DiffBn VDD RefrBp GndD GndA PrSFBp OffBn PrBp OnBn pixRst[24] net51 net52 pixRst[25]
+ rowReadON[59] rowReadON[58] rowReadOFF[59] rowReadOFF[58] openDVS_pixel2x2
x941 DiffBn VDD RefrBp GndD GndA PrSFBp OffBn PrBp OnBn pixRst[26] net55 net56 pixRst[27]
+ rowReadON[59] rowReadON[58] rowReadOFF[59] rowReadOFF[58] openDVS_pixel2x2
x942 DiffBn VDD RefrBp GndD GndA PrSFBp OffBn PrBp OnBn pixRst[28] net59 net60 pixRst[29]
+ rowReadON[59] rowReadON[58] rowReadOFF[59] rowReadOFF[58] openDVS_pixel2x2
x943 DiffBn VDD RefrBp GndD GndA PrSFBp OffBn PrBp OnBn pixRst[30] net63 net64 pixRst[31]
+ rowReadON[59] rowReadON[58] rowReadOFF[59] rowReadOFF[58] openDVS_pixel2x2
x944 DiffBn VDD RefrBp GndD GndA PrSFBp OffBn PrBp OnBn pixRst[32] net67 net68 pixRst[33]
+ rowReadON[59] rowReadON[58] rowReadOFF[59] rowReadOFF[58] openDVS_pixel2x2
x945 DiffBn VDD RefrBp GndD GndA PrSFBp OffBn PrBp OnBn pixRst[34] net71 net72 pixRst[35]
+ rowReadON[59] rowReadON[58] rowReadOFF[59] rowReadOFF[58] openDVS_pixel2x2
x946 DiffBn VDD RefrBp GndD GndA PrSFBp OffBn PrBp OnBn pixRst[36] net75 net76 pixRst[37]
+ rowReadON[59] rowReadON[58] rowReadOFF[59] rowReadOFF[58] openDVS_pixel2x2
x947 DiffBn VDD RefrBp GndD GndA PrSFBp OffBn PrBp OnBn pixRst[38] net79 net80 pixRst[39]
+ rowReadON[59] rowReadON[58] rowReadOFF[59] rowReadOFF[58] openDVS_pixel2x2
x948 DiffBn VDD RefrBp GndD GndA PrSFBp OffBn PrBp OnBn pixRst[40] net83 net84 pixRst[41]
+ rowReadON[59] rowReadON[58] rowReadOFF[59] rowReadOFF[58] openDVS_pixel2x2
x949 DiffBn VDD RefrBp GndD GndA PrSFBp OffBn PrBp OnBn pixRst[42] net87 net88 pixRst[43]
+ rowReadON[59] rowReadON[58] rowReadOFF[59] rowReadOFF[58] openDVS_pixel2x2
x950 DiffBn VDD RefrBp GndD GndA PrSFBp OffBn PrBp OnBn pixRst[44] net91 net92 pixRst[45]
+ rowReadON[59] rowReadON[58] rowReadOFF[59] rowReadOFF[58] openDVS_pixel2x2
x951 DiffBn VDD RefrBp GndD GndA PrSFBp OffBn PrBp OnBn pixRst[46] net95 net96 pixRst[47]
+ rowReadON[59] rowReadON[58] rowReadOFF[59] rowReadOFF[58] openDVS_pixel2x2
x952 DiffBn VDD RefrBp GndD GndA PrSFBp OffBn PrBp OnBn pixRst[48] net99 net100 pixRst[49]
+ rowReadON[59] rowReadON[58] rowReadOFF[59] rowReadOFF[58] openDVS_pixel2x2
x953 DiffBn VDD RefrBp GndD GndA PrSFBp OffBn PrBp OnBn pixRst[50] net103 net104 pixRst[51]
+ rowReadON[59] rowReadON[58] rowReadOFF[59] rowReadOFF[58] openDVS_pixel2x2
x954 DiffBn VDD RefrBp GndD GndA PrSFBp OffBn PrBp OnBn pixRst[52] net107 net108 pixRst[53]
+ rowReadON[59] rowReadON[58] rowReadOFF[59] rowReadOFF[58] openDVS_pixel2x2
x955 DiffBn VDD RefrBp GndD GndA PrSFBp OffBn PrBp OnBn pixRst[54] net111 net112 pixRst[55]
+ rowReadON[59] rowReadON[58] rowReadOFF[59] rowReadOFF[58] openDVS_pixel2x2
x956 DiffBn VDD RefrBp GndD GndA PrSFBp OffBn PrBp OnBn pixRst[56] net115 net116 pixRst[57]
+ rowReadON[59] rowReadON[58] rowReadOFF[59] rowReadOFF[58] openDVS_pixel2x2
x957 DiffBn VDD RefrBp GndD GndA PrSFBp OffBn PrBp OnBn pixRst[58] net119 net120 pixRst[59]
+ rowReadON[59] rowReadON[58] rowReadOFF[59] rowReadOFF[58] openDVS_pixel2x2
x958 DiffBn VDD RefrBp GndD GndA PrSFBp OffBn PrBp OnBn pixRst[60] net123 net124 pixRst[61]
+ rowReadON[59] rowReadON[58] rowReadOFF[59] rowReadOFF[58] openDVS_pixel2x2
x959 DiffBn VDD RefrBp GndD GndA PrSFBp OffBn PrBp OnBn pixRst[62] net127 net128 pixRst[63]
+ rowReadON[59] rowReadON[58] rowReadOFF[59] rowReadOFF[58] openDVS_pixel2x2
x960 DiffBn VDD RefrBp GndD GndA PrSFBp OffBn PrBp OnBn pixRst[0] net3 net4 pixRst[1] rowReadON[61]
+ rowReadON[60] rowReadOFF[61] rowReadOFF[60] openDVS_pixel2x2
x961 DiffBn VDD RefrBp GndD GndA PrSFBp OffBn PrBp OnBn pixRst[2] net7 net8 pixRst[3] rowReadON[61]
+ rowReadON[60] rowReadOFF[61] rowReadOFF[60] openDVS_pixel2x2
x962 DiffBn VDD RefrBp GndD GndA PrSFBp OffBn PrBp OnBn pixRst[4] net11 net12 pixRst[5]
+ rowReadON[61] rowReadON[60] rowReadOFF[61] rowReadOFF[60] openDVS_pixel2x2
x963 DiffBn VDD RefrBp GndD GndA PrSFBp OffBn PrBp OnBn pixRst[6] net15 net16 pixRst[7]
+ rowReadON[61] rowReadON[60] rowReadOFF[61] rowReadOFF[60] openDVS_pixel2x2
x964 DiffBn VDD RefrBp GndD GndA PrSFBp OffBn PrBp OnBn pixRst[8] net19 net20 pixRst[9]
+ rowReadON[61] rowReadON[60] rowReadOFF[61] rowReadOFF[60] openDVS_pixel2x2
x965 DiffBn VDD RefrBp GndD GndA PrSFBp OffBn PrBp OnBn pixRst[10] net23 net24 pixRst[11]
+ rowReadON[61] rowReadON[60] rowReadOFF[61] rowReadOFF[60] openDVS_pixel2x2
x966 DiffBn VDD RefrBp GndD GndA PrSFBp OffBn PrBp OnBn pixRst[12] net27 net28 pixRst[13]
+ rowReadON[61] rowReadON[60] rowReadOFF[61] rowReadOFF[60] openDVS_pixel2x2
x967 DiffBn VDD RefrBp GndD GndA PrSFBp OffBn PrBp OnBn pixRst[14] net31 net32 pixRst[15]
+ rowReadON[61] rowReadON[60] rowReadOFF[61] rowReadOFF[60] openDVS_pixel2x2
x968 DiffBn VDD RefrBp GndD GndA PrSFBp OffBn PrBp OnBn pixRst[16] net35 net36 pixRst[17]
+ rowReadON[61] rowReadON[60] rowReadOFF[61] rowReadOFF[60] openDVS_pixel2x2
x969 DiffBn VDD RefrBp GndD GndA PrSFBp OffBn PrBp OnBn pixRst[18] net39 net40 pixRst[19]
+ rowReadON[61] rowReadON[60] rowReadOFF[61] rowReadOFF[60] openDVS_pixel2x2
x970 DiffBn VDD RefrBp GndD GndA PrSFBp OffBn PrBp OnBn pixRst[20] net43 net44 pixRst[21]
+ rowReadON[61] rowReadON[60] rowReadOFF[61] rowReadOFF[60] openDVS_pixel2x2
x971 DiffBn VDD RefrBp GndD GndA PrSFBp OffBn PrBp OnBn pixRst[22] net47 net48 pixRst[23]
+ rowReadON[61] rowReadON[60] rowReadOFF[61] rowReadOFF[60] openDVS_pixel2x2
x972 DiffBn VDD RefrBp GndD GndA PrSFBp OffBn PrBp OnBn pixRst[24] net51 net52 pixRst[25]
+ rowReadON[61] rowReadON[60] rowReadOFF[61] rowReadOFF[60] openDVS_pixel2x2
x973 DiffBn VDD RefrBp GndD GndA PrSFBp OffBn PrBp OnBn pixRst[26] net55 net56 pixRst[27]
+ rowReadON[61] rowReadON[60] rowReadOFF[61] rowReadOFF[60] openDVS_pixel2x2
x974 DiffBn VDD RefrBp GndD GndA PrSFBp OffBn PrBp OnBn pixRst[28] net59 net60 pixRst[29]
+ rowReadON[61] rowReadON[60] rowReadOFF[61] rowReadOFF[60] openDVS_pixel2x2
x975 DiffBn VDD RefrBp GndD GndA PrSFBp OffBn PrBp OnBn pixRst[30] net63 net64 pixRst[31]
+ rowReadON[61] rowReadON[60] rowReadOFF[61] rowReadOFF[60] openDVS_pixel2x2
x976 DiffBn VDD RefrBp GndD GndA PrSFBp OffBn PrBp OnBn pixRst[32] net67 net68 pixRst[33]
+ rowReadON[61] rowReadON[60] rowReadOFF[61] rowReadOFF[60] openDVS_pixel2x2
x977 DiffBn VDD RefrBp GndD GndA PrSFBp OffBn PrBp OnBn pixRst[34] net71 net72 pixRst[35]
+ rowReadON[61] rowReadON[60] rowReadOFF[61] rowReadOFF[60] openDVS_pixel2x2
x978 DiffBn VDD RefrBp GndD GndA PrSFBp OffBn PrBp OnBn pixRst[36] net75 net76 pixRst[37]
+ rowReadON[61] rowReadON[60] rowReadOFF[61] rowReadOFF[60] openDVS_pixel2x2
x979 DiffBn VDD RefrBp GndD GndA PrSFBp OffBn PrBp OnBn pixRst[38] net79 net80 pixRst[39]
+ rowReadON[61] rowReadON[60] rowReadOFF[61] rowReadOFF[60] openDVS_pixel2x2
x980 DiffBn VDD RefrBp GndD GndA PrSFBp OffBn PrBp OnBn pixRst[40] net83 net84 pixRst[41]
+ rowReadON[61] rowReadON[60] rowReadOFF[61] rowReadOFF[60] openDVS_pixel2x2
x981 DiffBn VDD RefrBp GndD GndA PrSFBp OffBn PrBp OnBn pixRst[42] net87 net88 pixRst[43]
+ rowReadON[61] rowReadON[60] rowReadOFF[61] rowReadOFF[60] openDVS_pixel2x2
x982 DiffBn VDD RefrBp GndD GndA PrSFBp OffBn PrBp OnBn pixRst[44] net91 net92 pixRst[45]
+ rowReadON[61] rowReadON[60] rowReadOFF[61] rowReadOFF[60] openDVS_pixel2x2
x983 DiffBn VDD RefrBp GndD GndA PrSFBp OffBn PrBp OnBn pixRst[46] net95 net96 pixRst[47]
+ rowReadON[61] rowReadON[60] rowReadOFF[61] rowReadOFF[60] openDVS_pixel2x2
x984 DiffBn VDD RefrBp GndD GndA PrSFBp OffBn PrBp OnBn pixRst[48] net99 net100 pixRst[49]
+ rowReadON[61] rowReadON[60] rowReadOFF[61] rowReadOFF[60] openDVS_pixel2x2
x985 DiffBn VDD RefrBp GndD GndA PrSFBp OffBn PrBp OnBn pixRst[50] net103 net104 pixRst[51]
+ rowReadON[61] rowReadON[60] rowReadOFF[61] rowReadOFF[60] openDVS_pixel2x2
x986 DiffBn VDD RefrBp GndD GndA PrSFBp OffBn PrBp OnBn pixRst[52] net107 net108 pixRst[53]
+ rowReadON[61] rowReadON[60] rowReadOFF[61] rowReadOFF[60] openDVS_pixel2x2
x987 DiffBn VDD RefrBp GndD GndA PrSFBp OffBn PrBp OnBn pixRst[54] net111 net112 pixRst[55]
+ rowReadON[61] rowReadON[60] rowReadOFF[61] rowReadOFF[60] openDVS_pixel2x2
x988 DiffBn VDD RefrBp GndD GndA PrSFBp OffBn PrBp OnBn pixRst[56] net115 net116 pixRst[57]
+ rowReadON[61] rowReadON[60] rowReadOFF[61] rowReadOFF[60] openDVS_pixel2x2
x989 DiffBn VDD RefrBp GndD GndA PrSFBp OffBn PrBp OnBn pixRst[58] net119 net120 pixRst[59]
+ rowReadON[61] rowReadON[60] rowReadOFF[61] rowReadOFF[60] openDVS_pixel2x2
x990 DiffBn VDD RefrBp GndD GndA PrSFBp OffBn PrBp OnBn pixRst[60] net123 net124 pixRst[61]
+ rowReadON[61] rowReadON[60] rowReadOFF[61] rowReadOFF[60] openDVS_pixel2x2
x991 DiffBn VDD RefrBp GndD GndA PrSFBp OffBn PrBp OnBn pixRst[62] net127 net128 pixRst[63]
+ rowReadON[61] rowReadON[60] rowReadOFF[61] rowReadOFF[60] openDVS_pixel2x2
x992 DiffBn VDD RefrBp GndD GndA PrSFBp OffBn PrBp OnBn pixRst[0] net3 net4 pixRst[1] rowReadON[63]
+ rowReadON[62] rowReadOFF[63] rowReadOFF[62] openDVS_pixel2x2
x993 DiffBn VDD RefrBp GndD GndA PrSFBp OffBn PrBp OnBn pixRst[2] net7 net8 pixRst[3] rowReadON[63]
+ rowReadON[62] rowReadOFF[63] rowReadOFF[62] openDVS_pixel2x2
x994 DiffBn VDD RefrBp GndD GndA PrSFBp OffBn PrBp OnBn pixRst[4] net11 net12 pixRst[5]
+ rowReadON[63] rowReadON[62] rowReadOFF[63] rowReadOFF[62] openDVS_pixel2x2
x995 DiffBn VDD RefrBp GndD GndA PrSFBp OffBn PrBp OnBn pixRst[6] net15 net16 pixRst[7]
+ rowReadON[63] rowReadON[62] rowReadOFF[63] rowReadOFF[62] openDVS_pixel2x2
x996 DiffBn VDD RefrBp GndD GndA PrSFBp OffBn PrBp OnBn pixRst[8] net19 net20 pixRst[9]
+ rowReadON[63] rowReadON[62] rowReadOFF[63] rowReadOFF[62] openDVS_pixel2x2
x997 DiffBn VDD RefrBp GndD GndA PrSFBp OffBn PrBp OnBn pixRst[10] net23 net24 pixRst[11]
+ rowReadON[63] rowReadON[62] rowReadOFF[63] rowReadOFF[62] openDVS_pixel2x2
x998 DiffBn VDD RefrBp GndD GndA PrSFBp OffBn PrBp OnBn pixRst[12] net27 net28 pixRst[13]
+ rowReadON[63] rowReadON[62] rowReadOFF[63] rowReadOFF[62] openDVS_pixel2x2
x999 DiffBn VDD RefrBp GndD GndA PrSFBp OffBn PrBp OnBn pixRst[14] net31 net32 pixRst[15]
+ rowReadON[63] rowReadON[62] rowReadOFF[63] rowReadOFF[62] openDVS_pixel2x2
x1000 DiffBn VDD RefrBp GndD GndA PrSFBp OffBn PrBp OnBn pixRst[16] net35 net36 pixRst[17]
+ rowReadON[63] rowReadON[62] rowReadOFF[63] rowReadOFF[62] openDVS_pixel2x2
x1001 DiffBn VDD RefrBp GndD GndA PrSFBp OffBn PrBp OnBn pixRst[18] net39 net40 pixRst[19]
+ rowReadON[63] rowReadON[62] rowReadOFF[63] rowReadOFF[62] openDVS_pixel2x2
x1002 DiffBn VDD RefrBp GndD GndA PrSFBp OffBn PrBp OnBn pixRst[20] net43 net44 pixRst[21]
+ rowReadON[63] rowReadON[62] rowReadOFF[63] rowReadOFF[62] openDVS_pixel2x2
x1003 DiffBn VDD RefrBp GndD GndA PrSFBp OffBn PrBp OnBn pixRst[22] net47 net48 pixRst[23]
+ rowReadON[63] rowReadON[62] rowReadOFF[63] rowReadOFF[62] openDVS_pixel2x2
x1004 DiffBn VDD RefrBp GndD GndA PrSFBp OffBn PrBp OnBn pixRst[24] net51 net52 pixRst[25]
+ rowReadON[63] rowReadON[62] rowReadOFF[63] rowReadOFF[62] openDVS_pixel2x2
x1005 DiffBn VDD RefrBp GndD GndA PrSFBp OffBn PrBp OnBn pixRst[26] net55 net56 pixRst[27]
+ rowReadON[63] rowReadON[62] rowReadOFF[63] rowReadOFF[62] openDVS_pixel2x2
x1006 DiffBn VDD RefrBp GndD GndA PrSFBp OffBn PrBp OnBn pixRst[28] net59 net60 pixRst[29]
+ rowReadON[63] rowReadON[62] rowReadOFF[63] rowReadOFF[62] openDVS_pixel2x2
x1007 DiffBn VDD RefrBp GndD GndA PrSFBp OffBn PrBp OnBn pixRst[30] net63 net64 pixRst[31]
+ rowReadON[63] rowReadON[62] rowReadOFF[63] rowReadOFF[62] openDVS_pixel2x2
x1008 DiffBn VDD RefrBp GndD GndA PrSFBp OffBn PrBp OnBn pixRst[32] net67 net68 pixRst[33]
+ rowReadON[63] rowReadON[62] rowReadOFF[63] rowReadOFF[62] openDVS_pixel2x2
x1009 DiffBn VDD RefrBp GndD GndA PrSFBp OffBn PrBp OnBn pixRst[34] net71 net72 pixRst[35]
+ rowReadON[63] rowReadON[62] rowReadOFF[63] rowReadOFF[62] openDVS_pixel2x2
x1010 DiffBn VDD RefrBp GndD GndA PrSFBp OffBn PrBp OnBn pixRst[36] net75 net76 pixRst[37]
+ rowReadON[63] rowReadON[62] rowReadOFF[63] rowReadOFF[62] openDVS_pixel2x2
x1011 DiffBn VDD RefrBp GndD GndA PrSFBp OffBn PrBp OnBn pixRst[38] net79 net80 pixRst[39]
+ rowReadON[63] rowReadON[62] rowReadOFF[63] rowReadOFF[62] openDVS_pixel2x2
x1012 DiffBn VDD RefrBp GndD GndA PrSFBp OffBn PrBp OnBn pixRst[40] net83 net84 pixRst[41]
+ rowReadON[63] rowReadON[62] rowReadOFF[63] rowReadOFF[62] openDVS_pixel2x2
x1013 DiffBn VDD RefrBp GndD GndA PrSFBp OffBn PrBp OnBn pixRst[42] net87 net88 pixRst[43]
+ rowReadON[63] rowReadON[62] rowReadOFF[63] rowReadOFF[62] openDVS_pixel2x2
x1014 DiffBn VDD RefrBp GndD GndA PrSFBp OffBn PrBp OnBn pixRst[44] net91 net92 pixRst[45]
+ rowReadON[63] rowReadON[62] rowReadOFF[63] rowReadOFF[62] openDVS_pixel2x2
x1015 DiffBn VDD RefrBp GndD GndA PrSFBp OffBn PrBp OnBn pixRst[46] net95 net96 pixRst[47]
+ rowReadON[63] rowReadON[62] rowReadOFF[63] rowReadOFF[62] openDVS_pixel2x2
x1016 DiffBn VDD RefrBp GndD GndA PrSFBp OffBn PrBp OnBn pixRst[48] net99 net100 pixRst[49]
+ rowReadON[63] rowReadON[62] rowReadOFF[63] rowReadOFF[62] openDVS_pixel2x2
x1017 DiffBn VDD RefrBp GndD GndA PrSFBp OffBn PrBp OnBn pixRst[50] net103 net104 pixRst[51]
+ rowReadON[63] rowReadON[62] rowReadOFF[63] rowReadOFF[62] openDVS_pixel2x2
x1018 DiffBn VDD RefrBp GndD GndA PrSFBp OffBn PrBp OnBn pixRst[52] net107 net108 pixRst[53]
+ rowReadON[63] rowReadON[62] rowReadOFF[63] rowReadOFF[62] openDVS_pixel2x2
x1019 DiffBn VDD RefrBp GndD GndA PrSFBp OffBn PrBp OnBn pixRst[54] net111 net112 pixRst[55]
+ rowReadON[63] rowReadON[62] rowReadOFF[63] rowReadOFF[62] openDVS_pixel2x2
x1020 DiffBn VDD RefrBp GndD GndA PrSFBp OffBn PrBp OnBn pixRst[56] net115 net116 pixRst[57]
+ rowReadON[63] rowReadON[62] rowReadOFF[63] rowReadOFF[62] openDVS_pixel2x2
x1021 DiffBn VDD RefrBp GndD GndA PrSFBp OffBn PrBp OnBn pixRst[58] net119 net120 pixRst[59]
+ rowReadON[63] rowReadON[62] rowReadOFF[63] rowReadOFF[62] openDVS_pixel2x2
x1022 DiffBn VDD RefrBp GndD GndA PrSFBp OffBn PrBp OnBn pixRst[60] net123 net124 pixRst[61]
+ rowReadON[63] rowReadON[62] rowReadOFF[63] rowReadOFF[62] openDVS_pixel2x2
x1023 DiffBn VDD RefrBp GndD GndA PrSFBp OffBn PrBp OnBn pixRst[62] net127 net128 pixRst[63]
+ rowReadON[63] rowReadON[62] rowReadOFF[63] rowReadOFF[62] openDVS_pixel2x2
x1088 DETECT nDETECT VTHRESH nCHARGE VDD GndA net1 net2 voutn[0] voutn[1] pixRst[0] pixRst[1]
+ col_amp_2x1
x1089 DETECT nDETECT VTHRESH nCHARGE VDD GndA net5 net6 voutn[2] voutn[3] pixRst[2] pixRst[3]
+ col_amp_2x1
x1090 DETECT nDETECT VTHRESH nCHARGE VDD GndA net9 net10 voutn[4] voutn[5] pixRst[4] pixRst[5]
+ col_amp_2x1
x1091 DETECT nDETECT VTHRESH nCHARGE VDD GndA net13 net14 voutn[6] voutn[7] pixRst[6] pixRst[7]
+ col_amp_2x1
x1092 DETECT nDETECT VTHRESH nCHARGE VDD GndA net17 net18 voutn[8] voutn[9] pixRst[8] pixRst[9]
+ col_amp_2x1
x1093 DETECT nDETECT VTHRESH nCHARGE VDD GndA net21 net22 voutn[10] voutn[11] pixRst[10] pixRst[11]
+ col_amp_2x1
x1094 DETECT nDETECT VTHRESH nCHARGE VDD GndA net25 net26 voutn[12] voutn[13] pixRst[12] pixRst[13]
+ col_amp_2x1
x1095 DETECT nDETECT VTHRESH nCHARGE VDD GndA net29 net30 voutn[14] voutn[15] pixRst[14] pixRst[15]
+ col_amp_2x1
x1096 DETECT nDETECT VTHRESH nCHARGE VDD GndA net33 net34 voutn[16] voutn[17] pixRst[16] pixRst[17]
+ col_amp_2x1
x1097 DETECT nDETECT VTHRESH nCHARGE VDD GndA net37 net38 voutn[18] voutn[19] pixRst[18] pixRst[19]
+ col_amp_2x1
x1098 DETECT nDETECT VTHRESH nCHARGE VDD GndA net41 net42 voutn[20] voutn[21] pixRst[20] pixRst[21]
+ col_amp_2x1
x1099 DETECT nDETECT VTHRESH nCHARGE VDD GndA net45 net46 voutn[22] voutn[23] pixRst[22] pixRst[23]
+ col_amp_2x1
x1100 DETECT nDETECT VTHRESH nCHARGE VDD GndA net49 net50 voutn[24] voutn[25] pixRst[24] pixRst[25]
+ col_amp_2x1
x1101 DETECT nDETECT VTHRESH nCHARGE VDD GndA net53 net54 voutn[26] voutn[27] pixRst[26] pixRst[27]
+ col_amp_2x1
x1102 DETECT nDETECT VTHRESH nCHARGE VDD GndA net57 net58 voutn[28] voutn[29] pixRst[28] pixRst[29]
+ col_amp_2x1
x1103 DETECT nDETECT VTHRESH nCHARGE VDD GndA net61 net62 voutn[30] voutn[31] pixRst[30] pixRst[31]
+ col_amp_2x1
x1104 DETECT nDETECT VTHRESH nCHARGE VDD GndA net65 net66 voutn[32] voutn[33] pixRst[32] pixRst[33]
+ col_amp_2x1
x1105 DETECT nDETECT VTHRESH nCHARGE VDD GndA net69 net70 voutn[34] voutn[35] pixRst[34] pixRst[35]
+ col_amp_2x1
x1106 DETECT nDETECT VTHRESH nCHARGE VDD GndA net73 net74 voutn[36] voutn[37] pixRst[36] pixRst[37]
+ col_amp_2x1
x1107 DETECT nDETECT VTHRESH nCHARGE VDD GndA net77 net78 voutn[38] voutn[39] pixRst[38] pixRst[39]
+ col_amp_2x1
x1108 DETECT nDETECT VTHRESH nCHARGE VDD GndA net81 net82 voutn[40] voutn[41] pixRst[40] pixRst[41]
+ col_amp_2x1
x1109 DETECT nDETECT VTHRESH nCHARGE VDD GndA net85 net86 voutn[42] voutn[43] pixRst[42] pixRst[43]
+ col_amp_2x1
x1110 DETECT nDETECT VTHRESH nCHARGE VDD GndA net89 net90 voutn[44] voutn[45] pixRst[44] pixRst[45]
+ col_amp_2x1
x1111 DETECT nDETECT VTHRESH nCHARGE VDD GndA net93 net94 voutn[46] voutn[47] pixRst[46] pixRst[47]
+ col_amp_2x1
x1112 DETECT nDETECT VTHRESH nCHARGE VDD GndA net97 net98 voutn[48] voutn[49] pixRst[48] pixRst[49]
+ col_amp_2x1
x1113 DETECT nDETECT VTHRESH nCHARGE VDD GndA net101 net102 voutn[50] voutn[51] pixRst[50]
+ pixRst[51] col_amp_2x1
x1114 DETECT nDETECT VTHRESH nCHARGE VDD GndA net105 net106 voutn[52] voutn[53] pixRst[52]
+ pixRst[53] col_amp_2x1
x1115 DETECT nDETECT VTHRESH nCHARGE VDD GndA net109 net110 voutn[54] voutn[55] pixRst[54]
+ pixRst[55] col_amp_2x1
x1116 DETECT nDETECT VTHRESH nCHARGE VDD GndA net113 net114 voutn[56] voutn[57] pixRst[56]
+ pixRst[57] col_amp_2x1
x1117 DETECT nDETECT VTHRESH nCHARGE VDD GndA net117 net118 voutn[58] voutn[59] pixRst[58]
+ pixRst[59] col_amp_2x1
x1118 DETECT nDETECT VTHRESH nCHARGE VDD GndA net121 net122 voutn[60] voutn[61] pixRst[60]
+ pixRst[61] col_amp_2x1
x1119 DETECT nDETECT VTHRESH nCHARGE VDD GndA net125 net126 voutn[62] voutn[63] pixRst[62]
+ pixRst[63] col_amp_2x1
.ends

* expanding   symbol:  pixel_layout_tile_bot.sym # of pins=29
** sym_path: /home/alienfalcon/Projects/skywater/open_dvs_py312/open_dvs/git_dvs/nic2025_openDVS/analog/xschem/pixel_layout_tile_bot.sym
** sch_path: /home/alienfalcon/Projects/skywater/open_dvs_py312/open_dvs/git_dvs/nic2025_openDVS/analog/xschem/pixel_layout_tile_bot.sch
.subckt pixel_layout_tile_bot DiffBn RefrBp PrBp GndA PrSFBp OffBn VDD OnBn VTHRESH nCHARGE rowReadOFF[63] rowReadOFF[62] rowReadOFF[61] rowReadOFF[60] rowReadOFF[59] rowReadOFF[58] rowReadOFF[57] rowReadOFF[56] rowReadOFF[55] rowReadOFF[54] rowReadOFF[53] rowReadOFF[52] rowReadOFF[51] rowReadOFF[50] rowReadOFF[49] rowReadOFF[48] rowReadOFF[47] rowReadOFF[46] rowReadOFF[45] rowReadOFF[44] rowReadOFF[43] rowReadOFF[42] rowReadOFF[41] rowReadOFF[40] rowReadOFF[39] rowReadOFF[38] rowReadOFF[37] rowReadOFF[36] rowReadOFF[35] rowReadOFF[34] rowReadOFF[33] rowReadOFF[32] rowReadOFF[31] rowReadOFF[30] rowReadOFF[29] rowReadOFF[28] rowReadOFF[27] rowReadOFF[26] rowReadOFF[25] rowReadOFF[24] rowReadOFF[23] rowReadOFF[22] rowReadOFF[21] rowReadOFF[20] rowReadOFF[19] rowReadOFF[18] rowReadOFF[17] rowReadOFF[16] rowReadOFF[15] rowReadOFF[14] rowReadOFF[13] rowReadOFF[12] rowReadOFF[11] rowReadOFF[10] rowReadOFF[9] rowReadOFF[8] rowReadOFF[7] rowReadOFF[6] rowReadOFF[5] rowReadOFF[4] rowReadOFF[3] rowReadOFF[2] rowReadOFF[1] rowReadOFF[0] rowReadON[63] rowReadON[62] rowReadON[61] rowReadON[60] rowReadON[59] rowReadON[58] rowReadON[57] rowReadON[56] rowReadON[55] rowReadON[54] rowReadON[53] rowReadON[52] rowReadON[51] rowReadON[50] rowReadON[49] rowReadON[48] rowReadON[47] rowReadON[46] rowReadON[45] rowReadON[44] rowReadON[43] rowReadON[42] rowReadON[41] rowReadON[40] rowReadON[39] rowReadON[38] rowReadON[37] rowReadON[36] rowReadON[35] rowReadON[34] rowReadON[33] rowReadON[32] rowReadON[31] rowReadON[30] rowReadON[29] rowReadON[28] rowReadON[27] rowReadON[26] rowReadON[25] rowReadON[24] rowReadON[23] rowReadON[22] rowReadON[21] rowReadON[20] rowReadON[19] rowReadON[18] rowReadON[17] rowReadON[16] rowReadON[15] rowReadON[14] rowReadON[13] rowReadON[12] rowReadON[11] rowReadON[10] rowReadON[9] rowReadON[8] rowReadON[7] rowReadON[6] rowReadON[5] rowReadON[4] rowReadON[3] rowReadON[2] rowReadON[1] rowReadON[0] DETECT pixRst[63] pixRst[62] pixRst[61] pixRst[60] pixRst[59] pixRst[58] pixRst[57] pixRst[56] pixRst[55] pixRst[54] pixRst[53] pixRst[52] pixRst[51] pixRst[50] pixRst[49] pixRst[48] pixRst[47] pixRst[46] pixRst[45] pixRst[44] pixRst[43] pixRst[42] pixRst[41] pixRst[40] pixRst[39] pixRst[38] pixRst[37] pixRst[36] pixRst[35] pixRst[34] pixRst[33] pixRst[32] pixRst[31] pixRst[30] pixRst[29] pixRst[28] pixRst[27] pixRst[26] pixRst[25] pixRst[24] pixRst[23] pixRst[22] pixRst[21] pixRst[20] pixRst[19] pixRst[18] pixRst[17] pixRst[16] pixRst[15] pixRst[14] pixRst[13] pixRst[12] pixRst[11] pixRst[10] pixRst[9] pixRst[8] pixRst[7] pixRst[6] pixRst[5] pixRst[4] pixRst[3] pixRst[2] pixRst[1] pixRst[0] voutn[63] voutn[62] voutn[61] voutn[60] voutn[59] voutn[58] voutn[57] voutn[56] voutn[55] voutn[54] voutn[53] voutn[52] voutn[51] voutn[50] voutn[49] voutn[48] voutn[47] voutn[46] voutn[45] voutn[44] voutn[43] voutn[42] voutn[41] voutn[40] voutn[39] voutn[38] voutn[37] voutn[36] voutn[35] voutn[34] voutn[33] voutn[32] voutn[31] voutn[30] voutn[29] voutn[28] voutn[27] voutn[26] voutn[25] voutn[24] voutn[23] voutn[22] voutn[21] voutn[20] voutn[19] voutn[18] voutn[17] voutn[16] voutn[15] voutn[14] voutn[13] voutn[12] voutn[11] voutn[10] voutn[9] voutn[8] voutn[7] voutn[6] voutn[5] voutn[4] voutn[3] voutn[2] voutn[1] voutn[0] nDETECT GndD
*.iopin GndA
*.iopin VDD
*.iopin OffBn
*.iopin OnBn
*.iopin DiffBn
*.iopin RefrBp
*.iopin PrSFBp
*.iopin PrBp
*.iopin nCHARGE
*.iopin VTHRESH
*.iopin nDETECT
*.iopin DETECT
*.iopin
*+ rowReadON[63],rowReadON[62],rowReadON[61],rowReadON[60],rowReadON[59],rowReadON[58],rowReadON[57],rowReadON[56],rowReadON[55],rowReadON[54],rowReadON[53],rowReadON[52],rowReadON[51],rowReadON[50],rowReadON[49],rowReadON[48],rowReadON[47],rowReadON[46],rowReadON[45],rowReadON[44],rowReadON[43],rowReadON[42],rowReadON[41],rowReadON[40],rowReadON[39],rowReadON[38],rowReadON[37],rowReadON[36],rowReadON[35],rowReadON[34],rowReadON[33],rowReadON[32],rowReadON[31],rowReadON[30],rowReadON[29],rowReadON[28],rowReadON[27],rowReadON[26],rowReadON[25],rowReadON[24],rowReadON[23],rowReadON[22],rowReadON[21],rowReadON[20],rowReadON[19],rowReadON[18],rowReadON[17],rowReadON[16],rowReadON[15],rowReadON[14],rowReadON[13],rowReadON[12],rowReadON[11],rowReadON[10],rowReadON[9],rowReadON[8],rowReadON[7],rowReadON[6],rowReadON[5],rowReadON[4],rowReadON[3],rowReadON[2],rowReadON[1],rowReadON[0]
*.iopin
*+ rowReadOFF[63],rowReadOFF[62],rowReadOFF[61],rowReadOFF[60],rowReadOFF[59],rowReadOFF[58],rowReadOFF[57],rowReadOFF[56],rowReadOFF[55],rowReadOFF[54],rowReadOFF[53],rowReadOFF[52],rowReadOFF[51],rowReadOFF[50],rowReadOFF[49],rowReadOFF[48],rowReadOFF[47],rowReadOFF[46],rowReadOFF[45],rowReadOFF[44],rowReadOFF[43],rowReadOFF[42],rowReadOFF[41],rowReadOFF[40],rowReadOFF[39],rowReadOFF[38],rowReadOFF[37],rowReadOFF[36],rowReadOFF[35],rowReadOFF[34],rowReadOFF[33],rowReadOFF[32],rowReadOFF[31],rowReadOFF[30],rowReadOFF[29],rowReadOFF[28],rowReadOFF[27],rowReadOFF[26],rowReadOFF[25],rowReadOFF[24],rowReadOFF[23],rowReadOFF[22],rowReadOFF[21],rowReadOFF[20],rowReadOFF[19],rowReadOFF[18],rowReadOFF[17],rowReadOFF[16],rowReadOFF[15],rowReadOFF[14],rowReadOFF[13],rowReadOFF[12],rowReadOFF[11],rowReadOFF[10],rowReadOFF[9],rowReadOFF[8],rowReadOFF[7],rowReadOFF[6],rowReadOFF[5],rowReadOFF[4],rowReadOFF[3],rowReadOFF[2],rowReadOFF[1],rowReadOFF[0]
*.iopin
*+ pixRst[63],pixRst[62],pixRst[61],pixRst[60],pixRst[59],pixRst[58],pixRst[57],pixRst[56],pixRst[55],pixRst[54],pixRst[53],pixRst[52],pixRst[51],pixRst[50],pixRst[49],pixRst[48],pixRst[47],pixRst[46],pixRst[45],pixRst[44],pixRst[43],pixRst[42],pixRst[41],pixRst[40],pixRst[39],pixRst[38],pixRst[37],pixRst[36],pixRst[35],pixRst[34],pixRst[33],pixRst[32],pixRst[31],pixRst[30],pixRst[29],pixRst[28],pixRst[27],pixRst[26],pixRst[25],pixRst[24],pixRst[23],pixRst[22],pixRst[21],pixRst[20],pixRst[19],pixRst[18],pixRst[17],pixRst[16],pixRst[15],pixRst[14],pixRst[13],pixRst[12],pixRst[11],pixRst[10],pixRst[9],pixRst[8],pixRst[7],pixRst[6],pixRst[5],pixRst[4],pixRst[3],pixRst[2],pixRst[1],pixRst[0]
*.iopin
*+ voutn[63],voutn[62],voutn[61],voutn[60],voutn[59],voutn[58],voutn[57],voutn[56],voutn[55],voutn[54],voutn[53],voutn[52],voutn[51],voutn[50],voutn[49],voutn[48],voutn[47],voutn[46],voutn[45],voutn[44],voutn[43],voutn[42],voutn[41],voutn[40],voutn[39],voutn[38],voutn[37],voutn[36],voutn[35],voutn[34],voutn[33],voutn[32],voutn[31],voutn[30],voutn[29],voutn[28],voutn[27],voutn[26],voutn[25],voutn[24],voutn[23],voutn[22],voutn[21],voutn[20],voutn[19],voutn[18],voutn[17],voutn[16],voutn[15],voutn[14],voutn[13],voutn[12],voutn[11],voutn[10],voutn[9],voutn[8],voutn[7],voutn[6],voutn[5],voutn[4],voutn[3],voutn[2],voutn[1],voutn[0]
*.iopin GndD
x0 DiffBn VDD RefrBp GndD GndA PrSFBp OffBn PrBp OnBn pixRst[0] net1 net2 pixRst[1] rowReadON[62]
+ rowReadON[63] rowReadOFF[62] rowReadOFF[63] openDVS_pixel2x2
x1 DiffBn VDD RefrBp GndD GndA PrSFBp OffBn PrBp OnBn pixRst[2] net5 net6 pixRst[3] rowReadON[62]
+ rowReadON[63] rowReadOFF[62] rowReadOFF[63] openDVS_pixel2x2
x2 DiffBn VDD RefrBp GndD GndA PrSFBp OffBn PrBp OnBn pixRst[4] net9 net10 pixRst[5] rowReadON[62]
+ rowReadON[63] rowReadOFF[62] rowReadOFF[63] openDVS_pixel2x2
x3 DiffBn VDD RefrBp GndD GndA PrSFBp OffBn PrBp OnBn pixRst[6] net13 net14 pixRst[7] rowReadON[62]
+ rowReadON[63] rowReadOFF[62] rowReadOFF[63] openDVS_pixel2x2
x4 DiffBn VDD RefrBp GndD GndA PrSFBp OffBn PrBp OnBn pixRst[8] net17 net18 pixRst[9] rowReadON[62]
+ rowReadON[63] rowReadOFF[62] rowReadOFF[63] openDVS_pixel2x2
x5 DiffBn VDD RefrBp GndD GndA PrSFBp OffBn PrBp OnBn pixRst[10] net21 net22 pixRst[11]
+ rowReadON[62] rowReadON[63] rowReadOFF[62] rowReadOFF[63] openDVS_pixel2x2
x6 DiffBn VDD RefrBp GndD GndA PrSFBp OffBn PrBp OnBn pixRst[12] net25 net26 pixRst[13]
+ rowReadON[62] rowReadON[63] rowReadOFF[62] rowReadOFF[63] openDVS_pixel2x2
x7 DiffBn VDD RefrBp GndD GndA PrSFBp OffBn PrBp OnBn pixRst[14] net29 net30 pixRst[15]
+ rowReadON[62] rowReadON[63] rowReadOFF[62] rowReadOFF[63] openDVS_pixel2x2
x8 DiffBn VDD RefrBp GndD GndA PrSFBp OffBn PrBp OnBn pixRst[16] net33 net34 pixRst[17]
+ rowReadON[62] rowReadON[63] rowReadOFF[62] rowReadOFF[63] openDVS_pixel2x2
x9 DiffBn VDD RefrBp GndD GndA PrSFBp OffBn PrBp OnBn pixRst[18] net37 net38 pixRst[19]
+ rowReadON[62] rowReadON[63] rowReadOFF[62] rowReadOFF[63] openDVS_pixel2x2
x10 DiffBn VDD RefrBp GndD GndA PrSFBp OffBn PrBp OnBn pixRst[20] net41 net42 pixRst[21]
+ rowReadON[62] rowReadON[63] rowReadOFF[62] rowReadOFF[63] openDVS_pixel2x2
x11 DiffBn VDD RefrBp GndD GndA PrSFBp OffBn PrBp OnBn pixRst[22] net45 net46 pixRst[23]
+ rowReadON[62] rowReadON[63] rowReadOFF[62] rowReadOFF[63] openDVS_pixel2x2
x12 DiffBn VDD RefrBp GndD GndA PrSFBp OffBn PrBp OnBn pixRst[24] net49 net50 pixRst[25]
+ rowReadON[62] rowReadON[63] rowReadOFF[62] rowReadOFF[63] openDVS_pixel2x2
x13 DiffBn VDD RefrBp GndD GndA PrSFBp OffBn PrBp OnBn pixRst[26] net53 net54 pixRst[27]
+ rowReadON[62] rowReadON[63] rowReadOFF[62] rowReadOFF[63] openDVS_pixel2x2
x14 DiffBn VDD RefrBp GndD GndA PrSFBp OffBn PrBp OnBn pixRst[28] net57 net58 pixRst[29]
+ rowReadON[62] rowReadON[63] rowReadOFF[62] rowReadOFF[63] openDVS_pixel2x2
x15 DiffBn VDD RefrBp GndD GndA PrSFBp OffBn PrBp OnBn pixRst[30] net61 net62 pixRst[31]
+ rowReadON[62] rowReadON[63] rowReadOFF[62] rowReadOFF[63] openDVS_pixel2x2
x16 DiffBn VDD RefrBp GndD GndA PrSFBp OffBn PrBp OnBn pixRst[32] net65 net66 pixRst[33]
+ rowReadON[62] rowReadON[63] rowReadOFF[62] rowReadOFF[63] openDVS_pixel2x2
x17 DiffBn VDD RefrBp GndD GndA PrSFBp OffBn PrBp OnBn pixRst[34] net69 net70 pixRst[35]
+ rowReadON[62] rowReadON[63] rowReadOFF[62] rowReadOFF[63] openDVS_pixel2x2
x18 DiffBn VDD RefrBp GndD GndA PrSFBp OffBn PrBp OnBn pixRst[36] net73 net74 pixRst[37]
+ rowReadON[62] rowReadON[63] rowReadOFF[62] rowReadOFF[63] openDVS_pixel2x2
x19 DiffBn VDD RefrBp GndD GndA PrSFBp OffBn PrBp OnBn pixRst[38] net77 net78 pixRst[39]
+ rowReadON[62] rowReadON[63] rowReadOFF[62] rowReadOFF[63] openDVS_pixel2x2
x20 DiffBn VDD RefrBp GndD GndA PrSFBp OffBn PrBp OnBn pixRst[40] net81 net82 pixRst[41]
+ rowReadON[62] rowReadON[63] rowReadOFF[62] rowReadOFF[63] openDVS_pixel2x2
x21 DiffBn VDD RefrBp GndD GndA PrSFBp OffBn PrBp OnBn pixRst[42] net85 net86 pixRst[43]
+ rowReadON[62] rowReadON[63] rowReadOFF[62] rowReadOFF[63] openDVS_pixel2x2
x22 DiffBn VDD RefrBp GndD GndA PrSFBp OffBn PrBp OnBn pixRst[44] net89 net90 pixRst[45]
+ rowReadON[62] rowReadON[63] rowReadOFF[62] rowReadOFF[63] openDVS_pixel2x2
x23 DiffBn VDD RefrBp GndD GndA PrSFBp OffBn PrBp OnBn pixRst[46] net93 net94 pixRst[47]
+ rowReadON[62] rowReadON[63] rowReadOFF[62] rowReadOFF[63] openDVS_pixel2x2
x24 DiffBn VDD RefrBp GndD GndA PrSFBp OffBn PrBp OnBn pixRst[48] net97 net98 pixRst[49]
+ rowReadON[62] rowReadON[63] rowReadOFF[62] rowReadOFF[63] openDVS_pixel2x2
x25 DiffBn VDD RefrBp GndD GndA PrSFBp OffBn PrBp OnBn pixRst[50] net101 net102 pixRst[51]
+ rowReadON[62] rowReadON[63] rowReadOFF[62] rowReadOFF[63] openDVS_pixel2x2
x26 DiffBn VDD RefrBp GndD GndA PrSFBp OffBn PrBp OnBn pixRst[52] net105 net106 pixRst[53]
+ rowReadON[62] rowReadON[63] rowReadOFF[62] rowReadOFF[63] openDVS_pixel2x2
x27 DiffBn VDD RefrBp GndD GndA PrSFBp OffBn PrBp OnBn pixRst[54] net109 net110 pixRst[55]
+ rowReadON[62] rowReadON[63] rowReadOFF[62] rowReadOFF[63] openDVS_pixel2x2
x28 DiffBn VDD RefrBp GndD GndA PrSFBp OffBn PrBp OnBn pixRst[56] net113 net114 pixRst[57]
+ rowReadON[62] rowReadON[63] rowReadOFF[62] rowReadOFF[63] openDVS_pixel2x2
x29 DiffBn VDD RefrBp GndD GndA PrSFBp OffBn PrBp OnBn pixRst[58] net117 net118 pixRst[59]
+ rowReadON[62] rowReadON[63] rowReadOFF[62] rowReadOFF[63] openDVS_pixel2x2
x30 DiffBn VDD RefrBp GndD GndA PrSFBp OffBn PrBp OnBn pixRst[60] net121 net122 pixRst[61]
+ rowReadON[62] rowReadON[63] rowReadOFF[62] rowReadOFF[63] openDVS_pixel2x2
x31 DiffBn VDD RefrBp GndD GndA PrSFBp OffBn PrBp OnBn pixRst[62] net125 net126 pixRst[63]
+ rowReadON[62] rowReadON[63] rowReadOFF[62] rowReadOFF[63] openDVS_pixel2x2
x32 DiffBn VDD RefrBp GndD GndA PrSFBp OffBn PrBp OnBn pixRst[0] net3 net4 pixRst[1] rowReadOFF[60]
+ rowReadON[61] rowReadON[60] rowReadOFF[61] openDVS_pixel2x2
x33 DiffBn VDD RefrBp GndD GndA PrSFBp OffBn PrBp OnBn pixRst[2] net7 net8 pixRst[3] rowReadOFF[60]
+ rowReadON[61] rowReadON[60] rowReadOFF[61] openDVS_pixel2x2
x34 DiffBn VDD RefrBp GndD GndA PrSFBp OffBn PrBp OnBn pixRst[4] net11 net12 pixRst[5]
+ rowReadOFF[60] rowReadON[61] rowReadON[60] rowReadOFF[61] openDVS_pixel2x2
x35 DiffBn VDD RefrBp GndD GndA PrSFBp OffBn PrBp OnBn pixRst[6] net15 net16 pixRst[7]
+ rowReadOFF[60] rowReadON[61] rowReadON[60] rowReadOFF[61] openDVS_pixel2x2
x36 DiffBn VDD RefrBp GndD GndA PrSFBp OffBn PrBp OnBn pixRst[8] net19 net20 pixRst[9]
+ rowReadOFF[60] rowReadON[61] rowReadON[60] rowReadOFF[61] openDVS_pixel2x2
x37 DiffBn VDD RefrBp GndD GndA PrSFBp OffBn PrBp OnBn pixRst[10] net23 net24 pixRst[11]
+ rowReadOFF[60] rowReadON[61] rowReadON[60] rowReadOFF[61] openDVS_pixel2x2
x38 DiffBn VDD RefrBp GndD GndA PrSFBp OffBn PrBp OnBn pixRst[12] net27 net28 pixRst[13]
+ rowReadOFF[60] rowReadON[61] rowReadON[60] rowReadOFF[61] openDVS_pixel2x2
x39 DiffBn VDD RefrBp GndD GndA PrSFBp OffBn PrBp OnBn pixRst[14] net31 net32 pixRst[15]
+ rowReadOFF[60] rowReadON[61] rowReadON[60] rowReadOFF[61] openDVS_pixel2x2
x40 DiffBn VDD RefrBp GndD GndA PrSFBp OffBn PrBp OnBn pixRst[16] net35 net36 pixRst[17]
+ rowReadOFF[60] rowReadON[61] rowReadON[60] rowReadOFF[61] openDVS_pixel2x2
x41 DiffBn VDD RefrBp GndD GndA PrSFBp OffBn PrBp OnBn pixRst[18] net39 net40 pixRst[19]
+ rowReadOFF[60] rowReadON[61] rowReadON[60] rowReadOFF[61] openDVS_pixel2x2
x42 DiffBn VDD RefrBp GndD GndA PrSFBp OffBn PrBp OnBn pixRst[20] net43 net44 pixRst[21]
+ rowReadOFF[60] rowReadON[61] rowReadON[60] rowReadOFF[61] openDVS_pixel2x2
x43 DiffBn VDD RefrBp GndD GndA PrSFBp OffBn PrBp OnBn pixRst[22] net47 net48 pixRst[23]
+ rowReadOFF[60] rowReadON[61] rowReadON[60] rowReadOFF[61] openDVS_pixel2x2
x44 DiffBn VDD RefrBp GndD GndA PrSFBp OffBn PrBp OnBn pixRst[24] net51 net52 pixRst[25]
+ rowReadOFF[60] rowReadON[61] rowReadON[60] rowReadOFF[61] openDVS_pixel2x2
x45 DiffBn VDD RefrBp GndD GndA PrSFBp OffBn PrBp OnBn pixRst[26] net55 net56 pixRst[27]
+ rowReadOFF[60] rowReadON[61] rowReadON[60] rowReadOFF[61] openDVS_pixel2x2
x46 DiffBn VDD RefrBp GndD GndA PrSFBp OffBn PrBp OnBn pixRst[28] net59 net60 pixRst[29]
+ rowReadOFF[60] rowReadON[61] rowReadON[60] rowReadOFF[61] openDVS_pixel2x2
x47 DiffBn VDD RefrBp GndD GndA PrSFBp OffBn PrBp OnBn pixRst[30] net63 net64 pixRst[31]
+ rowReadOFF[60] rowReadON[61] rowReadON[60] rowReadOFF[61] openDVS_pixel2x2
x48 DiffBn VDD RefrBp GndD GndA PrSFBp OffBn PrBp OnBn pixRst[32] net67 net68 pixRst[33]
+ rowReadOFF[60] rowReadON[61] rowReadON[60] rowReadOFF[61] openDVS_pixel2x2
x49 DiffBn VDD RefrBp GndD GndA PrSFBp OffBn PrBp OnBn pixRst[34] net71 net72 pixRst[35]
+ rowReadOFF[60] rowReadON[61] rowReadON[60] rowReadOFF[61] openDVS_pixel2x2
x50 DiffBn VDD RefrBp GndD GndA PrSFBp OffBn PrBp OnBn pixRst[36] net75 net76 pixRst[37]
+ rowReadOFF[60] rowReadON[61] rowReadON[60] rowReadOFF[61] openDVS_pixel2x2
x51 DiffBn VDD RefrBp GndD GndA PrSFBp OffBn PrBp OnBn pixRst[38] net79 net80 pixRst[39]
+ rowReadOFF[60] rowReadON[61] rowReadON[60] rowReadOFF[61] openDVS_pixel2x2
x52 DiffBn VDD RefrBp GndD GndA PrSFBp OffBn PrBp OnBn pixRst[40] net83 net84 pixRst[41]
+ rowReadOFF[60] rowReadON[61] rowReadON[60] rowReadOFF[61] openDVS_pixel2x2
x53 DiffBn VDD RefrBp GndD GndA PrSFBp OffBn PrBp OnBn pixRst[42] net87 net88 pixRst[43]
+ rowReadOFF[60] rowReadON[61] rowReadON[60] rowReadOFF[61] openDVS_pixel2x2
x54 DiffBn VDD RefrBp GndD GndA PrSFBp OffBn PrBp OnBn pixRst[44] net91 net92 pixRst[45]
+ rowReadOFF[60] rowReadON[61] rowReadON[60] rowReadOFF[61] openDVS_pixel2x2
x55 DiffBn VDD RefrBp GndD GndA PrSFBp OffBn PrBp OnBn pixRst[46] net95 net96 pixRst[47]
+ rowReadOFF[60] rowReadON[61] rowReadON[60] rowReadOFF[61] openDVS_pixel2x2
x56 DiffBn VDD RefrBp GndD GndA PrSFBp OffBn PrBp OnBn pixRst[48] net99 net100 pixRst[49]
+ rowReadOFF[60] rowReadON[61] rowReadON[60] rowReadOFF[61] openDVS_pixel2x2
x57 DiffBn VDD RefrBp GndD GndA PrSFBp OffBn PrBp OnBn pixRst[50] net103 net104 pixRst[51]
+ rowReadOFF[60] rowReadON[61] rowReadON[60] rowReadOFF[61] openDVS_pixel2x2
x58 DiffBn VDD RefrBp GndD GndA PrSFBp OffBn PrBp OnBn pixRst[52] net107 net108 pixRst[53]
+ rowReadOFF[60] rowReadON[61] rowReadON[60] rowReadOFF[61] openDVS_pixel2x2
x59 DiffBn VDD RefrBp GndD GndA PrSFBp OffBn PrBp OnBn pixRst[54] net111 net112 pixRst[55]
+ rowReadOFF[60] rowReadON[61] rowReadON[60] rowReadOFF[61] openDVS_pixel2x2
x60 DiffBn VDD RefrBp GndD GndA PrSFBp OffBn PrBp OnBn pixRst[56] net115 net116 pixRst[57]
+ rowReadOFF[60] rowReadON[61] rowReadON[60] rowReadOFF[61] openDVS_pixel2x2
x61 DiffBn VDD RefrBp GndD GndA PrSFBp OffBn PrBp OnBn pixRst[58] net119 net120 pixRst[59]
+ rowReadOFF[60] rowReadON[61] rowReadON[60] rowReadOFF[61] openDVS_pixel2x2
x62 DiffBn VDD RefrBp GndD GndA PrSFBp OffBn PrBp OnBn pixRst[60] net123 net124 pixRst[61]
+ rowReadOFF[60] rowReadON[61] rowReadON[60] rowReadOFF[61] openDVS_pixel2x2
x63 DiffBn VDD RefrBp GndD GndA PrSFBp OffBn PrBp OnBn pixRst[62] net127 net128 pixRst[63]
+ rowReadOFF[60] rowReadON[61] rowReadON[60] rowReadOFF[61] openDVS_pixel2x2
x64 DiffBn VDD RefrBp GndD GndA PrSFBp OffBn PrBp OnBn pixRst[0] net3 net4 pixRst[1] rowReadON[58]
+ rowReadON[59] rowReadOFF[58] rowReadOFF[59] openDVS_pixel2x2
x65 DiffBn VDD RefrBp GndD GndA PrSFBp OffBn PrBp OnBn pixRst[2] net7 net8 pixRst[3] rowReadON[58]
+ rowReadON[59] rowReadOFF[58] rowReadOFF[59] openDVS_pixel2x2
x66 DiffBn VDD RefrBp GndD GndA PrSFBp OffBn PrBp OnBn pixRst[4] net11 net12 pixRst[5] rowReadON[58]
+ rowReadON[59] rowReadOFF[58] rowReadOFF[59] openDVS_pixel2x2
x67 DiffBn VDD RefrBp GndD GndA PrSFBp OffBn PrBp OnBn pixRst[6] net15 net16 pixRst[7] rowReadON[58]
+ rowReadON[59] rowReadOFF[58] rowReadOFF[59] openDVS_pixel2x2
x68 DiffBn VDD RefrBp GndD GndA PrSFBp OffBn PrBp OnBn pixRst[8] net19 net20 pixRst[9] rowReadON[58]
+ rowReadON[59] rowReadOFF[58] rowReadOFF[59] openDVS_pixel2x2
x69 DiffBn VDD RefrBp GndD GndA PrSFBp OffBn PrBp OnBn pixRst[10] net23 net24 pixRst[11]
+ rowReadON[58] rowReadON[59] rowReadOFF[58] rowReadOFF[59] openDVS_pixel2x2
x70 DiffBn VDD RefrBp GndD GndA PrSFBp OffBn PrBp OnBn pixRst[12] net27 net28 pixRst[13]
+ rowReadON[58] rowReadON[59] rowReadOFF[58] rowReadOFF[59] openDVS_pixel2x2
x71 DiffBn VDD RefrBp GndD GndA PrSFBp OffBn PrBp OnBn pixRst[14] net31 net32 pixRst[15]
+ rowReadON[58] rowReadON[59] rowReadOFF[58] rowReadOFF[59] openDVS_pixel2x2
x72 DiffBn VDD RefrBp GndD GndA PrSFBp OffBn PrBp OnBn pixRst[16] net35 net36 pixRst[17]
+ rowReadON[58] rowReadON[59] rowReadOFF[58] rowReadOFF[59] openDVS_pixel2x2
x73 DiffBn VDD RefrBp GndD GndA PrSFBp OffBn PrBp OnBn pixRst[18] net39 net40 pixRst[19]
+ rowReadON[58] rowReadON[59] rowReadOFF[58] rowReadOFF[59] openDVS_pixel2x2
x74 DiffBn VDD RefrBp GndD GndA PrSFBp OffBn PrBp OnBn pixRst[20] net43 net44 pixRst[21]
+ rowReadON[58] rowReadON[59] rowReadOFF[58] rowReadOFF[59] openDVS_pixel2x2
x75 DiffBn VDD RefrBp GndD GndA PrSFBp OffBn PrBp OnBn pixRst[22] net47 net48 pixRst[23]
+ rowReadON[58] rowReadON[59] rowReadOFF[58] rowReadOFF[59] openDVS_pixel2x2
x76 DiffBn VDD RefrBp GndD GndA PrSFBp OffBn PrBp OnBn pixRst[24] net51 net52 pixRst[25]
+ rowReadON[58] rowReadON[59] rowReadOFF[58] rowReadOFF[59] openDVS_pixel2x2
x77 DiffBn VDD RefrBp GndD GndA PrSFBp OffBn PrBp OnBn pixRst[26] net55 net56 pixRst[27]
+ rowReadON[58] rowReadON[59] rowReadOFF[58] rowReadOFF[59] openDVS_pixel2x2
x78 DiffBn VDD RefrBp GndD GndA PrSFBp OffBn PrBp OnBn pixRst[28] net59 net60 pixRst[29]
+ rowReadON[58] rowReadON[59] rowReadOFF[58] rowReadOFF[59] openDVS_pixel2x2
x79 DiffBn VDD RefrBp GndD GndA PrSFBp OffBn PrBp OnBn pixRst[30] net63 net64 pixRst[31]
+ rowReadON[58] rowReadON[59] rowReadOFF[58] rowReadOFF[59] openDVS_pixel2x2
x80 DiffBn VDD RefrBp GndD GndA PrSFBp OffBn PrBp OnBn pixRst[32] net67 net68 pixRst[33]
+ rowReadON[58] rowReadON[59] rowReadOFF[58] rowReadOFF[59] openDVS_pixel2x2
x81 DiffBn VDD RefrBp GndD GndA PrSFBp OffBn PrBp OnBn pixRst[34] net71 net72 pixRst[35]
+ rowReadON[58] rowReadON[59] rowReadOFF[58] rowReadOFF[59] openDVS_pixel2x2
x82 DiffBn VDD RefrBp GndD GndA PrSFBp OffBn PrBp OnBn pixRst[36] net75 net76 pixRst[37]
+ rowReadON[58] rowReadON[59] rowReadOFF[58] rowReadOFF[59] openDVS_pixel2x2
x83 DiffBn VDD RefrBp GndD GndA PrSFBp OffBn PrBp OnBn pixRst[38] net79 net80 pixRst[39]
+ rowReadON[58] rowReadON[59] rowReadOFF[58] rowReadOFF[59] openDVS_pixel2x2
x84 DiffBn VDD RefrBp GndD GndA PrSFBp OffBn PrBp OnBn pixRst[40] net83 net84 pixRst[41]
+ rowReadON[58] rowReadON[59] rowReadOFF[58] rowReadOFF[59] openDVS_pixel2x2
x85 DiffBn VDD RefrBp GndD GndA PrSFBp OffBn PrBp OnBn pixRst[42] net87 net88 pixRst[43]
+ rowReadON[58] rowReadON[59] rowReadOFF[58] rowReadOFF[59] openDVS_pixel2x2
x86 DiffBn VDD RefrBp GndD GndA PrSFBp OffBn PrBp OnBn pixRst[44] net91 net92 pixRst[45]
+ rowReadON[58] rowReadON[59] rowReadOFF[58] rowReadOFF[59] openDVS_pixel2x2
x87 DiffBn VDD RefrBp GndD GndA PrSFBp OffBn PrBp OnBn pixRst[46] net95 net96 pixRst[47]
+ rowReadON[58] rowReadON[59] rowReadOFF[58] rowReadOFF[59] openDVS_pixel2x2
x88 DiffBn VDD RefrBp GndD GndA PrSFBp OffBn PrBp OnBn pixRst[48] net99 net100 pixRst[49]
+ rowReadON[58] rowReadON[59] rowReadOFF[58] rowReadOFF[59] openDVS_pixel2x2
x89 DiffBn VDD RefrBp GndD GndA PrSFBp OffBn PrBp OnBn pixRst[50] net103 net104 pixRst[51]
+ rowReadON[58] rowReadON[59] rowReadOFF[58] rowReadOFF[59] openDVS_pixel2x2
x90 DiffBn VDD RefrBp GndD GndA PrSFBp OffBn PrBp OnBn pixRst[52] net107 net108 pixRst[53]
+ rowReadON[58] rowReadON[59] rowReadOFF[58] rowReadOFF[59] openDVS_pixel2x2
x91 DiffBn VDD RefrBp GndD GndA PrSFBp OffBn PrBp OnBn pixRst[54] net111 net112 pixRst[55]
+ rowReadON[58] rowReadON[59] rowReadOFF[58] rowReadOFF[59] openDVS_pixel2x2
x92 DiffBn VDD RefrBp GndD GndA PrSFBp OffBn PrBp OnBn pixRst[56] net115 net116 pixRst[57]
+ rowReadON[58] rowReadON[59] rowReadOFF[58] rowReadOFF[59] openDVS_pixel2x2
x93 DiffBn VDD RefrBp GndD GndA PrSFBp OffBn PrBp OnBn pixRst[58] net119 net120 pixRst[59]
+ rowReadON[58] rowReadON[59] rowReadOFF[58] rowReadOFF[59] openDVS_pixel2x2
x94 DiffBn VDD RefrBp GndD GndA PrSFBp OffBn PrBp OnBn pixRst[60] net123 net124 pixRst[61]
+ rowReadON[58] rowReadON[59] rowReadOFF[58] rowReadOFF[59] openDVS_pixel2x2
x95 DiffBn VDD RefrBp GndD GndA PrSFBp OffBn PrBp OnBn pixRst[62] net127 net128 pixRst[63]
+ rowReadON[58] rowReadON[59] rowReadOFF[58] rowReadOFF[59] openDVS_pixel2x2
x96 DiffBn VDD RefrBp GndD GndA PrSFBp OffBn PrBp OnBn pixRst[0] net3 net4 pixRst[1] rowReadON[56]
+ rowReadON[57] rowReadOFF[56] rowReadOFF[57] openDVS_pixel2x2
x97 DiffBn VDD RefrBp GndD GndA PrSFBp OffBn PrBp OnBn pixRst[2] net7 net8 pixRst[3] rowReadON[56]
+ rowReadON[57] rowReadOFF[56] rowReadOFF[57] openDVS_pixel2x2
x98 DiffBn VDD RefrBp GndD GndA PrSFBp OffBn PrBp OnBn pixRst[4] net11 net12 pixRst[5] rowReadON[56]
+ rowReadON[57] rowReadOFF[56] rowReadOFF[57] openDVS_pixel2x2
x99 DiffBn VDD RefrBp GndD GndA PrSFBp OffBn PrBp OnBn pixRst[6] net15 net16 pixRst[7] rowReadON[56]
+ rowReadON[57] rowReadOFF[56] rowReadOFF[57] openDVS_pixel2x2
x100 DiffBn VDD RefrBp GndD GndA PrSFBp OffBn PrBp OnBn pixRst[8] net19 net20 pixRst[9]
+ rowReadON[56] rowReadON[57] rowReadOFF[56] rowReadOFF[57] openDVS_pixel2x2
x101 DiffBn VDD RefrBp GndD GndA PrSFBp OffBn PrBp OnBn pixRst[10] net23 net24 pixRst[11]
+ rowReadON[56] rowReadON[57] rowReadOFF[56] rowReadOFF[57] openDVS_pixel2x2
x102 DiffBn VDD RefrBp GndD GndA PrSFBp OffBn PrBp OnBn pixRst[12] net27 net28 pixRst[13]
+ rowReadON[56] rowReadON[57] rowReadOFF[56] rowReadOFF[57] openDVS_pixel2x2
x103 DiffBn VDD RefrBp GndD GndA PrSFBp OffBn PrBp OnBn pixRst[14] net31 net32 pixRst[15]
+ rowReadON[56] rowReadON[57] rowReadOFF[56] rowReadOFF[57] openDVS_pixel2x2
x104 DiffBn VDD RefrBp GndD GndA PrSFBp OffBn PrBp OnBn pixRst[16] net35 net36 pixRst[17]
+ rowReadON[56] rowReadON[57] rowReadOFF[56] rowReadOFF[57] openDVS_pixel2x2
x105 DiffBn VDD RefrBp GndD GndA PrSFBp OffBn PrBp OnBn pixRst[18] net39 net40 pixRst[19]
+ rowReadON[56] rowReadON[57] rowReadOFF[56] rowReadOFF[57] openDVS_pixel2x2
x106 DiffBn VDD RefrBp GndD GndA PrSFBp OffBn PrBp OnBn pixRst[20] net43 net44 pixRst[21]
+ rowReadON[56] rowReadON[57] rowReadOFF[56] rowReadOFF[57] openDVS_pixel2x2
x107 DiffBn VDD RefrBp GndD GndA PrSFBp OffBn PrBp OnBn pixRst[22] net47 net48 pixRst[23]
+ rowReadON[56] rowReadON[57] rowReadOFF[56] rowReadOFF[57] openDVS_pixel2x2
x108 DiffBn VDD RefrBp GndD GndA PrSFBp OffBn PrBp OnBn pixRst[24] net51 net52 pixRst[25]
+ rowReadON[56] rowReadON[57] rowReadOFF[56] rowReadOFF[57] openDVS_pixel2x2
x109 DiffBn VDD RefrBp GndD GndA PrSFBp OffBn PrBp OnBn pixRst[26] net55 net56 pixRst[27]
+ rowReadON[56] rowReadON[57] rowReadOFF[56] rowReadOFF[57] openDVS_pixel2x2
x110 DiffBn VDD RefrBp GndD GndA PrSFBp OffBn PrBp OnBn pixRst[28] net59 net60 pixRst[29]
+ rowReadON[56] rowReadON[57] rowReadOFF[56] rowReadOFF[57] openDVS_pixel2x2
x111 DiffBn VDD RefrBp GndD GndA PrSFBp OffBn PrBp OnBn pixRst[30] net63 net64 pixRst[31]
+ rowReadON[56] rowReadON[57] rowReadOFF[56] rowReadOFF[57] openDVS_pixel2x2
x112 DiffBn VDD RefrBp GndD GndA PrSFBp OffBn PrBp OnBn pixRst[32] net67 net68 pixRst[33]
+ rowReadON[56] rowReadON[57] rowReadOFF[56] rowReadOFF[57] openDVS_pixel2x2
x113 DiffBn VDD RefrBp GndD GndA PrSFBp OffBn PrBp OnBn pixRst[34] net71 net72 pixRst[35]
+ rowReadON[56] rowReadON[57] rowReadOFF[56] rowReadOFF[57] openDVS_pixel2x2
x114 DiffBn VDD RefrBp GndD GndA PrSFBp OffBn PrBp OnBn pixRst[36] net75 net76 pixRst[37]
+ rowReadON[56] rowReadON[57] rowReadOFF[56] rowReadOFF[57] openDVS_pixel2x2
x115 DiffBn VDD RefrBp GndD GndA PrSFBp OffBn PrBp OnBn pixRst[38] net79 net80 pixRst[39]
+ rowReadON[56] rowReadON[57] rowReadOFF[56] rowReadOFF[57] openDVS_pixel2x2
x116 DiffBn VDD RefrBp GndD GndA PrSFBp OffBn PrBp OnBn pixRst[40] net83 net84 pixRst[41]
+ rowReadON[56] rowReadON[57] rowReadOFF[56] rowReadOFF[57] openDVS_pixel2x2
x117 DiffBn VDD RefrBp GndD GndA PrSFBp OffBn PrBp OnBn pixRst[42] net87 net88 pixRst[43]
+ rowReadON[56] rowReadON[57] rowReadOFF[56] rowReadOFF[57] openDVS_pixel2x2
x118 DiffBn VDD RefrBp GndD GndA PrSFBp OffBn PrBp OnBn pixRst[44] net91 net92 pixRst[45]
+ rowReadON[56] rowReadON[57] rowReadOFF[56] rowReadOFF[57] openDVS_pixel2x2
x119 DiffBn VDD RefrBp GndD GndA PrSFBp OffBn PrBp OnBn pixRst[46] net95 net96 pixRst[47]
+ rowReadON[56] rowReadON[57] rowReadOFF[56] rowReadOFF[57] openDVS_pixel2x2
x120 DiffBn VDD RefrBp GndD GndA PrSFBp OffBn PrBp OnBn pixRst[48] net99 net100 pixRst[49]
+ rowReadON[56] rowReadON[57] rowReadOFF[56] rowReadOFF[57] openDVS_pixel2x2
x121 DiffBn VDD RefrBp GndD GndA PrSFBp OffBn PrBp OnBn pixRst[50] net103 net104 pixRst[51]
+ rowReadON[56] rowReadON[57] rowReadOFF[56] rowReadOFF[57] openDVS_pixel2x2
x122 DiffBn VDD RefrBp GndD GndA PrSFBp OffBn PrBp OnBn pixRst[52] net107 net108 pixRst[53]
+ rowReadON[56] rowReadON[57] rowReadOFF[56] rowReadOFF[57] openDVS_pixel2x2
x123 DiffBn VDD RefrBp GndD GndA PrSFBp OffBn PrBp OnBn pixRst[54] net111 net112 pixRst[55]
+ rowReadON[56] rowReadON[57] rowReadOFF[56] rowReadOFF[57] openDVS_pixel2x2
x124 DiffBn VDD RefrBp GndD GndA PrSFBp OffBn PrBp OnBn pixRst[56] net115 net116 pixRst[57]
+ rowReadON[56] rowReadON[57] rowReadOFF[56] rowReadOFF[57] openDVS_pixel2x2
x125 DiffBn VDD RefrBp GndD GndA PrSFBp OffBn PrBp OnBn pixRst[58] net119 net120 pixRst[59]
+ rowReadON[56] rowReadON[57] rowReadOFF[56] rowReadOFF[57] openDVS_pixel2x2
x126 DiffBn VDD RefrBp GndD GndA PrSFBp OffBn PrBp OnBn pixRst[60] net123 net124 pixRst[61]
+ rowReadON[56] rowReadON[57] rowReadOFF[56] rowReadOFF[57] openDVS_pixel2x2
x127 DiffBn VDD RefrBp GndD GndA PrSFBp OffBn PrBp OnBn pixRst[62] net127 net128 pixRst[63]
+ rowReadON[56] rowReadON[57] rowReadOFF[56] rowReadOFF[57] openDVS_pixel2x2
x128 DiffBn VDD RefrBp GndD GndA PrSFBp OffBn PrBp OnBn pixRst[0] net3 net4 pixRst[1] rowReadON[54]
+ rowReadON[55] rowReadOFF[54] rowReadOFF[55] openDVS_pixel2x2
x129 DiffBn VDD RefrBp GndD GndA PrSFBp OffBn PrBp OnBn pixRst[2] net7 net8 pixRst[3] rowReadON[54]
+ rowReadON[55] rowReadOFF[54] rowReadOFF[55] openDVS_pixel2x2
x130 DiffBn VDD RefrBp GndD GndA PrSFBp OffBn PrBp OnBn pixRst[4] net11 net12 pixRst[5]
+ rowReadON[54] rowReadON[55] rowReadOFF[54] rowReadOFF[55] openDVS_pixel2x2
x131 DiffBn VDD RefrBp GndD GndA PrSFBp OffBn PrBp OnBn pixRst[6] net15 net16 pixRst[7]
+ rowReadON[54] rowReadON[55] rowReadOFF[54] rowReadOFF[55] openDVS_pixel2x2
x132 DiffBn VDD RefrBp GndD GndA PrSFBp OffBn PrBp OnBn pixRst[8] net19 net20 pixRst[9]
+ rowReadON[54] rowReadON[55] rowReadOFF[54] rowReadOFF[55] openDVS_pixel2x2
x133 DiffBn VDD RefrBp GndD GndA PrSFBp OffBn PrBp OnBn pixRst[10] net23 net24 pixRst[11]
+ rowReadON[54] rowReadON[55] rowReadOFF[54] rowReadOFF[55] openDVS_pixel2x2
x134 DiffBn VDD RefrBp GndD GndA PrSFBp OffBn PrBp OnBn pixRst[12] net27 net28 pixRst[13]
+ rowReadON[54] rowReadON[55] rowReadOFF[54] rowReadOFF[55] openDVS_pixel2x2
x135 DiffBn VDD RefrBp GndD GndA PrSFBp OffBn PrBp OnBn pixRst[14] net31 net32 pixRst[15]
+ rowReadON[54] rowReadON[55] rowReadOFF[54] rowReadOFF[55] openDVS_pixel2x2
x136 DiffBn VDD RefrBp GndD GndA PrSFBp OffBn PrBp OnBn pixRst[16] net35 net36 pixRst[17]
+ rowReadON[54] rowReadON[55] rowReadOFF[54] rowReadOFF[55] openDVS_pixel2x2
x137 DiffBn VDD RefrBp GndD GndA PrSFBp OffBn PrBp OnBn pixRst[18] net39 net40 pixRst[19]
+ rowReadON[54] rowReadON[55] rowReadOFF[54] rowReadOFF[55] openDVS_pixel2x2
x138 DiffBn VDD RefrBp GndD GndA PrSFBp OffBn PrBp OnBn pixRst[20] net43 net44 pixRst[21]
+ rowReadON[54] rowReadON[55] rowReadOFF[54] rowReadOFF[55] openDVS_pixel2x2
x139 DiffBn VDD RefrBp GndD GndA PrSFBp OffBn PrBp OnBn pixRst[22] net47 net48 pixRst[23]
+ rowReadON[54] rowReadON[55] rowReadOFF[54] rowReadOFF[55] openDVS_pixel2x2
x140 DiffBn VDD RefrBp GndD GndA PrSFBp OffBn PrBp OnBn pixRst[24] net51 net52 pixRst[25]
+ rowReadON[54] rowReadON[55] rowReadOFF[54] rowReadOFF[55] openDVS_pixel2x2
x141 DiffBn VDD RefrBp GndD GndA PrSFBp OffBn PrBp OnBn pixRst[26] net55 net56 pixRst[27]
+ rowReadON[54] rowReadON[55] rowReadOFF[54] rowReadOFF[55] openDVS_pixel2x2
x142 DiffBn VDD RefrBp GndD GndA PrSFBp OffBn PrBp OnBn pixRst[28] net59 net60 pixRst[29]
+ rowReadON[54] rowReadON[55] rowReadOFF[54] rowReadOFF[55] openDVS_pixel2x2
x143 DiffBn VDD RefrBp GndD GndA PrSFBp OffBn PrBp OnBn pixRst[30] net63 net64 pixRst[31]
+ rowReadON[54] rowReadON[55] rowReadOFF[54] rowReadOFF[55] openDVS_pixel2x2
x144 DiffBn VDD RefrBp GndD GndA PrSFBp OffBn PrBp OnBn pixRst[32] net67 net68 pixRst[33]
+ rowReadON[54] rowReadON[55] rowReadOFF[54] rowReadOFF[55] openDVS_pixel2x2
x145 DiffBn VDD RefrBp GndD GndA PrSFBp OffBn PrBp OnBn pixRst[34] net71 net72 pixRst[35]
+ rowReadON[54] rowReadON[55] rowReadOFF[54] rowReadOFF[55] openDVS_pixel2x2
x146 DiffBn VDD RefrBp GndD GndA PrSFBp OffBn PrBp OnBn pixRst[36] net75 net76 pixRst[37]
+ rowReadON[54] rowReadON[55] rowReadOFF[54] rowReadOFF[55] openDVS_pixel2x2
x147 DiffBn VDD RefrBp GndD GndA PrSFBp OffBn PrBp OnBn pixRst[38] net79 net80 pixRst[39]
+ rowReadON[54] rowReadON[55] rowReadOFF[54] rowReadOFF[55] openDVS_pixel2x2
x148 DiffBn VDD RefrBp GndD GndA PrSFBp OffBn PrBp OnBn pixRst[40] net83 net84 pixRst[41]
+ rowReadON[54] rowReadON[55] rowReadOFF[54] rowReadOFF[55] openDVS_pixel2x2
x149 DiffBn VDD RefrBp GndD GndA PrSFBp OffBn PrBp OnBn pixRst[42] net87 net88 pixRst[43]
+ rowReadON[54] rowReadON[55] rowReadOFF[54] rowReadOFF[55] openDVS_pixel2x2
x150 DiffBn VDD RefrBp GndD GndA PrSFBp OffBn PrBp OnBn pixRst[44] net91 net92 pixRst[45]
+ rowReadON[54] rowReadON[55] rowReadOFF[54] rowReadOFF[55] openDVS_pixel2x2
x151 DiffBn VDD RefrBp GndD GndA PrSFBp OffBn PrBp OnBn pixRst[46] net95 net96 pixRst[47]
+ rowReadON[54] rowReadON[55] rowReadOFF[54] rowReadOFF[55] openDVS_pixel2x2
x152 DiffBn VDD RefrBp GndD GndA PrSFBp OffBn PrBp OnBn pixRst[48] net99 net100 pixRst[49]
+ rowReadON[54] rowReadON[55] rowReadOFF[54] rowReadOFF[55] openDVS_pixel2x2
x153 DiffBn VDD RefrBp GndD GndA PrSFBp OffBn PrBp OnBn pixRst[50] net103 net104 pixRst[51]
+ rowReadON[54] rowReadON[55] rowReadOFF[54] rowReadOFF[55] openDVS_pixel2x2
x154 DiffBn VDD RefrBp GndD GndA PrSFBp OffBn PrBp OnBn pixRst[52] net107 net108 pixRst[53]
+ rowReadON[54] rowReadON[55] rowReadOFF[54] rowReadOFF[55] openDVS_pixel2x2
x155 DiffBn VDD RefrBp GndD GndA PrSFBp OffBn PrBp OnBn pixRst[54] net111 net112 pixRst[55]
+ rowReadON[54] rowReadON[55] rowReadOFF[54] rowReadOFF[55] openDVS_pixel2x2
x156 DiffBn VDD RefrBp GndD GndA PrSFBp OffBn PrBp OnBn pixRst[56] net115 net116 pixRst[57]
+ rowReadON[54] rowReadON[55] rowReadOFF[54] rowReadOFF[55] openDVS_pixel2x2
x157 DiffBn VDD RefrBp GndD GndA PrSFBp OffBn PrBp OnBn pixRst[58] net119 net120 pixRst[59]
+ rowReadON[54] rowReadON[55] rowReadOFF[54] rowReadOFF[55] openDVS_pixel2x2
x158 DiffBn VDD RefrBp GndD GndA PrSFBp OffBn PrBp OnBn pixRst[60] net123 net124 pixRst[61]
+ rowReadON[54] rowReadON[55] rowReadOFF[54] rowReadOFF[55] openDVS_pixel2x2
x159 DiffBn VDD RefrBp GndD GndA PrSFBp OffBn PrBp OnBn pixRst[62] net127 net128 pixRst[63]
+ rowReadON[54] rowReadON[55] rowReadOFF[54] rowReadOFF[55] openDVS_pixel2x2
x160 DiffBn VDD RefrBp GndD GndA PrSFBp OffBn PrBp OnBn pixRst[0] net3 net4 pixRst[1] rowReadON[52]
+ rowReadON[53] rowReadOFF[52] rowReadOFF[53] openDVS_pixel2x2
x161 DiffBn VDD RefrBp GndD GndA PrSFBp OffBn PrBp OnBn pixRst[2] net7 net8 pixRst[3] rowReadON[52]
+ rowReadON[53] rowReadOFF[52] rowReadOFF[53] openDVS_pixel2x2
x162 DiffBn VDD RefrBp GndD GndA PrSFBp OffBn PrBp OnBn pixRst[4] net11 net12 pixRst[5]
+ rowReadON[52] rowReadON[53] rowReadOFF[52] rowReadOFF[53] openDVS_pixel2x2
x163 DiffBn VDD RefrBp GndD GndA PrSFBp OffBn PrBp OnBn pixRst[6] net15 net16 pixRst[7]
+ rowReadON[52] rowReadON[53] rowReadOFF[52] rowReadOFF[53] openDVS_pixel2x2
x164 DiffBn VDD RefrBp GndD GndA PrSFBp OffBn PrBp OnBn pixRst[8] net19 net20 pixRst[9]
+ rowReadON[52] rowReadON[53] rowReadOFF[52] rowReadOFF[53] openDVS_pixel2x2
x165 DiffBn VDD RefrBp GndD GndA PrSFBp OffBn PrBp OnBn pixRst[10] net23 net24 pixRst[11]
+ rowReadON[52] rowReadON[53] rowReadOFF[52] rowReadOFF[53] openDVS_pixel2x2
x166 DiffBn VDD RefrBp GndD GndA PrSFBp OffBn PrBp OnBn pixRst[12] net27 net28 pixRst[13]
+ rowReadON[52] rowReadON[53] rowReadOFF[52] rowReadOFF[53] openDVS_pixel2x2
x167 DiffBn VDD RefrBp GndD GndA PrSFBp OffBn PrBp OnBn pixRst[14] net31 net32 pixRst[15]
+ rowReadON[52] rowReadON[53] rowReadOFF[52] rowReadOFF[53] openDVS_pixel2x2
x168 DiffBn VDD RefrBp GndD GndA PrSFBp OffBn PrBp OnBn pixRst[16] net35 net36 pixRst[17]
+ rowReadON[52] rowReadON[53] rowReadOFF[52] rowReadOFF[53] openDVS_pixel2x2
x169 DiffBn VDD RefrBp GndD GndA PrSFBp OffBn PrBp OnBn pixRst[18] net39 net40 pixRst[19]
+ rowReadON[52] rowReadON[53] rowReadOFF[52] rowReadOFF[53] openDVS_pixel2x2
x170 DiffBn VDD RefrBp GndD GndA PrSFBp OffBn PrBp OnBn pixRst[20] net43 net44 pixRst[21]
+ rowReadON[52] rowReadON[53] rowReadOFF[52] rowReadOFF[53] openDVS_pixel2x2
x171 DiffBn VDD RefrBp GndD GndA PrSFBp OffBn PrBp OnBn pixRst[22] net47 net48 pixRst[23]
+ rowReadON[52] rowReadON[53] rowReadOFF[52] rowReadOFF[53] openDVS_pixel2x2
x172 DiffBn VDD RefrBp GndD GndA PrSFBp OffBn PrBp OnBn pixRst[24] net51 net52 pixRst[25]
+ rowReadON[52] rowReadON[53] rowReadOFF[52] rowReadOFF[53] openDVS_pixel2x2
x173 DiffBn VDD RefrBp GndD GndA PrSFBp OffBn PrBp OnBn pixRst[26] net55 net56 pixRst[27]
+ rowReadON[52] rowReadON[53] rowReadOFF[52] rowReadOFF[53] openDVS_pixel2x2
x174 DiffBn VDD RefrBp GndD GndA PrSFBp OffBn PrBp OnBn pixRst[28] net59 net60 pixRst[29]
+ rowReadON[52] rowReadON[53] rowReadOFF[52] rowReadOFF[53] openDVS_pixel2x2
x175 DiffBn VDD RefrBp GndD GndA PrSFBp OffBn PrBp OnBn pixRst[30] net63 net64 pixRst[31]
+ rowReadON[52] rowReadON[53] rowReadOFF[52] rowReadOFF[53] openDVS_pixel2x2
x176 DiffBn VDD RefrBp GndD GndA PrSFBp OffBn PrBp OnBn pixRst[32] net67 net68 pixRst[33]
+ rowReadON[52] rowReadON[53] rowReadOFF[52] rowReadOFF[53] openDVS_pixel2x2
x177 DiffBn VDD RefrBp GndD GndA PrSFBp OffBn PrBp OnBn pixRst[34] net71 net72 pixRst[35]
+ rowReadON[52] rowReadON[53] rowReadOFF[52] rowReadOFF[53] openDVS_pixel2x2
x178 DiffBn VDD RefrBp GndD GndA PrSFBp OffBn PrBp OnBn pixRst[36] net75 net76 pixRst[37]
+ rowReadON[52] rowReadON[53] rowReadOFF[52] rowReadOFF[53] openDVS_pixel2x2
x179 DiffBn VDD RefrBp GndD GndA PrSFBp OffBn PrBp OnBn pixRst[38] net79 net80 pixRst[39]
+ rowReadON[52] rowReadON[53] rowReadOFF[52] rowReadOFF[53] openDVS_pixel2x2
x180 DiffBn VDD RefrBp GndD GndA PrSFBp OffBn PrBp OnBn pixRst[40] net83 net84 pixRst[41]
+ rowReadON[52] rowReadON[53] rowReadOFF[52] rowReadOFF[53] openDVS_pixel2x2
x181 DiffBn VDD RefrBp GndD GndA PrSFBp OffBn PrBp OnBn pixRst[42] net87 net88 pixRst[43]
+ rowReadON[52] rowReadON[53] rowReadOFF[52] rowReadOFF[53] openDVS_pixel2x2
x182 DiffBn VDD RefrBp GndD GndA PrSFBp OffBn PrBp OnBn pixRst[44] net91 net92 pixRst[45]
+ rowReadON[52] rowReadON[53] rowReadOFF[52] rowReadOFF[53] openDVS_pixel2x2
x183 DiffBn VDD RefrBp GndD GndA PrSFBp OffBn PrBp OnBn pixRst[46] net95 net96 pixRst[47]
+ rowReadON[52] rowReadON[53] rowReadOFF[52] rowReadOFF[53] openDVS_pixel2x2
x184 DiffBn VDD RefrBp GndD GndA PrSFBp OffBn PrBp OnBn pixRst[48] net99 net100 pixRst[49]
+ rowReadON[52] rowReadON[53] rowReadOFF[52] rowReadOFF[53] openDVS_pixel2x2
x185 DiffBn VDD RefrBp GndD GndA PrSFBp OffBn PrBp OnBn pixRst[50] net103 net104 pixRst[51]
+ rowReadON[52] rowReadON[53] rowReadOFF[52] rowReadOFF[53] openDVS_pixel2x2
x186 DiffBn VDD RefrBp GndD GndA PrSFBp OffBn PrBp OnBn pixRst[52] net107 net108 pixRst[53]
+ rowReadON[52] rowReadON[53] rowReadOFF[52] rowReadOFF[53] openDVS_pixel2x2
x187 DiffBn VDD RefrBp GndD GndA PrSFBp OffBn PrBp OnBn pixRst[54] net111 net112 pixRst[55]
+ rowReadON[52] rowReadON[53] rowReadOFF[52] rowReadOFF[53] openDVS_pixel2x2
x188 DiffBn VDD RefrBp GndD GndA PrSFBp OffBn PrBp OnBn pixRst[56] net115 net116 pixRst[57]
+ rowReadON[52] rowReadON[53] rowReadOFF[52] rowReadOFF[53] openDVS_pixel2x2
x189 DiffBn VDD RefrBp GndD GndA PrSFBp OffBn PrBp OnBn pixRst[58] net119 net120 pixRst[59]
+ rowReadON[52] rowReadON[53] rowReadOFF[52] rowReadOFF[53] openDVS_pixel2x2
x190 DiffBn VDD RefrBp GndD GndA PrSFBp OffBn PrBp OnBn pixRst[60] net123 net124 pixRst[61]
+ rowReadON[52] rowReadON[53] rowReadOFF[52] rowReadOFF[53] openDVS_pixel2x2
x191 DiffBn VDD RefrBp GndD GndA PrSFBp OffBn PrBp OnBn pixRst[62] net127 net128 pixRst[63]
+ rowReadON[52] rowReadON[53] rowReadOFF[52] rowReadOFF[53] openDVS_pixel2x2
x192 DiffBn VDD RefrBp GndD GndA PrSFBp OffBn PrBp OnBn pixRst[0] net3 net4 pixRst[1] rowReadON[50]
+ rowReadON[51] rowReadOFF[50] rowReadOFF[51] openDVS_pixel2x2
x193 DiffBn VDD RefrBp GndD GndA PrSFBp OffBn PrBp OnBn pixRst[2] net7 net8 pixRst[3] rowReadON[50]
+ rowReadON[51] rowReadOFF[50] rowReadOFF[51] openDVS_pixel2x2
x194 DiffBn VDD RefrBp GndD GndA PrSFBp OffBn PrBp OnBn pixRst[4] net11 net12 pixRst[5]
+ rowReadON[50] rowReadON[51] rowReadOFF[50] rowReadOFF[51] openDVS_pixel2x2
x195 DiffBn VDD RefrBp GndD GndA PrSFBp OffBn PrBp OnBn pixRst[6] net15 net16 pixRst[7]
+ rowReadON[50] rowReadON[51] rowReadOFF[50] rowReadOFF[51] openDVS_pixel2x2
x196 DiffBn VDD RefrBp GndD GndA PrSFBp OffBn PrBp OnBn pixRst[8] net19 net20 pixRst[9]
+ rowReadON[50] rowReadON[51] rowReadOFF[50] rowReadOFF[51] openDVS_pixel2x2
x197 DiffBn VDD RefrBp GndD GndA PrSFBp OffBn PrBp OnBn pixRst[10] net23 net24 pixRst[11]
+ rowReadON[50] rowReadON[51] rowReadOFF[50] rowReadOFF[51] openDVS_pixel2x2
x198 DiffBn VDD RefrBp GndD GndA PrSFBp OffBn PrBp OnBn pixRst[12] net27 net28 pixRst[13]
+ rowReadON[50] rowReadON[51] rowReadOFF[50] rowReadOFF[51] openDVS_pixel2x2
x199 DiffBn VDD RefrBp GndD GndA PrSFBp OffBn PrBp OnBn pixRst[14] net31 net32 pixRst[15]
+ rowReadON[50] rowReadON[51] rowReadOFF[50] rowReadOFF[51] openDVS_pixel2x2
x200 DiffBn VDD RefrBp GndD GndA PrSFBp OffBn PrBp OnBn pixRst[16] net35 net36 pixRst[17]
+ rowReadON[50] rowReadON[51] rowReadOFF[50] rowReadOFF[51] openDVS_pixel2x2
x201 DiffBn VDD RefrBp GndD GndA PrSFBp OffBn PrBp OnBn pixRst[18] net39 net40 pixRst[19]
+ rowReadON[50] rowReadON[51] rowReadOFF[50] rowReadOFF[51] openDVS_pixel2x2
x202 DiffBn VDD RefrBp GndD GndA PrSFBp OffBn PrBp OnBn pixRst[20] net43 net44 pixRst[21]
+ rowReadON[50] rowReadON[51] rowReadOFF[50] rowReadOFF[51] openDVS_pixel2x2
x203 DiffBn VDD RefrBp GndD GndA PrSFBp OffBn PrBp OnBn pixRst[22] net47 net48 pixRst[23]
+ rowReadON[50] rowReadON[51] rowReadOFF[50] rowReadOFF[51] openDVS_pixel2x2
x204 DiffBn VDD RefrBp GndD GndA PrSFBp OffBn PrBp OnBn pixRst[24] net51 net52 pixRst[25]
+ rowReadON[50] rowReadON[51] rowReadOFF[50] rowReadOFF[51] openDVS_pixel2x2
x205 DiffBn VDD RefrBp GndD GndA PrSFBp OffBn PrBp OnBn pixRst[26] net55 net56 pixRst[27]
+ rowReadON[50] rowReadON[51] rowReadOFF[50] rowReadOFF[51] openDVS_pixel2x2
x206 DiffBn VDD RefrBp GndD GndA PrSFBp OffBn PrBp OnBn pixRst[28] net59 net60 pixRst[29]
+ rowReadON[50] rowReadON[51] rowReadOFF[50] rowReadOFF[51] openDVS_pixel2x2
x207 DiffBn VDD RefrBp GndD GndA PrSFBp OffBn PrBp OnBn pixRst[30] net63 net64 pixRst[31]
+ rowReadON[50] rowReadON[51] rowReadOFF[50] rowReadOFF[51] openDVS_pixel2x2
x208 DiffBn VDD RefrBp GndD GndA PrSFBp OffBn PrBp OnBn pixRst[32] net67 net68 pixRst[33]
+ rowReadON[50] rowReadON[51] rowReadOFF[50] rowReadOFF[51] openDVS_pixel2x2
x209 DiffBn VDD RefrBp GndD GndA PrSFBp OffBn PrBp OnBn pixRst[34] net71 net72 pixRst[35]
+ rowReadON[50] rowReadON[51] rowReadOFF[50] rowReadOFF[51] openDVS_pixel2x2
x210 DiffBn VDD RefrBp GndD GndA PrSFBp OffBn PrBp OnBn pixRst[36] net75 net76 pixRst[37]
+ rowReadON[50] rowReadON[51] rowReadOFF[50] rowReadOFF[51] openDVS_pixel2x2
x211 DiffBn VDD RefrBp GndD GndA PrSFBp OffBn PrBp OnBn pixRst[38] net79 net80 pixRst[39]
+ rowReadON[50] rowReadON[51] rowReadOFF[50] rowReadOFF[51] openDVS_pixel2x2
x212 DiffBn VDD RefrBp GndD GndA PrSFBp OffBn PrBp OnBn pixRst[40] net83 net84 pixRst[41]
+ rowReadON[50] rowReadON[51] rowReadOFF[50] rowReadOFF[51] openDVS_pixel2x2
x213 DiffBn VDD RefrBp GndD GndA PrSFBp OffBn PrBp OnBn pixRst[42] net87 net88 pixRst[43]
+ rowReadON[50] rowReadON[51] rowReadOFF[50] rowReadOFF[51] openDVS_pixel2x2
x214 DiffBn VDD RefrBp GndD GndA PrSFBp OffBn PrBp OnBn pixRst[44] net91 net92 pixRst[45]
+ rowReadON[50] rowReadON[51] rowReadOFF[50] rowReadOFF[51] openDVS_pixel2x2
x215 DiffBn VDD RefrBp GndD GndA PrSFBp OffBn PrBp OnBn pixRst[46] net95 net96 pixRst[47]
+ rowReadON[50] rowReadON[51] rowReadOFF[50] rowReadOFF[51] openDVS_pixel2x2
x216 DiffBn VDD RefrBp GndD GndA PrSFBp OffBn PrBp OnBn pixRst[48] net99 net100 pixRst[49]
+ rowReadON[50] rowReadON[51] rowReadOFF[50] rowReadOFF[51] openDVS_pixel2x2
x217 DiffBn VDD RefrBp GndD GndA PrSFBp OffBn PrBp OnBn pixRst[50] net103 net104 pixRst[51]
+ rowReadON[50] rowReadON[51] rowReadOFF[50] rowReadOFF[51] openDVS_pixel2x2
x218 DiffBn VDD RefrBp GndD GndA PrSFBp OffBn PrBp OnBn pixRst[52] net107 net108 pixRst[53]
+ rowReadON[50] rowReadON[51] rowReadOFF[50] rowReadOFF[51] openDVS_pixel2x2
x219 DiffBn VDD RefrBp GndD GndA PrSFBp OffBn PrBp OnBn pixRst[54] net111 net112 pixRst[55]
+ rowReadON[50] rowReadON[51] rowReadOFF[50] rowReadOFF[51] openDVS_pixel2x2
x220 DiffBn VDD RefrBp GndD GndA PrSFBp OffBn PrBp OnBn pixRst[56] net115 net116 pixRst[57]
+ rowReadON[50] rowReadON[51] rowReadOFF[50] rowReadOFF[51] openDVS_pixel2x2
x221 DiffBn VDD RefrBp GndD GndA PrSFBp OffBn PrBp OnBn pixRst[58] net119 net120 pixRst[59]
+ rowReadON[50] rowReadON[51] rowReadOFF[50] rowReadOFF[51] openDVS_pixel2x2
x222 DiffBn VDD RefrBp GndD GndA PrSFBp OffBn PrBp OnBn pixRst[60] net123 net124 pixRst[61]
+ rowReadON[50] rowReadON[51] rowReadOFF[50] rowReadOFF[51] openDVS_pixel2x2
x223 DiffBn VDD RefrBp GndD GndA PrSFBp OffBn PrBp OnBn pixRst[62] net127 net128 pixRst[63]
+ rowReadON[50] rowReadON[51] rowReadOFF[50] rowReadOFF[51] openDVS_pixel2x2
x224 DiffBn VDD RefrBp GndD GndA PrSFBp OffBn PrBp OnBn pixRst[0] net3 net4 pixRst[1] rowReadON[48]
+ rowReadON[49] rowReadOFF[48] rowReadOFF[49] openDVS_pixel2x2
x225 DiffBn VDD RefrBp GndD GndA PrSFBp OffBn PrBp OnBn pixRst[2] net7 net8 pixRst[3] rowReadON[48]
+ rowReadON[49] rowReadOFF[48] rowReadOFF[49] openDVS_pixel2x2
x226 DiffBn VDD RefrBp GndD GndA PrSFBp OffBn PrBp OnBn pixRst[4] net11 net12 pixRst[5]
+ rowReadON[48] rowReadON[49] rowReadOFF[48] rowReadOFF[49] openDVS_pixel2x2
x227 DiffBn VDD RefrBp GndD GndA PrSFBp OffBn PrBp OnBn pixRst[6] net15 net16 pixRst[7]
+ rowReadON[48] rowReadON[49] rowReadOFF[48] rowReadOFF[49] openDVS_pixel2x2
x228 DiffBn VDD RefrBp GndD GndA PrSFBp OffBn PrBp OnBn pixRst[8] net19 net20 pixRst[9]
+ rowReadON[48] rowReadON[49] rowReadOFF[48] rowReadOFF[49] openDVS_pixel2x2
x229 DiffBn VDD RefrBp GndD GndA PrSFBp OffBn PrBp OnBn pixRst[10] net23 net24 pixRst[11]
+ rowReadON[48] rowReadON[49] rowReadOFF[48] rowReadOFF[49] openDVS_pixel2x2
x230 DiffBn VDD RefrBp GndD GndA PrSFBp OffBn PrBp OnBn pixRst[12] net27 net28 pixRst[13]
+ rowReadON[48] rowReadON[49] rowReadOFF[48] rowReadOFF[49] openDVS_pixel2x2
x231 DiffBn VDD RefrBp GndD GndA PrSFBp OffBn PrBp OnBn pixRst[14] net31 net32 pixRst[15]
+ rowReadON[48] rowReadON[49] rowReadOFF[48] rowReadOFF[49] openDVS_pixel2x2
x232 DiffBn VDD RefrBp GndD GndA PrSFBp OffBn PrBp OnBn pixRst[16] net35 net36 pixRst[17]
+ rowReadON[48] rowReadON[49] rowReadOFF[48] rowReadOFF[49] openDVS_pixel2x2
x233 DiffBn VDD RefrBp GndD GndA PrSFBp OffBn PrBp OnBn pixRst[18] net39 net40 pixRst[19]
+ rowReadON[48] rowReadON[49] rowReadOFF[48] rowReadOFF[49] openDVS_pixel2x2
x234 DiffBn VDD RefrBp GndD GndA PrSFBp OffBn PrBp OnBn pixRst[20] net43 net44 pixRst[21]
+ rowReadON[48] rowReadON[49] rowReadOFF[48] rowReadOFF[49] openDVS_pixel2x2
x235 DiffBn VDD RefrBp GndD GndA PrSFBp OffBn PrBp OnBn pixRst[22] net47 net48 pixRst[23]
+ rowReadON[48] rowReadON[49] rowReadOFF[48] rowReadOFF[49] openDVS_pixel2x2
x236 DiffBn VDD RefrBp GndD GndA PrSFBp OffBn PrBp OnBn pixRst[24] net51 net52 pixRst[25]
+ rowReadON[48] rowReadON[49] rowReadOFF[48] rowReadOFF[49] openDVS_pixel2x2
x237 DiffBn VDD RefrBp GndD GndA PrSFBp OffBn PrBp OnBn pixRst[26] net55 net56 pixRst[27]
+ rowReadON[48] rowReadON[49] rowReadOFF[48] rowReadOFF[49] openDVS_pixel2x2
x238 DiffBn VDD RefrBp GndD GndA PrSFBp OffBn PrBp OnBn pixRst[28] net59 net60 pixRst[29]
+ rowReadON[48] rowReadON[49] rowReadOFF[48] rowReadOFF[49] openDVS_pixel2x2
x239 DiffBn VDD RefrBp GndD GndA PrSFBp OffBn PrBp OnBn pixRst[30] net63 net64 pixRst[31]
+ rowReadON[48] rowReadON[49] rowReadOFF[48] rowReadOFF[49] openDVS_pixel2x2
x240 DiffBn VDD RefrBp GndD GndA PrSFBp OffBn PrBp OnBn pixRst[32] net67 net68 pixRst[33]
+ rowReadON[48] rowReadON[49] rowReadOFF[48] rowReadOFF[49] openDVS_pixel2x2
x241 DiffBn VDD RefrBp GndD GndA PrSFBp OffBn PrBp OnBn pixRst[34] net71 net72 pixRst[35]
+ rowReadON[48] rowReadON[49] rowReadOFF[48] rowReadOFF[49] openDVS_pixel2x2
x242 DiffBn VDD RefrBp GndD GndA PrSFBp OffBn PrBp OnBn pixRst[36] net75 net76 pixRst[37]
+ rowReadON[48] rowReadON[49] rowReadOFF[48] rowReadOFF[49] openDVS_pixel2x2
x243 DiffBn VDD RefrBp GndD GndA PrSFBp OffBn PrBp OnBn pixRst[38] net79 net80 pixRst[39]
+ rowReadON[48] rowReadON[49] rowReadOFF[48] rowReadOFF[49] openDVS_pixel2x2
x244 DiffBn VDD RefrBp GndD GndA PrSFBp OffBn PrBp OnBn pixRst[40] net83 net84 pixRst[41]
+ rowReadON[48] rowReadON[49] rowReadOFF[48] rowReadOFF[49] openDVS_pixel2x2
x245 DiffBn VDD RefrBp GndD GndA PrSFBp OffBn PrBp OnBn pixRst[42] net87 net88 pixRst[43]
+ rowReadON[48] rowReadON[49] rowReadOFF[48] rowReadOFF[49] openDVS_pixel2x2
x246 DiffBn VDD RefrBp GndD GndA PrSFBp OffBn PrBp OnBn pixRst[44] net91 net92 pixRst[45]
+ rowReadON[48] rowReadON[49] rowReadOFF[48] rowReadOFF[49] openDVS_pixel2x2
x247 DiffBn VDD RefrBp GndD GndA PrSFBp OffBn PrBp OnBn pixRst[46] net95 net96 pixRst[47]
+ rowReadON[48] rowReadON[49] rowReadOFF[48] rowReadOFF[49] openDVS_pixel2x2
x248 DiffBn VDD RefrBp GndD GndA PrSFBp OffBn PrBp OnBn pixRst[48] net99 net100 pixRst[49]
+ rowReadON[48] rowReadON[49] rowReadOFF[48] rowReadOFF[49] openDVS_pixel2x2
x249 DiffBn VDD RefrBp GndD GndA PrSFBp OffBn PrBp OnBn pixRst[50] net103 net104 pixRst[51]
+ rowReadON[48] rowReadON[49] rowReadOFF[48] rowReadOFF[49] openDVS_pixel2x2
x250 DiffBn VDD RefrBp GndD GndA PrSFBp OffBn PrBp OnBn pixRst[52] net107 net108 pixRst[53]
+ rowReadON[48] rowReadON[49] rowReadOFF[48] rowReadOFF[49] openDVS_pixel2x2
x251 DiffBn VDD RefrBp GndD GndA PrSFBp OffBn PrBp OnBn pixRst[54] net111 net112 pixRst[55]
+ rowReadON[48] rowReadON[49] rowReadOFF[48] rowReadOFF[49] openDVS_pixel2x2
x252 DiffBn VDD RefrBp GndD GndA PrSFBp OffBn PrBp OnBn pixRst[56] net115 net116 pixRst[57]
+ rowReadON[48] rowReadON[49] rowReadOFF[48] rowReadOFF[49] openDVS_pixel2x2
x253 DiffBn VDD RefrBp GndD GndA PrSFBp OffBn PrBp OnBn pixRst[58] net119 net120 pixRst[59]
+ rowReadON[48] rowReadON[49] rowReadOFF[48] rowReadOFF[49] openDVS_pixel2x2
x254 DiffBn VDD RefrBp GndD GndA PrSFBp OffBn PrBp OnBn pixRst[60] net123 net124 pixRst[61]
+ rowReadON[48] rowReadON[49] rowReadOFF[48] rowReadOFF[49] openDVS_pixel2x2
x255 DiffBn VDD RefrBp GndD GndA PrSFBp OffBn PrBp OnBn pixRst[62] net127 net128 pixRst[63]
+ rowReadON[48] rowReadON[49] rowReadOFF[48] rowReadOFF[49] openDVS_pixel2x2
x256 DiffBn VDD RefrBp GndD GndA PrSFBp OffBn PrBp OnBn pixRst[0] net3 net4 pixRst[1] rowReadON[46]
+ rowReadON[47] rowReadOFF[46] rowReadOFF[47] openDVS_pixel2x2
x257 DiffBn VDD RefrBp GndD GndA PrSFBp OffBn PrBp OnBn pixRst[2] net7 net8 pixRst[3] rowReadON[46]
+ rowReadON[47] rowReadOFF[46] rowReadOFF[47] openDVS_pixel2x2
x258 DiffBn VDD RefrBp GndD GndA PrSFBp OffBn PrBp OnBn pixRst[4] net11 net12 pixRst[5]
+ rowReadON[46] rowReadON[47] rowReadOFF[46] rowReadOFF[47] openDVS_pixel2x2
x259 DiffBn VDD RefrBp GndD GndA PrSFBp OffBn PrBp OnBn pixRst[6] net15 net16 pixRst[7]
+ rowReadON[46] rowReadON[47] rowReadOFF[46] rowReadOFF[47] openDVS_pixel2x2
x260 DiffBn VDD RefrBp GndD GndA PrSFBp OffBn PrBp OnBn pixRst[8] net19 net20 pixRst[9]
+ rowReadON[46] rowReadON[47] rowReadOFF[46] rowReadOFF[47] openDVS_pixel2x2
x261 DiffBn VDD RefrBp GndD GndA PrSFBp OffBn PrBp OnBn pixRst[10] net23 net24 pixRst[11]
+ rowReadON[46] rowReadON[47] rowReadOFF[46] rowReadOFF[47] openDVS_pixel2x2
x262 DiffBn VDD RefrBp GndD GndA PrSFBp OffBn PrBp OnBn pixRst[12] net27 net28 pixRst[13]
+ rowReadON[46] rowReadON[47] rowReadOFF[46] rowReadOFF[47] openDVS_pixel2x2
x263 DiffBn VDD RefrBp GndD GndA PrSFBp OffBn PrBp OnBn pixRst[14] net31 net32 pixRst[15]
+ rowReadON[46] rowReadON[47] rowReadOFF[46] rowReadOFF[47] openDVS_pixel2x2
x264 DiffBn VDD RefrBp GndD GndA PrSFBp OffBn PrBp OnBn pixRst[16] net35 net36 pixRst[17]
+ rowReadON[46] rowReadON[47] rowReadOFF[46] rowReadOFF[47] openDVS_pixel2x2
x265 DiffBn VDD RefrBp GndD GndA PrSFBp OffBn PrBp OnBn pixRst[18] net39 net40 pixRst[19]
+ rowReadON[46] rowReadON[47] rowReadOFF[46] rowReadOFF[47] openDVS_pixel2x2
x266 DiffBn VDD RefrBp GndD GndA PrSFBp OffBn PrBp OnBn pixRst[20] net43 net44 pixRst[21]
+ rowReadON[46] rowReadON[47] rowReadOFF[46] rowReadOFF[47] openDVS_pixel2x2
x267 DiffBn VDD RefrBp GndD GndA PrSFBp OffBn PrBp OnBn pixRst[22] net47 net48 pixRst[23]
+ rowReadON[46] rowReadON[47] rowReadOFF[46] rowReadOFF[47] openDVS_pixel2x2
x268 DiffBn VDD RefrBp GndD GndA PrSFBp OffBn PrBp OnBn pixRst[24] net51 net52 pixRst[25]
+ rowReadON[46] rowReadON[47] rowReadOFF[46] rowReadOFF[47] openDVS_pixel2x2
x269 DiffBn VDD RefrBp GndD GndA PrSFBp OffBn PrBp OnBn pixRst[26] net55 net56 pixRst[27]
+ rowReadON[46] rowReadON[47] rowReadOFF[46] rowReadOFF[47] openDVS_pixel2x2
x270 DiffBn VDD RefrBp GndD GndA PrSFBp OffBn PrBp OnBn pixRst[28] net59 net60 pixRst[29]
+ rowReadON[46] rowReadON[47] rowReadOFF[46] rowReadOFF[47] openDVS_pixel2x2
x271 DiffBn VDD RefrBp GndD GndA PrSFBp OffBn PrBp OnBn pixRst[30] net63 net64 pixRst[31]
+ rowReadON[46] rowReadON[47] rowReadOFF[46] rowReadOFF[47] openDVS_pixel2x2
x272 DiffBn VDD RefrBp GndD GndA PrSFBp OffBn PrBp OnBn pixRst[32] net67 net68 pixRst[33]
+ rowReadON[46] rowReadON[47] rowReadOFF[46] rowReadOFF[47] openDVS_pixel2x2
x273 DiffBn VDD RefrBp GndD GndA PrSFBp OffBn PrBp OnBn pixRst[34] net71 net72 pixRst[35]
+ rowReadON[46] rowReadON[47] rowReadOFF[46] rowReadOFF[47] openDVS_pixel2x2
x274 DiffBn VDD RefrBp GndD GndA PrSFBp OffBn PrBp OnBn pixRst[36] net75 net76 pixRst[37]
+ rowReadON[46] rowReadON[47] rowReadOFF[46] rowReadOFF[47] openDVS_pixel2x2
x275 DiffBn VDD RefrBp GndD GndA PrSFBp OffBn PrBp OnBn pixRst[38] net79 net80 pixRst[39]
+ rowReadON[46] rowReadON[47] rowReadOFF[46] rowReadOFF[47] openDVS_pixel2x2
x276 DiffBn VDD RefrBp GndD GndA PrSFBp OffBn PrBp OnBn pixRst[40] net83 net84 pixRst[41]
+ rowReadON[46] rowReadON[47] rowReadOFF[46] rowReadOFF[47] openDVS_pixel2x2
x277 DiffBn VDD RefrBp GndD GndA PrSFBp OffBn PrBp OnBn pixRst[42] net87 net88 pixRst[43]
+ rowReadON[46] rowReadON[47] rowReadOFF[46] rowReadOFF[47] openDVS_pixel2x2
x278 DiffBn VDD RefrBp GndD GndA PrSFBp OffBn PrBp OnBn pixRst[44] net91 net92 pixRst[45]
+ rowReadON[46] rowReadON[47] rowReadOFF[46] rowReadOFF[47] openDVS_pixel2x2
x279 DiffBn VDD RefrBp GndD GndA PrSFBp OffBn PrBp OnBn pixRst[46] net95 net96 pixRst[47]
+ rowReadON[46] rowReadON[47] rowReadOFF[46] rowReadOFF[47] openDVS_pixel2x2
x280 DiffBn VDD RefrBp GndD GndA PrSFBp OffBn PrBp OnBn pixRst[48] net99 net100 pixRst[49]
+ rowReadON[46] rowReadON[47] rowReadOFF[46] rowReadOFF[47] openDVS_pixel2x2
x281 DiffBn VDD RefrBp GndD GndA PrSFBp OffBn PrBp OnBn pixRst[50] net103 net104 pixRst[51]
+ rowReadON[46] rowReadON[47] rowReadOFF[46] rowReadOFF[47] openDVS_pixel2x2
x282 DiffBn VDD RefrBp GndD GndA PrSFBp OffBn PrBp OnBn pixRst[52] net107 net108 pixRst[53]
+ rowReadON[46] rowReadON[47] rowReadOFF[46] rowReadOFF[47] openDVS_pixel2x2
x283 DiffBn VDD RefrBp GndD GndA PrSFBp OffBn PrBp OnBn pixRst[54] net111 net112 pixRst[55]
+ rowReadON[46] rowReadON[47] rowReadOFF[46] rowReadOFF[47] openDVS_pixel2x2
x284 DiffBn VDD RefrBp GndD GndA PrSFBp OffBn PrBp OnBn pixRst[56] net115 net116 pixRst[57]
+ rowReadON[46] rowReadON[47] rowReadOFF[46] rowReadOFF[47] openDVS_pixel2x2
x285 DiffBn VDD RefrBp GndD GndA PrSFBp OffBn PrBp OnBn pixRst[58] net119 net120 pixRst[59]
+ rowReadON[46] rowReadON[47] rowReadOFF[46] rowReadOFF[47] openDVS_pixel2x2
x286 DiffBn VDD RefrBp GndD GndA PrSFBp OffBn PrBp OnBn pixRst[60] net123 net124 pixRst[61]
+ rowReadON[46] rowReadON[47] rowReadOFF[46] rowReadOFF[47] openDVS_pixel2x2
x287 DiffBn VDD RefrBp GndD GndA PrSFBp OffBn PrBp OnBn pixRst[62] net127 net128 pixRst[63]
+ rowReadON[46] rowReadON[47] rowReadOFF[46] rowReadOFF[47] openDVS_pixel2x2
x288 DiffBn VDD RefrBp GndD GndA PrSFBp OffBn PrBp OnBn pixRst[0] net3 net4 pixRst[1] rowReadON[44]
+ rowReadON[45] rowReadOFF[44] rowReadOFF[45] openDVS_pixel2x2
x289 DiffBn VDD RefrBp GndD GndA PrSFBp OffBn PrBp OnBn pixRst[2] net7 net8 pixRst[3] rowReadON[44]
+ rowReadON[45] rowReadOFF[44] rowReadOFF[45] openDVS_pixel2x2
x290 DiffBn VDD RefrBp GndD GndA PrSFBp OffBn PrBp OnBn pixRst[4] net11 net12 pixRst[5]
+ rowReadON[44] rowReadON[45] rowReadOFF[44] rowReadOFF[45] openDVS_pixel2x2
x291 DiffBn VDD RefrBp GndD GndA PrSFBp OffBn PrBp OnBn pixRst[6] net15 net16 pixRst[7]
+ rowReadON[44] rowReadON[45] rowReadOFF[44] rowReadOFF[45] openDVS_pixel2x2
x292 DiffBn VDD RefrBp GndD GndA PrSFBp OffBn PrBp OnBn pixRst[8] net19 net20 pixRst[9]
+ rowReadON[44] rowReadON[45] rowReadOFF[44] rowReadOFF[45] openDVS_pixel2x2
x293 DiffBn VDD RefrBp GndD GndA PrSFBp OffBn PrBp OnBn pixRst[10] net23 net24 pixRst[11]
+ rowReadON[44] rowReadON[45] rowReadOFF[44] rowReadOFF[45] openDVS_pixel2x2
x294 DiffBn VDD RefrBp GndD GndA PrSFBp OffBn PrBp OnBn pixRst[12] net27 net28 pixRst[13]
+ rowReadON[44] rowReadON[45] rowReadOFF[44] rowReadOFF[45] openDVS_pixel2x2
x295 DiffBn VDD RefrBp GndD GndA PrSFBp OffBn PrBp OnBn pixRst[14] net31 net32 pixRst[15]
+ rowReadON[44] rowReadON[45] rowReadOFF[44] rowReadOFF[45] openDVS_pixel2x2
x296 DiffBn VDD RefrBp GndD GndA PrSFBp OffBn PrBp OnBn pixRst[16] net35 net36 pixRst[17]
+ rowReadON[44] rowReadON[45] rowReadOFF[44] rowReadOFF[45] openDVS_pixel2x2
x297 DiffBn VDD RefrBp GndD GndA PrSFBp OffBn PrBp OnBn pixRst[18] net39 net40 pixRst[19]
+ rowReadON[44] rowReadON[45] rowReadOFF[44] rowReadOFF[45] openDVS_pixel2x2
x298 DiffBn VDD RefrBp GndD GndA PrSFBp OffBn PrBp OnBn pixRst[20] net43 net44 pixRst[21]
+ rowReadON[44] rowReadON[45] rowReadOFF[44] rowReadOFF[45] openDVS_pixel2x2
x299 DiffBn VDD RefrBp GndD GndA PrSFBp OffBn PrBp OnBn pixRst[22] net47 net48 pixRst[23]
+ rowReadON[44] rowReadON[45] rowReadOFF[44] rowReadOFF[45] openDVS_pixel2x2
x300 DiffBn VDD RefrBp GndD GndA PrSFBp OffBn PrBp OnBn pixRst[24] net51 net52 pixRst[25]
+ rowReadON[44] rowReadON[45] rowReadOFF[44] rowReadOFF[45] openDVS_pixel2x2
x301 DiffBn VDD RefrBp GndD GndA PrSFBp OffBn PrBp OnBn pixRst[26] net55 net56 pixRst[27]
+ rowReadON[44] rowReadON[45] rowReadOFF[44] rowReadOFF[45] openDVS_pixel2x2
x302 DiffBn VDD RefrBp GndD GndA PrSFBp OffBn PrBp OnBn pixRst[28] net59 net60 pixRst[29]
+ rowReadON[44] rowReadON[45] rowReadOFF[44] rowReadOFF[45] openDVS_pixel2x2
x303 DiffBn VDD RefrBp GndD GndA PrSFBp OffBn PrBp OnBn pixRst[30] net63 net64 pixRst[31]
+ rowReadON[44] rowReadON[45] rowReadOFF[44] rowReadOFF[45] openDVS_pixel2x2
x304 DiffBn VDD RefrBp GndD GndA PrSFBp OffBn PrBp OnBn pixRst[32] net67 net68 pixRst[33]
+ rowReadON[44] rowReadON[45] rowReadOFF[44] rowReadOFF[45] openDVS_pixel2x2
x305 DiffBn VDD RefrBp GndD GndA PrSFBp OffBn PrBp OnBn pixRst[34] net71 net72 pixRst[35]
+ rowReadON[44] rowReadON[45] rowReadOFF[44] rowReadOFF[45] openDVS_pixel2x2
x306 DiffBn VDD RefrBp GndD GndA PrSFBp OffBn PrBp OnBn pixRst[36] net75 net76 pixRst[37]
+ rowReadON[44] rowReadON[45] rowReadOFF[44] rowReadOFF[45] openDVS_pixel2x2
x307 DiffBn VDD RefrBp GndD GndA PrSFBp OffBn PrBp OnBn pixRst[38] net79 net80 pixRst[39]
+ rowReadON[44] rowReadON[45] rowReadOFF[44] rowReadOFF[45] openDVS_pixel2x2
x308 DiffBn VDD RefrBp GndD GndA PrSFBp OffBn PrBp OnBn pixRst[40] net83 net84 pixRst[41]
+ rowReadON[44] rowReadON[45] rowReadOFF[44] rowReadOFF[45] openDVS_pixel2x2
x309 DiffBn VDD RefrBp GndD GndA PrSFBp OffBn PrBp OnBn pixRst[42] net87 net88 pixRst[43]
+ rowReadON[44] rowReadON[45] rowReadOFF[44] rowReadOFF[45] openDVS_pixel2x2
x310 DiffBn VDD RefrBp GndD GndA PrSFBp OffBn PrBp OnBn pixRst[44] net91 net92 pixRst[45]
+ rowReadON[44] rowReadON[45] rowReadOFF[44] rowReadOFF[45] openDVS_pixel2x2
x311 DiffBn VDD RefrBp GndD GndA PrSFBp OffBn PrBp OnBn pixRst[46] net95 net96 pixRst[47]
+ rowReadON[44] rowReadON[45] rowReadOFF[44] rowReadOFF[45] openDVS_pixel2x2
x312 DiffBn VDD RefrBp GndD GndA PrSFBp OffBn PrBp OnBn pixRst[48] net99 net100 pixRst[49]
+ rowReadON[44] rowReadON[45] rowReadOFF[44] rowReadOFF[45] openDVS_pixel2x2
x313 DiffBn VDD RefrBp GndD GndA PrSFBp OffBn PrBp OnBn pixRst[50] net103 net104 pixRst[51]
+ rowReadON[44] rowReadON[45] rowReadOFF[44] rowReadOFF[45] openDVS_pixel2x2
x314 DiffBn VDD RefrBp GndD GndA PrSFBp OffBn PrBp OnBn pixRst[52] net107 net108 pixRst[53]
+ rowReadON[44] rowReadON[45] rowReadOFF[44] rowReadOFF[45] openDVS_pixel2x2
x315 DiffBn VDD RefrBp GndD GndA PrSFBp OffBn PrBp OnBn pixRst[54] net111 net112 pixRst[55]
+ rowReadON[44] rowReadON[45] rowReadOFF[44] rowReadOFF[45] openDVS_pixel2x2
x316 DiffBn VDD RefrBp GndD GndA PrSFBp OffBn PrBp OnBn pixRst[56] net115 net116 pixRst[57]
+ rowReadON[44] rowReadON[45] rowReadOFF[44] rowReadOFF[45] openDVS_pixel2x2
x317 DiffBn VDD RefrBp GndD GndA PrSFBp OffBn PrBp OnBn pixRst[58] net119 net120 pixRst[59]
+ rowReadON[44] rowReadON[45] rowReadOFF[44] rowReadOFF[45] openDVS_pixel2x2
x318 DiffBn VDD RefrBp GndD GndA PrSFBp OffBn PrBp OnBn pixRst[60] net123 net124 pixRst[61]
+ rowReadON[44] rowReadON[45] rowReadOFF[44] rowReadOFF[45] openDVS_pixel2x2
x319 DiffBn VDD RefrBp GndD GndA PrSFBp OffBn PrBp OnBn pixRst[62] net127 net128 pixRst[63]
+ rowReadON[44] rowReadON[45] rowReadOFF[44] rowReadOFF[45] openDVS_pixel2x2
x320 DiffBn VDD RefrBp GndD GndA PrSFBp OffBn PrBp OnBn pixRst[0] net3 net4 pixRst[1] rowReadON[42]
+ rowReadON[43] rowReadOFF[42] rowReadOFF[43] openDVS_pixel2x2
x321 DiffBn VDD RefrBp GndD GndA PrSFBp OffBn PrBp OnBn pixRst[2] net7 net8 pixRst[3] rowReadON[42]
+ rowReadON[43] rowReadOFF[42] rowReadOFF[43] openDVS_pixel2x2
x322 DiffBn VDD RefrBp GndD GndA PrSFBp OffBn PrBp OnBn pixRst[4] net11 net12 pixRst[5]
+ rowReadON[42] rowReadON[43] rowReadOFF[42] rowReadOFF[43] openDVS_pixel2x2
x323 DiffBn VDD RefrBp GndD GndA PrSFBp OffBn PrBp OnBn pixRst[6] net15 net16 pixRst[7]
+ rowReadON[42] rowReadON[43] rowReadOFF[42] rowReadOFF[43] openDVS_pixel2x2
x324 DiffBn VDD RefrBp GndD GndA PrSFBp OffBn PrBp OnBn pixRst[8] net19 net20 pixRst[9]
+ rowReadON[42] rowReadON[43] rowReadOFF[42] rowReadOFF[43] openDVS_pixel2x2
x325 DiffBn VDD RefrBp GndD GndA PrSFBp OffBn PrBp OnBn pixRst[10] net23 net24 pixRst[11]
+ rowReadON[42] rowReadON[43] rowReadOFF[42] rowReadOFF[43] openDVS_pixel2x2
x326 DiffBn VDD RefrBp GndD GndA PrSFBp OffBn PrBp OnBn pixRst[12] net27 net28 pixRst[13]
+ rowReadON[42] rowReadON[43] rowReadOFF[42] rowReadOFF[43] openDVS_pixel2x2
x327 DiffBn VDD RefrBp GndD GndA PrSFBp OffBn PrBp OnBn pixRst[14] net31 net32 pixRst[15]
+ rowReadON[42] rowReadON[43] rowReadOFF[42] rowReadOFF[43] openDVS_pixel2x2
x328 DiffBn VDD RefrBp GndD GndA PrSFBp OffBn PrBp OnBn pixRst[16] net35 net36 pixRst[17]
+ rowReadON[42] rowReadON[43] rowReadOFF[42] rowReadOFF[43] openDVS_pixel2x2
x329 DiffBn VDD RefrBp GndD GndA PrSFBp OffBn PrBp OnBn pixRst[18] net39 net40 pixRst[19]
+ rowReadON[42] rowReadON[43] rowReadOFF[42] rowReadOFF[43] openDVS_pixel2x2
x330 DiffBn VDD RefrBp GndD GndA PrSFBp OffBn PrBp OnBn pixRst[20] net43 net44 pixRst[21]
+ rowReadON[42] rowReadON[43] rowReadOFF[42] rowReadOFF[43] openDVS_pixel2x2
x331 DiffBn VDD RefrBp GndD GndA PrSFBp OffBn PrBp OnBn pixRst[22] net47 net48 pixRst[23]
+ rowReadON[42] rowReadON[43] rowReadOFF[42] rowReadOFF[43] openDVS_pixel2x2
x332 DiffBn VDD RefrBp GndD GndA PrSFBp OffBn PrBp OnBn pixRst[24] net51 net52 pixRst[25]
+ rowReadON[42] rowReadON[43] rowReadOFF[42] rowReadOFF[43] openDVS_pixel2x2
x333 DiffBn VDD RefrBp GndD GndA PrSFBp OffBn PrBp OnBn pixRst[26] net55 net56 pixRst[27]
+ rowReadON[42] rowReadON[43] rowReadOFF[42] rowReadOFF[43] openDVS_pixel2x2
x334 DiffBn VDD RefrBp GndD GndA PrSFBp OffBn PrBp OnBn pixRst[28] net59 net60 pixRst[29]
+ rowReadON[42] rowReadON[43] rowReadOFF[42] rowReadOFF[43] openDVS_pixel2x2
x335 DiffBn VDD RefrBp GndD GndA PrSFBp OffBn PrBp OnBn pixRst[30] net63 net64 pixRst[31]
+ rowReadON[42] rowReadON[43] rowReadOFF[42] rowReadOFF[43] openDVS_pixel2x2
x336 DiffBn VDD RefrBp GndD GndA PrSFBp OffBn PrBp OnBn pixRst[32] net67 net68 pixRst[33]
+ rowReadON[42] rowReadON[43] rowReadOFF[42] rowReadOFF[43] openDVS_pixel2x2
x337 DiffBn VDD RefrBp GndD GndA PrSFBp OffBn PrBp OnBn pixRst[34] net71 net72 pixRst[35]
+ rowReadON[42] rowReadON[43] rowReadOFF[42] rowReadOFF[43] openDVS_pixel2x2
x338 DiffBn VDD RefrBp GndD GndA PrSFBp OffBn PrBp OnBn pixRst[36] net75 net76 pixRst[37]
+ rowReadON[42] rowReadON[43] rowReadOFF[42] rowReadOFF[43] openDVS_pixel2x2
x339 DiffBn VDD RefrBp GndD GndA PrSFBp OffBn PrBp OnBn pixRst[38] net79 net80 pixRst[39]
+ rowReadON[42] rowReadON[43] rowReadOFF[42] rowReadOFF[43] openDVS_pixel2x2
x340 DiffBn VDD RefrBp GndD GndA PrSFBp OffBn PrBp OnBn pixRst[40] net83 net84 pixRst[41]
+ rowReadON[42] rowReadON[43] rowReadOFF[42] rowReadOFF[43] openDVS_pixel2x2
x341 DiffBn VDD RefrBp GndD GndA PrSFBp OffBn PrBp OnBn pixRst[42] net87 net88 pixRst[43]
+ rowReadON[42] rowReadON[43] rowReadOFF[42] rowReadOFF[43] openDVS_pixel2x2
x342 DiffBn VDD RefrBp GndD GndA PrSFBp OffBn PrBp OnBn pixRst[44] net91 net92 pixRst[45]
+ rowReadON[42] rowReadON[43] rowReadOFF[42] rowReadOFF[43] openDVS_pixel2x2
x343 DiffBn VDD RefrBp GndD GndA PrSFBp OffBn PrBp OnBn pixRst[46] net95 net96 pixRst[47]
+ rowReadON[42] rowReadON[43] rowReadOFF[42] rowReadOFF[43] openDVS_pixel2x2
x344 DiffBn VDD RefrBp GndD GndA PrSFBp OffBn PrBp OnBn pixRst[48] net99 net100 pixRst[49]
+ rowReadON[42] rowReadON[43] rowReadOFF[42] rowReadOFF[43] openDVS_pixel2x2
x345 DiffBn VDD RefrBp GndD GndA PrSFBp OffBn PrBp OnBn pixRst[50] net103 net104 pixRst[51]
+ rowReadON[42] rowReadON[43] rowReadOFF[42] rowReadOFF[43] openDVS_pixel2x2
x346 DiffBn VDD RefrBp GndD GndA PrSFBp OffBn PrBp OnBn pixRst[52] net107 net108 pixRst[53]
+ rowReadON[42] rowReadON[43] rowReadOFF[42] rowReadOFF[43] openDVS_pixel2x2
x347 DiffBn VDD RefrBp GndD GndA PrSFBp OffBn PrBp OnBn pixRst[54] net111 net112 pixRst[55]
+ rowReadON[42] rowReadON[43] rowReadOFF[42] rowReadOFF[43] openDVS_pixel2x2
x348 DiffBn VDD RefrBp GndD GndA PrSFBp OffBn PrBp OnBn pixRst[56] net115 net116 pixRst[57]
+ rowReadON[42] rowReadON[43] rowReadOFF[42] rowReadOFF[43] openDVS_pixel2x2
x349 DiffBn VDD RefrBp GndD GndA PrSFBp OffBn PrBp OnBn pixRst[58] net119 net120 pixRst[59]
+ rowReadON[42] rowReadON[43] rowReadOFF[42] rowReadOFF[43] openDVS_pixel2x2
x350 DiffBn VDD RefrBp GndD GndA PrSFBp OffBn PrBp OnBn pixRst[60] net123 net124 pixRst[61]
+ rowReadON[42] rowReadON[43] rowReadOFF[42] rowReadOFF[43] openDVS_pixel2x2
x351 DiffBn VDD RefrBp GndD GndA PrSFBp OffBn PrBp OnBn pixRst[62] net127 net128 pixRst[63]
+ rowReadON[42] rowReadON[43] rowReadOFF[42] rowReadOFF[43] openDVS_pixel2x2
x352 DiffBn VDD RefrBp GndD GndA PrSFBp OffBn PrBp OnBn pixRst[0] net3 net4 pixRst[1] rowReadON[40]
+ rowReadON[41] rowReadOFF[40] rowReadOFF[41] openDVS_pixel2x2
x353 DiffBn VDD RefrBp GndD GndA PrSFBp OffBn PrBp OnBn pixRst[2] net7 net8 pixRst[3] rowReadON[40]
+ rowReadON[41] rowReadOFF[40] rowReadOFF[41] openDVS_pixel2x2
x354 DiffBn VDD RefrBp GndD GndA PrSFBp OffBn PrBp OnBn pixRst[4] net11 net12 pixRst[5]
+ rowReadON[40] rowReadON[41] rowReadOFF[40] rowReadOFF[41] openDVS_pixel2x2
x355 DiffBn VDD RefrBp GndD GndA PrSFBp OffBn PrBp OnBn pixRst[6] net15 net16 pixRst[7]
+ rowReadON[40] rowReadON[41] rowReadOFF[40] rowReadOFF[41] openDVS_pixel2x2
x356 DiffBn VDD RefrBp GndD GndA PrSFBp OffBn PrBp OnBn pixRst[8] net19 net20 pixRst[9]
+ rowReadON[40] rowReadON[41] rowReadOFF[40] rowReadOFF[41] openDVS_pixel2x2
x357 DiffBn VDD RefrBp GndD GndA PrSFBp OffBn PrBp OnBn pixRst[10] net23 net24 pixRst[11]
+ rowReadON[40] rowReadON[41] rowReadOFF[40] rowReadOFF[41] openDVS_pixel2x2
x358 DiffBn VDD RefrBp GndD GndA PrSFBp OffBn PrBp OnBn pixRst[12] net27 net28 pixRst[13]
+ rowReadON[40] rowReadON[41] rowReadOFF[40] rowReadOFF[41] openDVS_pixel2x2
x359 DiffBn VDD RefrBp GndD GndA PrSFBp OffBn PrBp OnBn pixRst[14] net31 net32 pixRst[15]
+ rowReadON[40] rowReadON[41] rowReadOFF[40] rowReadOFF[41] openDVS_pixel2x2
x360 DiffBn VDD RefrBp GndD GndA PrSFBp OffBn PrBp OnBn pixRst[16] net35 net36 pixRst[17]
+ rowReadON[40] rowReadON[41] rowReadOFF[40] rowReadOFF[41] openDVS_pixel2x2
x361 DiffBn VDD RefrBp GndD GndA PrSFBp OffBn PrBp OnBn pixRst[18] net39 net40 pixRst[19]
+ rowReadON[40] rowReadON[41] rowReadOFF[40] rowReadOFF[41] openDVS_pixel2x2
x362 DiffBn VDD RefrBp GndD GndA PrSFBp OffBn PrBp OnBn pixRst[20] net43 net44 pixRst[21]
+ rowReadON[40] rowReadON[41] rowReadOFF[40] rowReadOFF[41] openDVS_pixel2x2
x363 DiffBn VDD RefrBp GndD GndA PrSFBp OffBn PrBp OnBn pixRst[22] net47 net48 pixRst[23]
+ rowReadON[40] rowReadON[41] rowReadOFF[40] rowReadOFF[41] openDVS_pixel2x2
x364 DiffBn VDD RefrBp GndD GndA PrSFBp OffBn PrBp OnBn pixRst[24] net51 net52 pixRst[25]
+ rowReadON[40] rowReadON[41] rowReadOFF[40] rowReadOFF[41] openDVS_pixel2x2
x365 DiffBn VDD RefrBp GndD GndA PrSFBp OffBn PrBp OnBn pixRst[26] net55 net56 pixRst[27]
+ rowReadON[40] rowReadON[41] rowReadOFF[40] rowReadOFF[41] openDVS_pixel2x2
x366 DiffBn VDD RefrBp GndD GndA PrSFBp OffBn PrBp OnBn pixRst[28] net59 net60 pixRst[29]
+ rowReadON[40] rowReadON[41] rowReadOFF[40] rowReadOFF[41] openDVS_pixel2x2
x367 DiffBn VDD RefrBp GndD GndA PrSFBp OffBn PrBp OnBn pixRst[30] net63 net64 pixRst[31]
+ rowReadON[40] rowReadON[41] rowReadOFF[40] rowReadOFF[41] openDVS_pixel2x2
x368 DiffBn VDD RefrBp GndD GndA PrSFBp OffBn PrBp OnBn pixRst[32] net67 net68 pixRst[33]
+ rowReadON[40] rowReadON[41] rowReadOFF[40] rowReadOFF[41] openDVS_pixel2x2
x369 DiffBn VDD RefrBp GndD GndA PrSFBp OffBn PrBp OnBn pixRst[34] net71 net72 pixRst[35]
+ rowReadON[40] rowReadON[41] rowReadOFF[40] rowReadOFF[41] openDVS_pixel2x2
x370 DiffBn VDD RefrBp GndD GndA PrSFBp OffBn PrBp OnBn pixRst[36] net75 net76 pixRst[37]
+ rowReadON[40] rowReadON[41] rowReadOFF[40] rowReadOFF[41] openDVS_pixel2x2
x371 DiffBn VDD RefrBp GndD GndA PrSFBp OffBn PrBp OnBn pixRst[38] net79 net80 pixRst[39]
+ rowReadON[40] rowReadON[41] rowReadOFF[40] rowReadOFF[41] openDVS_pixel2x2
x372 DiffBn VDD RefrBp GndD GndA PrSFBp OffBn PrBp OnBn pixRst[40] net83 net84 pixRst[41]
+ rowReadON[40] rowReadON[41] rowReadOFF[40] rowReadOFF[41] openDVS_pixel2x2
x373 DiffBn VDD RefrBp GndD GndA PrSFBp OffBn PrBp OnBn pixRst[42] net87 net88 pixRst[43]
+ rowReadON[40] rowReadON[41] rowReadOFF[40] rowReadOFF[41] openDVS_pixel2x2
x374 DiffBn VDD RefrBp GndD GndA PrSFBp OffBn PrBp OnBn pixRst[44] net91 net92 pixRst[45]
+ rowReadON[40] rowReadON[41] rowReadOFF[40] rowReadOFF[41] openDVS_pixel2x2
x375 DiffBn VDD RefrBp GndD GndA PrSFBp OffBn PrBp OnBn pixRst[46] net95 net96 pixRst[47]
+ rowReadON[40] rowReadON[41] rowReadOFF[40] rowReadOFF[41] openDVS_pixel2x2
x376 DiffBn VDD RefrBp GndD GndA PrSFBp OffBn PrBp OnBn pixRst[48] net99 net100 pixRst[49]
+ rowReadON[40] rowReadON[41] rowReadOFF[40] rowReadOFF[41] openDVS_pixel2x2
x377 DiffBn VDD RefrBp GndD GndA PrSFBp OffBn PrBp OnBn pixRst[50] net103 net104 pixRst[51]
+ rowReadON[40] rowReadON[41] rowReadOFF[40] rowReadOFF[41] openDVS_pixel2x2
x378 DiffBn VDD RefrBp GndD GndA PrSFBp OffBn PrBp OnBn pixRst[52] net107 net108 pixRst[53]
+ rowReadON[40] rowReadON[41] rowReadOFF[40] rowReadOFF[41] openDVS_pixel2x2
x379 DiffBn VDD RefrBp GndD GndA PrSFBp OffBn PrBp OnBn pixRst[54] net111 net112 pixRst[55]
+ rowReadON[40] rowReadON[41] rowReadOFF[40] rowReadOFF[41] openDVS_pixel2x2
x380 DiffBn VDD RefrBp GndD GndA PrSFBp OffBn PrBp OnBn pixRst[56] net115 net116 pixRst[57]
+ rowReadON[40] rowReadON[41] rowReadOFF[40] rowReadOFF[41] openDVS_pixel2x2
x381 DiffBn VDD RefrBp GndD GndA PrSFBp OffBn PrBp OnBn pixRst[58] net119 net120 pixRst[59]
+ rowReadON[40] rowReadON[41] rowReadOFF[40] rowReadOFF[41] openDVS_pixel2x2
x382 DiffBn VDD RefrBp GndD GndA PrSFBp OffBn PrBp OnBn pixRst[60] net123 net124 pixRst[61]
+ rowReadON[40] rowReadON[41] rowReadOFF[40] rowReadOFF[41] openDVS_pixel2x2
x383 DiffBn VDD RefrBp GndD GndA PrSFBp OffBn PrBp OnBn pixRst[62] net127 net128 pixRst[63]
+ rowReadON[40] rowReadON[41] rowReadOFF[40] rowReadOFF[41] openDVS_pixel2x2
x384 DiffBn VDD RefrBp GndD GndA PrSFBp OffBn PrBp OnBn pixRst[0] net3 net4 pixRst[1] rowReadON[38]
+ rowReadON[39] rowReadOFF[38] rowReadOFF[39] openDVS_pixel2x2
x385 DiffBn VDD RefrBp GndD GndA PrSFBp OffBn PrBp OnBn pixRst[2] net7 net8 pixRst[3] rowReadON[38]
+ rowReadON[39] rowReadOFF[38] rowReadOFF[39] openDVS_pixel2x2
x386 DiffBn VDD RefrBp GndD GndA PrSFBp OffBn PrBp OnBn pixRst[4] net11 net12 pixRst[5]
+ rowReadON[38] rowReadON[39] rowReadOFF[38] rowReadOFF[39] openDVS_pixel2x2
x387 DiffBn VDD RefrBp GndD GndA PrSFBp OffBn PrBp OnBn pixRst[6] net15 net16 pixRst[7]
+ rowReadON[38] rowReadON[39] rowReadOFF[38] rowReadOFF[39] openDVS_pixel2x2
x388 DiffBn VDD RefrBp GndD GndA PrSFBp OffBn PrBp OnBn pixRst[8] net19 net20 pixRst[9]
+ rowReadON[38] rowReadON[39] rowReadOFF[38] rowReadOFF[39] openDVS_pixel2x2
x389 DiffBn VDD RefrBp GndD GndA PrSFBp OffBn PrBp OnBn pixRst[10] net23 net24 pixRst[11]
+ rowReadON[38] rowReadON[39] rowReadOFF[38] rowReadOFF[39] openDVS_pixel2x2
x390 DiffBn VDD RefrBp GndD GndA PrSFBp OffBn PrBp OnBn pixRst[12] net27 net28 pixRst[13]
+ rowReadON[38] rowReadON[39] rowReadOFF[38] rowReadOFF[39] openDVS_pixel2x2
x391 DiffBn VDD RefrBp GndD GndA PrSFBp OffBn PrBp OnBn pixRst[14] net31 net32 pixRst[15]
+ rowReadON[38] rowReadON[39] rowReadOFF[38] rowReadOFF[39] openDVS_pixel2x2
x392 DiffBn VDD RefrBp GndD GndA PrSFBp OffBn PrBp OnBn pixRst[16] net35 net36 pixRst[17]
+ rowReadON[38] rowReadON[39] rowReadOFF[38] rowReadOFF[39] openDVS_pixel2x2
x393 DiffBn VDD RefrBp GndD GndA PrSFBp OffBn PrBp OnBn pixRst[18] net39 net40 pixRst[19]
+ rowReadON[38] rowReadON[39] rowReadOFF[38] rowReadOFF[39] openDVS_pixel2x2
x394 DiffBn VDD RefrBp GndD GndA PrSFBp OffBn PrBp OnBn pixRst[20] net43 net44 pixRst[21]
+ rowReadON[38] rowReadON[39] rowReadOFF[38] rowReadOFF[39] openDVS_pixel2x2
x395 DiffBn VDD RefrBp GndD GndA PrSFBp OffBn PrBp OnBn pixRst[22] net47 net48 pixRst[23]
+ rowReadON[38] rowReadON[39] rowReadOFF[38] rowReadOFF[39] openDVS_pixel2x2
x396 DiffBn VDD RefrBp GndD GndA PrSFBp OffBn PrBp OnBn pixRst[24] net51 net52 pixRst[25]
+ rowReadON[38] rowReadON[39] rowReadOFF[38] rowReadOFF[39] openDVS_pixel2x2
x397 DiffBn VDD RefrBp GndD GndA PrSFBp OffBn PrBp OnBn pixRst[26] net55 net56 pixRst[27]
+ rowReadON[38] rowReadON[39] rowReadOFF[38] rowReadOFF[39] openDVS_pixel2x2
x398 DiffBn VDD RefrBp GndD GndA PrSFBp OffBn PrBp OnBn pixRst[28] net59 net60 pixRst[29]
+ rowReadON[38] rowReadON[39] rowReadOFF[38] rowReadOFF[39] openDVS_pixel2x2
x399 DiffBn VDD RefrBp GndD GndA PrSFBp OffBn PrBp OnBn pixRst[30] net63 net64 pixRst[31]
+ rowReadON[38] rowReadON[39] rowReadOFF[38] rowReadOFF[39] openDVS_pixel2x2
x400 DiffBn VDD RefrBp GndD GndA PrSFBp OffBn PrBp OnBn pixRst[32] net67 net68 pixRst[33]
+ rowReadON[38] rowReadON[39] rowReadOFF[38] rowReadOFF[39] openDVS_pixel2x2
x401 DiffBn VDD RefrBp GndD GndA PrSFBp OffBn PrBp OnBn pixRst[34] net71 net72 pixRst[35]
+ rowReadON[38] rowReadON[39] rowReadOFF[38] rowReadOFF[39] openDVS_pixel2x2
x402 DiffBn VDD RefrBp GndD GndA PrSFBp OffBn PrBp OnBn pixRst[36] net75 net76 pixRst[37]
+ rowReadON[38] rowReadON[39] rowReadOFF[38] rowReadOFF[39] openDVS_pixel2x2
x403 DiffBn VDD RefrBp GndD GndA PrSFBp OffBn PrBp OnBn pixRst[38] net79 net80 pixRst[39]
+ rowReadON[38] rowReadON[39] rowReadOFF[38] rowReadOFF[39] openDVS_pixel2x2
x404 DiffBn VDD RefrBp GndD GndA PrSFBp OffBn PrBp OnBn pixRst[40] net83 net84 pixRst[41]
+ rowReadON[38] rowReadON[39] rowReadOFF[38] rowReadOFF[39] openDVS_pixel2x2
x405 DiffBn VDD RefrBp GndD GndA PrSFBp OffBn PrBp OnBn pixRst[42] net87 net88 pixRst[43]
+ rowReadON[38] rowReadON[39] rowReadOFF[38] rowReadOFF[39] openDVS_pixel2x2
x406 DiffBn VDD RefrBp GndD GndA PrSFBp OffBn PrBp OnBn pixRst[44] net91 net92 pixRst[45]
+ rowReadON[38] rowReadON[39] rowReadOFF[38] rowReadOFF[39] openDVS_pixel2x2
x407 DiffBn VDD RefrBp GndD GndA PrSFBp OffBn PrBp OnBn pixRst[46] net95 net96 pixRst[47]
+ rowReadON[38] rowReadON[39] rowReadOFF[38] rowReadOFF[39] openDVS_pixel2x2
x408 DiffBn VDD RefrBp GndD GndA PrSFBp OffBn PrBp OnBn pixRst[48] net99 net100 pixRst[49]
+ rowReadON[38] rowReadON[39] rowReadOFF[38] rowReadOFF[39] openDVS_pixel2x2
x409 DiffBn VDD RefrBp GndD GndA PrSFBp OffBn PrBp OnBn pixRst[50] net103 net104 pixRst[51]
+ rowReadON[38] rowReadON[39] rowReadOFF[38] rowReadOFF[39] openDVS_pixel2x2
x410 DiffBn VDD RefrBp GndD GndA PrSFBp OffBn PrBp OnBn pixRst[52] net107 net108 pixRst[53]
+ rowReadON[38] rowReadON[39] rowReadOFF[38] rowReadOFF[39] openDVS_pixel2x2
x411 DiffBn VDD RefrBp GndD GndA PrSFBp OffBn PrBp OnBn pixRst[54] net111 net112 pixRst[55]
+ rowReadON[38] rowReadON[39] rowReadOFF[38] rowReadOFF[39] openDVS_pixel2x2
x412 DiffBn VDD RefrBp GndD GndA PrSFBp OffBn PrBp OnBn pixRst[56] net115 net116 pixRst[57]
+ rowReadON[38] rowReadON[39] rowReadOFF[38] rowReadOFF[39] openDVS_pixel2x2
x413 DiffBn VDD RefrBp GndD GndA PrSFBp OffBn PrBp OnBn pixRst[58] net119 net120 pixRst[59]
+ rowReadON[38] rowReadON[39] rowReadOFF[38] rowReadOFF[39] openDVS_pixel2x2
x414 DiffBn VDD RefrBp GndD GndA PrSFBp OffBn PrBp OnBn pixRst[60] net123 net124 pixRst[61]
+ rowReadON[38] rowReadON[39] rowReadOFF[38] rowReadOFF[39] openDVS_pixel2x2
x415 DiffBn VDD RefrBp GndD GndA PrSFBp OffBn PrBp OnBn pixRst[62] net127 net128 pixRst[63]
+ rowReadON[38] rowReadON[39] rowReadOFF[38] rowReadOFF[39] openDVS_pixel2x2
x416 DiffBn VDD RefrBp GndD GndA PrSFBp OffBn PrBp OnBn pixRst[0] net3 net4 pixRst[1] rowReadON[36]
+ rowReadON[37] rowReadOFF[36] rowReadOFF[37] openDVS_pixel2x2
x417 DiffBn VDD RefrBp GndD GndA PrSFBp OffBn PrBp OnBn pixRst[2] net7 net8 pixRst[3] rowReadON[36]
+ rowReadON[37] rowReadOFF[36] rowReadOFF[37] openDVS_pixel2x2
x418 DiffBn VDD RefrBp GndD GndA PrSFBp OffBn PrBp OnBn pixRst[4] net11 net12 pixRst[5]
+ rowReadON[36] rowReadON[37] rowReadOFF[36] rowReadOFF[37] openDVS_pixel2x2
x419 DiffBn VDD RefrBp GndD GndA PrSFBp OffBn PrBp OnBn pixRst[6] net15 net16 pixRst[7]
+ rowReadON[36] rowReadON[37] rowReadOFF[36] rowReadOFF[37] openDVS_pixel2x2
x420 DiffBn VDD RefrBp GndD GndA PrSFBp OffBn PrBp OnBn pixRst[8] net19 net20 pixRst[9]
+ rowReadON[36] rowReadON[37] rowReadOFF[36] rowReadOFF[37] openDVS_pixel2x2
x421 DiffBn VDD RefrBp GndD GndA PrSFBp OffBn PrBp OnBn pixRst[10] net23 net24 pixRst[11]
+ rowReadON[36] rowReadON[37] rowReadOFF[36] rowReadOFF[37] openDVS_pixel2x2
x422 DiffBn VDD RefrBp GndD GndA PrSFBp OffBn PrBp OnBn pixRst[12] net27 net28 pixRst[13]
+ rowReadON[36] rowReadON[37] rowReadOFF[36] rowReadOFF[37] openDVS_pixel2x2
x423 DiffBn VDD RefrBp GndD GndA PrSFBp OffBn PrBp OnBn pixRst[14] net31 net32 pixRst[15]
+ rowReadON[36] rowReadON[37] rowReadOFF[36] rowReadOFF[37] openDVS_pixel2x2
x424 DiffBn VDD RefrBp GndD GndA PrSFBp OffBn PrBp OnBn pixRst[16] net35 net36 pixRst[17]
+ rowReadON[36] rowReadON[37] rowReadOFF[36] rowReadOFF[37] openDVS_pixel2x2
x425 DiffBn VDD RefrBp GndD GndA PrSFBp OffBn PrBp OnBn pixRst[18] net39 net40 pixRst[19]
+ rowReadON[36] rowReadON[37] rowReadOFF[36] rowReadOFF[37] openDVS_pixel2x2
x426 DiffBn VDD RefrBp GndD GndA PrSFBp OffBn PrBp OnBn pixRst[20] net43 net44 pixRst[21]
+ rowReadON[36] rowReadON[37] rowReadOFF[36] rowReadOFF[37] openDVS_pixel2x2
x427 DiffBn VDD RefrBp GndD GndA PrSFBp OffBn PrBp OnBn pixRst[22] net47 net48 pixRst[23]
+ rowReadON[36] rowReadON[37] rowReadOFF[36] rowReadOFF[37] openDVS_pixel2x2
x428 DiffBn VDD RefrBp GndD GndA PrSFBp OffBn PrBp OnBn pixRst[24] net51 net52 pixRst[25]
+ rowReadON[36] rowReadON[37] rowReadOFF[36] rowReadOFF[37] openDVS_pixel2x2
x429 DiffBn VDD RefrBp GndD GndA PrSFBp OffBn PrBp OnBn pixRst[26] net55 net56 pixRst[27]
+ rowReadON[36] rowReadON[37] rowReadOFF[36] rowReadOFF[37] openDVS_pixel2x2
x430 DiffBn VDD RefrBp GndD GndA PrSFBp OffBn PrBp OnBn pixRst[28] net59 net60 pixRst[29]
+ rowReadON[36] rowReadON[37] rowReadOFF[36] rowReadOFF[37] openDVS_pixel2x2
x431 DiffBn VDD RefrBp GndD GndA PrSFBp OffBn PrBp OnBn pixRst[30] net63 net64 pixRst[31]
+ rowReadON[36] rowReadON[37] rowReadOFF[36] rowReadOFF[37] openDVS_pixel2x2
x432 DiffBn VDD RefrBp GndD GndA PrSFBp OffBn PrBp OnBn pixRst[32] net67 net68 pixRst[33]
+ rowReadON[36] rowReadON[37] rowReadOFF[36] rowReadOFF[37] openDVS_pixel2x2
x433 DiffBn VDD RefrBp GndD GndA PrSFBp OffBn PrBp OnBn pixRst[34] net71 net72 pixRst[35]
+ rowReadON[36] rowReadON[37] rowReadOFF[36] rowReadOFF[37] openDVS_pixel2x2
x434 DiffBn VDD RefrBp GndD GndA PrSFBp OffBn PrBp OnBn pixRst[36] net75 net76 pixRst[37]
+ rowReadON[36] rowReadON[37] rowReadOFF[36] rowReadOFF[37] openDVS_pixel2x2
x435 DiffBn VDD RefrBp GndD GndA PrSFBp OffBn PrBp OnBn pixRst[38] net79 net80 pixRst[39]
+ rowReadON[36] rowReadON[37] rowReadOFF[36] rowReadOFF[37] openDVS_pixel2x2
x436 DiffBn VDD RefrBp GndD GndA PrSFBp OffBn PrBp OnBn pixRst[40] net83 net84 pixRst[41]
+ rowReadON[36] rowReadON[37] rowReadOFF[36] rowReadOFF[37] openDVS_pixel2x2
x437 DiffBn VDD RefrBp GndD GndA PrSFBp OffBn PrBp OnBn pixRst[42] net87 net88 pixRst[43]
+ rowReadON[36] rowReadON[37] rowReadOFF[36] rowReadOFF[37] openDVS_pixel2x2
x438 DiffBn VDD RefrBp GndD GndA PrSFBp OffBn PrBp OnBn pixRst[44] net91 net92 pixRst[45]
+ rowReadON[36] rowReadON[37] rowReadOFF[36] rowReadOFF[37] openDVS_pixel2x2
x439 DiffBn VDD RefrBp GndD GndA PrSFBp OffBn PrBp OnBn pixRst[46] net95 net96 pixRst[47]
+ rowReadON[36] rowReadON[37] rowReadOFF[36] rowReadOFF[37] openDVS_pixel2x2
x440 DiffBn VDD RefrBp GndD GndA PrSFBp OffBn PrBp OnBn pixRst[48] net99 net100 pixRst[49]
+ rowReadON[36] rowReadON[37] rowReadOFF[36] rowReadOFF[37] openDVS_pixel2x2
x441 DiffBn VDD RefrBp GndD GndA PrSFBp OffBn PrBp OnBn pixRst[50] net103 net104 pixRst[51]
+ rowReadON[36] rowReadON[37] rowReadOFF[36] rowReadOFF[37] openDVS_pixel2x2
x442 DiffBn VDD RefrBp GndD GndA PrSFBp OffBn PrBp OnBn pixRst[52] net107 net108 pixRst[53]
+ rowReadON[36] rowReadON[37] rowReadOFF[36] rowReadOFF[37] openDVS_pixel2x2
x443 DiffBn VDD RefrBp GndD GndA PrSFBp OffBn PrBp OnBn pixRst[54] net111 net112 pixRst[55]
+ rowReadON[36] rowReadON[37] rowReadOFF[36] rowReadOFF[37] openDVS_pixel2x2
x444 DiffBn VDD RefrBp GndD GndA PrSFBp OffBn PrBp OnBn pixRst[56] net115 net116 pixRst[57]
+ rowReadON[36] rowReadON[37] rowReadOFF[36] rowReadOFF[37] openDVS_pixel2x2
x445 DiffBn VDD RefrBp GndD GndA PrSFBp OffBn PrBp OnBn pixRst[58] net119 net120 pixRst[59]
+ rowReadON[36] rowReadON[37] rowReadOFF[36] rowReadOFF[37] openDVS_pixel2x2
x446 DiffBn VDD RefrBp GndD GndA PrSFBp OffBn PrBp OnBn pixRst[60] net123 net124 pixRst[61]
+ rowReadON[36] rowReadON[37] rowReadOFF[36] rowReadOFF[37] openDVS_pixel2x2
x447 DiffBn VDD RefrBp GndD GndA PrSFBp OffBn PrBp OnBn pixRst[62] net127 net128 pixRst[63]
+ rowReadON[36] rowReadON[37] rowReadOFF[36] rowReadOFF[37] openDVS_pixel2x2
x448 DiffBn VDD RefrBp GndD GndA PrSFBp OffBn PrBp OnBn pixRst[0] net3 net4 pixRst[1] rowReadON[34]
+ rowReadON[35] rowReadOFF[34] rowReadOFF[35] openDVS_pixel2x2
x449 DiffBn VDD RefrBp GndD GndA PrSFBp OffBn PrBp OnBn pixRst[2] net7 net8 pixRst[3] rowReadON[34]
+ rowReadON[35] rowReadOFF[34] rowReadOFF[35] openDVS_pixel2x2
x450 DiffBn VDD RefrBp GndD GndA PrSFBp OffBn PrBp OnBn pixRst[4] net11 net12 pixRst[5]
+ rowReadON[34] rowReadON[35] rowReadOFF[34] rowReadOFF[35] openDVS_pixel2x2
x451 DiffBn VDD RefrBp GndD GndA PrSFBp OffBn PrBp OnBn pixRst[6] net15 net16 pixRst[7]
+ rowReadON[34] rowReadON[35] rowReadOFF[34] rowReadOFF[35] openDVS_pixel2x2
x452 DiffBn VDD RefrBp GndD GndA PrSFBp OffBn PrBp OnBn pixRst[8] net19 net20 pixRst[9]
+ rowReadON[34] rowReadON[35] rowReadOFF[34] rowReadOFF[35] openDVS_pixel2x2
x453 DiffBn VDD RefrBp GndD GndA PrSFBp OffBn PrBp OnBn pixRst[10] net23 net24 pixRst[11]
+ rowReadON[34] rowReadON[35] rowReadOFF[34] rowReadOFF[35] openDVS_pixel2x2
x454 DiffBn VDD RefrBp GndD GndA PrSFBp OffBn PrBp OnBn pixRst[12] net27 net28 pixRst[13]
+ rowReadON[34] rowReadON[35] rowReadOFF[34] rowReadOFF[35] openDVS_pixel2x2
x455 DiffBn VDD RefrBp GndD GndA PrSFBp OffBn PrBp OnBn pixRst[14] net31 net32 pixRst[15]
+ rowReadON[34] rowReadON[35] rowReadOFF[34] rowReadOFF[35] openDVS_pixel2x2
x456 DiffBn VDD RefrBp GndD GndA PrSFBp OffBn PrBp OnBn pixRst[16] net35 net36 pixRst[17]
+ rowReadON[34] rowReadON[35] rowReadOFF[34] rowReadOFF[35] openDVS_pixel2x2
x457 DiffBn VDD RefrBp GndD GndA PrSFBp OffBn PrBp OnBn pixRst[18] net39 net40 pixRst[19]
+ rowReadON[34] rowReadON[35] rowReadOFF[34] rowReadOFF[35] openDVS_pixel2x2
x458 DiffBn VDD RefrBp GndD GndA PrSFBp OffBn PrBp OnBn pixRst[20] net43 net44 pixRst[21]
+ rowReadON[34] rowReadON[35] rowReadOFF[34] rowReadOFF[35] openDVS_pixel2x2
x459 DiffBn VDD RefrBp GndD GndA PrSFBp OffBn PrBp OnBn pixRst[22] net47 net48 pixRst[23]
+ rowReadON[34] rowReadON[35] rowReadOFF[34] rowReadOFF[35] openDVS_pixel2x2
x460 DiffBn VDD RefrBp GndD GndA PrSFBp OffBn PrBp OnBn pixRst[24] net51 net52 pixRst[25]
+ rowReadON[34] rowReadON[35] rowReadOFF[34] rowReadOFF[35] openDVS_pixel2x2
x461 DiffBn VDD RefrBp GndD GndA PrSFBp OffBn PrBp OnBn pixRst[26] net55 net56 pixRst[27]
+ rowReadON[34] rowReadON[35] rowReadOFF[34] rowReadOFF[35] openDVS_pixel2x2
x462 DiffBn VDD RefrBp GndD GndA PrSFBp OffBn PrBp OnBn pixRst[28] net59 net60 pixRst[29]
+ rowReadON[34] rowReadON[35] rowReadOFF[34] rowReadOFF[35] openDVS_pixel2x2
x463 DiffBn VDD RefrBp GndD GndA PrSFBp OffBn PrBp OnBn pixRst[30] net63 net64 pixRst[31]
+ rowReadON[34] rowReadON[35] rowReadOFF[34] rowReadOFF[35] openDVS_pixel2x2
x464 DiffBn VDD RefrBp GndD GndA PrSFBp OffBn PrBp OnBn pixRst[32] net67 net68 pixRst[33]
+ rowReadON[34] rowReadON[35] rowReadOFF[34] rowReadOFF[35] openDVS_pixel2x2
x465 DiffBn VDD RefrBp GndD GndA PrSFBp OffBn PrBp OnBn pixRst[34] net71 net72 pixRst[35]
+ rowReadON[34] rowReadON[35] rowReadOFF[34] rowReadOFF[35] openDVS_pixel2x2
x466 DiffBn VDD RefrBp GndD GndA PrSFBp OffBn PrBp OnBn pixRst[36] net75 net76 pixRst[37]
+ rowReadON[34] rowReadON[35] rowReadOFF[34] rowReadOFF[35] openDVS_pixel2x2
x467 DiffBn VDD RefrBp GndD GndA PrSFBp OffBn PrBp OnBn pixRst[38] net79 net80 pixRst[39]
+ rowReadON[34] rowReadON[35] rowReadOFF[34] rowReadOFF[35] openDVS_pixel2x2
x468 DiffBn VDD RefrBp GndD GndA PrSFBp OffBn PrBp OnBn pixRst[40] net83 net84 pixRst[41]
+ rowReadON[34] rowReadON[35] rowReadOFF[34] rowReadOFF[35] openDVS_pixel2x2
x469 DiffBn VDD RefrBp GndD GndA PrSFBp OffBn PrBp OnBn pixRst[42] net87 net88 pixRst[43]
+ rowReadON[34] rowReadON[35] rowReadOFF[34] rowReadOFF[35] openDVS_pixel2x2
x470 DiffBn VDD RefrBp GndD GndA PrSFBp OffBn PrBp OnBn pixRst[44] net91 net92 pixRst[45]
+ rowReadON[34] rowReadON[35] rowReadOFF[34] rowReadOFF[35] openDVS_pixel2x2
x471 DiffBn VDD RefrBp GndD GndA PrSFBp OffBn PrBp OnBn pixRst[46] net95 net96 pixRst[47]
+ rowReadON[34] rowReadON[35] rowReadOFF[34] rowReadOFF[35] openDVS_pixel2x2
x472 DiffBn VDD RefrBp GndD GndA PrSFBp OffBn PrBp OnBn pixRst[48] net99 net100 pixRst[49]
+ rowReadON[34] rowReadON[35] rowReadOFF[34] rowReadOFF[35] openDVS_pixel2x2
x473 DiffBn VDD RefrBp GndD GndA PrSFBp OffBn PrBp OnBn pixRst[50] net103 net104 pixRst[51]
+ rowReadON[34] rowReadON[35] rowReadOFF[34] rowReadOFF[35] openDVS_pixel2x2
x474 DiffBn VDD RefrBp GndD GndA PrSFBp OffBn PrBp OnBn pixRst[52] net107 net108 pixRst[53]
+ rowReadON[34] rowReadON[35] rowReadOFF[34] rowReadOFF[35] openDVS_pixel2x2
x475 DiffBn VDD RefrBp GndD GndA PrSFBp OffBn PrBp OnBn pixRst[54] net111 net112 pixRst[55]
+ rowReadON[34] rowReadON[35] rowReadOFF[34] rowReadOFF[35] openDVS_pixel2x2
x476 DiffBn VDD RefrBp GndD GndA PrSFBp OffBn PrBp OnBn pixRst[56] net115 net116 pixRst[57]
+ rowReadON[34] rowReadON[35] rowReadOFF[34] rowReadOFF[35] openDVS_pixel2x2
x477 DiffBn VDD RefrBp GndD GndA PrSFBp OffBn PrBp OnBn pixRst[58] net119 net120 pixRst[59]
+ rowReadON[34] rowReadON[35] rowReadOFF[34] rowReadOFF[35] openDVS_pixel2x2
x478 DiffBn VDD RefrBp GndD GndA PrSFBp OffBn PrBp OnBn pixRst[60] net123 net124 pixRst[61]
+ rowReadON[34] rowReadON[35] rowReadOFF[34] rowReadOFF[35] openDVS_pixel2x2
x479 DiffBn VDD RefrBp GndD GndA PrSFBp OffBn PrBp OnBn pixRst[62] net127 net128 pixRst[63]
+ rowReadON[34] rowReadON[35] rowReadOFF[34] rowReadOFF[35] openDVS_pixel2x2
x480 DiffBn VDD RefrBp GndD GndA PrSFBp OffBn PrBp OnBn pixRst[0] net3 net4 pixRst[1] rowReadON[32]
+ rowReadON[33] rowReadOFF[32] rowReadOFF[33] openDVS_pixel2x2
x481 DiffBn VDD RefrBp GndD GndA PrSFBp OffBn PrBp OnBn pixRst[2] net7 net8 pixRst[3] rowReadON[32]
+ rowReadON[33] rowReadOFF[32] rowReadOFF[33] openDVS_pixel2x2
x482 DiffBn VDD RefrBp GndD GndA PrSFBp OffBn PrBp OnBn pixRst[4] net11 net12 pixRst[5]
+ rowReadON[32] rowReadON[33] rowReadOFF[32] rowReadOFF[33] openDVS_pixel2x2
x483 DiffBn VDD RefrBp GndD GndA PrSFBp OffBn PrBp OnBn pixRst[6] net15 net16 pixRst[7]
+ rowReadON[32] rowReadON[33] rowReadOFF[32] rowReadOFF[33] openDVS_pixel2x2
x484 DiffBn VDD RefrBp GndD GndA PrSFBp OffBn PrBp OnBn pixRst[8] net19 net20 pixRst[9]
+ rowReadON[32] rowReadON[33] rowReadOFF[32] rowReadOFF[33] openDVS_pixel2x2
x485 DiffBn VDD RefrBp GndD GndA PrSFBp OffBn PrBp OnBn pixRst[10] net23 net24 pixRst[11]
+ rowReadON[32] rowReadON[33] rowReadOFF[32] rowReadOFF[33] openDVS_pixel2x2
x486 DiffBn VDD RefrBp GndD GndA PrSFBp OffBn PrBp OnBn pixRst[12] net27 net28 pixRst[13]
+ rowReadON[32] rowReadON[33] rowReadOFF[32] rowReadOFF[33] openDVS_pixel2x2
x487 DiffBn VDD RefrBp GndD GndA PrSFBp OffBn PrBp OnBn pixRst[14] net31 net32 pixRst[15]
+ rowReadON[32] rowReadON[33] rowReadOFF[32] rowReadOFF[33] openDVS_pixel2x2
x488 DiffBn VDD RefrBp GndD GndA PrSFBp OffBn PrBp OnBn pixRst[16] net35 net36 pixRst[17]
+ rowReadON[32] rowReadON[33] rowReadOFF[32] rowReadOFF[33] openDVS_pixel2x2
x489 DiffBn VDD RefrBp GndD GndA PrSFBp OffBn PrBp OnBn pixRst[18] net39 net40 pixRst[19]
+ rowReadON[32] rowReadON[33] rowReadOFF[32] rowReadOFF[33] openDVS_pixel2x2
x490 DiffBn VDD RefrBp GndD GndA PrSFBp OffBn PrBp OnBn pixRst[20] net43 net44 pixRst[21]
+ rowReadON[32] rowReadON[33] rowReadOFF[32] rowReadOFF[33] openDVS_pixel2x2
x491 DiffBn VDD RefrBp GndD GndA PrSFBp OffBn PrBp OnBn pixRst[22] net47 net48 pixRst[23]
+ rowReadON[32] rowReadON[33] rowReadOFF[32] rowReadOFF[33] openDVS_pixel2x2
x492 DiffBn VDD RefrBp GndD GndA PrSFBp OffBn PrBp OnBn pixRst[24] net51 net52 pixRst[25]
+ rowReadON[32] rowReadON[33] rowReadOFF[32] rowReadOFF[33] openDVS_pixel2x2
x493 DiffBn VDD RefrBp GndD GndA PrSFBp OffBn PrBp OnBn pixRst[26] net55 net56 pixRst[27]
+ rowReadON[32] rowReadON[33] rowReadOFF[32] rowReadOFF[33] openDVS_pixel2x2
x494 DiffBn VDD RefrBp GndD GndA PrSFBp OffBn PrBp OnBn pixRst[28] net59 net60 pixRst[29]
+ rowReadON[32] rowReadON[33] rowReadOFF[32] rowReadOFF[33] openDVS_pixel2x2
x495 DiffBn VDD RefrBp GndD GndA PrSFBp OffBn PrBp OnBn pixRst[30] net63 net64 pixRst[31]
+ rowReadON[32] rowReadON[33] rowReadOFF[32] rowReadOFF[33] openDVS_pixel2x2
x496 DiffBn VDD RefrBp GndD GndA PrSFBp OffBn PrBp OnBn pixRst[32] net67 net68 pixRst[33]
+ rowReadON[32] rowReadON[33] rowReadOFF[32] rowReadOFF[33] openDVS_pixel2x2
x497 DiffBn VDD RefrBp GndD GndA PrSFBp OffBn PrBp OnBn pixRst[34] net71 net72 pixRst[35]
+ rowReadON[32] rowReadON[33] rowReadOFF[32] rowReadOFF[33] openDVS_pixel2x2
x498 DiffBn VDD RefrBp GndD GndA PrSFBp OffBn PrBp OnBn pixRst[36] net75 net76 pixRst[37]
+ rowReadON[32] rowReadON[33] rowReadOFF[32] rowReadOFF[33] openDVS_pixel2x2
x499 DiffBn VDD RefrBp GndD GndA PrSFBp OffBn PrBp OnBn pixRst[38] net79 net80 pixRst[39]
+ rowReadON[32] rowReadON[33] rowReadOFF[32] rowReadOFF[33] openDVS_pixel2x2
x500 DiffBn VDD RefrBp GndD GndA PrSFBp OffBn PrBp OnBn pixRst[40] net83 net84 pixRst[41]
+ rowReadON[32] rowReadON[33] rowReadOFF[32] rowReadOFF[33] openDVS_pixel2x2
x501 DiffBn VDD RefrBp GndD GndA PrSFBp OffBn PrBp OnBn pixRst[42] net87 net88 pixRst[43]
+ rowReadON[32] rowReadON[33] rowReadOFF[32] rowReadOFF[33] openDVS_pixel2x2
x502 DiffBn VDD RefrBp GndD GndA PrSFBp OffBn PrBp OnBn pixRst[44] net91 net92 pixRst[45]
+ rowReadON[32] rowReadON[33] rowReadOFF[32] rowReadOFF[33] openDVS_pixel2x2
x503 DiffBn VDD RefrBp GndD GndA PrSFBp OffBn PrBp OnBn pixRst[46] net95 net96 pixRst[47]
+ rowReadON[32] rowReadON[33] rowReadOFF[32] rowReadOFF[33] openDVS_pixel2x2
x504 DiffBn VDD RefrBp GndD GndA PrSFBp OffBn PrBp OnBn pixRst[48] net99 net100 pixRst[49]
+ rowReadON[32] rowReadON[33] rowReadOFF[32] rowReadOFF[33] openDVS_pixel2x2
x505 DiffBn VDD RefrBp GndD GndA PrSFBp OffBn PrBp OnBn pixRst[50] net103 net104 pixRst[51]
+ rowReadON[32] rowReadON[33] rowReadOFF[32] rowReadOFF[33] openDVS_pixel2x2
x506 DiffBn VDD RefrBp GndD GndA PrSFBp OffBn PrBp OnBn pixRst[52] net107 net108 pixRst[53]
+ rowReadON[32] rowReadON[33] rowReadOFF[32] rowReadOFF[33] openDVS_pixel2x2
x507 DiffBn VDD RefrBp GndD GndA PrSFBp OffBn PrBp OnBn pixRst[54] net111 net112 pixRst[55]
+ rowReadON[32] rowReadON[33] rowReadOFF[32] rowReadOFF[33] openDVS_pixel2x2
x508 DiffBn VDD RefrBp GndD GndA PrSFBp OffBn PrBp OnBn pixRst[56] net115 net116 pixRst[57]
+ rowReadON[32] rowReadON[33] rowReadOFF[32] rowReadOFF[33] openDVS_pixel2x2
x509 DiffBn VDD RefrBp GndD GndA PrSFBp OffBn PrBp OnBn pixRst[58] net119 net120 pixRst[59]
+ rowReadON[32] rowReadON[33] rowReadOFF[32] rowReadOFF[33] openDVS_pixel2x2
x510 DiffBn VDD RefrBp GndD GndA PrSFBp OffBn PrBp OnBn pixRst[60] net123 net124 pixRst[61]
+ rowReadON[32] rowReadON[33] rowReadOFF[32] rowReadOFF[33] openDVS_pixel2x2
x511 DiffBn VDD RefrBp GndD GndA PrSFBp OffBn PrBp OnBn pixRst[62] net127 net128 pixRst[63]
+ rowReadON[32] rowReadON[33] rowReadOFF[32] rowReadOFF[33] openDVS_pixel2x2
x512 DiffBn VDD RefrBp GndD GndA PrSFBp OffBn PrBp OnBn pixRst[0] net3 net4 pixRst[1] rowReadON[30]
+ rowReadON[31] rowReadOFF[30] rowReadOFF[31] openDVS_pixel2x2
x513 DiffBn VDD RefrBp GndD GndA PrSFBp OffBn PrBp OnBn pixRst[2] net7 net8 pixRst[3] rowReadON[30]
+ rowReadON[31] rowReadOFF[30] rowReadOFF[31] openDVS_pixel2x2
x514 DiffBn VDD RefrBp GndD GndA PrSFBp OffBn PrBp OnBn pixRst[4] net11 net12 pixRst[5]
+ rowReadON[30] rowReadON[31] rowReadOFF[30] rowReadOFF[31] openDVS_pixel2x2
x515 DiffBn VDD RefrBp GndD GndA PrSFBp OffBn PrBp OnBn pixRst[6] net15 net16 pixRst[7]
+ rowReadON[30] rowReadON[31] rowReadOFF[30] rowReadOFF[31] openDVS_pixel2x2
x516 DiffBn VDD RefrBp GndD GndA PrSFBp OffBn PrBp OnBn pixRst[8] net19 net20 pixRst[9]
+ rowReadON[30] rowReadON[31] rowReadOFF[30] rowReadOFF[31] openDVS_pixel2x2
x517 DiffBn VDD RefrBp GndD GndA PrSFBp OffBn PrBp OnBn pixRst[10] net23 net24 pixRst[11]
+ rowReadON[30] rowReadON[31] rowReadOFF[30] rowReadOFF[31] openDVS_pixel2x2
x518 DiffBn VDD RefrBp GndD GndA PrSFBp OffBn PrBp OnBn pixRst[12] net27 net28 pixRst[13]
+ rowReadON[30] rowReadON[31] rowReadOFF[30] rowReadOFF[31] openDVS_pixel2x2
x519 DiffBn VDD RefrBp GndD GndA PrSFBp OffBn PrBp OnBn pixRst[14] net31 net32 pixRst[15]
+ rowReadON[30] rowReadON[31] rowReadOFF[30] rowReadOFF[31] openDVS_pixel2x2
x520 DiffBn VDD RefrBp GndD GndA PrSFBp OffBn PrBp OnBn pixRst[16] net35 net36 pixRst[17]
+ rowReadON[30] rowReadON[31] rowReadOFF[30] rowReadOFF[31] openDVS_pixel2x2
x521 DiffBn VDD RefrBp GndD GndA PrSFBp OffBn PrBp OnBn pixRst[18] net39 net40 pixRst[19]
+ rowReadON[30] rowReadON[31] rowReadOFF[30] rowReadOFF[31] openDVS_pixel2x2
x522 DiffBn VDD RefrBp GndD GndA PrSFBp OffBn PrBp OnBn pixRst[20] net43 net44 pixRst[21]
+ rowReadON[30] rowReadON[31] rowReadOFF[30] rowReadOFF[31] openDVS_pixel2x2
x523 DiffBn VDD RefrBp GndD GndA PrSFBp OffBn PrBp OnBn pixRst[22] net47 net48 pixRst[23]
+ rowReadON[30] rowReadON[31] rowReadOFF[30] rowReadOFF[31] openDVS_pixel2x2
x524 DiffBn VDD RefrBp GndD GndA PrSFBp OffBn PrBp OnBn pixRst[24] net51 net52 pixRst[25]
+ rowReadON[30] rowReadON[31] rowReadOFF[30] rowReadOFF[31] openDVS_pixel2x2
x525 DiffBn VDD RefrBp GndD GndA PrSFBp OffBn PrBp OnBn pixRst[26] net55 net56 pixRst[27]
+ rowReadON[30] rowReadON[31] rowReadOFF[30] rowReadOFF[31] openDVS_pixel2x2
x526 DiffBn VDD RefrBp GndD GndA PrSFBp OffBn PrBp OnBn pixRst[28] net59 net60 pixRst[29]
+ rowReadON[30] rowReadON[31] rowReadOFF[30] rowReadOFF[31] openDVS_pixel2x2
x527 DiffBn VDD RefrBp GndD GndA PrSFBp OffBn PrBp OnBn pixRst[30] net63 net64 pixRst[31]
+ rowReadON[30] rowReadON[31] rowReadOFF[30] rowReadOFF[31] openDVS_pixel2x2
x528 DiffBn VDD RefrBp GndD GndA PrSFBp OffBn PrBp OnBn pixRst[32] net67 net68 pixRst[33]
+ rowReadON[30] rowReadON[31] rowReadOFF[30] rowReadOFF[31] openDVS_pixel2x2
x529 DiffBn VDD RefrBp GndD GndA PrSFBp OffBn PrBp OnBn pixRst[34] net71 net72 pixRst[35]
+ rowReadON[30] rowReadON[31] rowReadOFF[30] rowReadOFF[31] openDVS_pixel2x2
x530 DiffBn VDD RefrBp GndD GndA PrSFBp OffBn PrBp OnBn pixRst[36] net75 net76 pixRst[37]
+ rowReadON[30] rowReadON[31] rowReadOFF[30] rowReadOFF[31] openDVS_pixel2x2
x531 DiffBn VDD RefrBp GndD GndA PrSFBp OffBn PrBp OnBn pixRst[38] net79 net80 pixRst[39]
+ rowReadON[30] rowReadON[31] rowReadOFF[30] rowReadOFF[31] openDVS_pixel2x2
x532 DiffBn VDD RefrBp GndD GndA PrSFBp OffBn PrBp OnBn pixRst[40] net83 net84 pixRst[41]
+ rowReadON[30] rowReadON[31] rowReadOFF[30] rowReadOFF[31] openDVS_pixel2x2
x533 DiffBn VDD RefrBp GndD GndA PrSFBp OffBn PrBp OnBn pixRst[42] net87 net88 pixRst[43]
+ rowReadON[30] rowReadON[31] rowReadOFF[30] rowReadOFF[31] openDVS_pixel2x2
x534 DiffBn VDD RefrBp GndD GndA PrSFBp OffBn PrBp OnBn pixRst[44] net91 net92 pixRst[45]
+ rowReadON[30] rowReadON[31] rowReadOFF[30] rowReadOFF[31] openDVS_pixel2x2
x535 DiffBn VDD RefrBp GndD GndA PrSFBp OffBn PrBp OnBn pixRst[46] net95 net96 pixRst[47]
+ rowReadON[30] rowReadON[31] rowReadOFF[30] rowReadOFF[31] openDVS_pixel2x2
x536 DiffBn VDD RefrBp GndD GndA PrSFBp OffBn PrBp OnBn pixRst[48] net99 net100 pixRst[49]
+ rowReadON[30] rowReadON[31] rowReadOFF[30] rowReadOFF[31] openDVS_pixel2x2
x537 DiffBn VDD RefrBp GndD GndA PrSFBp OffBn PrBp OnBn pixRst[50] net103 net104 pixRst[51]
+ rowReadON[30] rowReadON[31] rowReadOFF[30] rowReadOFF[31] openDVS_pixel2x2
x538 DiffBn VDD RefrBp GndD GndA PrSFBp OffBn PrBp OnBn pixRst[52] net107 net108 pixRst[53]
+ rowReadON[30] rowReadON[31] rowReadOFF[30] rowReadOFF[31] openDVS_pixel2x2
x539 DiffBn VDD RefrBp GndD GndA PrSFBp OffBn PrBp OnBn pixRst[54] net111 net112 pixRst[55]
+ rowReadON[30] rowReadON[31] rowReadOFF[30] rowReadOFF[31] openDVS_pixel2x2
x540 DiffBn VDD RefrBp GndD GndA PrSFBp OffBn PrBp OnBn pixRst[56] net115 net116 pixRst[57]
+ rowReadON[30] rowReadON[31] rowReadOFF[30] rowReadOFF[31] openDVS_pixel2x2
x541 DiffBn VDD RefrBp GndD GndA PrSFBp OffBn PrBp OnBn pixRst[58] net119 net120 pixRst[59]
+ rowReadON[30] rowReadON[31] rowReadOFF[30] rowReadOFF[31] openDVS_pixel2x2
x542 DiffBn VDD RefrBp GndD GndA PrSFBp OffBn PrBp OnBn pixRst[60] net123 net124 pixRst[61]
+ rowReadON[30] rowReadON[31] rowReadOFF[30] rowReadOFF[31] openDVS_pixel2x2
x543 DiffBn VDD RefrBp GndD GndA PrSFBp OffBn PrBp OnBn pixRst[62] net127 net128 pixRst[63]
+ rowReadON[30] rowReadON[31] rowReadOFF[30] rowReadOFF[31] openDVS_pixel2x2
x544 DiffBn VDD RefrBp GndD GndA PrSFBp OffBn PrBp OnBn pixRst[0] net3 net4 pixRst[1] rowReadON[28]
+ rowReadON[29] rowReadOFF[28] rowReadOFF[29] openDVS_pixel2x2
x545 DiffBn VDD RefrBp GndD GndA PrSFBp OffBn PrBp OnBn pixRst[2] net7 net8 pixRst[3] rowReadON[28]
+ rowReadON[29] rowReadOFF[28] rowReadOFF[29] openDVS_pixel2x2
x546 DiffBn VDD RefrBp GndD GndA PrSFBp OffBn PrBp OnBn pixRst[4] net11 net12 pixRst[5]
+ rowReadON[28] rowReadON[29] rowReadOFF[28] rowReadOFF[29] openDVS_pixel2x2
x547 DiffBn VDD RefrBp GndD GndA PrSFBp OffBn PrBp OnBn pixRst[6] net15 net16 pixRst[7]
+ rowReadON[28] rowReadON[29] rowReadOFF[28] rowReadOFF[29] openDVS_pixel2x2
x548 DiffBn VDD RefrBp GndD GndA PrSFBp OffBn PrBp OnBn pixRst[8] net19 net20 pixRst[9]
+ rowReadON[28] rowReadON[29] rowReadOFF[28] rowReadOFF[29] openDVS_pixel2x2
x549 DiffBn VDD RefrBp GndD GndA PrSFBp OffBn PrBp OnBn pixRst[10] net23 net24 pixRst[11]
+ rowReadON[28] rowReadON[29] rowReadOFF[28] rowReadOFF[29] openDVS_pixel2x2
x550 DiffBn VDD RefrBp GndD GndA PrSFBp OffBn PrBp OnBn pixRst[12] net27 net28 pixRst[13]
+ rowReadON[28] rowReadON[29] rowReadOFF[28] rowReadOFF[29] openDVS_pixel2x2
x551 DiffBn VDD RefrBp GndD GndA PrSFBp OffBn PrBp OnBn pixRst[14] net31 net32 pixRst[15]
+ rowReadON[28] rowReadON[29] rowReadOFF[28] rowReadOFF[29] openDVS_pixel2x2
x552 DiffBn VDD RefrBp GndD GndA PrSFBp OffBn PrBp OnBn pixRst[16] net35 net36 pixRst[17]
+ rowReadON[28] rowReadON[29] rowReadOFF[28] rowReadOFF[29] openDVS_pixel2x2
x553 DiffBn VDD RefrBp GndD GndA PrSFBp OffBn PrBp OnBn pixRst[18] net39 net40 pixRst[19]
+ rowReadON[28] rowReadON[29] rowReadOFF[28] rowReadOFF[29] openDVS_pixel2x2
x554 DiffBn VDD RefrBp GndD GndA PrSFBp OffBn PrBp OnBn pixRst[20] net43 net44 pixRst[21]
+ rowReadON[28] rowReadON[29] rowReadOFF[28] rowReadOFF[29] openDVS_pixel2x2
x555 DiffBn VDD RefrBp GndD GndA PrSFBp OffBn PrBp OnBn pixRst[22] net47 net48 pixRst[23]
+ rowReadON[28] rowReadON[29] rowReadOFF[28] rowReadOFF[29] openDVS_pixel2x2
x556 DiffBn VDD RefrBp GndD GndA PrSFBp OffBn PrBp OnBn pixRst[24] net51 net52 pixRst[25]
+ rowReadON[28] rowReadON[29] rowReadOFF[28] rowReadOFF[29] openDVS_pixel2x2
x557 DiffBn VDD RefrBp GndD GndA PrSFBp OffBn PrBp OnBn pixRst[26] net55 net56 pixRst[27]
+ rowReadON[28] rowReadON[29] rowReadOFF[28] rowReadOFF[29] openDVS_pixel2x2
x558 DiffBn VDD RefrBp GndD GndA PrSFBp OffBn PrBp OnBn pixRst[28] net59 net60 pixRst[29]
+ rowReadON[28] rowReadON[29] rowReadOFF[28] rowReadOFF[29] openDVS_pixel2x2
x559 DiffBn VDD RefrBp GndD GndA PrSFBp OffBn PrBp OnBn pixRst[30] net63 net64 pixRst[31]
+ rowReadON[28] rowReadON[29] rowReadOFF[28] rowReadOFF[29] openDVS_pixel2x2
x560 DiffBn VDD RefrBp GndD GndA PrSFBp OffBn PrBp OnBn pixRst[32] net67 net68 pixRst[33]
+ rowReadON[28] rowReadON[29] rowReadOFF[28] rowReadOFF[29] openDVS_pixel2x2
x561 DiffBn VDD RefrBp GndD GndA PrSFBp OffBn PrBp OnBn pixRst[34] net71 net72 pixRst[35]
+ rowReadON[28] rowReadON[29] rowReadOFF[28] rowReadOFF[29] openDVS_pixel2x2
x562 DiffBn VDD RefrBp GndD GndA PrSFBp OffBn PrBp OnBn pixRst[36] net75 net76 pixRst[37]
+ rowReadON[28] rowReadON[29] rowReadOFF[28] rowReadOFF[29] openDVS_pixel2x2
x563 DiffBn VDD RefrBp GndD GndA PrSFBp OffBn PrBp OnBn pixRst[38] net79 net80 pixRst[39]
+ rowReadON[28] rowReadON[29] rowReadOFF[28] rowReadOFF[29] openDVS_pixel2x2
x564 DiffBn VDD RefrBp GndD GndA PrSFBp OffBn PrBp OnBn pixRst[40] net83 net84 pixRst[41]
+ rowReadON[28] rowReadON[29] rowReadOFF[28] rowReadOFF[29] openDVS_pixel2x2
x565 DiffBn VDD RefrBp GndD GndA PrSFBp OffBn PrBp OnBn pixRst[42] net87 net88 pixRst[43]
+ rowReadON[28] rowReadON[29] rowReadOFF[28] rowReadOFF[29] openDVS_pixel2x2
x566 DiffBn VDD RefrBp GndD GndA PrSFBp OffBn PrBp OnBn pixRst[44] net91 net92 pixRst[45]
+ rowReadON[28] rowReadON[29] rowReadOFF[28] rowReadOFF[29] openDVS_pixel2x2
x567 DiffBn VDD RefrBp GndD GndA PrSFBp OffBn PrBp OnBn pixRst[46] net95 net96 pixRst[47]
+ rowReadON[28] rowReadON[29] rowReadOFF[28] rowReadOFF[29] openDVS_pixel2x2
x568 DiffBn VDD RefrBp GndD GndA PrSFBp OffBn PrBp OnBn pixRst[48] net99 net100 pixRst[49]
+ rowReadON[28] rowReadON[29] rowReadOFF[28] rowReadOFF[29] openDVS_pixel2x2
x569 DiffBn VDD RefrBp GndD GndA PrSFBp OffBn PrBp OnBn pixRst[50] net103 net104 pixRst[51]
+ rowReadON[28] rowReadON[29] rowReadOFF[28] rowReadOFF[29] openDVS_pixel2x2
x570 DiffBn VDD RefrBp GndD GndA PrSFBp OffBn PrBp OnBn pixRst[52] net107 net108 pixRst[53]
+ rowReadON[28] rowReadON[29] rowReadOFF[28] rowReadOFF[29] openDVS_pixel2x2
x571 DiffBn VDD RefrBp GndD GndA PrSFBp OffBn PrBp OnBn pixRst[54] net111 net112 pixRst[55]
+ rowReadON[28] rowReadON[29] rowReadOFF[28] rowReadOFF[29] openDVS_pixel2x2
x572 DiffBn VDD RefrBp GndD GndA PrSFBp OffBn PrBp OnBn pixRst[56] net115 net116 pixRst[57]
+ rowReadON[28] rowReadON[29] rowReadOFF[28] rowReadOFF[29] openDVS_pixel2x2
x573 DiffBn VDD RefrBp GndD GndA PrSFBp OffBn PrBp OnBn pixRst[58] net119 net120 pixRst[59]
+ rowReadON[28] rowReadON[29] rowReadOFF[28] rowReadOFF[29] openDVS_pixel2x2
x574 DiffBn VDD RefrBp GndD GndA PrSFBp OffBn PrBp OnBn pixRst[60] net123 net124 pixRst[61]
+ rowReadON[28] rowReadON[29] rowReadOFF[28] rowReadOFF[29] openDVS_pixel2x2
x575 DiffBn VDD RefrBp GndD GndA PrSFBp OffBn PrBp OnBn pixRst[62] net127 net128 pixRst[63]
+ rowReadON[28] rowReadON[29] rowReadOFF[28] rowReadOFF[29] openDVS_pixel2x2
x576 DiffBn VDD RefrBp GndD GndA PrSFBp OffBn PrBp OnBn pixRst[0] net3 net4 pixRst[1] rowReadON[26]
+ rowReadON[27] rowReadOFF[26] rowReadOFF[27] openDVS_pixel2x2
x577 DiffBn VDD RefrBp GndD GndA PrSFBp OffBn PrBp OnBn pixRst[2] net7 net8 pixRst[3] rowReadON[26]
+ rowReadON[27] rowReadOFF[26] rowReadOFF[27] openDVS_pixel2x2
x578 DiffBn VDD RefrBp GndD GndA PrSFBp OffBn PrBp OnBn pixRst[4] net11 net12 pixRst[5]
+ rowReadON[26] rowReadON[27] rowReadOFF[26] rowReadOFF[27] openDVS_pixel2x2
x579 DiffBn VDD RefrBp GndD GndA PrSFBp OffBn PrBp OnBn pixRst[6] net15 net16 pixRst[7]
+ rowReadON[26] rowReadON[27] rowReadOFF[26] rowReadOFF[27] openDVS_pixel2x2
x580 DiffBn VDD RefrBp GndD GndA PrSFBp OffBn PrBp OnBn pixRst[8] net19 net20 pixRst[9]
+ rowReadON[26] rowReadON[27] rowReadOFF[26] rowReadOFF[27] openDVS_pixel2x2
x581 DiffBn VDD RefrBp GndD GndA PrSFBp OffBn PrBp OnBn pixRst[10] net23 net24 pixRst[11]
+ rowReadON[26] rowReadON[27] rowReadOFF[26] rowReadOFF[27] openDVS_pixel2x2
x582 DiffBn VDD RefrBp GndD GndA PrSFBp OffBn PrBp OnBn pixRst[12] net27 net28 pixRst[13]
+ rowReadON[26] rowReadON[27] rowReadOFF[26] rowReadOFF[27] openDVS_pixel2x2
x583 DiffBn VDD RefrBp GndD GndA PrSFBp OffBn PrBp OnBn pixRst[14] net31 net32 pixRst[15]
+ rowReadON[26] rowReadON[27] rowReadOFF[26] rowReadOFF[27] openDVS_pixel2x2
x584 DiffBn VDD RefrBp GndD GndA PrSFBp OffBn PrBp OnBn pixRst[16] net35 net36 pixRst[17]
+ rowReadON[26] rowReadON[27] rowReadOFF[26] rowReadOFF[27] openDVS_pixel2x2
x585 DiffBn VDD RefrBp GndD GndA PrSFBp OffBn PrBp OnBn pixRst[18] net39 net40 pixRst[19]
+ rowReadON[26] rowReadON[27] rowReadOFF[26] rowReadOFF[27] openDVS_pixel2x2
x586 DiffBn VDD RefrBp GndD GndA PrSFBp OffBn PrBp OnBn pixRst[20] net43 net44 pixRst[21]
+ rowReadON[26] rowReadON[27] rowReadOFF[26] rowReadOFF[27] openDVS_pixel2x2
x587 DiffBn VDD RefrBp GndD GndA PrSFBp OffBn PrBp OnBn pixRst[22] net47 net48 pixRst[23]
+ rowReadON[26] rowReadON[27] rowReadOFF[26] rowReadOFF[27] openDVS_pixel2x2
x588 DiffBn VDD RefrBp GndD GndA PrSFBp OffBn PrBp OnBn pixRst[24] net51 net52 pixRst[25]
+ rowReadON[26] rowReadON[27] rowReadOFF[26] rowReadOFF[27] openDVS_pixel2x2
x589 DiffBn VDD RefrBp GndD GndA PrSFBp OffBn PrBp OnBn pixRst[26] net55 net56 pixRst[27]
+ rowReadON[26] rowReadON[27] rowReadOFF[26] rowReadOFF[27] openDVS_pixel2x2
x590 DiffBn VDD RefrBp GndD GndA PrSFBp OffBn PrBp OnBn pixRst[28] net59 net60 pixRst[29]
+ rowReadON[26] rowReadON[27] rowReadOFF[26] rowReadOFF[27] openDVS_pixel2x2
x591 DiffBn VDD RefrBp GndD GndA PrSFBp OffBn PrBp OnBn pixRst[30] net63 net64 pixRst[31]
+ rowReadON[26] rowReadON[27] rowReadOFF[26] rowReadOFF[27] openDVS_pixel2x2
x592 DiffBn VDD RefrBp GndD GndA PrSFBp OffBn PrBp OnBn pixRst[32] net67 net68 pixRst[33]
+ rowReadON[26] rowReadON[27] rowReadOFF[26] rowReadOFF[27] openDVS_pixel2x2
x593 DiffBn VDD RefrBp GndD GndA PrSFBp OffBn PrBp OnBn pixRst[34] net71 net72 pixRst[35]
+ rowReadON[26] rowReadON[27] rowReadOFF[26] rowReadOFF[27] openDVS_pixel2x2
x594 DiffBn VDD RefrBp GndD GndA PrSFBp OffBn PrBp OnBn pixRst[36] net75 net76 pixRst[37]
+ rowReadON[26] rowReadON[27] rowReadOFF[26] rowReadOFF[27] openDVS_pixel2x2
x595 DiffBn VDD RefrBp GndD GndA PrSFBp OffBn PrBp OnBn pixRst[38] net79 net80 pixRst[39]
+ rowReadON[26] rowReadON[27] rowReadOFF[26] rowReadOFF[27] openDVS_pixel2x2
x596 DiffBn VDD RefrBp GndD GndA PrSFBp OffBn PrBp OnBn pixRst[40] net83 net84 pixRst[41]
+ rowReadON[26] rowReadON[27] rowReadOFF[26] rowReadOFF[27] openDVS_pixel2x2
x597 DiffBn VDD RefrBp GndD GndA PrSFBp OffBn PrBp OnBn pixRst[42] net87 net88 pixRst[43]
+ rowReadON[26] rowReadON[27] rowReadOFF[26] rowReadOFF[27] openDVS_pixel2x2
x598 DiffBn VDD RefrBp GndD GndA PrSFBp OffBn PrBp OnBn pixRst[44] net91 net92 pixRst[45]
+ rowReadON[26] rowReadON[27] rowReadOFF[26] rowReadOFF[27] openDVS_pixel2x2
x599 DiffBn VDD RefrBp GndD GndA PrSFBp OffBn PrBp OnBn pixRst[46] net95 net96 pixRst[47]
+ rowReadON[26] rowReadON[27] rowReadOFF[26] rowReadOFF[27] openDVS_pixel2x2
x600 DiffBn VDD RefrBp GndD GndA PrSFBp OffBn PrBp OnBn pixRst[48] net99 net100 pixRst[49]
+ rowReadON[26] rowReadON[27] rowReadOFF[26] rowReadOFF[27] openDVS_pixel2x2
x601 DiffBn VDD RefrBp GndD GndA PrSFBp OffBn PrBp OnBn pixRst[50] net103 net104 pixRst[51]
+ rowReadON[26] rowReadON[27] rowReadOFF[26] rowReadOFF[27] openDVS_pixel2x2
x602 DiffBn VDD RefrBp GndD GndA PrSFBp OffBn PrBp OnBn pixRst[52] net107 net108 pixRst[53]
+ rowReadON[26] rowReadON[27] rowReadOFF[26] rowReadOFF[27] openDVS_pixel2x2
x603 DiffBn VDD RefrBp GndD GndA PrSFBp OffBn PrBp OnBn pixRst[54] net111 net112 pixRst[55]
+ rowReadON[26] rowReadON[27] rowReadOFF[26] rowReadOFF[27] openDVS_pixel2x2
x604 DiffBn VDD RefrBp GndD GndA PrSFBp OffBn PrBp OnBn pixRst[56] net115 net116 pixRst[57]
+ rowReadON[26] rowReadON[27] rowReadOFF[26] rowReadOFF[27] openDVS_pixel2x2
x605 DiffBn VDD RefrBp GndD GndA PrSFBp OffBn PrBp OnBn pixRst[58] net119 net120 pixRst[59]
+ rowReadON[26] rowReadON[27] rowReadOFF[26] rowReadOFF[27] openDVS_pixel2x2
x606 DiffBn VDD RefrBp GndD GndA PrSFBp OffBn PrBp OnBn pixRst[60] net123 net124 pixRst[61]
+ rowReadON[26] rowReadON[27] rowReadOFF[26] rowReadOFF[27] openDVS_pixel2x2
x607 DiffBn VDD RefrBp GndD GndA PrSFBp OffBn PrBp OnBn pixRst[62] net127 net128 pixRst[63]
+ rowReadON[26] rowReadON[27] rowReadOFF[26] rowReadOFF[27] openDVS_pixel2x2
x608 DiffBn VDD RefrBp GndD GndA PrSFBp OffBn PrBp OnBn pixRst[0] net3 net4 pixRst[1] rowReadON[24]
+ rowReadON[25] rowReadOFF[24] rowReadOFF[25] openDVS_pixel2x2
x609 DiffBn VDD RefrBp GndD GndA PrSFBp OffBn PrBp OnBn pixRst[2] net7 net8 pixRst[3] rowReadON[24]
+ rowReadON[25] rowReadOFF[24] rowReadOFF[25] openDVS_pixel2x2
x610 DiffBn VDD RefrBp GndD GndA PrSFBp OffBn PrBp OnBn pixRst[4] net11 net12 pixRst[5]
+ rowReadON[24] rowReadON[25] rowReadOFF[24] rowReadOFF[25] openDVS_pixel2x2
x611 DiffBn VDD RefrBp GndD GndA PrSFBp OffBn PrBp OnBn pixRst[6] net15 net16 pixRst[7]
+ rowReadON[24] rowReadON[25] rowReadOFF[24] rowReadOFF[25] openDVS_pixel2x2
x612 DiffBn VDD RefrBp GndD GndA PrSFBp OffBn PrBp OnBn pixRst[8] net19 net20 pixRst[9]
+ rowReadON[24] rowReadON[25] rowReadOFF[24] rowReadOFF[25] openDVS_pixel2x2
x613 DiffBn VDD RefrBp GndD GndA PrSFBp OffBn PrBp OnBn pixRst[10] net23 net24 pixRst[11]
+ rowReadON[24] rowReadON[25] rowReadOFF[24] rowReadOFF[25] openDVS_pixel2x2
x614 DiffBn VDD RefrBp GndD GndA PrSFBp OffBn PrBp OnBn pixRst[12] net27 net28 pixRst[13]
+ rowReadON[24] rowReadON[25] rowReadOFF[24] rowReadOFF[25] openDVS_pixel2x2
x615 DiffBn VDD RefrBp GndD GndA PrSFBp OffBn PrBp OnBn pixRst[14] net31 net32 pixRst[15]
+ rowReadON[24] rowReadON[25] rowReadOFF[24] rowReadOFF[25] openDVS_pixel2x2
x616 DiffBn VDD RefrBp GndD GndA PrSFBp OffBn PrBp OnBn pixRst[16] net35 net36 pixRst[17]
+ rowReadON[24] rowReadON[25] rowReadOFF[24] rowReadOFF[25] openDVS_pixel2x2
x617 DiffBn VDD RefrBp GndD GndA PrSFBp OffBn PrBp OnBn pixRst[18] net39 net40 pixRst[19]
+ rowReadON[24] rowReadON[25] rowReadOFF[24] rowReadOFF[25] openDVS_pixel2x2
x618 DiffBn VDD RefrBp GndD GndA PrSFBp OffBn PrBp OnBn pixRst[20] net43 net44 pixRst[21]
+ rowReadON[24] rowReadON[25] rowReadOFF[24] rowReadOFF[25] openDVS_pixel2x2
x619 DiffBn VDD RefrBp GndD GndA PrSFBp OffBn PrBp OnBn pixRst[22] net47 net48 pixRst[23]
+ rowReadON[24] rowReadON[25] rowReadOFF[24] rowReadOFF[25] openDVS_pixel2x2
x620 DiffBn VDD RefrBp GndD GndA PrSFBp OffBn PrBp OnBn pixRst[24] net51 net52 pixRst[25]
+ rowReadON[24] rowReadON[25] rowReadOFF[24] rowReadOFF[25] openDVS_pixel2x2
x621 DiffBn VDD RefrBp GndD GndA PrSFBp OffBn PrBp OnBn pixRst[26] net55 net56 pixRst[27]
+ rowReadON[24] rowReadON[25] rowReadOFF[24] rowReadOFF[25] openDVS_pixel2x2
x622 DiffBn VDD RefrBp GndD GndA PrSFBp OffBn PrBp OnBn pixRst[28] net59 net60 pixRst[29]
+ rowReadON[24] rowReadON[25] rowReadOFF[24] rowReadOFF[25] openDVS_pixel2x2
x623 DiffBn VDD RefrBp GndD GndA PrSFBp OffBn PrBp OnBn pixRst[30] net63 net64 pixRst[31]
+ rowReadON[24] rowReadON[25] rowReadOFF[24] rowReadOFF[25] openDVS_pixel2x2
x624 DiffBn VDD RefrBp GndD GndA PrSFBp OffBn PrBp OnBn pixRst[32] net67 net68 pixRst[33]
+ rowReadON[24] rowReadON[25] rowReadOFF[24] rowReadOFF[25] openDVS_pixel2x2
x625 DiffBn VDD RefrBp GndD GndA PrSFBp OffBn PrBp OnBn pixRst[34] net71 net72 pixRst[35]
+ rowReadON[24] rowReadON[25] rowReadOFF[24] rowReadOFF[25] openDVS_pixel2x2
x626 DiffBn VDD RefrBp GndD GndA PrSFBp OffBn PrBp OnBn pixRst[36] net75 net76 pixRst[37]
+ rowReadON[24] rowReadON[25] rowReadOFF[24] rowReadOFF[25] openDVS_pixel2x2
x627 DiffBn VDD RefrBp GndD GndA PrSFBp OffBn PrBp OnBn pixRst[38] net79 net80 pixRst[39]
+ rowReadON[24] rowReadON[25] rowReadOFF[24] rowReadOFF[25] openDVS_pixel2x2
x628 DiffBn VDD RefrBp GndD GndA PrSFBp OffBn PrBp OnBn pixRst[40] net83 net84 pixRst[41]
+ rowReadON[24] rowReadON[25] rowReadOFF[24] rowReadOFF[25] openDVS_pixel2x2
x629 DiffBn VDD RefrBp GndD GndA PrSFBp OffBn PrBp OnBn pixRst[42] net87 net88 pixRst[43]
+ rowReadON[24] rowReadON[25] rowReadOFF[24] rowReadOFF[25] openDVS_pixel2x2
x630 DiffBn VDD RefrBp GndD GndA PrSFBp OffBn PrBp OnBn pixRst[44] net91 net92 pixRst[45]
+ rowReadON[24] rowReadON[25] rowReadOFF[24] rowReadOFF[25] openDVS_pixel2x2
x631 DiffBn VDD RefrBp GndD GndA PrSFBp OffBn PrBp OnBn pixRst[46] net95 net96 pixRst[47]
+ rowReadON[24] rowReadON[25] rowReadOFF[24] rowReadOFF[25] openDVS_pixel2x2
x632 DiffBn VDD RefrBp GndD GndA PrSFBp OffBn PrBp OnBn pixRst[48] net99 net100 pixRst[49]
+ rowReadON[24] rowReadON[25] rowReadOFF[24] rowReadOFF[25] openDVS_pixel2x2
x633 DiffBn VDD RefrBp GndD GndA PrSFBp OffBn PrBp OnBn pixRst[50] net103 net104 pixRst[51]
+ rowReadON[24] rowReadON[25] rowReadOFF[24] rowReadOFF[25] openDVS_pixel2x2
x634 DiffBn VDD RefrBp GndD GndA PrSFBp OffBn PrBp OnBn pixRst[52] net107 net108 pixRst[53]
+ rowReadON[24] rowReadON[25] rowReadOFF[24] rowReadOFF[25] openDVS_pixel2x2
x635 DiffBn VDD RefrBp GndD GndA PrSFBp OffBn PrBp OnBn pixRst[54] net111 net112 pixRst[55]
+ rowReadON[24] rowReadON[25] rowReadOFF[24] rowReadOFF[25] openDVS_pixel2x2
x636 DiffBn VDD RefrBp GndD GndA PrSFBp OffBn PrBp OnBn pixRst[56] net115 net116 pixRst[57]
+ rowReadON[24] rowReadON[25] rowReadOFF[24] rowReadOFF[25] openDVS_pixel2x2
x637 DiffBn VDD RefrBp GndD GndA PrSFBp OffBn PrBp OnBn pixRst[58] net119 net120 pixRst[59]
+ rowReadON[24] rowReadON[25] rowReadOFF[24] rowReadOFF[25] openDVS_pixel2x2
x638 DiffBn VDD RefrBp GndD GndA PrSFBp OffBn PrBp OnBn pixRst[60] net123 net124 pixRst[61]
+ rowReadON[24] rowReadON[25] rowReadOFF[24] rowReadOFF[25] openDVS_pixel2x2
x639 DiffBn VDD RefrBp GndD GndA PrSFBp OffBn PrBp OnBn pixRst[62] net127 net128 pixRst[63]
+ rowReadON[24] rowReadON[25] rowReadOFF[24] rowReadOFF[25] openDVS_pixel2x2
x640 DiffBn VDD RefrBp GndD GndA PrSFBp OffBn PrBp OnBn pixRst[0] net3 net4 pixRst[1] rowReadON[22]
+ rowReadON[23] rowReadOFF[22] rowReadOFF[23] openDVS_pixel2x2
x641 DiffBn VDD RefrBp GndD GndA PrSFBp OffBn PrBp OnBn pixRst[2] net7 net8 pixRst[3] rowReadON[22]
+ rowReadON[23] rowReadOFF[22] rowReadOFF[23] openDVS_pixel2x2
x642 DiffBn VDD RefrBp GndD GndA PrSFBp OffBn PrBp OnBn pixRst[4] net11 net12 pixRst[5]
+ rowReadON[22] rowReadON[23] rowReadOFF[22] rowReadOFF[23] openDVS_pixel2x2
x643 DiffBn VDD RefrBp GndD GndA PrSFBp OffBn PrBp OnBn pixRst[6] net15 net16 pixRst[7]
+ rowReadON[22] rowReadON[23] rowReadOFF[22] rowReadOFF[23] openDVS_pixel2x2
x644 DiffBn VDD RefrBp GndD GndA PrSFBp OffBn PrBp OnBn pixRst[8] net19 net20 pixRst[9]
+ rowReadON[22] rowReadON[23] rowReadOFF[22] rowReadOFF[23] openDVS_pixel2x2
x645 DiffBn VDD RefrBp GndD GndA PrSFBp OffBn PrBp OnBn pixRst[10] net23 net24 pixRst[11]
+ rowReadON[22] rowReadON[23] rowReadOFF[22] rowReadOFF[23] openDVS_pixel2x2
x646 DiffBn VDD RefrBp GndD GndA PrSFBp OffBn PrBp OnBn pixRst[12] net27 net28 pixRst[13]
+ rowReadON[22] rowReadON[23] rowReadOFF[22] rowReadOFF[23] openDVS_pixel2x2
x647 DiffBn VDD RefrBp GndD GndA PrSFBp OffBn PrBp OnBn pixRst[14] net31 net32 pixRst[15]
+ rowReadON[22] rowReadON[23] rowReadOFF[22] rowReadOFF[23] openDVS_pixel2x2
x648 DiffBn VDD RefrBp GndD GndA PrSFBp OffBn PrBp OnBn pixRst[16] net35 net36 pixRst[17]
+ rowReadON[22] rowReadON[23] rowReadOFF[22] rowReadOFF[23] openDVS_pixel2x2
x649 DiffBn VDD RefrBp GndD GndA PrSFBp OffBn PrBp OnBn pixRst[18] net39 net40 pixRst[19]
+ rowReadON[22] rowReadON[23] rowReadOFF[22] rowReadOFF[23] openDVS_pixel2x2
x650 DiffBn VDD RefrBp GndD GndA PrSFBp OffBn PrBp OnBn pixRst[20] net43 net44 pixRst[21]
+ rowReadON[22] rowReadON[23] rowReadOFF[22] rowReadOFF[23] openDVS_pixel2x2
x651 DiffBn VDD RefrBp GndD GndA PrSFBp OffBn PrBp OnBn pixRst[22] net47 net48 pixRst[23]
+ rowReadON[22] rowReadON[23] rowReadOFF[22] rowReadOFF[23] openDVS_pixel2x2
x652 DiffBn VDD RefrBp GndD GndA PrSFBp OffBn PrBp OnBn pixRst[24] net51 net52 pixRst[25]
+ rowReadON[22] rowReadON[23] rowReadOFF[22] rowReadOFF[23] openDVS_pixel2x2
x653 DiffBn VDD RefrBp GndD GndA PrSFBp OffBn PrBp OnBn pixRst[26] net55 net56 pixRst[27]
+ rowReadON[22] rowReadON[23] rowReadOFF[22] rowReadOFF[23] openDVS_pixel2x2
x654 DiffBn VDD RefrBp GndD GndA PrSFBp OffBn PrBp OnBn pixRst[28] net59 net60 pixRst[29]
+ rowReadON[22] rowReadON[23] rowReadOFF[22] rowReadOFF[23] openDVS_pixel2x2
x655 DiffBn VDD RefrBp GndD GndA PrSFBp OffBn PrBp OnBn pixRst[30] net63 net64 pixRst[31]
+ rowReadON[22] rowReadON[23] rowReadOFF[22] rowReadOFF[23] openDVS_pixel2x2
x656 DiffBn VDD RefrBp GndD GndA PrSFBp OffBn PrBp OnBn pixRst[32] net67 net68 pixRst[33]
+ rowReadON[22] rowReadON[23] rowReadOFF[22] rowReadOFF[23] openDVS_pixel2x2
x657 DiffBn VDD RefrBp GndD GndA PrSFBp OffBn PrBp OnBn pixRst[34] net71 net72 pixRst[35]
+ rowReadON[22] rowReadON[23] rowReadOFF[22] rowReadOFF[23] openDVS_pixel2x2
x658 DiffBn VDD RefrBp GndD GndA PrSFBp OffBn PrBp OnBn pixRst[36] net75 net76 pixRst[37]
+ rowReadON[22] rowReadON[23] rowReadOFF[22] rowReadOFF[23] openDVS_pixel2x2
x659 DiffBn VDD RefrBp GndD GndA PrSFBp OffBn PrBp OnBn pixRst[38] net79 net80 pixRst[39]
+ rowReadON[22] rowReadON[23] rowReadOFF[22] rowReadOFF[23] openDVS_pixel2x2
x660 DiffBn VDD RefrBp GndD GndA PrSFBp OffBn PrBp OnBn pixRst[40] net83 net84 pixRst[41]
+ rowReadON[22] rowReadON[23] rowReadOFF[22] rowReadOFF[23] openDVS_pixel2x2
x661 DiffBn VDD RefrBp GndD GndA PrSFBp OffBn PrBp OnBn pixRst[42] net87 net88 pixRst[43]
+ rowReadON[22] rowReadON[23] rowReadOFF[22] rowReadOFF[23] openDVS_pixel2x2
x662 DiffBn VDD RefrBp GndD GndA PrSFBp OffBn PrBp OnBn pixRst[44] net91 net92 pixRst[45]
+ rowReadON[22] rowReadON[23] rowReadOFF[22] rowReadOFF[23] openDVS_pixel2x2
x663 DiffBn VDD RefrBp GndD GndA PrSFBp OffBn PrBp OnBn pixRst[46] net95 net96 pixRst[47]
+ rowReadON[22] rowReadON[23] rowReadOFF[22] rowReadOFF[23] openDVS_pixel2x2
x664 DiffBn VDD RefrBp GndD GndA PrSFBp OffBn PrBp OnBn pixRst[48] net99 net100 pixRst[49]
+ rowReadON[22] rowReadON[23] rowReadOFF[22] rowReadOFF[23] openDVS_pixel2x2
x665 DiffBn VDD RefrBp GndD GndA PrSFBp OffBn PrBp OnBn pixRst[50] net103 net104 pixRst[51]
+ rowReadON[22] rowReadON[23] rowReadOFF[22] rowReadOFF[23] openDVS_pixel2x2
x666 DiffBn VDD RefrBp GndD GndA PrSFBp OffBn PrBp OnBn pixRst[52] net107 net108 pixRst[53]
+ rowReadON[22] rowReadON[23] rowReadOFF[22] rowReadOFF[23] openDVS_pixel2x2
x667 DiffBn VDD RefrBp GndD GndA PrSFBp OffBn PrBp OnBn pixRst[54] net111 net112 pixRst[55]
+ rowReadON[22] rowReadON[23] rowReadOFF[22] rowReadOFF[23] openDVS_pixel2x2
x668 DiffBn VDD RefrBp GndD GndA PrSFBp OffBn PrBp OnBn pixRst[56] net115 net116 pixRst[57]
+ rowReadON[22] rowReadON[23] rowReadOFF[22] rowReadOFF[23] openDVS_pixel2x2
x669 DiffBn VDD RefrBp GndD GndA PrSFBp OffBn PrBp OnBn pixRst[58] net119 net120 pixRst[59]
+ rowReadON[22] rowReadON[23] rowReadOFF[22] rowReadOFF[23] openDVS_pixel2x2
x670 DiffBn VDD RefrBp GndD GndA PrSFBp OffBn PrBp OnBn pixRst[60] net123 net124 pixRst[61]
+ rowReadON[22] rowReadON[23] rowReadOFF[22] rowReadOFF[23] openDVS_pixel2x2
x671 DiffBn VDD RefrBp GndD GndA PrSFBp OffBn PrBp OnBn pixRst[62] net127 net128 pixRst[63]
+ rowReadON[22] rowReadON[23] rowReadOFF[22] rowReadOFF[23] openDVS_pixel2x2
x672 DiffBn VDD RefrBp GndD GndA PrSFBp OffBn PrBp OnBn pixRst[0] net3 net4 pixRst[1] rowReadON[20]
+ rowReadON[21] rowReadOFF[20] rowReadOFF[21] openDVS_pixel2x2
x673 DiffBn VDD RefrBp GndD GndA PrSFBp OffBn PrBp OnBn pixRst[2] net7 net8 pixRst[3] rowReadON[20]
+ rowReadON[21] rowReadOFF[20] rowReadOFF[21] openDVS_pixel2x2
x674 DiffBn VDD RefrBp GndD GndA PrSFBp OffBn PrBp OnBn pixRst[4] net11 net12 pixRst[5]
+ rowReadON[20] rowReadON[21] rowReadOFF[20] rowReadOFF[21] openDVS_pixel2x2
x675 DiffBn VDD RefrBp GndD GndA PrSFBp OffBn PrBp OnBn pixRst[6] net15 net16 pixRst[7]
+ rowReadON[20] rowReadON[21] rowReadOFF[20] rowReadOFF[21] openDVS_pixel2x2
x676 DiffBn VDD RefrBp GndD GndA PrSFBp OffBn PrBp OnBn pixRst[8] net19 net20 pixRst[9]
+ rowReadON[20] rowReadON[21] rowReadOFF[20] rowReadOFF[21] openDVS_pixel2x2
x677 DiffBn VDD RefrBp GndD GndA PrSFBp OffBn PrBp OnBn pixRst[10] net23 net24 pixRst[11]
+ rowReadON[20] rowReadON[21] rowReadOFF[20] rowReadOFF[21] openDVS_pixel2x2
x678 DiffBn VDD RefrBp GndD GndA PrSFBp OffBn PrBp OnBn pixRst[12] net27 net28 pixRst[13]
+ rowReadON[20] rowReadON[21] rowReadOFF[20] rowReadOFF[21] openDVS_pixel2x2
x679 DiffBn VDD RefrBp GndD GndA PrSFBp OffBn PrBp OnBn pixRst[14] net31 net32 pixRst[15]
+ rowReadON[20] rowReadON[21] rowReadOFF[20] rowReadOFF[21] openDVS_pixel2x2
x680 DiffBn VDD RefrBp GndD GndA PrSFBp OffBn PrBp OnBn pixRst[16] net35 net36 pixRst[17]
+ rowReadON[20] rowReadON[21] rowReadOFF[20] rowReadOFF[21] openDVS_pixel2x2
x681 DiffBn VDD RefrBp GndD GndA PrSFBp OffBn PrBp OnBn pixRst[18] net39 net40 pixRst[19]
+ rowReadON[20] rowReadON[21] rowReadOFF[20] rowReadOFF[21] openDVS_pixel2x2
x682 DiffBn VDD RefrBp GndD GndA PrSFBp OffBn PrBp OnBn pixRst[20] net43 net44 pixRst[21]
+ rowReadON[20] rowReadON[21] rowReadOFF[20] rowReadOFF[21] openDVS_pixel2x2
x683 DiffBn VDD RefrBp GndD GndA PrSFBp OffBn PrBp OnBn pixRst[22] net47 net48 pixRst[23]
+ rowReadON[20] rowReadON[21] rowReadOFF[20] rowReadOFF[21] openDVS_pixel2x2
x684 DiffBn VDD RefrBp GndD GndA PrSFBp OffBn PrBp OnBn pixRst[24] net51 net52 pixRst[25]
+ rowReadON[20] rowReadON[21] rowReadOFF[20] rowReadOFF[21] openDVS_pixel2x2
x685 DiffBn VDD RefrBp GndD GndA PrSFBp OffBn PrBp OnBn pixRst[26] net55 net56 pixRst[27]
+ rowReadON[20] rowReadON[21] rowReadOFF[20] rowReadOFF[21] openDVS_pixel2x2
x686 DiffBn VDD RefrBp GndD GndA PrSFBp OffBn PrBp OnBn pixRst[28] net59 net60 pixRst[29]
+ rowReadON[20] rowReadON[21] rowReadOFF[20] rowReadOFF[21] openDVS_pixel2x2
x687 DiffBn VDD RefrBp GndD GndA PrSFBp OffBn PrBp OnBn pixRst[30] net63 net64 pixRst[31]
+ rowReadON[20] rowReadON[21] rowReadOFF[20] rowReadOFF[21] openDVS_pixel2x2
x688 DiffBn VDD RefrBp GndD GndA PrSFBp OffBn PrBp OnBn pixRst[32] net67 net68 pixRst[33]
+ rowReadON[20] rowReadON[21] rowReadOFF[20] rowReadOFF[21] openDVS_pixel2x2
x689 DiffBn VDD RefrBp GndD GndA PrSFBp OffBn PrBp OnBn pixRst[34] net71 net72 pixRst[35]
+ rowReadON[20] rowReadON[21] rowReadOFF[20] rowReadOFF[21] openDVS_pixel2x2
x690 DiffBn VDD RefrBp GndD GndA PrSFBp OffBn PrBp OnBn pixRst[36] net75 net76 pixRst[37]
+ rowReadON[20] rowReadON[21] rowReadOFF[20] rowReadOFF[21] openDVS_pixel2x2
x691 DiffBn VDD RefrBp GndD GndA PrSFBp OffBn PrBp OnBn pixRst[38] net79 net80 pixRst[39]
+ rowReadON[20] rowReadON[21] rowReadOFF[20] rowReadOFF[21] openDVS_pixel2x2
x692 DiffBn VDD RefrBp GndD GndA PrSFBp OffBn PrBp OnBn pixRst[40] net83 net84 pixRst[41]
+ rowReadON[20] rowReadON[21] rowReadOFF[20] rowReadOFF[21] openDVS_pixel2x2
x693 DiffBn VDD RefrBp GndD GndA PrSFBp OffBn PrBp OnBn pixRst[42] net87 net88 pixRst[43]
+ rowReadON[20] rowReadON[21] rowReadOFF[20] rowReadOFF[21] openDVS_pixel2x2
x694 DiffBn VDD RefrBp GndD GndA PrSFBp OffBn PrBp OnBn pixRst[44] net91 net92 pixRst[45]
+ rowReadON[20] rowReadON[21] rowReadOFF[20] rowReadOFF[21] openDVS_pixel2x2
x695 DiffBn VDD RefrBp GndD GndA PrSFBp OffBn PrBp OnBn pixRst[46] net95 net96 pixRst[47]
+ rowReadON[20] rowReadON[21] rowReadOFF[20] rowReadOFF[21] openDVS_pixel2x2
x696 DiffBn VDD RefrBp GndD GndA PrSFBp OffBn PrBp OnBn pixRst[48] net99 net100 pixRst[49]
+ rowReadON[20] rowReadON[21] rowReadOFF[20] rowReadOFF[21] openDVS_pixel2x2
x697 DiffBn VDD RefrBp GndD GndA PrSFBp OffBn PrBp OnBn pixRst[50] net103 net104 pixRst[51]
+ rowReadON[20] rowReadON[21] rowReadOFF[20] rowReadOFF[21] openDVS_pixel2x2
x698 DiffBn VDD RefrBp GndD GndA PrSFBp OffBn PrBp OnBn pixRst[52] net107 net108 pixRst[53]
+ rowReadON[20] rowReadON[21] rowReadOFF[20] rowReadOFF[21] openDVS_pixel2x2
x699 DiffBn VDD RefrBp GndD GndA PrSFBp OffBn PrBp OnBn pixRst[54] net111 net112 pixRst[55]
+ rowReadON[20] rowReadON[21] rowReadOFF[20] rowReadOFF[21] openDVS_pixel2x2
x700 DiffBn VDD RefrBp GndD GndA PrSFBp OffBn PrBp OnBn pixRst[56] net115 net116 pixRst[57]
+ rowReadON[20] rowReadON[21] rowReadOFF[20] rowReadOFF[21] openDVS_pixel2x2
x701 DiffBn VDD RefrBp GndD GndA PrSFBp OffBn PrBp OnBn pixRst[58] net119 net120 pixRst[59]
+ rowReadON[20] rowReadON[21] rowReadOFF[20] rowReadOFF[21] openDVS_pixel2x2
x702 DiffBn VDD RefrBp GndD GndA PrSFBp OffBn PrBp OnBn pixRst[60] net123 net124 pixRst[61]
+ rowReadON[20] rowReadON[21] rowReadOFF[20] rowReadOFF[21] openDVS_pixel2x2
x703 DiffBn VDD RefrBp GndD GndA PrSFBp OffBn PrBp OnBn pixRst[62] net127 net128 pixRst[63]
+ rowReadON[20] rowReadON[21] rowReadOFF[20] rowReadOFF[21] openDVS_pixel2x2
x704 DiffBn VDD RefrBp GndD GndA PrSFBp OffBn PrBp OnBn pixRst[0] net3 net4 pixRst[1] rowReadON[18]
+ rowReadON[19] rowReadOFF[18] rowReadOFF[19] openDVS_pixel2x2
x705 DiffBn VDD RefrBp GndD GndA PrSFBp OffBn PrBp OnBn pixRst[2] net7 net8 pixRst[3] rowReadON[18]
+ rowReadON[19] rowReadOFF[18] rowReadOFF[19] openDVS_pixel2x2
x706 DiffBn VDD RefrBp GndD GndA PrSFBp OffBn PrBp OnBn pixRst[4] net11 net12 pixRst[5]
+ rowReadON[18] rowReadON[19] rowReadOFF[18] rowReadOFF[19] openDVS_pixel2x2
x707 DiffBn VDD RefrBp GndD GndA PrSFBp OffBn PrBp OnBn pixRst[6] net15 net16 pixRst[7]
+ rowReadON[18] rowReadON[19] rowReadOFF[18] rowReadOFF[19] openDVS_pixel2x2
x708 DiffBn VDD RefrBp GndD GndA PrSFBp OffBn PrBp OnBn pixRst[8] net19 net20 pixRst[9]
+ rowReadON[18] rowReadON[19] rowReadOFF[18] rowReadOFF[19] openDVS_pixel2x2
x709 DiffBn VDD RefrBp GndD GndA PrSFBp OffBn PrBp OnBn pixRst[10] net23 net24 pixRst[11]
+ rowReadON[18] rowReadON[19] rowReadOFF[18] rowReadOFF[19] openDVS_pixel2x2
x710 DiffBn VDD RefrBp GndD GndA PrSFBp OffBn PrBp OnBn pixRst[12] net27 net28 pixRst[13]
+ rowReadON[18] rowReadON[19] rowReadOFF[18] rowReadOFF[19] openDVS_pixel2x2
x711 DiffBn VDD RefrBp GndD GndA PrSFBp OffBn PrBp OnBn pixRst[14] net31 net32 pixRst[15]
+ rowReadON[18] rowReadON[19] rowReadOFF[18] rowReadOFF[19] openDVS_pixel2x2
x712 DiffBn VDD RefrBp GndD GndA PrSFBp OffBn PrBp OnBn pixRst[16] net35 net36 pixRst[17]
+ rowReadON[18] rowReadON[19] rowReadOFF[18] rowReadOFF[19] openDVS_pixel2x2
x713 DiffBn VDD RefrBp GndD GndA PrSFBp OffBn PrBp OnBn pixRst[18] net39 net40 pixRst[19]
+ rowReadON[18] rowReadON[19] rowReadOFF[18] rowReadOFF[19] openDVS_pixel2x2
x714 DiffBn VDD RefrBp GndD GndA PrSFBp OffBn PrBp OnBn pixRst[20] net43 net44 pixRst[21]
+ rowReadON[18] rowReadON[19] rowReadOFF[18] rowReadOFF[19] openDVS_pixel2x2
x715 DiffBn VDD RefrBp GndD GndA PrSFBp OffBn PrBp OnBn pixRst[22] net47 net48 pixRst[23]
+ rowReadON[18] rowReadON[19] rowReadOFF[18] rowReadOFF[19] openDVS_pixel2x2
x716 DiffBn VDD RefrBp GndD GndA PrSFBp OffBn PrBp OnBn pixRst[24] net51 net52 pixRst[25]
+ rowReadON[18] rowReadON[19] rowReadOFF[18] rowReadOFF[19] openDVS_pixel2x2
x717 DiffBn VDD RefrBp GndD GndA PrSFBp OffBn PrBp OnBn pixRst[26] net55 net56 pixRst[27]
+ rowReadON[18] rowReadON[19] rowReadOFF[18] rowReadOFF[19] openDVS_pixel2x2
x718 DiffBn VDD RefrBp GndD GndA PrSFBp OffBn PrBp OnBn pixRst[28] net59 net60 pixRst[29]
+ rowReadON[18] rowReadON[19] rowReadOFF[18] rowReadOFF[19] openDVS_pixel2x2
x719 DiffBn VDD RefrBp GndD GndA PrSFBp OffBn PrBp OnBn pixRst[30] net63 net64 pixRst[31]
+ rowReadON[18] rowReadON[19] rowReadOFF[18] rowReadOFF[19] openDVS_pixel2x2
x720 DiffBn VDD RefrBp GndD GndA PrSFBp OffBn PrBp OnBn pixRst[32] net67 net68 pixRst[33]
+ rowReadON[18] rowReadON[19] rowReadOFF[18] rowReadOFF[19] openDVS_pixel2x2
x721 DiffBn VDD RefrBp GndD GndA PrSFBp OffBn PrBp OnBn pixRst[34] net71 net72 pixRst[35]
+ rowReadON[18] rowReadON[19] rowReadOFF[18] rowReadOFF[19] openDVS_pixel2x2
x722 DiffBn VDD RefrBp GndD GndA PrSFBp OffBn PrBp OnBn pixRst[36] net75 net76 pixRst[37]
+ rowReadON[18] rowReadON[19] rowReadOFF[18] rowReadOFF[19] openDVS_pixel2x2
x723 DiffBn VDD RefrBp GndD GndA PrSFBp OffBn PrBp OnBn pixRst[38] net79 net80 pixRst[39]
+ rowReadON[18] rowReadON[19] rowReadOFF[18] rowReadOFF[19] openDVS_pixel2x2
x724 DiffBn VDD RefrBp GndD GndA PrSFBp OffBn PrBp OnBn pixRst[40] net83 net84 pixRst[41]
+ rowReadON[18] rowReadON[19] rowReadOFF[18] rowReadOFF[19] openDVS_pixel2x2
x725 DiffBn VDD RefrBp GndD GndA PrSFBp OffBn PrBp OnBn pixRst[42] net87 net88 pixRst[43]
+ rowReadON[18] rowReadON[19] rowReadOFF[18] rowReadOFF[19] openDVS_pixel2x2
x726 DiffBn VDD RefrBp GndD GndA PrSFBp OffBn PrBp OnBn pixRst[44] net91 net92 pixRst[45]
+ rowReadON[18] rowReadON[19] rowReadOFF[18] rowReadOFF[19] openDVS_pixel2x2
x727 DiffBn VDD RefrBp GndD GndA PrSFBp OffBn PrBp OnBn pixRst[46] net95 net96 pixRst[47]
+ rowReadON[18] rowReadON[19] rowReadOFF[18] rowReadOFF[19] openDVS_pixel2x2
x728 DiffBn VDD RefrBp GndD GndA PrSFBp OffBn PrBp OnBn pixRst[48] net99 net100 pixRst[49]
+ rowReadON[18] rowReadON[19] rowReadOFF[18] rowReadOFF[19] openDVS_pixel2x2
x729 DiffBn VDD RefrBp GndD GndA PrSFBp OffBn PrBp OnBn pixRst[50] net103 net104 pixRst[51]
+ rowReadON[18] rowReadON[19] rowReadOFF[18] rowReadOFF[19] openDVS_pixel2x2
x730 DiffBn VDD RefrBp GndD GndA PrSFBp OffBn PrBp OnBn pixRst[52] net107 net108 pixRst[53]
+ rowReadON[18] rowReadON[19] rowReadOFF[18] rowReadOFF[19] openDVS_pixel2x2
x731 DiffBn VDD RefrBp GndD GndA PrSFBp OffBn PrBp OnBn pixRst[54] net111 net112 pixRst[55]
+ rowReadON[18] rowReadON[19] rowReadOFF[18] rowReadOFF[19] openDVS_pixel2x2
x732 DiffBn VDD RefrBp GndD GndA PrSFBp OffBn PrBp OnBn pixRst[56] net115 net116 pixRst[57]
+ rowReadON[18] rowReadON[19] rowReadOFF[18] rowReadOFF[19] openDVS_pixel2x2
x733 DiffBn VDD RefrBp GndD GndA PrSFBp OffBn PrBp OnBn pixRst[58] net119 net120 pixRst[59]
+ rowReadON[18] rowReadON[19] rowReadOFF[18] rowReadOFF[19] openDVS_pixel2x2
x734 DiffBn VDD RefrBp GndD GndA PrSFBp OffBn PrBp OnBn pixRst[60] net123 net124 pixRst[61]
+ rowReadON[18] rowReadON[19] rowReadOFF[18] rowReadOFF[19] openDVS_pixel2x2
x735 DiffBn VDD RefrBp GndD GndA PrSFBp OffBn PrBp OnBn pixRst[62] net127 net128 pixRst[63]
+ rowReadON[18] rowReadON[19] rowReadOFF[18] rowReadOFF[19] openDVS_pixel2x2
x736 DiffBn VDD RefrBp GndD GndA PrSFBp OffBn PrBp OnBn pixRst[0] net3 net4 pixRst[1] rowReadON[16]
+ rowReadON[17] rowReadOFF[16] rowReadOFF[17] openDVS_pixel2x2
x737 DiffBn VDD RefrBp GndD GndA PrSFBp OffBn PrBp OnBn pixRst[2] net7 net8 pixRst[3] rowReadON[16]
+ rowReadON[17] rowReadOFF[16] rowReadOFF[17] openDVS_pixel2x2
x738 DiffBn VDD RefrBp GndD GndA PrSFBp OffBn PrBp OnBn pixRst[4] net11 net12 pixRst[5]
+ rowReadON[16] rowReadON[17] rowReadOFF[16] rowReadOFF[17] openDVS_pixel2x2
x739 DiffBn VDD RefrBp GndD GndA PrSFBp OffBn PrBp OnBn pixRst[6] net15 net16 pixRst[7]
+ rowReadON[16] rowReadON[17] rowReadOFF[16] rowReadOFF[17] openDVS_pixel2x2
x740 DiffBn VDD RefrBp GndD GndA PrSFBp OffBn PrBp OnBn pixRst[8] net19 net20 pixRst[9]
+ rowReadON[16] rowReadON[17] rowReadOFF[16] rowReadOFF[17] openDVS_pixel2x2
x741 DiffBn VDD RefrBp GndD GndA PrSFBp OffBn PrBp OnBn pixRst[10] net23 net24 pixRst[11]
+ rowReadON[16] rowReadON[17] rowReadOFF[16] rowReadOFF[17] openDVS_pixel2x2
x742 DiffBn VDD RefrBp GndD GndA PrSFBp OffBn PrBp OnBn pixRst[12] net27 net28 pixRst[13]
+ rowReadON[16] rowReadON[17] rowReadOFF[16] rowReadOFF[17] openDVS_pixel2x2
x743 DiffBn VDD RefrBp GndD GndA PrSFBp OffBn PrBp OnBn pixRst[14] net31 net32 pixRst[15]
+ rowReadON[16] rowReadON[17] rowReadOFF[16] rowReadOFF[17] openDVS_pixel2x2
x744 DiffBn VDD RefrBp GndD GndA PrSFBp OffBn PrBp OnBn pixRst[16] net35 net36 pixRst[17]
+ rowReadON[16] rowReadON[17] rowReadOFF[16] rowReadOFF[17] openDVS_pixel2x2
x745 DiffBn VDD RefrBp GndD GndA PrSFBp OffBn PrBp OnBn pixRst[18] net39 net40 pixRst[19]
+ rowReadON[16] rowReadON[17] rowReadOFF[16] rowReadOFF[17] openDVS_pixel2x2
x746 DiffBn VDD RefrBp GndD GndA PrSFBp OffBn PrBp OnBn pixRst[20] net43 net44 pixRst[21]
+ rowReadON[16] rowReadON[17] rowReadOFF[16] rowReadOFF[17] openDVS_pixel2x2
x747 DiffBn VDD RefrBp GndD GndA PrSFBp OffBn PrBp OnBn pixRst[22] net47 net48 pixRst[23]
+ rowReadON[16] rowReadON[17] rowReadOFF[16] rowReadOFF[17] openDVS_pixel2x2
x748 DiffBn VDD RefrBp GndD GndA PrSFBp OffBn PrBp OnBn pixRst[24] net51 net52 pixRst[25]
+ rowReadON[16] rowReadON[17] rowReadOFF[16] rowReadOFF[17] openDVS_pixel2x2
x749 DiffBn VDD RefrBp GndD GndA PrSFBp OffBn PrBp OnBn pixRst[26] net55 net56 pixRst[27]
+ rowReadON[16] rowReadON[17] rowReadOFF[16] rowReadOFF[17] openDVS_pixel2x2
x750 DiffBn VDD RefrBp GndD GndA PrSFBp OffBn PrBp OnBn pixRst[28] net59 net60 pixRst[29]
+ rowReadON[16] rowReadON[17] rowReadOFF[16] rowReadOFF[17] openDVS_pixel2x2
x751 DiffBn VDD RefrBp GndD GndA PrSFBp OffBn PrBp OnBn pixRst[30] net63 net64 pixRst[31]
+ rowReadON[16] rowReadON[17] rowReadOFF[16] rowReadOFF[17] openDVS_pixel2x2
x752 DiffBn VDD RefrBp GndD GndA PrSFBp OffBn PrBp OnBn pixRst[32] net67 net68 pixRst[33]
+ rowReadON[16] rowReadON[17] rowReadOFF[16] rowReadOFF[17] openDVS_pixel2x2
x753 DiffBn VDD RefrBp GndD GndA PrSFBp OffBn PrBp OnBn pixRst[34] net71 net72 pixRst[35]
+ rowReadON[16] rowReadON[17] rowReadOFF[16] rowReadOFF[17] openDVS_pixel2x2
x754 DiffBn VDD RefrBp GndD GndA PrSFBp OffBn PrBp OnBn pixRst[36] net75 net76 pixRst[37]
+ rowReadON[16] rowReadON[17] rowReadOFF[16] rowReadOFF[17] openDVS_pixel2x2
x755 DiffBn VDD RefrBp GndD GndA PrSFBp OffBn PrBp OnBn pixRst[38] net79 net80 pixRst[39]
+ rowReadON[16] rowReadON[17] rowReadOFF[16] rowReadOFF[17] openDVS_pixel2x2
x756 DiffBn VDD RefrBp GndD GndA PrSFBp OffBn PrBp OnBn pixRst[40] net83 net84 pixRst[41]
+ rowReadON[16] rowReadON[17] rowReadOFF[16] rowReadOFF[17] openDVS_pixel2x2
x757 DiffBn VDD RefrBp GndD GndA PrSFBp OffBn PrBp OnBn pixRst[42] net87 net88 pixRst[43]
+ rowReadON[16] rowReadON[17] rowReadOFF[16] rowReadOFF[17] openDVS_pixel2x2
x758 DiffBn VDD RefrBp GndD GndA PrSFBp OffBn PrBp OnBn pixRst[44] net91 net92 pixRst[45]
+ rowReadON[16] rowReadON[17] rowReadOFF[16] rowReadOFF[17] openDVS_pixel2x2
x759 DiffBn VDD RefrBp GndD GndA PrSFBp OffBn PrBp OnBn pixRst[46] net95 net96 pixRst[47]
+ rowReadON[16] rowReadON[17] rowReadOFF[16] rowReadOFF[17] openDVS_pixel2x2
x760 DiffBn VDD RefrBp GndD GndA PrSFBp OffBn PrBp OnBn pixRst[48] net99 net100 pixRst[49]
+ rowReadON[16] rowReadON[17] rowReadOFF[16] rowReadOFF[17] openDVS_pixel2x2
x761 DiffBn VDD RefrBp GndD GndA PrSFBp OffBn PrBp OnBn pixRst[50] net103 net104 pixRst[51]
+ rowReadON[16] rowReadON[17] rowReadOFF[16] rowReadOFF[17] openDVS_pixel2x2
x762 DiffBn VDD RefrBp GndD GndA PrSFBp OffBn PrBp OnBn pixRst[52] net107 net108 pixRst[53]
+ rowReadON[16] rowReadON[17] rowReadOFF[16] rowReadOFF[17] openDVS_pixel2x2
x763 DiffBn VDD RefrBp GndD GndA PrSFBp OffBn PrBp OnBn pixRst[54] net111 net112 pixRst[55]
+ rowReadON[16] rowReadON[17] rowReadOFF[16] rowReadOFF[17] openDVS_pixel2x2
x764 DiffBn VDD RefrBp GndD GndA PrSFBp OffBn PrBp OnBn pixRst[56] net115 net116 pixRst[57]
+ rowReadON[16] rowReadON[17] rowReadOFF[16] rowReadOFF[17] openDVS_pixel2x2
x765 DiffBn VDD RefrBp GndD GndA PrSFBp OffBn PrBp OnBn pixRst[58] net119 net120 pixRst[59]
+ rowReadON[16] rowReadON[17] rowReadOFF[16] rowReadOFF[17] openDVS_pixel2x2
x766 DiffBn VDD RefrBp GndD GndA PrSFBp OffBn PrBp OnBn pixRst[60] net123 net124 pixRst[61]
+ rowReadON[16] rowReadON[17] rowReadOFF[16] rowReadOFF[17] openDVS_pixel2x2
x767 DiffBn VDD RefrBp GndD GndA PrSFBp OffBn PrBp OnBn pixRst[62] net127 net128 pixRst[63]
+ rowReadON[16] rowReadON[17] rowReadOFF[16] rowReadOFF[17] openDVS_pixel2x2
x768 DiffBn VDD RefrBp GndD GndA PrSFBp OffBn PrBp OnBn pixRst[0] net3 net4 pixRst[1] rowReadON[14]
+ rowReadON[15] rowReadOFF[14] rowReadOFF[15] openDVS_pixel2x2
x769 DiffBn VDD RefrBp GndD GndA PrSFBp OffBn PrBp OnBn pixRst[2] net7 net8 pixRst[3] rowReadON[14]
+ rowReadON[15] rowReadOFF[14] rowReadOFF[15] openDVS_pixel2x2
x770 DiffBn VDD RefrBp GndD GndA PrSFBp OffBn PrBp OnBn pixRst[4] net11 net12 pixRst[5]
+ rowReadON[14] rowReadON[15] rowReadOFF[14] rowReadOFF[15] openDVS_pixel2x2
x771 DiffBn VDD RefrBp GndD GndA PrSFBp OffBn PrBp OnBn pixRst[6] net15 net16 pixRst[7]
+ rowReadON[14] rowReadON[15] rowReadOFF[14] rowReadOFF[15] openDVS_pixel2x2
x772 DiffBn VDD RefrBp GndD GndA PrSFBp OffBn PrBp OnBn pixRst[8] net19 net20 pixRst[9]
+ rowReadON[14] rowReadON[15] rowReadOFF[14] rowReadOFF[15] openDVS_pixel2x2
x773 DiffBn VDD RefrBp GndD GndA PrSFBp OffBn PrBp OnBn pixRst[10] net23 net24 pixRst[11]
+ rowReadON[14] rowReadON[15] rowReadOFF[14] rowReadOFF[15] openDVS_pixel2x2
x774 DiffBn VDD RefrBp GndD GndA PrSFBp OffBn PrBp OnBn pixRst[12] net27 net28 pixRst[13]
+ rowReadON[14] rowReadON[15] rowReadOFF[14] rowReadOFF[15] openDVS_pixel2x2
x775 DiffBn VDD RefrBp GndD GndA PrSFBp OffBn PrBp OnBn pixRst[14] net31 net32 pixRst[15]
+ rowReadON[14] rowReadON[15] rowReadOFF[14] rowReadOFF[15] openDVS_pixel2x2
x776 DiffBn VDD RefrBp GndD GndA PrSFBp OffBn PrBp OnBn pixRst[16] net35 net36 pixRst[17]
+ rowReadON[14] rowReadON[15] rowReadOFF[14] rowReadOFF[15] openDVS_pixel2x2
x777 DiffBn VDD RefrBp GndD GndA PrSFBp OffBn PrBp OnBn pixRst[18] net39 net40 pixRst[19]
+ rowReadON[14] rowReadON[15] rowReadOFF[14] rowReadOFF[15] openDVS_pixel2x2
x778 DiffBn VDD RefrBp GndD GndA PrSFBp OffBn PrBp OnBn pixRst[20] net43 net44 pixRst[21]
+ rowReadON[14] rowReadON[15] rowReadOFF[14] rowReadOFF[15] openDVS_pixel2x2
x779 DiffBn VDD RefrBp GndD GndA PrSFBp OffBn PrBp OnBn pixRst[22] net47 net48 pixRst[23]
+ rowReadON[14] rowReadON[15] rowReadOFF[14] rowReadOFF[15] openDVS_pixel2x2
x780 DiffBn VDD RefrBp GndD GndA PrSFBp OffBn PrBp OnBn pixRst[24] net51 net52 pixRst[25]
+ rowReadON[14] rowReadON[15] rowReadOFF[14] rowReadOFF[15] openDVS_pixel2x2
x781 DiffBn VDD RefrBp GndD GndA PrSFBp OffBn PrBp OnBn pixRst[26] net55 net56 pixRst[27]
+ rowReadON[14] rowReadON[15] rowReadOFF[14] rowReadOFF[15] openDVS_pixel2x2
x782 DiffBn VDD RefrBp GndD GndA PrSFBp OffBn PrBp OnBn pixRst[28] net59 net60 pixRst[29]
+ rowReadON[14] rowReadON[15] rowReadOFF[14] rowReadOFF[15] openDVS_pixel2x2
x783 DiffBn VDD RefrBp GndD GndA PrSFBp OffBn PrBp OnBn pixRst[30] net63 net64 pixRst[31]
+ rowReadON[14] rowReadON[15] rowReadOFF[14] rowReadOFF[15] openDVS_pixel2x2
x784 DiffBn VDD RefrBp GndD GndA PrSFBp OffBn PrBp OnBn pixRst[32] net67 net68 pixRst[33]
+ rowReadON[14] rowReadON[15] rowReadOFF[14] rowReadOFF[15] openDVS_pixel2x2
x785 DiffBn VDD RefrBp GndD GndA PrSFBp OffBn PrBp OnBn pixRst[34] net71 net72 pixRst[35]
+ rowReadON[14] rowReadON[15] rowReadOFF[14] rowReadOFF[15] openDVS_pixel2x2
x786 DiffBn VDD RefrBp GndD GndA PrSFBp OffBn PrBp OnBn pixRst[36] net75 net76 pixRst[37]
+ rowReadON[14] rowReadON[15] rowReadOFF[14] rowReadOFF[15] openDVS_pixel2x2
x787 DiffBn VDD RefrBp GndD GndA PrSFBp OffBn PrBp OnBn pixRst[38] net79 net80 pixRst[39]
+ rowReadON[14] rowReadON[15] rowReadOFF[14] rowReadOFF[15] openDVS_pixel2x2
x788 DiffBn VDD RefrBp GndD GndA PrSFBp OffBn PrBp OnBn pixRst[40] net83 net84 pixRst[41]
+ rowReadON[14] rowReadON[15] rowReadOFF[14] rowReadOFF[15] openDVS_pixel2x2
x789 DiffBn VDD RefrBp GndD GndA PrSFBp OffBn PrBp OnBn pixRst[42] net87 net88 pixRst[43]
+ rowReadON[14] rowReadON[15] rowReadOFF[14] rowReadOFF[15] openDVS_pixel2x2
x790 DiffBn VDD RefrBp GndD GndA PrSFBp OffBn PrBp OnBn pixRst[44] net91 net92 pixRst[45]
+ rowReadON[14] rowReadON[15] rowReadOFF[14] rowReadOFF[15] openDVS_pixel2x2
x791 DiffBn VDD RefrBp GndD GndA PrSFBp OffBn PrBp OnBn pixRst[46] net95 net96 pixRst[47]
+ rowReadON[14] rowReadON[15] rowReadOFF[14] rowReadOFF[15] openDVS_pixel2x2
x792 DiffBn VDD RefrBp GndD GndA PrSFBp OffBn PrBp OnBn pixRst[48] net99 net100 pixRst[49]
+ rowReadON[14] rowReadON[15] rowReadOFF[14] rowReadOFF[15] openDVS_pixel2x2
x793 DiffBn VDD RefrBp GndD GndA PrSFBp OffBn PrBp OnBn pixRst[50] net103 net104 pixRst[51]
+ rowReadON[14] rowReadON[15] rowReadOFF[14] rowReadOFF[15] openDVS_pixel2x2
x794 DiffBn VDD RefrBp GndD GndA PrSFBp OffBn PrBp OnBn pixRst[52] net107 net108 pixRst[53]
+ rowReadON[14] rowReadON[15] rowReadOFF[14] rowReadOFF[15] openDVS_pixel2x2
x795 DiffBn VDD RefrBp GndD GndA PrSFBp OffBn PrBp OnBn pixRst[54] net111 net112 pixRst[55]
+ rowReadON[14] rowReadON[15] rowReadOFF[14] rowReadOFF[15] openDVS_pixel2x2
x796 DiffBn VDD RefrBp GndD GndA PrSFBp OffBn PrBp OnBn pixRst[56] net115 net116 pixRst[57]
+ rowReadON[14] rowReadON[15] rowReadOFF[14] rowReadOFF[15] openDVS_pixel2x2
x797 DiffBn VDD RefrBp GndD GndA PrSFBp OffBn PrBp OnBn pixRst[58] net119 net120 pixRst[59]
+ rowReadON[14] rowReadON[15] rowReadOFF[14] rowReadOFF[15] openDVS_pixel2x2
x798 DiffBn VDD RefrBp GndD GndA PrSFBp OffBn PrBp OnBn pixRst[60] net123 net124 pixRst[61]
+ rowReadON[14] rowReadON[15] rowReadOFF[14] rowReadOFF[15] openDVS_pixel2x2
x799 DiffBn VDD RefrBp GndD GndA PrSFBp OffBn PrBp OnBn pixRst[62] net127 net128 pixRst[63]
+ rowReadON[14] rowReadON[15] rowReadOFF[14] rowReadOFF[15] openDVS_pixel2x2
x800 DiffBn VDD RefrBp GndD GndA PrSFBp OffBn PrBp OnBn pixRst[0] net3 net4 pixRst[1] rowReadON[12]
+ rowReadON[13] rowReadOFF[12] rowReadOFF[13] openDVS_pixel2x2
x801 DiffBn VDD RefrBp GndD GndA PrSFBp OffBn PrBp OnBn pixRst[2] net7 net8 pixRst[3] rowReadON[12]
+ rowReadON[13] rowReadOFF[12] rowReadOFF[13] openDVS_pixel2x2
x802 DiffBn VDD RefrBp GndD GndA PrSFBp OffBn PrBp OnBn pixRst[4] net11 net12 pixRst[5]
+ rowReadON[12] rowReadON[13] rowReadOFF[12] rowReadOFF[13] openDVS_pixel2x2
x803 DiffBn VDD RefrBp GndD GndA PrSFBp OffBn PrBp OnBn pixRst[6] net15 net16 pixRst[7]
+ rowReadON[12] rowReadON[13] rowReadOFF[12] rowReadOFF[13] openDVS_pixel2x2
x804 DiffBn VDD RefrBp GndD GndA PrSFBp OffBn PrBp OnBn pixRst[8] net19 net20 pixRst[9]
+ rowReadON[12] rowReadON[13] rowReadOFF[12] rowReadOFF[13] openDVS_pixel2x2
x805 DiffBn VDD RefrBp GndD GndA PrSFBp OffBn PrBp OnBn pixRst[10] net23 net24 pixRst[11]
+ rowReadON[12] rowReadON[13] rowReadOFF[12] rowReadOFF[13] openDVS_pixel2x2
x806 DiffBn VDD RefrBp GndD GndA PrSFBp OffBn PrBp OnBn pixRst[12] net27 net28 pixRst[13]
+ rowReadON[12] rowReadON[13] rowReadOFF[12] rowReadOFF[13] openDVS_pixel2x2
x807 DiffBn VDD RefrBp GndD GndA PrSFBp OffBn PrBp OnBn pixRst[14] net31 net32 pixRst[15]
+ rowReadON[12] rowReadON[13] rowReadOFF[12] rowReadOFF[13] openDVS_pixel2x2
x808 DiffBn VDD RefrBp GndD GndA PrSFBp OffBn PrBp OnBn pixRst[16] net35 net36 pixRst[17]
+ rowReadON[12] rowReadON[13] rowReadOFF[12] rowReadOFF[13] openDVS_pixel2x2
x809 DiffBn VDD RefrBp GndD GndA PrSFBp OffBn PrBp OnBn pixRst[18] net39 net40 pixRst[19]
+ rowReadON[12] rowReadON[13] rowReadOFF[12] rowReadOFF[13] openDVS_pixel2x2
x810 DiffBn VDD RefrBp GndD GndA PrSFBp OffBn PrBp OnBn pixRst[20] net43 net44 pixRst[21]
+ rowReadON[12] rowReadON[13] rowReadOFF[12] rowReadOFF[13] openDVS_pixel2x2
x811 DiffBn VDD RefrBp GndD GndA PrSFBp OffBn PrBp OnBn pixRst[22] net47 net48 pixRst[23]
+ rowReadON[12] rowReadON[13] rowReadOFF[12] rowReadOFF[13] openDVS_pixel2x2
x812 DiffBn VDD RefrBp GndD GndA PrSFBp OffBn PrBp OnBn pixRst[24] net51 net52 pixRst[25]
+ rowReadON[12] rowReadON[13] rowReadOFF[12] rowReadOFF[13] openDVS_pixel2x2
x813 DiffBn VDD RefrBp GndD GndA PrSFBp OffBn PrBp OnBn pixRst[26] net55 net56 pixRst[27]
+ rowReadON[12] rowReadON[13] rowReadOFF[12] rowReadOFF[13] openDVS_pixel2x2
x814 DiffBn VDD RefrBp GndD GndA PrSFBp OffBn PrBp OnBn pixRst[28] net59 net60 pixRst[29]
+ rowReadON[12] rowReadON[13] rowReadOFF[12] rowReadOFF[13] openDVS_pixel2x2
x815 DiffBn VDD RefrBp GndD GndA PrSFBp OffBn PrBp OnBn pixRst[30] net63 net64 pixRst[31]
+ rowReadON[12] rowReadON[13] rowReadOFF[12] rowReadOFF[13] openDVS_pixel2x2
x816 DiffBn VDD RefrBp GndD GndA PrSFBp OffBn PrBp OnBn pixRst[32] net67 net68 pixRst[33]
+ rowReadON[12] rowReadON[13] rowReadOFF[12] rowReadOFF[13] openDVS_pixel2x2
x817 DiffBn VDD RefrBp GndD GndA PrSFBp OffBn PrBp OnBn pixRst[34] net71 net72 pixRst[35]
+ rowReadON[12] rowReadON[13] rowReadOFF[12] rowReadOFF[13] openDVS_pixel2x2
x818 DiffBn VDD RefrBp GndD GndA PrSFBp OffBn PrBp OnBn pixRst[36] net75 net76 pixRst[37]
+ rowReadON[12] rowReadON[13] rowReadOFF[12] rowReadOFF[13] openDVS_pixel2x2
x819 DiffBn VDD RefrBp GndD GndA PrSFBp OffBn PrBp OnBn pixRst[38] net79 net80 pixRst[39]
+ rowReadON[12] rowReadON[13] rowReadOFF[12] rowReadOFF[13] openDVS_pixel2x2
x820 DiffBn VDD RefrBp GndD GndA PrSFBp OffBn PrBp OnBn pixRst[40] net83 net84 pixRst[41]
+ rowReadON[12] rowReadON[13] rowReadOFF[12] rowReadOFF[13] openDVS_pixel2x2
x821 DiffBn VDD RefrBp GndD GndA PrSFBp OffBn PrBp OnBn pixRst[42] net87 net88 pixRst[43]
+ rowReadON[12] rowReadON[13] rowReadOFF[12] rowReadOFF[13] openDVS_pixel2x2
x822 DiffBn VDD RefrBp GndD GndA PrSFBp OffBn PrBp OnBn pixRst[44] net91 net92 pixRst[45]
+ rowReadON[12] rowReadON[13] rowReadOFF[12] rowReadOFF[13] openDVS_pixel2x2
x823 DiffBn VDD RefrBp GndD GndA PrSFBp OffBn PrBp OnBn pixRst[46] net95 net96 pixRst[47]
+ rowReadON[12] rowReadON[13] rowReadOFF[12] rowReadOFF[13] openDVS_pixel2x2
x824 DiffBn VDD RefrBp GndD GndA PrSFBp OffBn PrBp OnBn pixRst[48] net99 net100 pixRst[49]
+ rowReadON[12] rowReadON[13] rowReadOFF[12] rowReadOFF[13] openDVS_pixel2x2
x825 DiffBn VDD RefrBp GndD GndA PrSFBp OffBn PrBp OnBn pixRst[50] net103 net104 pixRst[51]
+ rowReadON[12] rowReadON[13] rowReadOFF[12] rowReadOFF[13] openDVS_pixel2x2
x826 DiffBn VDD RefrBp GndD GndA PrSFBp OffBn PrBp OnBn pixRst[52] net107 net108 pixRst[53]
+ rowReadON[12] rowReadON[13] rowReadOFF[12] rowReadOFF[13] openDVS_pixel2x2
x827 DiffBn VDD RefrBp GndD GndA PrSFBp OffBn PrBp OnBn pixRst[54] net111 net112 pixRst[55]
+ rowReadON[12] rowReadON[13] rowReadOFF[12] rowReadOFF[13] openDVS_pixel2x2
x828 DiffBn VDD RefrBp GndD GndA PrSFBp OffBn PrBp OnBn pixRst[56] net115 net116 pixRst[57]
+ rowReadON[12] rowReadON[13] rowReadOFF[12] rowReadOFF[13] openDVS_pixel2x2
x829 DiffBn VDD RefrBp GndD GndA PrSFBp OffBn PrBp OnBn pixRst[58] net119 net120 pixRst[59]
+ rowReadON[12] rowReadON[13] rowReadOFF[12] rowReadOFF[13] openDVS_pixel2x2
x830 DiffBn VDD RefrBp GndD GndA PrSFBp OffBn PrBp OnBn pixRst[60] net123 net124 pixRst[61]
+ rowReadON[12] rowReadON[13] rowReadOFF[12] rowReadOFF[13] openDVS_pixel2x2
x831 DiffBn VDD RefrBp GndD GndA PrSFBp OffBn PrBp OnBn pixRst[62] net127 net128 pixRst[63]
+ rowReadON[12] rowReadON[13] rowReadOFF[12] rowReadOFF[13] openDVS_pixel2x2
x832 DiffBn VDD RefrBp GndD GndA PrSFBp OffBn PrBp OnBn pixRst[0] net3 net4 pixRst[1] rowReadON[10]
+ rowReadON[11] rowReadOFF[10] rowReadOFF[11] openDVS_pixel2x2
x833 DiffBn VDD RefrBp GndD GndA PrSFBp OffBn PrBp OnBn pixRst[2] net7 net8 pixRst[3] rowReadON[10]
+ rowReadON[11] rowReadOFF[10] rowReadOFF[11] openDVS_pixel2x2
x834 DiffBn VDD RefrBp GndD GndA PrSFBp OffBn PrBp OnBn pixRst[4] net11 net12 pixRst[5]
+ rowReadON[10] rowReadON[11] rowReadOFF[10] rowReadOFF[11] openDVS_pixel2x2
x835 DiffBn VDD RefrBp GndD GndA PrSFBp OffBn PrBp OnBn pixRst[6] net15 net16 pixRst[7]
+ rowReadON[10] rowReadON[11] rowReadOFF[10] rowReadOFF[11] openDVS_pixel2x2
x836 DiffBn VDD RefrBp GndD GndA PrSFBp OffBn PrBp OnBn pixRst[8] net19 net20 pixRst[9]
+ rowReadON[10] rowReadON[11] rowReadOFF[10] rowReadOFF[11] openDVS_pixel2x2
x837 DiffBn VDD RefrBp GndD GndA PrSFBp OffBn PrBp OnBn pixRst[10] net23 net24 pixRst[11]
+ rowReadON[10] rowReadON[11] rowReadOFF[10] rowReadOFF[11] openDVS_pixel2x2
x838 DiffBn VDD RefrBp GndD GndA PrSFBp OffBn PrBp OnBn pixRst[12] net27 net28 pixRst[13]
+ rowReadON[10] rowReadON[11] rowReadOFF[10] rowReadOFF[11] openDVS_pixel2x2
x839 DiffBn VDD RefrBp GndD GndA PrSFBp OffBn PrBp OnBn pixRst[14] net31 net32 pixRst[15]
+ rowReadON[10] rowReadON[11] rowReadOFF[10] rowReadOFF[11] openDVS_pixel2x2
x840 DiffBn VDD RefrBp GndD GndA PrSFBp OffBn PrBp OnBn pixRst[16] net35 net36 pixRst[17]
+ rowReadON[10] rowReadON[11] rowReadOFF[10] rowReadOFF[11] openDVS_pixel2x2
x841 DiffBn VDD RefrBp GndD GndA PrSFBp OffBn PrBp OnBn pixRst[18] net39 net40 pixRst[19]
+ rowReadON[10] rowReadON[11] rowReadOFF[10] rowReadOFF[11] openDVS_pixel2x2
x842 DiffBn VDD RefrBp GndD GndA PrSFBp OffBn PrBp OnBn pixRst[20] net43 net44 pixRst[21]
+ rowReadON[10] rowReadON[11] rowReadOFF[10] rowReadOFF[11] openDVS_pixel2x2
x843 DiffBn VDD RefrBp GndD GndA PrSFBp OffBn PrBp OnBn pixRst[22] net47 net48 pixRst[23]
+ rowReadON[10] rowReadON[11] rowReadOFF[10] rowReadOFF[11] openDVS_pixel2x2
x844 DiffBn VDD RefrBp GndD GndA PrSFBp OffBn PrBp OnBn pixRst[24] net51 net52 pixRst[25]
+ rowReadON[10] rowReadON[11] rowReadOFF[10] rowReadOFF[11] openDVS_pixel2x2
x845 DiffBn VDD RefrBp GndD GndA PrSFBp OffBn PrBp OnBn pixRst[26] net55 net56 pixRst[27]
+ rowReadON[10] rowReadON[11] rowReadOFF[10] rowReadOFF[11] openDVS_pixel2x2
x846 DiffBn VDD RefrBp GndD GndA PrSFBp OffBn PrBp OnBn pixRst[28] net59 net60 pixRst[29]
+ rowReadON[10] rowReadON[11] rowReadOFF[10] rowReadOFF[11] openDVS_pixel2x2
x847 DiffBn VDD RefrBp GndD GndA PrSFBp OffBn PrBp OnBn pixRst[30] net63 net64 pixRst[31]
+ rowReadON[10] rowReadON[11] rowReadOFF[10] rowReadOFF[11] openDVS_pixel2x2
x848 DiffBn VDD RefrBp GndD GndA PrSFBp OffBn PrBp OnBn pixRst[32] net67 net68 pixRst[33]
+ rowReadON[10] rowReadON[11] rowReadOFF[10] rowReadOFF[11] openDVS_pixel2x2
x849 DiffBn VDD RefrBp GndD GndA PrSFBp OffBn PrBp OnBn pixRst[34] net71 net72 pixRst[35]
+ rowReadON[10] rowReadON[11] rowReadOFF[10] rowReadOFF[11] openDVS_pixel2x2
x850 DiffBn VDD RefrBp GndD GndA PrSFBp OffBn PrBp OnBn pixRst[36] net75 net76 pixRst[37]
+ rowReadON[10] rowReadON[11] rowReadOFF[10] rowReadOFF[11] openDVS_pixel2x2
x851 DiffBn VDD RefrBp GndD GndA PrSFBp OffBn PrBp OnBn pixRst[38] net79 net80 pixRst[39]
+ rowReadON[10] rowReadON[11] rowReadOFF[10] rowReadOFF[11] openDVS_pixel2x2
x852 DiffBn VDD RefrBp GndD GndA PrSFBp OffBn PrBp OnBn pixRst[40] net83 net84 pixRst[41]
+ rowReadON[10] rowReadON[11] rowReadOFF[10] rowReadOFF[11] openDVS_pixel2x2
x853 DiffBn VDD RefrBp GndD GndA PrSFBp OffBn PrBp OnBn pixRst[42] net87 net88 pixRst[43]
+ rowReadON[10] rowReadON[11] rowReadOFF[10] rowReadOFF[11] openDVS_pixel2x2
x854 DiffBn VDD RefrBp GndD GndA PrSFBp OffBn PrBp OnBn pixRst[44] net91 net92 pixRst[45]
+ rowReadON[10] rowReadON[11] rowReadOFF[10] rowReadOFF[11] openDVS_pixel2x2
x855 DiffBn VDD RefrBp GndD GndA PrSFBp OffBn PrBp OnBn pixRst[46] net95 net96 pixRst[47]
+ rowReadON[10] rowReadON[11] rowReadOFF[10] rowReadOFF[11] openDVS_pixel2x2
x856 DiffBn VDD RefrBp GndD GndA PrSFBp OffBn PrBp OnBn pixRst[48] net99 net100 pixRst[49]
+ rowReadON[10] rowReadON[11] rowReadOFF[10] rowReadOFF[11] openDVS_pixel2x2
x857 DiffBn VDD RefrBp GndD GndA PrSFBp OffBn PrBp OnBn pixRst[50] net103 net104 pixRst[51]
+ rowReadON[10] rowReadON[11] rowReadOFF[10] rowReadOFF[11] openDVS_pixel2x2
x858 DiffBn VDD RefrBp GndD GndA PrSFBp OffBn PrBp OnBn pixRst[52] net107 net108 pixRst[53]
+ rowReadON[10] rowReadON[11] rowReadOFF[10] rowReadOFF[11] openDVS_pixel2x2
x859 DiffBn VDD RefrBp GndD GndA PrSFBp OffBn PrBp OnBn pixRst[54] net111 net112 pixRst[55]
+ rowReadON[10] rowReadON[11] rowReadOFF[10] rowReadOFF[11] openDVS_pixel2x2
x860 DiffBn VDD RefrBp GndD GndA PrSFBp OffBn PrBp OnBn pixRst[56] net115 net116 pixRst[57]
+ rowReadON[10] rowReadON[11] rowReadOFF[10] rowReadOFF[11] openDVS_pixel2x2
x861 DiffBn VDD RefrBp GndD GndA PrSFBp OffBn PrBp OnBn pixRst[58] net119 net120 pixRst[59]
+ rowReadON[10] rowReadON[11] rowReadOFF[10] rowReadOFF[11] openDVS_pixel2x2
x862 DiffBn VDD RefrBp GndD GndA PrSFBp OffBn PrBp OnBn pixRst[60] net123 net124 pixRst[61]
+ rowReadON[10] rowReadON[11] rowReadOFF[10] rowReadOFF[11] openDVS_pixel2x2
x863 DiffBn VDD RefrBp GndD GndA PrSFBp OffBn PrBp OnBn pixRst[62] net127 net128 pixRst[63]
+ rowReadON[10] rowReadON[11] rowReadOFF[10] rowReadOFF[11] openDVS_pixel2x2
x864 DiffBn VDD RefrBp GndD GndA PrSFBp OffBn PrBp OnBn pixRst[0] net3 net4 pixRst[1] rowReadON[8]
+ rowReadON[9] rowReadOFF[8] rowReadOFF[9] openDVS_pixel2x2
x865 DiffBn VDD RefrBp GndD GndA PrSFBp OffBn PrBp OnBn pixRst[2] net7 net8 pixRst[3] rowReadON[8]
+ rowReadON[9] rowReadOFF[8] rowReadOFF[9] openDVS_pixel2x2
x866 DiffBn VDD RefrBp GndD GndA PrSFBp OffBn PrBp OnBn pixRst[4] net11 net12 pixRst[5] rowReadON[8]
+ rowReadON[9] rowReadOFF[8] rowReadOFF[9] openDVS_pixel2x2
x867 DiffBn VDD RefrBp GndD GndA PrSFBp OffBn PrBp OnBn pixRst[6] net15 net16 pixRst[7] rowReadON[8]
+ rowReadON[9] rowReadOFF[8] rowReadOFF[9] openDVS_pixel2x2
x868 DiffBn VDD RefrBp GndD GndA PrSFBp OffBn PrBp OnBn pixRst[8] net19 net20 pixRst[9] rowReadON[8]
+ rowReadON[9] rowReadOFF[8] rowReadOFF[9] openDVS_pixel2x2
x869 DiffBn VDD RefrBp GndD GndA PrSFBp OffBn PrBp OnBn pixRst[10] net23 net24 pixRst[11]
+ rowReadON[8] rowReadON[9] rowReadOFF[8] rowReadOFF[9] openDVS_pixel2x2
x870 DiffBn VDD RefrBp GndD GndA PrSFBp OffBn PrBp OnBn pixRst[12] net27 net28 pixRst[13]
+ rowReadON[8] rowReadON[9] rowReadOFF[8] rowReadOFF[9] openDVS_pixel2x2
x871 DiffBn VDD RefrBp GndD GndA PrSFBp OffBn PrBp OnBn pixRst[14] net31 net32 pixRst[15]
+ rowReadON[8] rowReadON[9] rowReadOFF[8] rowReadOFF[9] openDVS_pixel2x2
x872 DiffBn VDD RefrBp GndD GndA PrSFBp OffBn PrBp OnBn pixRst[16] net35 net36 pixRst[17]
+ rowReadON[8] rowReadON[9] rowReadOFF[8] rowReadOFF[9] openDVS_pixel2x2
x873 DiffBn VDD RefrBp GndD GndA PrSFBp OffBn PrBp OnBn pixRst[18] net39 net40 pixRst[19]
+ rowReadON[8] rowReadON[9] rowReadOFF[8] rowReadOFF[9] openDVS_pixel2x2
x874 DiffBn VDD RefrBp GndD GndA PrSFBp OffBn PrBp OnBn pixRst[20] net43 net44 pixRst[21]
+ rowReadON[8] rowReadON[9] rowReadOFF[8] rowReadOFF[9] openDVS_pixel2x2
x875 DiffBn VDD RefrBp GndD GndA PrSFBp OffBn PrBp OnBn pixRst[22] net47 net48 pixRst[23]
+ rowReadON[8] rowReadON[9] rowReadOFF[8] rowReadOFF[9] openDVS_pixel2x2
x876 DiffBn VDD RefrBp GndD GndA PrSFBp OffBn PrBp OnBn pixRst[24] net51 net52 pixRst[25]
+ rowReadON[8] rowReadON[9] rowReadOFF[8] rowReadOFF[9] openDVS_pixel2x2
x877 DiffBn VDD RefrBp GndD GndA PrSFBp OffBn PrBp OnBn pixRst[26] net55 net56 pixRst[27]
+ rowReadON[8] rowReadON[9] rowReadOFF[8] rowReadOFF[9] openDVS_pixel2x2
x878 DiffBn VDD RefrBp GndD GndA PrSFBp OffBn PrBp OnBn pixRst[28] net59 net60 pixRst[29]
+ rowReadON[8] rowReadON[9] rowReadOFF[8] rowReadOFF[9] openDVS_pixel2x2
x879 DiffBn VDD RefrBp GndD GndA PrSFBp OffBn PrBp OnBn pixRst[30] net63 net64 pixRst[31]
+ rowReadON[8] rowReadON[9] rowReadOFF[8] rowReadOFF[9] openDVS_pixel2x2
x880 DiffBn VDD RefrBp GndD GndA PrSFBp OffBn PrBp OnBn pixRst[32] net67 net68 pixRst[33]
+ rowReadON[8] rowReadON[9] rowReadOFF[8] rowReadOFF[9] openDVS_pixel2x2
x881 DiffBn VDD RefrBp GndD GndA PrSFBp OffBn PrBp OnBn pixRst[34] net71 net72 pixRst[35]
+ rowReadON[8] rowReadON[9] rowReadOFF[8] rowReadOFF[9] openDVS_pixel2x2
x882 DiffBn VDD RefrBp GndD GndA PrSFBp OffBn PrBp OnBn pixRst[36] net75 net76 pixRst[37]
+ rowReadON[8] rowReadON[9] rowReadOFF[8] rowReadOFF[9] openDVS_pixel2x2
x883 DiffBn VDD RefrBp GndD GndA PrSFBp OffBn PrBp OnBn pixRst[38] net79 net80 pixRst[39]
+ rowReadON[8] rowReadON[9] rowReadOFF[8] rowReadOFF[9] openDVS_pixel2x2
x884 DiffBn VDD RefrBp GndD GndA PrSFBp OffBn PrBp OnBn pixRst[40] net83 net84 pixRst[41]
+ rowReadON[8] rowReadON[9] rowReadOFF[8] rowReadOFF[9] openDVS_pixel2x2
x885 DiffBn VDD RefrBp GndD GndA PrSFBp OffBn PrBp OnBn pixRst[42] net87 net88 pixRst[43]
+ rowReadON[8] rowReadON[9] rowReadOFF[8] rowReadOFF[9] openDVS_pixel2x2
x886 DiffBn VDD RefrBp GndD GndA PrSFBp OffBn PrBp OnBn pixRst[44] net91 net92 pixRst[45]
+ rowReadON[8] rowReadON[9] rowReadOFF[8] rowReadOFF[9] openDVS_pixel2x2
x887 DiffBn VDD RefrBp GndD GndA PrSFBp OffBn PrBp OnBn pixRst[46] net95 net96 pixRst[47]
+ rowReadON[8] rowReadON[9] rowReadOFF[8] rowReadOFF[9] openDVS_pixel2x2
x888 DiffBn VDD RefrBp GndD GndA PrSFBp OffBn PrBp OnBn pixRst[48] net99 net100 pixRst[49]
+ rowReadON[8] rowReadON[9] rowReadOFF[8] rowReadOFF[9] openDVS_pixel2x2
x889 DiffBn VDD RefrBp GndD GndA PrSFBp OffBn PrBp OnBn pixRst[50] net103 net104 pixRst[51]
+ rowReadON[8] rowReadON[9] rowReadOFF[8] rowReadOFF[9] openDVS_pixel2x2
x890 DiffBn VDD RefrBp GndD GndA PrSFBp OffBn PrBp OnBn pixRst[52] net107 net108 pixRst[53]
+ rowReadON[8] rowReadON[9] rowReadOFF[8] rowReadOFF[9] openDVS_pixel2x2
x891 DiffBn VDD RefrBp GndD GndA PrSFBp OffBn PrBp OnBn pixRst[54] net111 net112 pixRst[55]
+ rowReadON[8] rowReadON[9] rowReadOFF[8] rowReadOFF[9] openDVS_pixel2x2
x892 DiffBn VDD RefrBp GndD GndA PrSFBp OffBn PrBp OnBn pixRst[56] net115 net116 pixRst[57]
+ rowReadON[8] rowReadON[9] rowReadOFF[8] rowReadOFF[9] openDVS_pixel2x2
x893 DiffBn VDD RefrBp GndD GndA PrSFBp OffBn PrBp OnBn pixRst[58] net119 net120 pixRst[59]
+ rowReadON[8] rowReadON[9] rowReadOFF[8] rowReadOFF[9] openDVS_pixel2x2
x894 DiffBn VDD RefrBp GndD GndA PrSFBp OffBn PrBp OnBn pixRst[60] net123 net124 pixRst[61]
+ rowReadON[8] rowReadON[9] rowReadOFF[8] rowReadOFF[9] openDVS_pixel2x2
x895 DiffBn VDD RefrBp GndD GndA PrSFBp OffBn PrBp OnBn pixRst[62] net127 net128 pixRst[63]
+ rowReadON[8] rowReadON[9] rowReadOFF[8] rowReadOFF[9] openDVS_pixel2x2
x896 DiffBn VDD RefrBp GndD GndA PrSFBp OffBn PrBp OnBn pixRst[0] net3 net4 pixRst[1] rowReadON[6]
+ rowReadON[7] rowReadOFF[6] rowReadOFF[7] openDVS_pixel2x2
x897 DiffBn VDD RefrBp GndD GndA PrSFBp OffBn PrBp OnBn pixRst[2] net7 net8 pixRst[3] rowReadON[6]
+ rowReadON[7] rowReadOFF[6] rowReadOFF[7] openDVS_pixel2x2
x898 DiffBn VDD RefrBp GndD GndA PrSFBp OffBn PrBp OnBn pixRst[4] net11 net12 pixRst[5] rowReadON[6]
+ rowReadON[7] rowReadOFF[6] rowReadOFF[7] openDVS_pixel2x2
x899 DiffBn VDD RefrBp GndD GndA PrSFBp OffBn PrBp OnBn pixRst[6] net15 net16 pixRst[7] rowReadON[6]
+ rowReadON[7] rowReadOFF[6] rowReadOFF[7] openDVS_pixel2x2
x900 DiffBn VDD RefrBp GndD GndA PrSFBp OffBn PrBp OnBn pixRst[8] net19 net20 pixRst[9] rowReadON[6]
+ rowReadON[7] rowReadOFF[6] rowReadOFF[7] openDVS_pixel2x2
x901 DiffBn VDD RefrBp GndD GndA PrSFBp OffBn PrBp OnBn pixRst[10] net23 net24 pixRst[11]
+ rowReadON[6] rowReadON[7] rowReadOFF[6] rowReadOFF[7] openDVS_pixel2x2
x902 DiffBn VDD RefrBp GndD GndA PrSFBp OffBn PrBp OnBn pixRst[12] net27 net28 pixRst[13]
+ rowReadON[6] rowReadON[7] rowReadOFF[6] rowReadOFF[7] openDVS_pixel2x2
x903 DiffBn VDD RefrBp GndD GndA PrSFBp OffBn PrBp OnBn pixRst[14] net31 net32 pixRst[15]
+ rowReadON[6] rowReadON[7] rowReadOFF[6] rowReadOFF[7] openDVS_pixel2x2
x904 DiffBn VDD RefrBp GndD GndA PrSFBp OffBn PrBp OnBn pixRst[16] net35 net36 pixRst[17]
+ rowReadON[6] rowReadON[7] rowReadOFF[6] rowReadOFF[7] openDVS_pixel2x2
x905 DiffBn VDD RefrBp GndD GndA PrSFBp OffBn PrBp OnBn pixRst[18] net39 net40 pixRst[19]
+ rowReadON[6] rowReadON[7] rowReadOFF[6] rowReadOFF[7] openDVS_pixel2x2
x906 DiffBn VDD RefrBp GndD GndA PrSFBp OffBn PrBp OnBn pixRst[20] net43 net44 pixRst[21]
+ rowReadON[6] rowReadON[7] rowReadOFF[6] rowReadOFF[7] openDVS_pixel2x2
x907 DiffBn VDD RefrBp GndD GndA PrSFBp OffBn PrBp OnBn pixRst[22] net47 net48 pixRst[23]
+ rowReadON[6] rowReadON[7] rowReadOFF[6] rowReadOFF[7] openDVS_pixel2x2
x908 DiffBn VDD RefrBp GndD GndA PrSFBp OffBn PrBp OnBn pixRst[24] net51 net52 pixRst[25]
+ rowReadON[6] rowReadON[7] rowReadOFF[6] rowReadOFF[7] openDVS_pixel2x2
x909 DiffBn VDD RefrBp GndD GndA PrSFBp OffBn PrBp OnBn pixRst[26] net55 net56 pixRst[27]
+ rowReadON[6] rowReadON[7] rowReadOFF[6] rowReadOFF[7] openDVS_pixel2x2
x910 DiffBn VDD RefrBp GndD GndA PrSFBp OffBn PrBp OnBn pixRst[28] net59 net60 pixRst[29]
+ rowReadON[6] rowReadON[7] rowReadOFF[6] rowReadOFF[7] openDVS_pixel2x2
x911 DiffBn VDD RefrBp GndD GndA PrSFBp OffBn PrBp OnBn pixRst[30] net63 net64 pixRst[31]
+ rowReadON[6] rowReadON[7] rowReadOFF[6] rowReadOFF[7] openDVS_pixel2x2
x912 DiffBn VDD RefrBp GndD GndA PrSFBp OffBn PrBp OnBn pixRst[32] net67 net68 pixRst[33]
+ rowReadON[6] rowReadON[7] rowReadOFF[6] rowReadOFF[7] openDVS_pixel2x2
x913 DiffBn VDD RefrBp GndD GndA PrSFBp OffBn PrBp OnBn pixRst[34] net71 net72 pixRst[35]
+ rowReadON[6] rowReadON[7] rowReadOFF[6] rowReadOFF[7] openDVS_pixel2x2
x914 DiffBn VDD RefrBp GndD GndA PrSFBp OffBn PrBp OnBn pixRst[36] net75 net76 pixRst[37]
+ rowReadON[6] rowReadON[7] rowReadOFF[6] rowReadOFF[7] openDVS_pixel2x2
x915 DiffBn VDD RefrBp GndD GndA PrSFBp OffBn PrBp OnBn pixRst[38] net79 net80 pixRst[39]
+ rowReadON[6] rowReadON[7] rowReadOFF[6] rowReadOFF[7] openDVS_pixel2x2
x916 DiffBn VDD RefrBp GndD GndA PrSFBp OffBn PrBp OnBn pixRst[40] net83 net84 pixRst[41]
+ rowReadON[6] rowReadON[7] rowReadOFF[6] rowReadOFF[7] openDVS_pixel2x2
x917 DiffBn VDD RefrBp GndD GndA PrSFBp OffBn PrBp OnBn pixRst[42] net87 net88 pixRst[43]
+ rowReadON[6] rowReadON[7] rowReadOFF[6] rowReadOFF[7] openDVS_pixel2x2
x918 DiffBn VDD RefrBp GndD GndA PrSFBp OffBn PrBp OnBn pixRst[44] net91 net92 pixRst[45]
+ rowReadON[6] rowReadON[7] rowReadOFF[6] rowReadOFF[7] openDVS_pixel2x2
x919 DiffBn VDD RefrBp GndD GndA PrSFBp OffBn PrBp OnBn pixRst[46] net95 net96 pixRst[47]
+ rowReadON[6] rowReadON[7] rowReadOFF[6] rowReadOFF[7] openDVS_pixel2x2
x920 DiffBn VDD RefrBp GndD GndA PrSFBp OffBn PrBp OnBn pixRst[48] net99 net100 pixRst[49]
+ rowReadON[6] rowReadON[7] rowReadOFF[6] rowReadOFF[7] openDVS_pixel2x2
x921 DiffBn VDD RefrBp GndD GndA PrSFBp OffBn PrBp OnBn pixRst[50] net103 net104 pixRst[51]
+ rowReadON[6] rowReadON[7] rowReadOFF[6] rowReadOFF[7] openDVS_pixel2x2
x922 DiffBn VDD RefrBp GndD GndA PrSFBp OffBn PrBp OnBn pixRst[52] net107 net108 pixRst[53]
+ rowReadON[6] rowReadON[7] rowReadOFF[6] rowReadOFF[7] openDVS_pixel2x2
x923 DiffBn VDD RefrBp GndD GndA PrSFBp OffBn PrBp OnBn pixRst[54] net111 net112 pixRst[55]
+ rowReadON[6] rowReadON[7] rowReadOFF[6] rowReadOFF[7] openDVS_pixel2x2
x924 DiffBn VDD RefrBp GndD GndA PrSFBp OffBn PrBp OnBn pixRst[56] net115 net116 pixRst[57]
+ rowReadON[6] rowReadON[7] rowReadOFF[6] rowReadOFF[7] openDVS_pixel2x2
x925 DiffBn VDD RefrBp GndD GndA PrSFBp OffBn PrBp OnBn pixRst[58] net119 net120 pixRst[59]
+ rowReadON[6] rowReadON[7] rowReadOFF[6] rowReadOFF[7] openDVS_pixel2x2
x926 DiffBn VDD RefrBp GndD GndA PrSFBp OffBn PrBp OnBn pixRst[60] net123 net124 pixRst[61]
+ rowReadON[6] rowReadON[7] rowReadOFF[6] rowReadOFF[7] openDVS_pixel2x2
x927 DiffBn VDD RefrBp GndD GndA PrSFBp OffBn PrBp OnBn pixRst[62] net127 net128 pixRst[63]
+ rowReadON[6] rowReadON[7] rowReadOFF[6] rowReadOFF[7] openDVS_pixel2x2
x928 DiffBn VDD RefrBp GndD GndA PrSFBp OffBn PrBp OnBn pixRst[0] net3 net4 pixRst[1] rowReadON[4]
+ rowReadON[5] rowReadOFF[4] rowReadOFF[5] openDVS_pixel2x2
x929 DiffBn VDD RefrBp GndD GndA PrSFBp OffBn PrBp OnBn pixRst[2] net7 net8 pixRst[3] rowReadON[4]
+ rowReadON[5] rowReadOFF[4] rowReadOFF[5] openDVS_pixel2x2
x930 DiffBn VDD RefrBp GndD GndA PrSFBp OffBn PrBp OnBn pixRst[4] net11 net12 pixRst[5] rowReadON[4]
+ rowReadON[5] rowReadOFF[4] rowReadOFF[5] openDVS_pixel2x2
x931 DiffBn VDD RefrBp GndD GndA PrSFBp OffBn PrBp OnBn pixRst[6] net15 net16 pixRst[7] rowReadON[4]
+ rowReadON[5] rowReadOFF[4] rowReadOFF[5] openDVS_pixel2x2
x932 DiffBn VDD RefrBp GndD GndA PrSFBp OffBn PrBp OnBn pixRst[8] net19 net20 pixRst[9] rowReadON[4]
+ rowReadON[5] rowReadOFF[4] rowReadOFF[5] openDVS_pixel2x2
x933 DiffBn VDD RefrBp GndD GndA PrSFBp OffBn PrBp OnBn pixRst[10] net23 net24 pixRst[11]
+ rowReadON[4] rowReadON[5] rowReadOFF[4] rowReadOFF[5] openDVS_pixel2x2
x934 DiffBn VDD RefrBp GndD GndA PrSFBp OffBn PrBp OnBn pixRst[12] net27 net28 pixRst[13]
+ rowReadON[4] rowReadON[5] rowReadOFF[4] rowReadOFF[5] openDVS_pixel2x2
x935 DiffBn VDD RefrBp GndD GndA PrSFBp OffBn PrBp OnBn pixRst[14] net31 net32 pixRst[15]
+ rowReadON[4] rowReadON[5] rowReadOFF[4] rowReadOFF[5] openDVS_pixel2x2
x936 DiffBn VDD RefrBp GndD GndA PrSFBp OffBn PrBp OnBn pixRst[16] net35 net36 pixRst[17]
+ rowReadON[4] rowReadON[5] rowReadOFF[4] rowReadOFF[5] openDVS_pixel2x2
x937 DiffBn VDD RefrBp GndD GndA PrSFBp OffBn PrBp OnBn pixRst[18] net39 net40 pixRst[19]
+ rowReadON[4] rowReadON[5] rowReadOFF[4] rowReadOFF[5] openDVS_pixel2x2
x938 DiffBn VDD RefrBp GndD GndA PrSFBp OffBn PrBp OnBn pixRst[20] net43 net44 pixRst[21]
+ rowReadON[4] rowReadON[5] rowReadOFF[4] rowReadOFF[5] openDVS_pixel2x2
x939 DiffBn VDD RefrBp GndD GndA PrSFBp OffBn PrBp OnBn pixRst[22] net47 net48 pixRst[23]
+ rowReadON[4] rowReadON[5] rowReadOFF[4] rowReadOFF[5] openDVS_pixel2x2
x940 DiffBn VDD RefrBp GndD GndA PrSFBp OffBn PrBp OnBn pixRst[24] net51 net52 pixRst[25]
+ rowReadON[4] rowReadON[5] rowReadOFF[4] rowReadOFF[5] openDVS_pixel2x2
x941 DiffBn VDD RefrBp GndD GndA PrSFBp OffBn PrBp OnBn pixRst[26] net55 net56 pixRst[27]
+ rowReadON[4] rowReadON[5] rowReadOFF[4] rowReadOFF[5] openDVS_pixel2x2
x942 DiffBn VDD RefrBp GndD GndA PrSFBp OffBn PrBp OnBn pixRst[28] net59 net60 pixRst[29]
+ rowReadON[4] rowReadON[5] rowReadOFF[4] rowReadOFF[5] openDVS_pixel2x2
x943 DiffBn VDD RefrBp GndD GndA PrSFBp OffBn PrBp OnBn pixRst[30] net63 net64 pixRst[31]
+ rowReadON[4] rowReadON[5] rowReadOFF[4] rowReadOFF[5] openDVS_pixel2x2
x944 DiffBn VDD RefrBp GndD GndA PrSFBp OffBn PrBp OnBn pixRst[32] net67 net68 pixRst[33]
+ rowReadON[4] rowReadON[5] rowReadOFF[4] rowReadOFF[5] openDVS_pixel2x2
x945 DiffBn VDD RefrBp GndD GndA PrSFBp OffBn PrBp OnBn pixRst[34] net71 net72 pixRst[35]
+ rowReadON[4] rowReadON[5] rowReadOFF[4] rowReadOFF[5] openDVS_pixel2x2
x946 DiffBn VDD RefrBp GndD GndA PrSFBp OffBn PrBp OnBn pixRst[36] net75 net76 pixRst[37]
+ rowReadON[4] rowReadON[5] rowReadOFF[4] rowReadOFF[5] openDVS_pixel2x2
x947 DiffBn VDD RefrBp GndD GndA PrSFBp OffBn PrBp OnBn pixRst[38] net79 net80 pixRst[39]
+ rowReadON[4] rowReadON[5] rowReadOFF[4] rowReadOFF[5] openDVS_pixel2x2
x948 DiffBn VDD RefrBp GndD GndA PrSFBp OffBn PrBp OnBn pixRst[40] net83 net84 pixRst[41]
+ rowReadON[4] rowReadON[5] rowReadOFF[4] rowReadOFF[5] openDVS_pixel2x2
x949 DiffBn VDD RefrBp GndD GndA PrSFBp OffBn PrBp OnBn pixRst[42] net87 net88 pixRst[43]
+ rowReadON[4] rowReadON[5] rowReadOFF[4] rowReadOFF[5] openDVS_pixel2x2
x950 DiffBn VDD RefrBp GndD GndA PrSFBp OffBn PrBp OnBn pixRst[44] net91 net92 pixRst[45]
+ rowReadON[4] rowReadON[5] rowReadOFF[4] rowReadOFF[5] openDVS_pixel2x2
x951 DiffBn VDD RefrBp GndD GndA PrSFBp OffBn PrBp OnBn pixRst[46] net95 net96 pixRst[47]
+ rowReadON[4] rowReadON[5] rowReadOFF[4] rowReadOFF[5] openDVS_pixel2x2
x952 DiffBn VDD RefrBp GndD GndA PrSFBp OffBn PrBp OnBn pixRst[48] net99 net100 pixRst[49]
+ rowReadON[4] rowReadON[5] rowReadOFF[4] rowReadOFF[5] openDVS_pixel2x2
x953 DiffBn VDD RefrBp GndD GndA PrSFBp OffBn PrBp OnBn pixRst[50] net103 net104 pixRst[51]
+ rowReadON[4] rowReadON[5] rowReadOFF[4] rowReadOFF[5] openDVS_pixel2x2
x954 DiffBn VDD RefrBp GndD GndA PrSFBp OffBn PrBp OnBn pixRst[52] net107 net108 pixRst[53]
+ rowReadON[4] rowReadON[5] rowReadOFF[4] rowReadOFF[5] openDVS_pixel2x2
x955 DiffBn VDD RefrBp GndD GndA PrSFBp OffBn PrBp OnBn pixRst[54] net111 net112 pixRst[55]
+ rowReadON[4] rowReadON[5] rowReadOFF[4] rowReadOFF[5] openDVS_pixel2x2
x956 DiffBn VDD RefrBp GndD GndA PrSFBp OffBn PrBp OnBn pixRst[56] net115 net116 pixRst[57]
+ rowReadON[4] rowReadON[5] rowReadOFF[4] rowReadOFF[5] openDVS_pixel2x2
x957 DiffBn VDD RefrBp GndD GndA PrSFBp OffBn PrBp OnBn pixRst[58] net119 net120 pixRst[59]
+ rowReadON[4] rowReadON[5] rowReadOFF[4] rowReadOFF[5] openDVS_pixel2x2
x958 DiffBn VDD RefrBp GndD GndA PrSFBp OffBn PrBp OnBn pixRst[60] net123 net124 pixRst[61]
+ rowReadON[4] rowReadON[5] rowReadOFF[4] rowReadOFF[5] openDVS_pixel2x2
x959 DiffBn VDD RefrBp GndD GndA PrSFBp OffBn PrBp OnBn pixRst[62] net127 net128 pixRst[63]
+ rowReadON[4] rowReadON[5] rowReadOFF[4] rowReadOFF[5] openDVS_pixel2x2
x960 DiffBn VDD RefrBp GndD GndA PrSFBp OffBn PrBp OnBn pixRst[0] net3 net4 pixRst[1] rowReadON[2]
+ rowReadON[3] rowReadOFF[2] rowReadOFF[3] openDVS_pixel2x2
x961 DiffBn VDD RefrBp GndD GndA PrSFBp OffBn PrBp OnBn pixRst[2] net7 net8 pixRst[3] rowReadON[2]
+ rowReadON[3] rowReadOFF[2] rowReadOFF[3] openDVS_pixel2x2
x962 DiffBn VDD RefrBp GndD GndA PrSFBp OffBn PrBp OnBn pixRst[4] net11 net12 pixRst[5] rowReadON[2]
+ rowReadON[3] rowReadOFF[2] rowReadOFF[3] openDVS_pixel2x2
x963 DiffBn VDD RefrBp GndD GndA PrSFBp OffBn PrBp OnBn pixRst[6] net15 net16 pixRst[7] rowReadON[2]
+ rowReadON[3] rowReadOFF[2] rowReadOFF[3] openDVS_pixel2x2
x964 DiffBn VDD RefrBp GndD GndA PrSFBp OffBn PrBp OnBn pixRst[8] net19 net20 pixRst[9] rowReadON[2]
+ rowReadON[3] rowReadOFF[2] rowReadOFF[3] openDVS_pixel2x2
x965 DiffBn VDD RefrBp GndD GndA PrSFBp OffBn PrBp OnBn pixRst[10] net23 net24 pixRst[11]
+ rowReadON[2] rowReadON[3] rowReadOFF[2] rowReadOFF[3] openDVS_pixel2x2
x966 DiffBn VDD RefrBp GndD GndA PrSFBp OffBn PrBp OnBn pixRst[12] net27 net28 pixRst[13]
+ rowReadON[2] rowReadON[3] rowReadOFF[2] rowReadOFF[3] openDVS_pixel2x2
x967 DiffBn VDD RefrBp GndD GndA PrSFBp OffBn PrBp OnBn pixRst[14] net31 net32 pixRst[15]
+ rowReadON[2] rowReadON[3] rowReadOFF[2] rowReadOFF[3] openDVS_pixel2x2
x968 DiffBn VDD RefrBp GndD GndA PrSFBp OffBn PrBp OnBn pixRst[16] net35 net36 pixRst[17]
+ rowReadON[2] rowReadON[3] rowReadOFF[2] rowReadOFF[3] openDVS_pixel2x2
x969 DiffBn VDD RefrBp GndD GndA PrSFBp OffBn PrBp OnBn pixRst[18] net39 net40 pixRst[19]
+ rowReadON[2] rowReadON[3] rowReadOFF[2] rowReadOFF[3] openDVS_pixel2x2
x970 DiffBn VDD RefrBp GndD GndA PrSFBp OffBn PrBp OnBn pixRst[20] net43 net44 pixRst[21]
+ rowReadON[2] rowReadON[3] rowReadOFF[2] rowReadOFF[3] openDVS_pixel2x2
x971 DiffBn VDD RefrBp GndD GndA PrSFBp OffBn PrBp OnBn pixRst[22] net47 net48 pixRst[23]
+ rowReadON[2] rowReadON[3] rowReadOFF[2] rowReadOFF[3] openDVS_pixel2x2
x972 DiffBn VDD RefrBp GndD GndA PrSFBp OffBn PrBp OnBn pixRst[24] net51 net52 pixRst[25]
+ rowReadON[2] rowReadON[3] rowReadOFF[2] rowReadOFF[3] openDVS_pixel2x2
x973 DiffBn VDD RefrBp GndD GndA PrSFBp OffBn PrBp OnBn pixRst[26] net55 net56 pixRst[27]
+ rowReadON[2] rowReadON[3] rowReadOFF[2] rowReadOFF[3] openDVS_pixel2x2
x974 DiffBn VDD RefrBp GndD GndA PrSFBp OffBn PrBp OnBn pixRst[28] net59 net60 pixRst[29]
+ rowReadON[2] rowReadON[3] rowReadOFF[2] rowReadOFF[3] openDVS_pixel2x2
x975 DiffBn VDD RefrBp GndD GndA PrSFBp OffBn PrBp OnBn pixRst[30] net63 net64 pixRst[31]
+ rowReadON[2] rowReadON[3] rowReadOFF[2] rowReadOFF[3] openDVS_pixel2x2
x976 DiffBn VDD RefrBp GndD GndA PrSFBp OffBn PrBp OnBn pixRst[32] net67 net68 pixRst[33]
+ rowReadON[2] rowReadON[3] rowReadOFF[2] rowReadOFF[3] openDVS_pixel2x2
x977 DiffBn VDD RefrBp GndD GndA PrSFBp OffBn PrBp OnBn pixRst[34] net71 net72 pixRst[35]
+ rowReadON[2] rowReadON[3] rowReadOFF[2] rowReadOFF[3] openDVS_pixel2x2
x978 DiffBn VDD RefrBp GndD GndA PrSFBp OffBn PrBp OnBn pixRst[36] net75 net76 pixRst[37]
+ rowReadON[2] rowReadON[3] rowReadOFF[2] rowReadOFF[3] openDVS_pixel2x2
x979 DiffBn VDD RefrBp GndD GndA PrSFBp OffBn PrBp OnBn pixRst[38] net79 net80 pixRst[39]
+ rowReadON[2] rowReadON[3] rowReadOFF[2] rowReadOFF[3] openDVS_pixel2x2
x980 DiffBn VDD RefrBp GndD GndA PrSFBp OffBn PrBp OnBn pixRst[40] net83 net84 pixRst[41]
+ rowReadON[2] rowReadON[3] rowReadOFF[2] rowReadOFF[3] openDVS_pixel2x2
x981 DiffBn VDD RefrBp GndD GndA PrSFBp OffBn PrBp OnBn pixRst[42] net87 net88 pixRst[43]
+ rowReadON[2] rowReadON[3] rowReadOFF[2] rowReadOFF[3] openDVS_pixel2x2
x982 DiffBn VDD RefrBp GndD GndA PrSFBp OffBn PrBp OnBn pixRst[44] net91 net92 pixRst[45]
+ rowReadON[2] rowReadON[3] rowReadOFF[2] rowReadOFF[3] openDVS_pixel2x2
x983 DiffBn VDD RefrBp GndD GndA PrSFBp OffBn PrBp OnBn pixRst[46] net95 net96 pixRst[47]
+ rowReadON[2] rowReadON[3] rowReadOFF[2] rowReadOFF[3] openDVS_pixel2x2
x984 DiffBn VDD RefrBp GndD GndA PrSFBp OffBn PrBp OnBn pixRst[48] net99 net100 pixRst[49]
+ rowReadON[2] rowReadON[3] rowReadOFF[2] rowReadOFF[3] openDVS_pixel2x2
x985 DiffBn VDD RefrBp GndD GndA PrSFBp OffBn PrBp OnBn pixRst[50] net103 net104 pixRst[51]
+ rowReadON[2] rowReadON[3] rowReadOFF[2] rowReadOFF[3] openDVS_pixel2x2
x986 DiffBn VDD RefrBp GndD GndA PrSFBp OffBn PrBp OnBn pixRst[52] net107 net108 pixRst[53]
+ rowReadON[2] rowReadON[3] rowReadOFF[2] rowReadOFF[3] openDVS_pixel2x2
x987 DiffBn VDD RefrBp GndD GndA PrSFBp OffBn PrBp OnBn pixRst[54] net111 net112 pixRst[55]
+ rowReadON[2] rowReadON[3] rowReadOFF[2] rowReadOFF[3] openDVS_pixel2x2
x988 DiffBn VDD RefrBp GndD GndA PrSFBp OffBn PrBp OnBn pixRst[56] net115 net116 pixRst[57]
+ rowReadON[2] rowReadON[3] rowReadOFF[2] rowReadOFF[3] openDVS_pixel2x2
x989 DiffBn VDD RefrBp GndD GndA PrSFBp OffBn PrBp OnBn pixRst[58] net119 net120 pixRst[59]
+ rowReadON[2] rowReadON[3] rowReadOFF[2] rowReadOFF[3] openDVS_pixel2x2
x990 DiffBn VDD RefrBp GndD GndA PrSFBp OffBn PrBp OnBn pixRst[60] net123 net124 pixRst[61]
+ rowReadON[2] rowReadON[3] rowReadOFF[2] rowReadOFF[3] openDVS_pixel2x2
x991 DiffBn VDD RefrBp GndD GndA PrSFBp OffBn PrBp OnBn pixRst[62] net127 net128 pixRst[63]
+ rowReadON[2] rowReadON[3] rowReadOFF[2] rowReadOFF[3] openDVS_pixel2x2
x992 DiffBn VDD RefrBp GndD GndA PrSFBp OffBn PrBp OnBn pixRst[0] net3 net4 pixRst[1] rowReadON[0]
+ rowReadON[1] rowReadOFF[0] rowReadOFF[1] openDVS_pixel2x2
x993 DiffBn VDD RefrBp GndD GndA PrSFBp OffBn PrBp OnBn pixRst[2] net7 net8 pixRst[3] rowReadON[0]
+ rowReadON[1] rowReadOFF[0] rowReadOFF[1] openDVS_pixel2x2
x994 DiffBn VDD RefrBp GndD GndA PrSFBp OffBn PrBp OnBn pixRst[4] net11 net12 pixRst[5] rowReadON[0]
+ rowReadON[1] rowReadOFF[0] rowReadOFF[1] openDVS_pixel2x2
x995 DiffBn VDD RefrBp GndD GndA PrSFBp OffBn PrBp OnBn pixRst[6] net15 net16 pixRst[7] rowReadON[0]
+ rowReadON[1] rowReadOFF[0] rowReadOFF[1] openDVS_pixel2x2
x996 DiffBn VDD RefrBp GndD GndA PrSFBp OffBn PrBp OnBn pixRst[8] net19 net20 pixRst[9] rowReadON[0]
+ rowReadON[1] rowReadOFF[0] rowReadOFF[1] openDVS_pixel2x2
x997 DiffBn VDD RefrBp GndD GndA PrSFBp OffBn PrBp OnBn pixRst[10] net23 net24 pixRst[11]
+ rowReadON[0] rowReadON[1] rowReadOFF[0] rowReadOFF[1] openDVS_pixel2x2
x998 DiffBn VDD RefrBp GndD GndA PrSFBp OffBn PrBp OnBn pixRst[12] net27 net28 pixRst[13]
+ rowReadON[0] rowReadON[1] rowReadOFF[0] rowReadOFF[1] openDVS_pixel2x2
x999 DiffBn VDD RefrBp GndD GndA PrSFBp OffBn PrBp OnBn pixRst[14] net31 net32 pixRst[15]
+ rowReadON[0] rowReadON[1] rowReadOFF[0] rowReadOFF[1] openDVS_pixel2x2
x1000 DiffBn VDD RefrBp GndD GndA PrSFBp OffBn PrBp OnBn pixRst[16] net35 net36 pixRst[17]
+ rowReadON[0] rowReadON[1] rowReadOFF[0] rowReadOFF[1] openDVS_pixel2x2
x1001 DiffBn VDD RefrBp GndD GndA PrSFBp OffBn PrBp OnBn pixRst[18] net39 net40 pixRst[19]
+ rowReadON[0] rowReadON[1] rowReadOFF[0] rowReadOFF[1] openDVS_pixel2x2
x1002 DiffBn VDD RefrBp GndD GndA PrSFBp OffBn PrBp OnBn pixRst[20] net43 net44 pixRst[21]
+ rowReadON[0] rowReadON[1] rowReadOFF[0] rowReadOFF[1] openDVS_pixel2x2
x1003 DiffBn VDD RefrBp GndD GndA PrSFBp OffBn PrBp OnBn pixRst[22] net47 net48 pixRst[23]
+ rowReadON[0] rowReadON[1] rowReadOFF[0] rowReadOFF[1] openDVS_pixel2x2
x1004 DiffBn VDD RefrBp GndD GndA PrSFBp OffBn PrBp OnBn pixRst[24] net51 net52 pixRst[25]
+ rowReadON[0] rowReadON[1] rowReadOFF[0] rowReadOFF[1] openDVS_pixel2x2
x1005 DiffBn VDD RefrBp GndD GndA PrSFBp OffBn PrBp OnBn pixRst[26] net55 net56 pixRst[27]
+ rowReadON[0] rowReadON[1] rowReadOFF[0] rowReadOFF[1] openDVS_pixel2x2
x1006 DiffBn VDD RefrBp GndD GndA PrSFBp OffBn PrBp OnBn pixRst[28] net59 net60 pixRst[29]
+ rowReadON[0] rowReadON[1] rowReadOFF[0] rowReadOFF[1] openDVS_pixel2x2
x1007 DiffBn VDD RefrBp GndD GndA PrSFBp OffBn PrBp OnBn pixRst[30] net63 net64 pixRst[31]
+ rowReadON[0] rowReadON[1] rowReadOFF[0] rowReadOFF[1] openDVS_pixel2x2
x1008 DiffBn VDD RefrBp GndD GndA PrSFBp OffBn PrBp OnBn pixRst[32] net67 net68 pixRst[33]
+ rowReadON[0] rowReadON[1] rowReadOFF[0] rowReadOFF[1] openDVS_pixel2x2
x1009 DiffBn VDD RefrBp GndD GndA PrSFBp OffBn PrBp OnBn pixRst[34] net71 net72 pixRst[35]
+ rowReadON[0] rowReadON[1] rowReadOFF[0] rowReadOFF[1] openDVS_pixel2x2
x1010 DiffBn VDD RefrBp GndD GndA PrSFBp OffBn PrBp OnBn pixRst[36] net75 net76 pixRst[37]
+ rowReadON[0] rowReadON[1] rowReadOFF[0] rowReadOFF[1] openDVS_pixel2x2
x1011 DiffBn VDD RefrBp GndD GndA PrSFBp OffBn PrBp OnBn pixRst[38] net79 net80 pixRst[39]
+ rowReadON[0] rowReadON[1] rowReadOFF[0] rowReadOFF[1] openDVS_pixel2x2
x1012 DiffBn VDD RefrBp GndD GndA PrSFBp OffBn PrBp OnBn pixRst[40] net83 net84 pixRst[41]
+ rowReadON[0] rowReadON[1] rowReadOFF[0] rowReadOFF[1] openDVS_pixel2x2
x1013 DiffBn VDD RefrBp GndD GndA PrSFBp OffBn PrBp OnBn pixRst[42] net87 net88 pixRst[43]
+ rowReadON[0] rowReadON[1] rowReadOFF[0] rowReadOFF[1] openDVS_pixel2x2
x1014 DiffBn VDD RefrBp GndD GndA PrSFBp OffBn PrBp OnBn pixRst[44] net91 net92 pixRst[45]
+ rowReadON[0] rowReadON[1] rowReadOFF[0] rowReadOFF[1] openDVS_pixel2x2
x1015 DiffBn VDD RefrBp GndD GndA PrSFBp OffBn PrBp OnBn pixRst[46] net95 net96 pixRst[47]
+ rowReadON[0] rowReadON[1] rowReadOFF[0] rowReadOFF[1] openDVS_pixel2x2
x1016 DiffBn VDD RefrBp GndD GndA PrSFBp OffBn PrBp OnBn pixRst[48] net99 net100 pixRst[49]
+ rowReadON[0] rowReadON[1] rowReadOFF[0] rowReadOFF[1] openDVS_pixel2x2
x1017 DiffBn VDD RefrBp GndD GndA PrSFBp OffBn PrBp OnBn pixRst[50] net103 net104 pixRst[51]
+ rowReadON[0] rowReadON[1] rowReadOFF[0] rowReadOFF[1] openDVS_pixel2x2
x1018 DiffBn VDD RefrBp GndD GndA PrSFBp OffBn PrBp OnBn pixRst[52] net107 net108 pixRst[53]
+ rowReadON[0] rowReadON[1] rowReadOFF[0] rowReadOFF[1] openDVS_pixel2x2
x1019 DiffBn VDD RefrBp GndD GndA PrSFBp OffBn PrBp OnBn pixRst[54] net111 net112 pixRst[55]
+ rowReadON[0] rowReadON[1] rowReadOFF[0] rowReadOFF[1] openDVS_pixel2x2
x1020 DiffBn VDD RefrBp GndD GndA PrSFBp OffBn PrBp OnBn pixRst[56] net115 net116 pixRst[57]
+ rowReadON[0] rowReadON[1] rowReadOFF[0] rowReadOFF[1] openDVS_pixel2x2
x1021 DiffBn VDD RefrBp GndD GndA PrSFBp OffBn PrBp OnBn pixRst[58] net119 net120 pixRst[59]
+ rowReadON[0] rowReadON[1] rowReadOFF[0] rowReadOFF[1] openDVS_pixel2x2
x1022 DiffBn VDD RefrBp GndD GndA PrSFBp OffBn PrBp OnBn pixRst[60] net123 net124 pixRst[61]
+ rowReadON[0] rowReadON[1] rowReadOFF[0] rowReadOFF[1] openDVS_pixel2x2
x1023 DiffBn VDD RefrBp GndD GndA PrSFBp OffBn PrBp OnBn pixRst[62] net127 net128 pixRst[63]
+ rowReadON[0] rowReadON[1] rowReadOFF[0] rowReadOFF[1] openDVS_pixel2x2
x1024 DETECT nDETECT VTHRESH nCHARGE VDD GndA net3 net4 voutn[0] voutn[1] pixRst[0] pixRst[1]
+ col_amp_2x1
x1025 DETECT nDETECT VTHRESH nCHARGE VDD GndA net7 net8 voutn[2] voutn[3] pixRst[2] pixRst[3]
+ col_amp_2x1
x1026 DETECT nDETECT VTHRESH nCHARGE VDD GndA net11 net12 voutn[4] voutn[5] pixRst[4] pixRst[5]
+ col_amp_2x1
x1027 DETECT nDETECT VTHRESH nCHARGE VDD GndA net15 net16 voutn[6] voutn[7] pixRst[6] pixRst[7]
+ col_amp_2x1
x1028 DETECT nDETECT VTHRESH nCHARGE VDD GndA net19 net20 voutn[8] voutn[9] pixRst[8] pixRst[9]
+ col_amp_2x1
x1029 DETECT nDETECT VTHRESH nCHARGE VDD GndA net23 net24 voutn[10] voutn[11] pixRst[10] pixRst[11]
+ col_amp_2x1
x1030 DETECT nDETECT VTHRESH nCHARGE VDD GndA net27 net28 voutn[12] voutn[13] pixRst[12] pixRst[13]
+ col_amp_2x1
x1031 DETECT nDETECT VTHRESH nCHARGE VDD GndA net31 net32 voutn[14] voutn[15] pixRst[14] pixRst[15]
+ col_amp_2x1
x1032 DETECT nDETECT VTHRESH nCHARGE VDD GndA net35 net36 voutn[16] voutn[17] pixRst[16] pixRst[17]
+ col_amp_2x1
x1033 DETECT nDETECT VTHRESH nCHARGE VDD GndA net39 net40 voutn[18] voutn[19] pixRst[18] pixRst[19]
+ col_amp_2x1
x1034 DETECT nDETECT VTHRESH nCHARGE VDD GndA net43 net44 voutn[20] voutn[21] pixRst[20] pixRst[21]
+ col_amp_2x1
x1035 DETECT nDETECT VTHRESH nCHARGE VDD GndA net47 net48 voutn[22] voutn[23] pixRst[22] pixRst[23]
+ col_amp_2x1
x1036 DETECT nDETECT VTHRESH nCHARGE VDD GndA net51 net52 voutn[24] voutn[25] pixRst[24] pixRst[25]
+ col_amp_2x1
x1037 DETECT nDETECT VTHRESH nCHARGE VDD GndA net55 net56 voutn[26] voutn[27] pixRst[26] pixRst[27]
+ col_amp_2x1
x1038 DETECT nDETECT VTHRESH nCHARGE VDD GndA net59 net60 voutn[28] voutn[29] pixRst[28] pixRst[29]
+ col_amp_2x1
x1039 DETECT nDETECT VTHRESH nCHARGE VDD GndA net63 net64 voutn[30] voutn[31] pixRst[30] pixRst[31]
+ col_amp_2x1
x1040 DETECT nDETECT VTHRESH nCHARGE VDD GndA net67 net68 voutn[32] voutn[33] pixRst[32] pixRst[33]
+ col_amp_2x1
x1041 DETECT nDETECT VTHRESH nCHARGE VDD GndA net71 net72 voutn[34] voutn[35] pixRst[34] pixRst[35]
+ col_amp_2x1
x1042 DETECT nDETECT VTHRESH nCHARGE VDD GndA net75 net76 voutn[36] voutn[37] pixRst[36] pixRst[37]
+ col_amp_2x1
x1043 DETECT nDETECT VTHRESH nCHARGE VDD GndA net79 net80 voutn[38] voutn[39] pixRst[38] pixRst[39]
+ col_amp_2x1
x1044 DETECT nDETECT VTHRESH nCHARGE VDD GndA net83 net84 voutn[40] voutn[41] pixRst[40] pixRst[41]
+ col_amp_2x1
x1045 DETECT nDETECT VTHRESH nCHARGE VDD GndA net87 net88 voutn[42] voutn[43] pixRst[42] pixRst[43]
+ col_amp_2x1
x1046 DETECT nDETECT VTHRESH nCHARGE VDD GndA net91 net92 voutn[44] voutn[45] pixRst[44] pixRst[45]
+ col_amp_2x1
x1047 DETECT nDETECT VTHRESH nCHARGE VDD GndA net95 net96 voutn[46] voutn[47] pixRst[46] pixRst[47]
+ col_amp_2x1
x1048 DETECT nDETECT VTHRESH nCHARGE VDD GndA net99 net100 voutn[48] voutn[49] pixRst[48] pixRst[49]
+ col_amp_2x1
x1049 DETECT nDETECT VTHRESH nCHARGE VDD GndA net103 net104 voutn[50] voutn[51] pixRst[50]
+ pixRst[51] col_amp_2x1
x1050 DETECT nDETECT VTHRESH nCHARGE VDD GndA net107 net108 voutn[52] voutn[53] pixRst[52]
+ pixRst[53] col_amp_2x1
x1051 DETECT nDETECT VTHRESH nCHARGE VDD GndA net111 net112 voutn[54] voutn[55] pixRst[54]
+ pixRst[55] col_amp_2x1
x1052 DETECT nDETECT VTHRESH nCHARGE VDD GndA net115 net116 voutn[56] voutn[57] pixRst[56]
+ pixRst[57] col_amp_2x1
x1053 DETECT nDETECT VTHRESH nCHARGE VDD GndA net119 net120 voutn[58] voutn[59] pixRst[58]
+ pixRst[59] col_amp_2x1
x1054 DETECT nDETECT VTHRESH nCHARGE VDD GndA net123 net124 voutn[60] voutn[61] pixRst[60]
+ pixRst[61] col_amp_2x1
x1055 DETECT nDETECT VTHRESH nCHARGE VDD GndA net127 net128 voutn[62] voutn[63] pixRst[62]
+ pixRst[63] col_amp_2x1
.ends

* expanding   symbol:  openDVS_pixel2x2.sym # of pins=52
** sym_path: /home/alienfalcon/Projects/skywater/open_dvs_py312/open_dvs/git_dvs/nic2025_openDVS/analog/xschem/openDVS_pixel2x2.sym
** sch_path: /home/alienfalcon/Projects/skywater/open_dvs_py312/open_dvs/git_dvs/nic2025_openDVS/analog/xschem/openDVS_pixel2x2.sch
.subckt openDVS_pixel2x2 DiffBn Vdd18A RefrBp GndD GndA PrSFBp OffBn PrBp OnBn pixRst[0] readLine[0] readLine[1] pixRst[1] rowReadON[0] rowReadON[1] rowReadOFF[0] rowReadOFF[1]
*.iopin GndD
*.iopin Vdd18A
*.iopin GndA
*.iopin OffBn
*.iopin OnBn
*.iopin DiffBn
*.iopin RefrBp
*.iopin PrSFBp
*.iopin PrBp
*.iopin readLine[0]
*.iopin readLine[1]
*.iopin pixRst[0]
*.iopin rowReadON[1]
*.iopin rowReadOFF[1]
*.iopin rowReadON[0]
*.iopin rowReadOFF[0]
*.iopin pixRst[1]
x1 rowReadON[0] Vdd18A PrBp GndA vpd00 rowReadOFF[0] pixRst[0] PrSFBp DiffBn OnBn OffBn RefrBp
+ readLine[0] GndD openDVS_pixel
x2 rowReadON[0] Vdd18A PrBp GndA vpd01 rowReadOFF[0] pixRst[1] PrSFBp DiffBn OnBn OffBn RefrBp
+ readLine[1] GndD openDVS_pixel
x3 rowReadON[1] Vdd18A PrBp GndA vpd10 rowReadOFF[1] pixRst[0] PrSFBp DiffBn OnBn OffBn RefrBp
+ readLine[0] GndD openDVS_pixel
x4 rowReadON[1] Vdd18A PrBp GndA vpd11 rowReadOFF[1] pixRst[1] PrSFBp DiffBn OnBn OffBn RefrBp
+ readLine[1] GndD openDVS_pixel
.ends

* expanding   symbol:  col_amp_2x1.sym # of pins=20
** sym_path: /home/alienfalcon/Projects/skywater/open_dvs_py312/open_dvs/git_dvs/nic2025_openDVS/analog/xschem/col_amp_2x1.sym
** sch_path: /home/alienfalcon/Projects/skywater/open_dvs_py312/open_dvs/git_dvs/nic2025_openDVS/analog/xschem/col_amp_2x1.sch
.subckt col_amp_2x1 DETECT nDETECT VTHRESH nCHARGE VDD GND readLine[0] readLine[1] voutn[0] voutn[1] pixRst[0] pixRst[1]
*.iopin nCHARGE
*.iopin VDD
*.iopin GND
*.iopin readLine[0]
*.iopin readLine[1]
*.iopin VTHRESH
*.iopin voutn[0]
*.iopin voutn[1]
*.iopin nDETECT
*.iopin DETECT
*.iopin pixRst[0]
*.iopin pixRst[1]
x1 VDD COL_OUT0 VTHRESH GND nDETECT DETECT voutp[0] voutn[0] dyn_comp
x2 VDD nCHARGE COL_OUT0 GND readLine[0] col_amp
x3 VDD COL_OUT1 VTHRESH GND nDETECT DETECT voutp[1] voutn[1] dyn_comp
x4 VDD nCHARGE COL_OUT1 GND readLine[1] col_amp
.ends

* expanding   symbol:  openDVS_pixel.sym # of pins=14
** sym_path: /home/alienfalcon/Projects/skywater/open_dvs_py312/open_dvs/git_dvs/nic2025_openDVS/analog/xschem/openDVS_pixel.sym
** sch_path: /home/alienfalcon/Projects/skywater/open_dvs_py312/open_dvs/git_dvs/nic2025_openDVS/analog/xschem/openDVS_pixel.sch
.subckt openDVS_pixel rowReadON VddA18 PrBp GndA vpd rowReadOFF pixRst PrSFBp DiffBn OnBn OffBn RefrBp readLine GndD
*.iopin vpd
*.iopin PrBp
*.iopin GndA
*.iopin VddA18
*.iopin PrSFBp
*.iopin DiffBn
*.iopin OnBn
*.iopin OffBn
*.iopin RefrBp
*.ipin pixRst
*.ipin rowReadON
*.ipin rowReadOFF
*.iopin readLine
*.iopin GndD
xpr VddA18 PrBp GndA vpd vpr PixelPhotoreceptor
xsf VddA18 PrSFBp GndA vpr vsf PixelSourceFollower
xchAmp VddA18 DiffBn GndA vsf vdiff nRst PixelChangeAmplifier
xcomp VddA18 OnBn GndA vdiff ON OffBn nOFF PixelComparators
xhandshake rowReadOFF GndA rowReadON readLine ON nOFF GndD PixelHandshake
xrst rowReadON GndA pixRst nRst RefrBp VddA18 PixelResetGen
.ends

* expanding   symbol:  col_amp_v2_std_dvs/xschem/dyn_comp.sym # of pins=8
** sym_path: /home/alienfalcon/Projects/skywater/open_dvs_py312/open_dvs/git_dvs/nic2025_openDVS/analog/xschem/col_amp_v2_std_dvs/xschem/dyn_comp.sym
** sch_path: /home/alienfalcon/Projects/skywater/open_dvs_py312/open_dvs/git_dvs/nic2025_openDVS/analog/xschem/col_amp_v2_std_dvs/xschem/dyn_comp.sch
.subckt dyn_comp vdd vp vm gnd nDETECT DETECT voutp voutn
*.iopin vdd
*.iopin gnd
*.ipin vp
*.ipin vm
*.ipin nDETECT
*.opin voutn
*.opin voutp
*.ipin DETECT
XMmirr3 int_outn DETECT vdd vdd sky130_fd_pr__pfet_01v8 L=0.5 W=1 nf=1 mult=1
XMdio2 int_outp DETECT vdd vdd sky130_fd_pr__pfet_01v8 L=0.5 W=1 nf=1 mult=1
XMinm3 int_outp vp vsource gnd sky130_fd_pr__nfet_01v8 L=0.15 W=1 nf=1 mult=1
XMinp3 int_outn vm vsource gnd sky130_fd_pr__nfet_01v8 L=0.15 W=1 nf=1 mult=1
XMbias1 vsource DETECT gnd gnd sky130_fd_pr__nfet_01v8 L=0.15 W=1 nf=1 mult=1
XMmirr4 net3 nDETECT vdd vdd sky130_fd_pr__pfet_01v8 L=0.5 W=1 nf=1 mult=1
XMmirr5 net2 net1 net3 vdd sky130_fd_pr__pfet_01v8 L=0.5 W=1 nf=1 mult=1
XMdio3 net1 net2 net3 vdd sky130_fd_pr__pfet_01v8 L=0.5 W=1 nf=1 mult=1
XMinp4 net1 net2 gnd gnd sky130_fd_pr__nfet_01v8 L=0.15 W=1 nf=1 mult=1
XMinm4 net2 net1 gnd gnd sky130_fd_pr__nfet_01v8 L=0.15 W=1 nf=1 mult=1
XMinm5 net1 int_outp gnd gnd sky130_fd_pr__nfet_01v8 L=0.15 W=1 nf=1 mult=4
XMinp5 net2 int_outn gnd gnd sky130_fd_pr__nfet_01v8 L=0.15 W=1 nf=1 mult=4
XMmirr1 voutp net2 vdd vdd sky130_fd_pr__pfet_01v8 L=1 W=2 nf=1 mult=1
XMinm1 voutp net2 gnd gnd sky130_fd_pr__nfet_01v8 L=1 W=1 nf=1 mult=1
XMmirr2 voutn net1 vdd vdd sky130_fd_pr__pfet_01v8 L=1 W=2 nf=1 mult=1
XMinm2 voutn net1 gnd gnd sky130_fd_pr__nfet_01v8 L=1 W=1 nf=1 mult=1
.ends

* expanding   symbol:  col_amp_v2_std_dvs/xschem/col_amp.sym # of pins=5
** sym_path: /home/alienfalcon/Projects/skywater/open_dvs_py312/open_dvs/git_dvs/nic2025_openDVS/analog/xschem/col_amp_v2_std_dvs/xschem/col_amp.sym
** sch_path: /home/alienfalcon/Projects/skywater/open_dvs_py312/open_dvs/git_dvs/nic2025_openDVS/analog/xschem/col_amp_v2_std_dvs/xschem/col_amp.sch
.subckt col_amp VDD nCHARGE COL_OUT GND COL_LINE
*.ipin nCHARGE
*.opin COL_OUT
*.iopin VDD
*.iopin GND
*.iopin COL_LINE
XM1 COL_OUT COL_OUT COL_LINE GND sky130_fd_pr__nfet_01v8 L=1 W=1 nf=1 mult=16
XM2 COL_OUT nCHARGE VDD VDD sky130_fd_pr__pfet_01v8 L=1 W=1 nf=1 mult=8
.ends

* expanding   symbol:  PixelPhotoreceptor.sym # of pins=5
** sym_path: /home/alienfalcon/Projects/skywater/open_dvs_py312/open_dvs/git_dvs/nic2025_openDVS/analog/xschem/PixelPhotoreceptor.sym
** sch_path: /home/alienfalcon/Projects/skywater/open_dvs_py312/open_dvs/git_dvs/nic2025_openDVS/analog/xschem/PixelPhotoreceptor.sch
.subckt PixelPhotoreceptor VddA18 PrBp GndA vpd vpr
*.iopin PrBp
*.iopin VddA18
*.iopin vpd
*.iopin GndA
*.iopin vpr
XMpd VddA18 vpr vpd GndA sky130_fd_pr__nfet_01v8 L=0.3 W=0.5 nf=1 mult=1
XMpr_amp vpr vpd GndA GndA sky130_fd_pr__nfet_01v8 L=0.3 W=0.42 nf=1 mult=1
XMprBias vpr PrBp VddA18 VddA18 sky130_fd_pr__pfet_01v8 L=0.15 W=0.5 nf=1 mult=1
XD1 GndA vpd sky130_fd_pr__model__parasitic__diode_ps2dn area=1e12 perim=4e6
.ends

* expanding   symbol:  PixelSourceFollower.sym # of pins=5
** sym_path: /home/alienfalcon/Projects/skywater/open_dvs_py312/open_dvs/git_dvs/nic2025_openDVS/analog/xschem/PixelSourceFollower.sym
** sch_path: /home/alienfalcon/Projects/skywater/open_dvs_py312/open_dvs/git_dvs/nic2025_openDVS/analog/xschem/PixelSourceFollower.sch
.subckt PixelSourceFollower VddA18 PrSFBp GndA vpr vsf
*.iopin GndA
*.iopin PrSFBp
*.iopin vpr
*.iopin vsf
*.iopin VddA18
XMsf GndA vpr vsf VddA18 sky130_fd_pr__pfet_01v8 L=0.25 W=0.42 nf=1 mult=1
XMsfBias vsf PrSFBp VddA18 VddA18 sky130_fd_pr__pfet_01v8_hvt L=1.5 W=0.42 nf=1 mult=1
.ends

* expanding   symbol:  PixelChangeAmplifier.sym # of pins=6
** sym_path: /home/alienfalcon/Projects/skywater/open_dvs_py312/open_dvs/git_dvs/nic2025_openDVS/analog/xschem/PixelChangeAmplifier.sym
** sch_path: /home/alienfalcon/Projects/skywater/open_dvs_py312/open_dvs/git_dvs/nic2025_openDVS/analog/xschem/PixelChangeAmplifier.sch
.subckt PixelChangeAmplifier VddA18 DiffBn GndA vsf vdiff nRst
*.iopin DiffBn
*.iopin vsf
*.iopin VddA18
*.iopin GndA
*.iopin vdiff
*.iopin nRst
XC1b vd vsf sky130_fd_pr__cap_mim_m3_1 W=6.47 L=1.05 MF=1
XC2 vd vdiff sky130_fd_pr__cap_mim_m3_1 W=1 L=1 MF=1
XMchAmpBias vdiff DiffBn GndA GndA sky130_fd_pr__nfet_01v8 L=1.5 W=1.5 nf=1 mult=1
XMrst vdiff nRst vd VddA18 sky130_fd_pr__pfet_01v8_hvt L=0.42 W=0.42 nf=1 mult=1
XMchAmp vdiff vd VddA18 VddA18 sky130_fd_pr__pfet_01v8 L=1.5 W=1.5 nf=1 mult=1
XC1a vd vsf sky130_fd_pr__cap_mim_m3_1 W=3.985 L=2.27 MF=1
.ends

* expanding   symbol:  PixelComparators.sym # of pins=7
** sym_path: /home/alienfalcon/Projects/skywater/open_dvs_py312/open_dvs/git_dvs/nic2025_openDVS/analog/xschem/PixelComparators.sym
** sch_path: /home/alienfalcon/Projects/skywater/open_dvs_py312/open_dvs/git_dvs/nic2025_openDVS/analog/xschem/PixelComparators.sch
.subckt PixelComparators VddA18 OnBn GndA vdiff ON OffBn nOFF
*.iopin OnBn
*.iopin OffBn
*.iopin VddA18
*.iopin vdiff
*.iopin GndA
*.iopin ON
*.iopin nOFF
XMonBias ON OnBn GndA GndA sky130_fd_pr__nfet_01v8 L=1.5 W=1.5 nf=1 mult=1
XMoffBias nOFF OffBn GndA GndA sky130_fd_pr__nfet_01v8 L=1.5 W=1.5 nf=1 mult=1
XMon ON vdiff VddA18 VddA18 sky130_fd_pr__pfet_01v8 L=1.5 W=1.5 nf=1 mult=1
XMoff nOFF vdiff VddA18 VddA18 sky130_fd_pr__pfet_01v8 L=1.5 W=1.5 nf=1 mult=1
.ends

* expanding   symbol:  PixelHandshake.sym # of pins=7
** sym_path: /home/alienfalcon/Projects/skywater/open_dvs_py312/open_dvs/git_dvs/nic2025_openDVS/analog/xschem/PixelHandshake.sym
** sch_path: /home/alienfalcon/Projects/skywater/open_dvs_py312/open_dvs/git_dvs/nic2025_openDVS/analog/xschem/PixelHandshake.sch
.subckt PixelHandshake rowReadOFF GndA rowReadON readLine ON nOFF GndD
*.ipin rowReadON
*.ipin rowReadOFF
*.iopin readLine
*.iopin ON
*.iopin nOFF
*.iopin GndD
*.iopin GndA
XMswON readLine rowReadON readLineONpd GndA sky130_fd_pr__nfet_01v8 L=0.15 W=0.42 nf=1 mult=1
XMoutON readLineONpd ON GndD GndA sky130_fd_pr__nfet_01v8 L=0.15 W=0.42 nf=1 mult=1
XMswOFF readLine rowReadOFF readLineOFFpd GndA sky130_fd_pr__nfet_01v8 L=0.15 W=0.42 nf=1 mult=1
XMoutOFF readLineOFFpd nOFF GndD GndA sky130_fd_pr__nfet_01v8 L=0.15 W=0.42 nf=1 mult=1
.ends

* expanding   symbol:  PixelResetGen.sym # of pins=6
** sym_path: /home/alienfalcon/Projects/skywater/open_dvs_py312/open_dvs/git_dvs/nic2025_openDVS/analog/xschem/PixelResetGen.sym
** sch_path: /home/alienfalcon/Projects/skywater/open_dvs_py312/open_dvs/git_dvs/nic2025_openDVS/analog/xschem/PixelResetGen.sch
.subckt PixelResetGen rowRst GndA colRst nRst RefrBp VddA18
*.ipin rowRst
*.ipin colRst
*.iopin RefrBp
*.iopin GndA
*.iopin VddA18
*.iopin nRst
XMPDrefrCol nRst colRst net1 GndA sky130_fd_pr__nfet_01v8 L=0.15 W=0.42 nf=1 mult=1
XMrefrBias nRst RefrBp VddA18 VddA18 sky130_fd_pr__pfet_01v8 L=1.5 W=0.42 nf=1 mult=1
XMcapRefr VddA18 nRst VddA18 VddA18 sky130_fd_pr__pfet_01v8 L=1.5 W=1.5 nf=1 mult=1
XMPDRefrRow net1 rowRst GndA GndA sky130_fd_pr__nfet_01v8 L=0.15 W=0.42 nf=1 mult=1
.ends
