* 2-pin LVS stub for Magic photodiode parasitic (avoids dummy_25/26)
.subckt sky130_fd_pr__model__parasitic__diode_ps2dn PLUS MINUS
.ends

.subckt openDVS_pixel rowReadON VddA18 PrBp GndA vpd rowReadOFF pixRst PrSFBp DiffBn OnBn OffBn RefrBp readLine GndD
XMpd VddA18 vpr vpd GndA sky130_fd_pr__nfet_01v8 L=0.3 W=0.5 nf=1 mult=1
XMpr_amp vpr vpd GndA GndA sky130_fd_pr__nfet_01v8 L=0.3 W=0.42 nf=1 mult=1
XMprBias vpr PrBp VddA18 VddA18 sky130_fd_pr__pfet_01v8 L=0.15 W=0.5 nf=1 mult=1
XD1 GndA vpd sky130_fd_pr__model__parasitic__diode_ps2dn area=1e12 perim=4e6
XMsf GndA vpr vsf VddA18 sky130_fd_pr__pfet_01v8 L=0.25 W=0.42 nf=1 mult=1
XMsfBias vsf PrSFBp VddA18 VddA18 sky130_fd_pr__pfet_01v8_hvt L=1.5 W=0.42 nf=1 mult=1
XC1b vd vsf sky130_fd_pr__cap_mim_m3_1 W=6.47 L=1.05 MF=1
XC2 vd vdiff sky130_fd_pr__cap_mim_m3_1 W=1 L=1 MF=1
XMchAmpBias vdiff DiffBn GndA GndA sky130_fd_pr__nfet_01v8 L=1.5 W=1.5 nf=1 mult=1
XMrst vdiff nRst vd VddA18 sky130_fd_pr__pfet_01v8_hvt L=0.42 W=0.42 nf=1 mult=1
XMchAmp vdiff vd VddA18 VddA18 sky130_fd_pr__pfet_01v8 L=1.5 W=1.5 nf=1 mult=1
XC1a vd vsf sky130_fd_pr__cap_mim_m3_1 W=3.985 L=2.27 MF=1
XMonBias ON OnBn GndA GndA sky130_fd_pr__nfet_01v8 L=1.5 W=1.5 nf=1 mult=1
XMoffBias nOFF OffBn GndA GndA sky130_fd_pr__nfet_01v8 L=1.5 W=1.5 nf=1 mult=1
XMon ON vdiff VddA18 VddA18 sky130_fd_pr__pfet_01v8 L=1.5 W=1.5 nf=1 mult=1
XMoff nOFF vdiff VddA18 VddA18 sky130_fd_pr__pfet_01v8 L=1.5 W=1.5 nf=1 mult=1
XMswON readLine rowReadON readLineONpd GndA sky130_fd_pr__nfet_01v8 L=0.15 W=0.42 nf=1 mult=1
XMoutON readLineONpd ON GndD GndA sky130_fd_pr__nfet_01v8 L=0.15 W=0.42 nf=1 mult=1
XMswOFF readLine rowReadOFF readLineOFFpd GndA sky130_fd_pr__nfet_01v8 L=0.15 W=0.42 nf=1 mult=1
XMoutOFF readLineOFFpd nOFF GndD GndA sky130_fd_pr__nfet_01v8 L=0.15 W=0.42 nf=1 mult=1
XMPDrefrCol nRst pixRst net1 GndA sky130_fd_pr__nfet_01v8 L=0.15 W=0.42 nf=1 mult=1
XMrefrBias nRst RefrBp VddA18 VddA18 sky130_fd_pr__pfet_01v8 L=1.5 W=0.42 nf=1 mult=1
XMcapRefr VddA18 nRst VddA18 VddA18 sky130_fd_pr__pfet_01v8 L=1.5 W=1.5 nf=1 mult=1
XMPDRefrRow net1 rowReadON GndA GndA sky130_fd_pr__nfet_01v8 L=0.15 W=0.42 nf=1 mult=1
.ends
