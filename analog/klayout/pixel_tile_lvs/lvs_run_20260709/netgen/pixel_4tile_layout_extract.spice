* NGSPICE file created from pixel_4tile.ext - technology: sky130A

.subckt openDVS_pixel m2_32_2198# rowReadOFF m2_298_1861# m3_2210_26# m2_196_1392#
+ PrSFBp m5_n506_n512# m2_32_2482# rowReadON m2_32_2254# RefrBp m3_2462_26# readLine
+ VddA18 vd vpd m3_2084_26# pixRst PrBp m3_2714_26# GndD m3_2336_26# GndA OnBn DiffBn
+ OffBn m3_2588_26#
X0 a_361_187# ON GndD GndA sky130_fd_pr__nfet_01v8 ad=0.105 pd=0.92 as=0.126 ps=1.44 w=0.42 l=0.15
X1 GndD nOFF a_621_187# GndA sky130_fd_pr__nfet_01v8 ad=0.126 pd=1.44 as=0.105 ps=0.92 w=0.42 l=0.15
X2 VddA18 vpr vpd GndA sky130_fd_pr__nfet_01v8 ad=0.15 pd=1.6 as=0.15 ps=1.6 w=0.5 l=0.3
X3 GndA vpr vsf VddA18 sky130_fd_pr__pfet_01v8 ad=0.126 pd=1.44 as=0.126 ps=1.44 w=0.42 l=0.25
X4 a_95_497# pixRst nRst GndA sky130_fd_pr__nfet_01v8 ad=0.105 pd=0.92 as=0.126 ps=1.44 w=0.42 l=0.15
X5 VddA18 nRst VddA18 VddA18 sky130_fd_pr__pfet_01v8 ad=0.45 pd=3.6 as=2.202 ps=18.88 w=1.5 l=1.5
X6 vd vdiff sky130_fd_pr__cap_mim_m3_1 l=1 w=1
X7 vdiff nRst vd VddA18 sky130_fd_pr__pfet_01v8_hvt ad=0.126 pd=1.44 as=0.126 ps=1.44 w=0.42 l=0.42
D0 GndA vpd sky130_fd_pr__model__parasitic__diode_ps2dn area=32.49
X8 nOFF OffBn GndA GndA sky130_fd_pr__nfet_01v8 ad=0.45 pd=3.6 as=0.45 ps=3.6 w=1.5 l=1.5
X9 vd vsf sky130_fd_pr__cap_mim_m3_1 l=1.505 w=6.47
X10 vpr vpd GndA GndA sky130_fd_pr__nfet_01v8 ad=0.126 pd=1.44 as=0.126 ps=1.44 w=0.42 l=0.3
X11 ON OnBn GndA GndA sky130_fd_pr__nfet_01v8 ad=0.45 pd=3.6 as=0.45 ps=3.6 w=1.5 l=1.5
X12 vdiff DiffBn GndA GndA sky130_fd_pr__nfet_01v8 ad=0.45 pd=3.6 as=0.45 ps=3.6 w=1.5 l=1.5
X13 VddA18 vdiff ON VddA18 sky130_fd_pr__pfet_01v8 ad=0.225 pd=1.8 as=0.45 ps=3.6 w=1.5 l=1.5
X14 VddA18 PrBp vpr VddA18 sky130_fd_pr__pfet_01v8 ad=0.15 pd=1.6 as=0.15 ps=1.6 w=0.5 l=0.15
X15 VddA18 vd vdiff VddA18 sky130_fd_pr__pfet_01v8 ad=0.45 pd=3.6 as=0.45 ps=3.6 w=1.5 l=1.5
X16 nOFF vdiff VddA18 VddA18 sky130_fd_pr__pfet_01v8 ad=0.45 pd=3.6 as=0.225 ps=1.8 w=1.5 l=1.5
X17 vd vsf sky130_fd_pr__cap_mim_m3_1 l=2.27 w=3.985
X18 VddA18 PrSFBp vsf VddA18 sky130_fd_pr__pfet_01v8_hvt ad=0.126 pd=1.44 as=0.126 ps=1.44 w=0.42 l=1.5
X19 a_621_187# rowReadOFF readLine GndA sky130_fd_pr__nfet_01v8 ad=0.105 pd=0.92 as=0.105 ps=0.92 w=0.42 l=0.15
X20 GndA rowReadON a_95_497# GndA sky130_fd_pr__nfet_01v8 ad=0.126 pd=1.44 as=0.105 ps=0.92 w=0.42 l=0.15
X21 readLine rowReadON a_361_187# GndA sky130_fd_pr__nfet_01v8 ad=0.105 pd=0.92 as=0.105 ps=0.92 w=0.42 l=0.15
X22 VddA18 RefrBp nRst VddA18 sky130_fd_pr__pfet_01v8 ad=0.126 pd=1.44 as=0.126 ps=1.44 w=0.42 l=1.5
.ends

.subckt openDVS_pixel2x2_bot vpd[0] vpd[1] vpd[3] vpd[2] rowReadON[1] rowReadON[0]
+ RefrBp PrBp PrSFBp readLine[0] pixRst[0] pixRst[1] readLine[1] OffBn rowReadOFF[1]
+ rowReadOFF[0] GndD DiffBn GndA OnBn VddA18
XopenDVS_pixel_1 DiffBn rowReadOFF[1] OnBn RefrBp OffBn PrSFBp GndA GndA rowReadON[1]
+ VddA18 RefrBp PrSFBp readLine[1] VddA18 GndA vpd[3] OnBn pixRst[1] PrBp DiffBn GndD
+ PrBp GndA OnBn DiffBn OffBn OffBn openDVS_pixel
XopenDVS_pixel_3 DiffBn rowReadOFF[0] OnBn RefrBp OffBn PrSFBp GndA VddA18 rowReadON[0]
+ GndA RefrBp PrSFBp readLine[1] VddA18 GndA vpd[2] OnBn pixRst[1] PrBp DiffBn GndD
+ PrBp GndA OnBn DiffBn OffBn OffBn openDVS_pixel
XopenDVS_pixel_2 DiffBn rowReadOFF[1] OnBn OffBn OffBn PrSFBp GndA GndA rowReadON[1]
+ VddA18 RefrBp PrBp readLine[0] VddA18 GndA vpd[1] DiffBn pixRst[0] PrBp OnBn GndD
+ PrSFBp GndA OnBn DiffBn OffBn RefrBp openDVS_pixel
XopenDVS_pixel_0 DiffBn rowReadOFF[0] OnBn OffBn OffBn PrSFBp GndA VddA18 rowReadON[0]
+ GndA RefrBp PrBp readLine[0] VddA18 GndA vpd[0] DiffBn pixRst[0] PrBp OnBn GndD
+ PrSFBp GndA OnBn DiffBn OffBn RefrBp openDVS_pixel
.ends

.subckt sky130_fd_pr__nfet_01v8_9ZWGZ9 G D m1_n29_101# S VSUBS
X0 S G D VSUBS sky130_fd_pr__nfet_01v8 ad=0.29 pd=2.58 as=0.29 ps=2.58 w=1 l=0.15
.ends

.subckt sky130_fd_pr__pfet_01v8_D48SMA G D S w_n194_n264#
X0 S G D w_n194_n264# sky130_fd_pr__pfet_01v8 ad=0.58 pd=4.58 as=0.58 ps=4.58 w=2 l=1
.ends

.subckt sky130_fd_pr__nfet_01v8_ML4XRG G D m1_n67_n69# S m1_21_n69# VSUBS
X0 S G D VSUBS sky130_fd_pr__nfet_01v8 ad=0.29 pd=2.58 as=0.29 ps=2.58 w=1 l=0.15
.ends

.subckt sky130_fd_pr__nfet_01v8_V52S8A G D S VSUBS
X0 S G D VSUBS sky130_fd_pr__nfet_01v8 ad=0.29 pd=2.58 as=0.29 ps=2.58 w=1 l=1
.ends

.subckt sky130_fd_pr__pfet_01v8_U2XPXD G D w_n144_n200# S
X0 S G D w_n144_n200# sky130_fd_pr__pfet_01v8 ad=0.29 pd=2.58 as=0.29 ps=2.58 w=1 l=0.5
.ends

.subckt sky130_fd_pr__pfet_01v8_KDZMJM G D S w_n144_n198#
X0 S G D w_n144_n198# sky130_fd_pr__pfet_01v8 ad=0.29 pd=2.58 as=0.29 ps=2.58 w=1 l=0.5
.ends

.subckt sky130_fd_pr__nfet_01v8_9ZAZEB G D S VSUBS
X0 S G D VSUBS sky130_fd_pr__nfet_01v8 ad=0.29 pd=2.58 as=0.29 ps=2.58 w=1 l=0.15
.ends

.subckt dyn_comp_v1 VDD nDETECT DETECT vm vp voutn GND
Xsky130_fd_pr__nfet_01v8_9ZWGZ9_7 sky130_fd_pr__pfet_01v8_KDZMJM_3/S sky130_fd_pr__pfet_01v8_KDZMJM_2/S
+ sky130_fd_pr__pfet_01v8_KDZMJM_3/S GND GND sky130_fd_pr__nfet_01v8_9ZWGZ9
Xsky130_fd_pr__nfet_01v8_9ZWGZ9_6 sky130_fd_pr__pfet_01v8_KDZMJM_1/D sky130_fd_pr__pfet_01v8_KDZMJM_2/G
+ sky130_fd_pr__pfet_01v8_KDZMJM_1/D GND GND sky130_fd_pr__nfet_01v8_9ZWGZ9
Xsky130_fd_pr__nfet_01v8_9ZWGZ9_8 sky130_fd_pr__pfet_01v8_KDZMJM_1/D sky130_fd_pr__pfet_01v8_KDZMJM_2/G
+ sky130_fd_pr__pfet_01v8_KDZMJM_1/D GND GND sky130_fd_pr__nfet_01v8_9ZWGZ9
Xsky130_fd_pr__nfet_01v8_9ZWGZ9_9 sky130_fd_pr__pfet_01v8_KDZMJM_3/S sky130_fd_pr__pfet_01v8_KDZMJM_2/S
+ sky130_fd_pr__pfet_01v8_KDZMJM_3/S GND GND sky130_fd_pr__nfet_01v8_9ZWGZ9
Xsky130_fd_pr__pfet_01v8_D48SMA_0 sky130_fd_pr__pfet_01v8_KDZMJM_2/G voutn VDD VDD
+ sky130_fd_pr__pfet_01v8_D48SMA
Xsky130_fd_pr__pfet_01v8_D48SMA_1 sky130_fd_pr__pfet_01v8_KDZMJM_2/S voutp VDD VDD
+ sky130_fd_pr__pfet_01v8_D48SMA
Xsky130_fd_pr__nfet_01v8_ML4XRG_0 sky130_fd_pr__pfet_01v8_KDZMJM_2/S sky130_fd_pr__pfet_01v8_KDZMJM_2/G
+ sky130_fd_pr__pfet_01v8_KDZMJM_2/G GND GND GND sky130_fd_pr__nfet_01v8_ML4XRG
Xsky130_fd_pr__nfet_01v8_ML4XRG_1 sky130_fd_pr__pfet_01v8_KDZMJM_2/G GND GND sky130_fd_pr__pfet_01v8_KDZMJM_2/S
+ sky130_fd_pr__pfet_01v8_KDZMJM_2/S GND sky130_fd_pr__nfet_01v8_ML4XRG
Xsky130_fd_pr__nfet_01v8_V52S8A_0 sky130_fd_pr__pfet_01v8_KDZMJM_2/S GND voutp GND
+ sky130_fd_pr__nfet_01v8_V52S8A
Xsky130_fd_pr__nfet_01v8_V52S8A_1 sky130_fd_pr__pfet_01v8_KDZMJM_2/G voutn GND GND
+ sky130_fd_pr__nfet_01v8_V52S8A
Xsky130_fd_pr__pfet_01v8_U2XPXD_0 nDETECT VDD VDD sky130_fd_pr__pfet_01v8_U2XPXD_0/S
+ sky130_fd_pr__pfet_01v8_U2XPXD
Xsky130_fd_pr__pfet_01v8_KDZMJM_0 sky130_fd_pr__pfet_01v8_KDZMJM_2/S sky130_fd_pr__pfet_01v8_KDZMJM_2/G
+ sky130_fd_pr__pfet_01v8_U2XPXD_0/S VDD sky130_fd_pr__pfet_01v8_KDZMJM
Xsky130_fd_pr__pfet_01v8_KDZMJM_1 DETECT sky130_fd_pr__pfet_01v8_KDZMJM_1/D VDD VDD
+ sky130_fd_pr__pfet_01v8_KDZMJM
Xsky130_fd_pr__pfet_01v8_KDZMJM_2 sky130_fd_pr__pfet_01v8_KDZMJM_2/G sky130_fd_pr__pfet_01v8_U2XPXD_0/S
+ sky130_fd_pr__pfet_01v8_KDZMJM_2/S VDD sky130_fd_pr__pfet_01v8_KDZMJM
Xsky130_fd_pr__pfet_01v8_KDZMJM_3 DETECT VDD sky130_fd_pr__pfet_01v8_KDZMJM_3/S VDD
+ sky130_fd_pr__pfet_01v8_KDZMJM
Xsky130_fd_pr__nfet_01v8_9ZAZEB_0 DETECT GND sky130_fd_pr__nfet_01v8_9ZWGZ9_2/D GND
+ sky130_fd_pr__nfet_01v8_9ZAZEB
Xsky130_fd_pr__nfet_01v8_9ZWGZ9_0 sky130_fd_pr__pfet_01v8_KDZMJM_1/D GND sky130_fd_pr__pfet_01v8_KDZMJM_1/D
+ sky130_fd_pr__pfet_01v8_KDZMJM_2/G GND sky130_fd_pr__nfet_01v8_9ZWGZ9
Xsky130_fd_pr__nfet_01v8_9ZWGZ9_1 vm sky130_fd_pr__pfet_01v8_KDZMJM_3/S vm sky130_fd_pr__nfet_01v8_9ZWGZ9_2/D
+ GND sky130_fd_pr__nfet_01v8_9ZWGZ9
Xsky130_fd_pr__nfet_01v8_9ZWGZ9_2 vp sky130_fd_pr__nfet_01v8_9ZWGZ9_2/D vp sky130_fd_pr__pfet_01v8_KDZMJM_1/D
+ GND sky130_fd_pr__nfet_01v8_9ZWGZ9
Xsky130_fd_pr__nfet_01v8_9ZWGZ9_3 sky130_fd_pr__pfet_01v8_KDZMJM_3/S sky130_fd_pr__pfet_01v8_KDZMJM_2/S
+ sky130_fd_pr__pfet_01v8_KDZMJM_3/S GND GND sky130_fd_pr__nfet_01v8_9ZWGZ9
Xsky130_fd_pr__nfet_01v8_9ZWGZ9_4 sky130_fd_pr__pfet_01v8_KDZMJM_1/D GND sky130_fd_pr__pfet_01v8_KDZMJM_1/D
+ sky130_fd_pr__pfet_01v8_KDZMJM_2/G GND sky130_fd_pr__nfet_01v8_9ZWGZ9
Xsky130_fd_pr__nfet_01v8_9ZWGZ9_5 sky130_fd_pr__pfet_01v8_KDZMJM_3/S sky130_fd_pr__pfet_01v8_KDZMJM_2/S
+ sky130_fd_pr__pfet_01v8_KDZMJM_3/S GND GND sky130_fd_pr__nfet_01v8_9ZWGZ9
.ends

.subckt col_periphery GND VDD NCHARGE pixRst COL_LINE m4_106_7678# VTHRESH voutn nDETECT
+ m4_566_7702# DETECT
Xdyn_comp_v1_0 VDD nDETECT DETECT VTHRESH dyn_comp_v1_0/vp voutn GND dyn_comp_v1
X0 dyn_comp_v1_0/vp dyn_comp_v1_0/vp COL_LINE GND sky130_fd_pr__nfet_01v8 ad=0.14 pd=1.28 as=0.14 ps=1.28 w=1 l=1
X1 dyn_comp_v1_0/vp NCHARGE VDD VDD sky130_fd_pr__pfet_01v8 ad=0.265 pd=2.53 as=0.35 ps=1.7 w=1 l=1
X2 COL_LINE dyn_comp_v1_0/vp dyn_comp_v1_0/vp GND sky130_fd_pr__nfet_01v8 ad=0.14 pd=1.28 as=0.14 ps=1.28 w=1 l=1
X3 dyn_comp_v1_0/vp NCHARGE VDD VDD sky130_fd_pr__pfet_01v8 ad=0.35 pd=1.7 as=0.35 ps=1.7 w=1 l=1
X4 COL_LINE dyn_comp_v1_0/vp dyn_comp_v1_0/vp GND sky130_fd_pr__nfet_01v8 ad=0.14 pd=1.28 as=0.14 ps=1.28 w=1 l=1
X5 dyn_comp_v1_0/vp NCHARGE VDD VDD sky130_fd_pr__pfet_01v8 ad=0.265 pd=2.53 as=0.35 ps=1.7 w=1 l=1
X6 VDD NCHARGE dyn_comp_v1_0/vp VDD sky130_fd_pr__pfet_01v8 ad=0.35 pd=1.7 as=0.35 ps=1.7 w=1 l=1
X7 COL_LINE dyn_comp_v1_0/vp dyn_comp_v1_0/vp GND sky130_fd_pr__nfet_01v8 ad=0.14 pd=1.28 as=0.265 ps=2.53 w=1 l=1
X8 dyn_comp_v1_0/vp NCHARGE VDD VDD sky130_fd_pr__pfet_01v8 ad=0.35 pd=1.7 as=0.35 ps=1.7 w=1 l=1
X9 dyn_comp_v1_0/vp dyn_comp_v1_0/vp COL_LINE GND sky130_fd_pr__nfet_01v8 ad=0.265 pd=2.53 as=0.14 ps=1.28 w=1 l=1
X10 COL_LINE dyn_comp_v1_0/vp dyn_comp_v1_0/vp GND sky130_fd_pr__nfet_01v8 ad=0.14 pd=1.28 as=0.265 ps=2.53 w=1 l=1
X11 VDD NCHARGE dyn_comp_v1_0/vp VDD sky130_fd_pr__pfet_01v8 ad=0.35 pd=1.7 as=0.265 ps=2.53 w=1 l=1
X12 VDD NCHARGE dyn_comp_v1_0/vp VDD sky130_fd_pr__pfet_01v8 ad=0.35 pd=1.7 as=0.35 ps=1.7 w=1 l=1
X13 dyn_comp_v1_0/vp dyn_comp_v1_0/vp COL_LINE GND sky130_fd_pr__nfet_01v8 ad=0.14 pd=1.28 as=0.14 ps=1.28 w=1 l=1
X14 dyn_comp_v1_0/vp dyn_comp_v1_0/vp COL_LINE GND sky130_fd_pr__nfet_01v8 ad=0.14 pd=1.28 as=0.14 ps=1.28 w=1 l=1
X15 VDD NCHARGE dyn_comp_v1_0/vp VDD sky130_fd_pr__pfet_01v8 ad=0.35 pd=1.7 as=0.265 ps=2.53 w=1 l=1
X16 dyn_comp_v1_0/vp dyn_comp_v1_0/vp COL_LINE GND sky130_fd_pr__nfet_01v8 ad=0.265 pd=2.53 as=0.14 ps=1.28 w=1 l=1
X17 COL_LINE dyn_comp_v1_0/vp dyn_comp_v1_0/vp GND sky130_fd_pr__nfet_01v8 ad=0.14 pd=1.28 as=0.14 ps=1.28 w=1 l=1
X18 COL_LINE dyn_comp_v1_0/vp dyn_comp_v1_0/vp GND sky130_fd_pr__nfet_01v8 ad=0.14 pd=1.28 as=0.14 ps=1.28 w=1 l=1
X19 dyn_comp_v1_0/vp dyn_comp_v1_0/vp COL_LINE GND sky130_fd_pr__nfet_01v8 ad=0.265 pd=2.53 as=0.14 ps=1.28 w=1 l=1
X20 COL_LINE dyn_comp_v1_0/vp dyn_comp_v1_0/vp GND sky130_fd_pr__nfet_01v8 ad=0.14 pd=1.28 as=0.265 ps=2.53 w=1 l=1
X21 COL_LINE dyn_comp_v1_0/vp dyn_comp_v1_0/vp GND sky130_fd_pr__nfet_01v8 ad=0.14 pd=1.28 as=0.265 ps=2.53 w=1 l=1
X22 dyn_comp_v1_0/vp dyn_comp_v1_0/vp COL_LINE GND sky130_fd_pr__nfet_01v8 ad=0.265 pd=2.53 as=0.14 ps=1.28 w=1 l=1
X23 dyn_comp_v1_0/vp dyn_comp_v1_0/vp COL_LINE GND sky130_fd_pr__nfet_01v8 ad=0.14 pd=1.28 as=0.14 ps=1.28 w=1 l=1
.ends

.subckt col_periphery_1x2 pixRst1 COL_LINE0 COL_LINE1 nDETECT VDD DETECT VTHRESH voutn0
+ GND NCHARGE voutn1 pixRst0
Xcol_periphery_0 GND VDD NCHARGE pixRst0 COL_LINE0 pixRst0 VTHRESH voutn0 nDETECT
+ voutn0 DETECT col_periphery
Xcol_periphery_1 GND VDD NCHARGE pixRst1 COL_LINE1 pixRst1 VTHRESH voutn1 nDETECT
+ voutn1 DETECT col_periphery
.ends

.subckt pixel_layout_tile_bot voutn[51] voutn[52] voutn[53] voutn[54] voutn[55] voutn[56]
+ voutn[57] pixRst[63] pixRst[59] pixRst[58] pixRst[57] pixRst[56] pixRst[55] pixRst[52]
+ voutn[31] voutn[32] voutn[33] voutn[36] voutn[37] voutn[38] voutn[39] pixRst[39]
+ pixRst[38] pixRst[37] pixRst[36] pixRst[31] pixRst[30] pixRst[29] voutn[11] voutn[12]
+ voutn[13] voutn[19] voutn[7] voutn[6] voutn[3] pixRst[10] pixRst[15] pixRst[18]
+ pixRst[19] pixRst[0] pixRst[5] pixRst[6] pixRst[7] pixRst[8] pixRst[9] rowReadON[63]
+ rowReadON[62] rowReadON[53] rowReadON[52] rowReadON[49] rowReadON[48] rowReadON[47]
+ rowReadON[46] rowReadON[45] rowReadON[44] rowReadON[43] rowReadON[42] rowReadON[41]
+ rowReadON[40] rowReadON[39] rowReadON[29] rowReadON[28] rowReadON[27] rowReadON[26]
+ rowReadON[23] rowReadON[1] rowReadOFF[61] rowReadOFF[60] rowReadOFF[56] rowReadOFF[55]
+ rowReadOFF[54] rowReadOFF[53] rowReadOFF[52] rowReadOFF[51] rowReadOFF[50] rowReadOFF[49]
+ rowReadOFF[40] rowReadOFF[39] rowReadOFF[37] rowReadOFF[36] rowReadOFF[33] rowReadOFF[32]
+ rowReadOFF[19] rowReadOFF[18] rowReadOFF[17] rowReadOFF[16] rowReadOFF[12] rowReadOFF[9]
+ rowReadOFF[8] rowReadOFF[7] rowReadOFF[6] rowReadOFF[3] rowReadOFF[2] m1_27543_n208#
+ m1_22743_n208# m1_152343_n208# m1_8343_n208# m1_89943_n208# m1_3543_n208# pixRst[21]
+ m1_128343_n208# m1_123543_n208# m1_61143_n208# openDVS_pixel2x2_bot_927/GndD rowReadOFF[21]
+ openDVS_pixel2x2_bot_223/GndD rowReadON[0] pixRst[20] m1_37143_n208# rowReadOFF[20]
+ m1_32343_n208# openDVS_pixel2x2_bot_703/GndD pixRst[62] m1_99543_n208# rowReadON[35]
+ m1_94743_n208# rowReadON[38] rowReadON[34] m1_133143_n208# voutn[45] pixRst[28]
+ pixRst[22] rowReadOFF[45] m1_65943_n208# openDVS_pixel2x2_bot_351/GndD pixRst[41]
+ rowReadOFF[44] m1_109143_n208# pixRst[49] rowReadOFF[25] pixRst[40] openDVS_pixel2x2_bot_415/GndD
+ voutn[40] m1_104343_n208# voutn[23] rowReadON[51] rowReadOFF[24] voutn[28] rowReadON[50]
+ openDVS_pixel2x2_bot_991/GndD rowReadON[17] rowReadOFF[57] rowReadOFF[48] rowReadON[37]
+ rowReadOFF[29] pixRst[48] rowReadON[13] rowReadON[16] pixRst[47] rowReadON[36] rowReadOFF[28]
+ rowReadOFF[63] rowReadON[12] m1_13143_n208# openDVS_pixel2x2_bot_287/GndD rowReadON[57]
+ rowReadOFF[62] voutn[44] voutn[43] voutn[2] openDVS_pixel2x2_bot_767/GndD rowReadON[56]
+ voutn[1] rowReadON[22] m1_137943_n208# rowReadON[33] m1_75543_n208# pixRst[25] voutn[27]
+ openDVS_pixel2x2_bot_447/GndD nDETECT openDVS_pixel2x2_bot_543/GndD openDVS_pixel2x2_bot_63/GndD
+ m1_70743_n208# rowReadON[32] voutn[22] rowReadOFF[11] voutn[26] voutn[21] rowReadON[19]
+ openDVS_pixel2x2_bot_607/GndD openDVS_pixel2x2_bot_99/GndD pixRst[32] rowReadOFF[10]
+ pixRst[14] pixRst[13] rowReadON[18] pixRst[51] rowReadON[5] pixRst[42] pixRst[17]
+ voutn[60] m1_46743_n208# rowReadON[9] voutn[63] pixRst[61] openDVS_pixel2x2_bot_383/GndD
+ pixRst[50] m1_41943_n208# rowReadON[4] pixRst[46] pixRst[16] voutn[48] rowReadON[8]
+ pixRst[4] voutn[16] pixRst[60] voutn[10] rowReadON[25] NCHARGE rowReadOFF[23] voutn[9]
+ rowReadOFF[1] openDVS_pixel2x2_bot_863/GndD pixRst[33] rowReadOFF[31] rowReadON[24]
+ openDVS_pixel2x2_bot_479/GndD rowReadOFF[22] voutn[5] rowReadOFF[0] voutn[42] rowReadON[15]
+ m1_17943_n208# voutn[41] openDVS_pixel2x2_bot_999/GndD voutn[0] rowReadOFF[46] rowReadOFF[30]
+ pixRst[24] voutn[25] voutn[4] openDVS_pixel2x2_bot_959/GndD pixRst[23] voutn[30]
+ rowReadON[11] rowReadON[14] voutn[29] openDVS_pixel2x2_bot_159/GndD rowReadON[31]
+ openDVS_pixel2x2_bot_255/GndD m1_147543_n208# rowReadON[59] voutn[24] rowReadOFF[26]
+ rowReadOFF[35] rowReadON[10] voutn[58] m1_85143_n208# m1_142743_n208# rowReadON[30]
+ openDVS_pixel2x2_bot_319/GndD rowReadON[55] DETECT rowReadON[58] openDVS_pixel2x2_bot_639/GndD
+ m1_80343_n208# rowReadOFF[59] openDVS_pixel2x2_bot_735/GndD rowReadOFF[43] voutn[20]
+ rowReadOFF[5] rowReadON[21] rowReadOFF[34] rowReadON[60] openDVS_pixel2x2_bot_831/GndD
+ rowReadOFF[15] pixRst[27] pixRst[54] voutn[47] rowReadON[54] voutn[15] rowReadOFF[58]
+ rowReadOFF[41] rowReadOFF[42] rowReadOFF[4] openDVS_pixel2x2_bot_799/GndD rowReadON[20]
+ pixRst[12] voutn[59] openDVS_pixel2x2_bot_895/GndD rowReadON[3] rowReadOFF[27] voutn[18]
+ col_periphery_1x2_9/VDD pixRst[35] rowReadOFF[14] voutn[17] pixRst[26] m1_118743_n208#
+ rowReadON[7] openDVS_pixel2x2_bot_191/GndD pixRst[3] voutn[46] voutn[62] openDVS_pixel2x2_bot_511/GndD
+ GND voutn[35] voutn[14] PrBp voutn[61] rowReadON[2] m1_56343_n208# pixRst[45] m1_113943_n208#
+ rowReadOFF[38] pixRst[34] rowReadOFF[47] pixRst[11] rowReadON[61] VTHRESH rowReadON[6]
+ RefrBp pixRst[43] m1_51543_n208# voutn[50] voutn[34] openDVS_pixel2x2_bot_575/GndD
+ openDVS_pixel2x2_bot_95/GndD pixRst[2] openDVS_pixel2x2_bot_671/GndD voutn[49] DiffBn
+ PrSFBp pixRst[53] rowReadOFF[13] OnBn OffBn pixRst[44] VDD pixRst[1] voutn[8] VSUBS
XopenDVS_pixel2x2_bot_574 openDVS_pixel2x2_bot_574/vpd[0] openDVS_pixel2x2_bot_574/vpd[1]
+ openDVS_pixel2x2_bot_574/vpd[3] openDVS_pixel2x2_bot_574/vpd[2] rowReadON[34] rowReadON[35]
+ RefrBp PrBp PrSFBp col_periphery_1x2_30/COL_LINE0 pixRst[60] pixRst[61] col_periphery_1x2_30/COL_LINE1
+ OffBn rowReadOFF[34] rowReadOFF[35] openDVS_pixel2x2_bot_575/GndD DiffBn VSUBS OnBn
+ VDD openDVS_pixel2x2_bot
XopenDVS_pixel2x2_bot_541 openDVS_pixel2x2_bot_541/vpd[0] openDVS_pixel2x2_bot_541/vpd[1]
+ openDVS_pixel2x2_bot_541/vpd[3] openDVS_pixel2x2_bot_541/vpd[2] rowReadON[32] rowReadON[33]
+ RefrBp PrBp PrSFBp col_periphery_1x2_29/COL_LINE0 pixRst[58] pixRst[59] col_periphery_1x2_29/COL_LINE1
+ OffBn rowReadOFF[32] rowReadOFF[33] openDVS_pixel2x2_bot_543/GndD DiffBn VSUBS OnBn
+ VDD openDVS_pixel2x2_bot
XopenDVS_pixel2x2_bot_596 openDVS_pixel2x2_bot_596/vpd[0] openDVS_pixel2x2_bot_596/vpd[1]
+ openDVS_pixel2x2_bot_596/vpd[3] openDVS_pixel2x2_bot_596/vpd[2] rowReadON[36] rowReadON[37]
+ RefrBp PrBp PrSFBp col_periphery_1x2_20/COL_LINE0 pixRst[40] pixRst[41] col_periphery_1x2_20/COL_LINE1
+ OffBn rowReadOFF[36] rowReadOFF[37] openDVS_pixel2x2_bot_607/GndD DiffBn VSUBS OnBn
+ VDD openDVS_pixel2x2_bot
XopenDVS_pixel2x2_bot_563 openDVS_pixel2x2_bot_563/vpd[0] openDVS_pixel2x2_bot_563/vpd[1]
+ openDVS_pixel2x2_bot_563/vpd[3] openDVS_pixel2x2_bot_563/vpd[2] rowReadON[34] rowReadON[35]
+ RefrBp PrBp PrSFBp col_periphery_1x2_19/COL_LINE0 pixRst[38] pixRst[39] col_periphery_1x2_19/COL_LINE1
+ OffBn rowReadOFF[34] rowReadOFF[35] openDVS_pixel2x2_bot_575/GndD DiffBn VSUBS OnBn
+ VDD openDVS_pixel2x2_bot
XopenDVS_pixel2x2_bot_530 openDVS_pixel2x2_bot_530/vpd[0] openDVS_pixel2x2_bot_530/vpd[1]
+ openDVS_pixel2x2_bot_530/vpd[3] openDVS_pixel2x2_bot_530/vpd[2] rowReadON[32] rowReadON[33]
+ RefrBp PrBp PrSFBp col_periphery_1x2_18/COL_LINE0 pixRst[36] pixRst[37] col_periphery_1x2_18/COL_LINE1
+ OffBn rowReadOFF[32] rowReadOFF[33] openDVS_pixel2x2_bot_543/GndD DiffBn VSUBS OnBn
+ VDD openDVS_pixel2x2_bot
XopenDVS_pixel2x2_bot_585 openDVS_pixel2x2_bot_585/vpd[0] openDVS_pixel2x2_bot_585/vpd[1]
+ openDVS_pixel2x2_bot_585/vpd[3] openDVS_pixel2x2_bot_585/vpd[2] rowReadON[36] rowReadON[37]
+ RefrBp PrBp PrSFBp col_periphery_1x2_9/COL_LINE0 pixRst[18] pixRst[19] col_periphery_1x2_9/COL_LINE1
+ OffBn rowReadOFF[36] rowReadOFF[37] openDVS_pixel2x2_bot_607/GndD DiffBn VSUBS OnBn
+ VDD openDVS_pixel2x2_bot
XopenDVS_pixel2x2_bot_552 openDVS_pixel2x2_bot_552/vpd[0] openDVS_pixel2x2_bot_552/vpd[1]
+ openDVS_pixel2x2_bot_552/vpd[3] openDVS_pixel2x2_bot_552/vpd[2] rowReadON[34] rowReadON[35]
+ RefrBp PrBp PrSFBp col_periphery_1x2_8/COL_LINE0 pixRst[16] pixRst[17] col_periphery_1x2_8/COL_LINE1
+ OffBn rowReadOFF[34] rowReadOFF[35] openDVS_pixel2x2_bot_575/GndD DiffBn VSUBS OnBn
+ VDD openDVS_pixel2x2_bot
XopenDVS_pixel2x2_bot_382 openDVS_pixel2x2_bot_382/vpd[0] openDVS_pixel2x2_bot_382/vpd[1]
+ openDVS_pixel2x2_bot_382/vpd[3] openDVS_pixel2x2_bot_382/vpd[2] rowReadON[22] rowReadON[23]
+ RefrBp PrBp PrSFBp col_periphery_1x2_30/COL_LINE0 pixRst[60] pixRst[61] col_periphery_1x2_30/COL_LINE1
+ OffBn rowReadOFF[22] rowReadOFF[23] openDVS_pixel2x2_bot_383/GndD DiffBn VSUBS OnBn
+ VDD openDVS_pixel2x2_bot
XopenDVS_pixel2x2_bot_371 openDVS_pixel2x2_bot_371/vpd[0] openDVS_pixel2x2_bot_371/vpd[1]
+ openDVS_pixel2x2_bot_371/vpd[3] openDVS_pixel2x2_bot_371/vpd[2] rowReadON[22] rowReadON[23]
+ RefrBp PrBp PrSFBp col_periphery_1x2_19/COL_LINE0 pixRst[38] pixRst[39] col_periphery_1x2_19/COL_LINE1
+ OffBn rowReadOFF[22] rowReadOFF[23] openDVS_pixel2x2_bot_383/GndD DiffBn VSUBS OnBn
+ VDD openDVS_pixel2x2_bot
XopenDVS_pixel2x2_bot_393 openDVS_pixel2x2_bot_393/vpd[0] openDVS_pixel2x2_bot_393/vpd[1]
+ openDVS_pixel2x2_bot_393/vpd[3] openDVS_pixel2x2_bot_393/vpd[2] rowReadON[24] rowReadON[25]
+ RefrBp PrBp PrSFBp col_periphery_1x2_9/COL_LINE0 pixRst[18] pixRst[19] col_periphery_1x2_9/COL_LINE1
+ OffBn rowReadOFF[24] rowReadOFF[25] openDVS_pixel2x2_bot_415/GndD DiffBn VSUBS OnBn
+ VDD openDVS_pixel2x2_bot
XopenDVS_pixel2x2_bot_360 openDVS_pixel2x2_bot_360/vpd[0] openDVS_pixel2x2_bot_360/vpd[1]
+ openDVS_pixel2x2_bot_360/vpd[3] openDVS_pixel2x2_bot_360/vpd[2] rowReadON[22] rowReadON[23]
+ RefrBp PrBp PrSFBp col_periphery_1x2_8/COL_LINE0 pixRst[16] pixRst[17] col_periphery_1x2_8/COL_LINE1
+ OffBn rowReadOFF[22] rowReadOFF[23] openDVS_pixel2x2_bot_383/GndD DiffBn VSUBS OnBn
+ VDD openDVS_pixel2x2_bot
XopenDVS_pixel2x2_bot_190 openDVS_pixel2x2_bot_190/vpd[0] openDVS_pixel2x2_bot_190/vpd[1]
+ openDVS_pixel2x2_bot_190/vpd[3] openDVS_pixel2x2_bot_190/vpd[2] rowReadON[10] rowReadON[11]
+ RefrBp PrBp PrSFBp col_periphery_1x2_30/COL_LINE0 pixRst[60] pixRst[61] col_periphery_1x2_30/COL_LINE1
+ OffBn rowReadOFF[10] rowReadOFF[11] openDVS_pixel2x2_bot_191/GndD DiffBn VSUBS OnBn
+ VDD openDVS_pixel2x2_bot
XopenDVS_pixel2x2_bot_959 openDVS_pixel2x2_bot_959/vpd[0] openDVS_pixel2x2_bot_959/vpd[1]
+ openDVS_pixel2x2_bot_959/vpd[3] openDVS_pixel2x2_bot_959/vpd[2] rowReadON[58] rowReadON[59]
+ RefrBp PrBp PrSFBp col_periphery_1x2_31/COL_LINE0 pixRst[62] pixRst[63] col_periphery_1x2_31/COL_LINE1
+ OffBn rowReadOFF[58] rowReadOFF[59] openDVS_pixel2x2_bot_959/GndD DiffBn VSUBS OnBn
+ VDD openDVS_pixel2x2_bot
XopenDVS_pixel2x2_bot_926 openDVS_pixel2x2_bot_926/vpd[0] openDVS_pixel2x2_bot_926/vpd[1]
+ openDVS_pixel2x2_bot_926/vpd[3] openDVS_pixel2x2_bot_926/vpd[2] rowReadON[56] rowReadON[57]
+ RefrBp PrBp PrSFBp col_periphery_1x2_30/COL_LINE0 pixRst[60] pixRst[61] col_periphery_1x2_30/COL_LINE1
+ OffBn rowReadOFF[56] rowReadOFF[57] openDVS_pixel2x2_bot_927/GndD DiffBn VSUBS OnBn
+ VDD openDVS_pixel2x2_bot
XopenDVS_pixel2x2_bot_948 openDVS_pixel2x2_bot_948/vpd[0] openDVS_pixel2x2_bot_948/vpd[1]
+ openDVS_pixel2x2_bot_948/vpd[3] openDVS_pixel2x2_bot_948/vpd[2] rowReadON[58] rowReadON[59]
+ RefrBp PrBp PrSFBp col_periphery_1x2_20/COL_LINE0 pixRst[40] pixRst[41] col_periphery_1x2_20/COL_LINE1
+ OffBn rowReadOFF[58] rowReadOFF[59] openDVS_pixel2x2_bot_959/GndD DiffBn VSUBS OnBn
+ VDD openDVS_pixel2x2_bot
XopenDVS_pixel2x2_bot_915 openDVS_pixel2x2_bot_915/vpd[0] openDVS_pixel2x2_bot_915/vpd[1]
+ openDVS_pixel2x2_bot_915/vpd[3] openDVS_pixel2x2_bot_915/vpd[2] rowReadON[56] rowReadON[57]
+ RefrBp PrBp PrSFBp col_periphery_1x2_19/COL_LINE0 pixRst[38] pixRst[39] col_periphery_1x2_19/COL_LINE1
+ OffBn rowReadOFF[56] rowReadOFF[57] openDVS_pixel2x2_bot_927/GndD DiffBn VSUBS OnBn
+ VDD openDVS_pixel2x2_bot
XopenDVS_pixel2x2_bot_937 openDVS_pixel2x2_bot_937/vpd[0] openDVS_pixel2x2_bot_937/vpd[1]
+ openDVS_pixel2x2_bot_937/vpd[3] openDVS_pixel2x2_bot_937/vpd[2] rowReadON[58] rowReadON[59]
+ RefrBp PrBp PrSFBp col_periphery_1x2_9/COL_LINE0 pixRst[18] pixRst[19] col_periphery_1x2_9/COL_LINE1
+ OffBn rowReadOFF[58] rowReadOFF[59] openDVS_pixel2x2_bot_959/GndD DiffBn VSUBS OnBn
+ VDD openDVS_pixel2x2_bot
XopenDVS_pixel2x2_bot_904 openDVS_pixel2x2_bot_904/vpd[0] openDVS_pixel2x2_bot_904/vpd[1]
+ openDVS_pixel2x2_bot_904/vpd[3] openDVS_pixel2x2_bot_904/vpd[2] rowReadON[56] rowReadON[57]
+ RefrBp PrBp PrSFBp col_periphery_1x2_8/COL_LINE0 pixRst[16] pixRst[17] col_periphery_1x2_8/COL_LINE1
+ OffBn rowReadOFF[56] rowReadOFF[57] openDVS_pixel2x2_bot_927/GndD DiffBn VSUBS OnBn
+ VDD openDVS_pixel2x2_bot
XopenDVS_pixel2x2_bot_767 openDVS_pixel2x2_bot_767/vpd[0] openDVS_pixel2x2_bot_767/vpd[1]
+ openDVS_pixel2x2_bot_767/vpd[3] openDVS_pixel2x2_bot_767/vpd[2] rowReadON[46] rowReadON[47]
+ RefrBp PrBp PrSFBp col_periphery_1x2_31/COL_LINE0 pixRst[62] pixRst[63] col_periphery_1x2_31/COL_LINE1
+ OffBn rowReadOFF[46] rowReadOFF[47] openDVS_pixel2x2_bot_767/GndD DiffBn VSUBS OnBn
+ VDD openDVS_pixel2x2_bot
XopenDVS_pixel2x2_bot_734 openDVS_pixel2x2_bot_734/vpd[0] openDVS_pixel2x2_bot_734/vpd[1]
+ openDVS_pixel2x2_bot_734/vpd[3] openDVS_pixel2x2_bot_734/vpd[2] rowReadON[44] rowReadON[45]
+ RefrBp PrBp PrSFBp col_periphery_1x2_30/COL_LINE0 pixRst[60] pixRst[61] col_periphery_1x2_30/COL_LINE1
+ OffBn rowReadOFF[44] rowReadOFF[45] openDVS_pixel2x2_bot_735/GndD DiffBn VSUBS OnBn
+ VDD openDVS_pixel2x2_bot
XopenDVS_pixel2x2_bot_701 openDVS_pixel2x2_bot_701/vpd[0] openDVS_pixel2x2_bot_701/vpd[1]
+ openDVS_pixel2x2_bot_701/vpd[3] openDVS_pixel2x2_bot_701/vpd[2] rowReadON[42] rowReadON[43]
+ RefrBp PrBp PrSFBp col_periphery_1x2_29/COL_LINE0 pixRst[58] pixRst[59] col_periphery_1x2_29/COL_LINE1
+ OffBn rowReadOFF[42] rowReadOFF[43] openDVS_pixel2x2_bot_703/GndD DiffBn VSUBS OnBn
+ VDD openDVS_pixel2x2_bot
XopenDVS_pixel2x2_bot_789 openDVS_pixel2x2_bot_789/vpd[0] openDVS_pixel2x2_bot_789/vpd[1]
+ openDVS_pixel2x2_bot_789/vpd[3] openDVS_pixel2x2_bot_789/vpd[2] rowReadON[48] rowReadON[49]
+ RefrBp PrBp PrSFBp col_periphery_1x2_21/COL_LINE0 pixRst[42] pixRst[43] col_periphery_1x2_21/COL_LINE1
+ OffBn rowReadOFF[48] rowReadOFF[49] openDVS_pixel2x2_bot_799/GndD DiffBn VSUBS OnBn
+ VDD openDVS_pixel2x2_bot
XopenDVS_pixel2x2_bot_756 openDVS_pixel2x2_bot_756/vpd[0] openDVS_pixel2x2_bot_756/vpd[1]
+ openDVS_pixel2x2_bot_756/vpd[3] openDVS_pixel2x2_bot_756/vpd[2] rowReadON[46] rowReadON[47]
+ RefrBp PrBp PrSFBp col_periphery_1x2_20/COL_LINE0 pixRst[40] pixRst[41] col_periphery_1x2_20/COL_LINE1
+ OffBn rowReadOFF[46] rowReadOFF[47] openDVS_pixel2x2_bot_767/GndD DiffBn VSUBS OnBn
+ VDD openDVS_pixel2x2_bot
XopenDVS_pixel2x2_bot_723 openDVS_pixel2x2_bot_723/vpd[0] openDVS_pixel2x2_bot_723/vpd[1]
+ openDVS_pixel2x2_bot_723/vpd[3] openDVS_pixel2x2_bot_723/vpd[2] rowReadON[44] rowReadON[45]
+ RefrBp PrBp PrSFBp col_periphery_1x2_19/COL_LINE0 pixRst[38] pixRst[39] col_periphery_1x2_19/COL_LINE1
+ OffBn rowReadOFF[44] rowReadOFF[45] openDVS_pixel2x2_bot_735/GndD DiffBn VSUBS OnBn
+ VDD openDVS_pixel2x2_bot
XopenDVS_pixel2x2_bot_778 openDVS_pixel2x2_bot_778/vpd[0] openDVS_pixel2x2_bot_778/vpd[1]
+ openDVS_pixel2x2_bot_778/vpd[3] openDVS_pixel2x2_bot_778/vpd[2] rowReadON[48] rowReadON[49]
+ RefrBp PrBp PrSFBp col_periphery_1x2_10/COL_LINE0 pixRst[20] pixRst[21] col_periphery_1x2_10/COL_LINE1
+ OffBn rowReadOFF[48] rowReadOFF[49] openDVS_pixel2x2_bot_799/GndD DiffBn VSUBS OnBn
+ VDD openDVS_pixel2x2_bot
XopenDVS_pixel2x2_bot_745 openDVS_pixel2x2_bot_745/vpd[0] openDVS_pixel2x2_bot_745/vpd[1]
+ openDVS_pixel2x2_bot_745/vpd[3] openDVS_pixel2x2_bot_745/vpd[2] rowReadON[46] rowReadON[47]
+ RefrBp PrBp PrSFBp col_periphery_1x2_9/COL_LINE0 pixRst[18] pixRst[19] col_periphery_1x2_9/COL_LINE1
+ OffBn rowReadOFF[46] rowReadOFF[47] openDVS_pixel2x2_bot_767/GndD DiffBn VSUBS OnBn
+ VDD openDVS_pixel2x2_bot
XopenDVS_pixel2x2_bot_712 openDVS_pixel2x2_bot_712/vpd[0] openDVS_pixel2x2_bot_712/vpd[1]
+ openDVS_pixel2x2_bot_712/vpd[3] openDVS_pixel2x2_bot_712/vpd[2] rowReadON[44] rowReadON[45]
+ RefrBp PrBp PrSFBp col_periphery_1x2_8/COL_LINE0 pixRst[16] pixRst[17] col_periphery_1x2_8/COL_LINE1
+ OffBn rowReadOFF[44] rowReadOFF[45] openDVS_pixel2x2_bot_735/GndD DiffBn VSUBS OnBn
+ VDD openDVS_pixel2x2_bot
XopenDVS_pixel2x2_bot_575 openDVS_pixel2x2_bot_575/vpd[0] openDVS_pixel2x2_bot_575/vpd[1]
+ openDVS_pixel2x2_bot_575/vpd[3] openDVS_pixel2x2_bot_575/vpd[2] rowReadON[34] rowReadON[35]
+ RefrBp PrBp PrSFBp col_periphery_1x2_31/COL_LINE0 pixRst[62] pixRst[63] col_periphery_1x2_31/COL_LINE1
+ OffBn rowReadOFF[34] rowReadOFF[35] openDVS_pixel2x2_bot_575/GndD DiffBn VSUBS OnBn
+ VDD openDVS_pixel2x2_bot
XopenDVS_pixel2x2_bot_542 openDVS_pixel2x2_bot_542/vpd[0] openDVS_pixel2x2_bot_542/vpd[1]
+ openDVS_pixel2x2_bot_542/vpd[3] openDVS_pixel2x2_bot_542/vpd[2] rowReadON[32] rowReadON[33]
+ RefrBp PrBp PrSFBp col_periphery_1x2_30/COL_LINE0 pixRst[60] pixRst[61] col_periphery_1x2_30/COL_LINE1
+ OffBn rowReadOFF[32] rowReadOFF[33] openDVS_pixel2x2_bot_543/GndD DiffBn VSUBS OnBn
+ VDD openDVS_pixel2x2_bot
XopenDVS_pixel2x2_bot_597 openDVS_pixel2x2_bot_597/vpd[0] openDVS_pixel2x2_bot_597/vpd[1]
+ openDVS_pixel2x2_bot_597/vpd[3] openDVS_pixel2x2_bot_597/vpd[2] rowReadON[36] rowReadON[37]
+ RefrBp PrBp PrSFBp col_periphery_1x2_21/COL_LINE0 pixRst[42] pixRst[43] col_periphery_1x2_21/COL_LINE1
+ OffBn rowReadOFF[36] rowReadOFF[37] openDVS_pixel2x2_bot_607/GndD DiffBn VSUBS OnBn
+ VDD openDVS_pixel2x2_bot
XopenDVS_pixel2x2_bot_564 openDVS_pixel2x2_bot_564/vpd[0] openDVS_pixel2x2_bot_564/vpd[1]
+ openDVS_pixel2x2_bot_564/vpd[3] openDVS_pixel2x2_bot_564/vpd[2] rowReadON[34] rowReadON[35]
+ RefrBp PrBp PrSFBp col_periphery_1x2_20/COL_LINE0 pixRst[40] pixRst[41] col_periphery_1x2_20/COL_LINE1
+ OffBn rowReadOFF[34] rowReadOFF[35] openDVS_pixel2x2_bot_575/GndD DiffBn VSUBS OnBn
+ VDD openDVS_pixel2x2_bot
XopenDVS_pixel2x2_bot_531 openDVS_pixel2x2_bot_531/vpd[0] openDVS_pixel2x2_bot_531/vpd[1]
+ openDVS_pixel2x2_bot_531/vpd[3] openDVS_pixel2x2_bot_531/vpd[2] rowReadON[32] rowReadON[33]
+ RefrBp PrBp PrSFBp col_periphery_1x2_19/COL_LINE0 pixRst[38] pixRst[39] col_periphery_1x2_19/COL_LINE1
+ OffBn rowReadOFF[32] rowReadOFF[33] openDVS_pixel2x2_bot_543/GndD DiffBn VSUBS OnBn
+ VDD openDVS_pixel2x2_bot
XopenDVS_pixel2x2_bot_586 openDVS_pixel2x2_bot_586/vpd[0] openDVS_pixel2x2_bot_586/vpd[1]
+ openDVS_pixel2x2_bot_586/vpd[3] openDVS_pixel2x2_bot_586/vpd[2] rowReadON[36] rowReadON[37]
+ RefrBp PrBp PrSFBp col_periphery_1x2_10/COL_LINE0 pixRst[20] pixRst[21] col_periphery_1x2_10/COL_LINE1
+ OffBn rowReadOFF[36] rowReadOFF[37] openDVS_pixel2x2_bot_607/GndD DiffBn VSUBS OnBn
+ VDD openDVS_pixel2x2_bot
XopenDVS_pixel2x2_bot_553 openDVS_pixel2x2_bot_553/vpd[0] openDVS_pixel2x2_bot_553/vpd[1]
+ openDVS_pixel2x2_bot_553/vpd[3] openDVS_pixel2x2_bot_553/vpd[2] rowReadON[34] rowReadON[35]
+ RefrBp PrBp PrSFBp col_periphery_1x2_9/COL_LINE0 pixRst[18] pixRst[19] col_periphery_1x2_9/COL_LINE1
+ OffBn rowReadOFF[34] rowReadOFF[35] openDVS_pixel2x2_bot_575/GndD DiffBn VSUBS OnBn
+ VDD openDVS_pixel2x2_bot
XopenDVS_pixel2x2_bot_520 openDVS_pixel2x2_bot_520/vpd[0] openDVS_pixel2x2_bot_520/vpd[1]
+ openDVS_pixel2x2_bot_520/vpd[3] openDVS_pixel2x2_bot_520/vpd[2] rowReadON[32] rowReadON[33]
+ RefrBp PrBp PrSFBp col_periphery_1x2_8/COL_LINE0 pixRst[16] pixRst[17] col_periphery_1x2_8/COL_LINE1
+ OffBn rowReadOFF[32] rowReadOFF[33] openDVS_pixel2x2_bot_543/GndD DiffBn VSUBS OnBn
+ VDD openDVS_pixel2x2_bot
XopenDVS_pixel2x2_bot_383 openDVS_pixel2x2_bot_383/vpd[0] openDVS_pixel2x2_bot_383/vpd[1]
+ openDVS_pixel2x2_bot_383/vpd[3] openDVS_pixel2x2_bot_383/vpd[2] rowReadON[22] rowReadON[23]
+ RefrBp PrBp PrSFBp col_periphery_1x2_31/COL_LINE0 pixRst[62] pixRst[63] col_periphery_1x2_31/COL_LINE1
+ OffBn rowReadOFF[22] rowReadOFF[23] openDVS_pixel2x2_bot_383/GndD DiffBn VSUBS OnBn
+ VDD openDVS_pixel2x2_bot
XopenDVS_pixel2x2_bot_372 openDVS_pixel2x2_bot_372/vpd[0] openDVS_pixel2x2_bot_372/vpd[1]
+ openDVS_pixel2x2_bot_372/vpd[3] openDVS_pixel2x2_bot_372/vpd[2] rowReadON[22] rowReadON[23]
+ RefrBp PrBp PrSFBp col_periphery_1x2_20/COL_LINE0 pixRst[40] pixRst[41] col_periphery_1x2_20/COL_LINE1
+ OffBn rowReadOFF[22] rowReadOFF[23] openDVS_pixel2x2_bot_383/GndD DiffBn VSUBS OnBn
+ VDD openDVS_pixel2x2_bot
XopenDVS_pixel2x2_bot_394 openDVS_pixel2x2_bot_394/vpd[0] openDVS_pixel2x2_bot_394/vpd[1]
+ openDVS_pixel2x2_bot_394/vpd[3] openDVS_pixel2x2_bot_394/vpd[2] rowReadON[24] rowReadON[25]
+ RefrBp PrBp PrSFBp col_periphery_1x2_10/COL_LINE0 pixRst[20] pixRst[21] col_periphery_1x2_10/COL_LINE1
+ OffBn rowReadOFF[24] rowReadOFF[25] openDVS_pixel2x2_bot_415/GndD DiffBn VSUBS OnBn
+ VDD openDVS_pixel2x2_bot
XopenDVS_pixel2x2_bot_361 openDVS_pixel2x2_bot_361/vpd[0] openDVS_pixel2x2_bot_361/vpd[1]
+ openDVS_pixel2x2_bot_361/vpd[3] openDVS_pixel2x2_bot_361/vpd[2] rowReadON[22] rowReadON[23]
+ RefrBp PrBp PrSFBp col_periphery_1x2_9/COL_LINE0 pixRst[18] pixRst[19] col_periphery_1x2_9/COL_LINE1
+ OffBn rowReadOFF[22] rowReadOFF[23] openDVS_pixel2x2_bot_383/GndD DiffBn VSUBS OnBn
+ VDD openDVS_pixel2x2_bot
XopenDVS_pixel2x2_bot_350 openDVS_pixel2x2_bot_350/vpd[0] openDVS_pixel2x2_bot_350/vpd[1]
+ openDVS_pixel2x2_bot_350/vpd[3] openDVS_pixel2x2_bot_350/vpd[2] rowReadON[20] rowReadON[21]
+ RefrBp PrBp PrSFBp col_periphery_1x2_30/COL_LINE0 pixRst[60] pixRst[61] col_periphery_1x2_30/COL_LINE1
+ OffBn rowReadOFF[20] rowReadOFF[21] openDVS_pixel2x2_bot_351/GndD DiffBn VSUBS OnBn
+ VDD openDVS_pixel2x2_bot
XopenDVS_pixel2x2_bot_180 openDVS_pixel2x2_bot_180/vpd[0] openDVS_pixel2x2_bot_180/vpd[1]
+ openDVS_pixel2x2_bot_180/vpd[3] openDVS_pixel2x2_bot_180/vpd[2] rowReadON[10] rowReadON[11]
+ RefrBp PrBp PrSFBp col_periphery_1x2_20/COL_LINE0 pixRst[40] pixRst[41] col_periphery_1x2_20/COL_LINE1
+ OffBn rowReadOFF[10] rowReadOFF[11] openDVS_pixel2x2_bot_191/GndD DiffBn VSUBS OnBn
+ VDD openDVS_pixel2x2_bot
XopenDVS_pixel2x2_bot_191 openDVS_pixel2x2_bot_191/vpd[0] openDVS_pixel2x2_bot_191/vpd[1]
+ openDVS_pixel2x2_bot_191/vpd[3] openDVS_pixel2x2_bot_191/vpd[2] rowReadON[10] rowReadON[11]
+ RefrBp PrBp PrSFBp col_periphery_1x2_31/COL_LINE0 pixRst[62] pixRst[63] col_periphery_1x2_31/COL_LINE1
+ OffBn rowReadOFF[10] rowReadOFF[11] openDVS_pixel2x2_bot_191/GndD DiffBn VSUBS OnBn
+ VDD openDVS_pixel2x2_bot
XopenDVS_pixel2x2_bot_927 openDVS_pixel2x2_bot_927/vpd[0] openDVS_pixel2x2_bot_927/vpd[1]
+ openDVS_pixel2x2_bot_927/vpd[3] openDVS_pixel2x2_bot_927/vpd[2] rowReadON[56] rowReadON[57]
+ RefrBp PrBp PrSFBp col_periphery_1x2_31/COL_LINE0 pixRst[62] pixRst[63] col_periphery_1x2_31/COL_LINE1
+ OffBn rowReadOFF[56] rowReadOFF[57] openDVS_pixel2x2_bot_927/GndD DiffBn VSUBS OnBn
+ VDD openDVS_pixel2x2_bot
XopenDVS_pixel2x2_bot_949 openDVS_pixel2x2_bot_949/vpd[0] openDVS_pixel2x2_bot_949/vpd[1]
+ openDVS_pixel2x2_bot_949/vpd[3] openDVS_pixel2x2_bot_949/vpd[2] rowReadON[58] rowReadON[59]
+ RefrBp PrBp PrSFBp col_periphery_1x2_21/COL_LINE0 pixRst[42] pixRst[43] col_periphery_1x2_21/COL_LINE1
+ OffBn rowReadOFF[58] rowReadOFF[59] openDVS_pixel2x2_bot_959/GndD DiffBn VSUBS OnBn
+ VDD openDVS_pixel2x2_bot
XopenDVS_pixel2x2_bot_916 openDVS_pixel2x2_bot_916/vpd[0] openDVS_pixel2x2_bot_916/vpd[1]
+ openDVS_pixel2x2_bot_916/vpd[3] openDVS_pixel2x2_bot_916/vpd[2] rowReadON[56] rowReadON[57]
+ RefrBp PrBp PrSFBp col_periphery_1x2_20/COL_LINE0 pixRst[40] pixRst[41] col_periphery_1x2_20/COL_LINE1
+ OffBn rowReadOFF[56] rowReadOFF[57] openDVS_pixel2x2_bot_927/GndD DiffBn VSUBS OnBn
+ VDD openDVS_pixel2x2_bot
XopenDVS_pixel2x2_bot_938 openDVS_pixel2x2_bot_938/vpd[0] openDVS_pixel2x2_bot_938/vpd[1]
+ openDVS_pixel2x2_bot_938/vpd[3] openDVS_pixel2x2_bot_938/vpd[2] rowReadON[58] rowReadON[59]
+ RefrBp PrBp PrSFBp col_periphery_1x2_10/COL_LINE0 pixRst[20] pixRst[21] col_periphery_1x2_10/COL_LINE1
+ OffBn rowReadOFF[58] rowReadOFF[59] openDVS_pixel2x2_bot_959/GndD DiffBn VSUBS OnBn
+ VDD openDVS_pixel2x2_bot
XopenDVS_pixel2x2_bot_905 openDVS_pixel2x2_bot_905/vpd[0] openDVS_pixel2x2_bot_905/vpd[1]
+ openDVS_pixel2x2_bot_905/vpd[3] openDVS_pixel2x2_bot_905/vpd[2] rowReadON[56] rowReadON[57]
+ RefrBp PrBp PrSFBp col_periphery_1x2_9/COL_LINE0 pixRst[18] pixRst[19] col_periphery_1x2_9/COL_LINE1
+ OffBn rowReadOFF[56] rowReadOFF[57] openDVS_pixel2x2_bot_927/GndD DiffBn VSUBS OnBn
+ VDD openDVS_pixel2x2_bot
XopenDVS_pixel2x2_bot_735 openDVS_pixel2x2_bot_735/vpd[0] openDVS_pixel2x2_bot_735/vpd[1]
+ openDVS_pixel2x2_bot_735/vpd[3] openDVS_pixel2x2_bot_735/vpd[2] rowReadON[44] rowReadON[45]
+ RefrBp PrBp PrSFBp col_periphery_1x2_31/COL_LINE0 pixRst[62] pixRst[63] col_periphery_1x2_31/COL_LINE1
+ OffBn rowReadOFF[44] rowReadOFF[45] openDVS_pixel2x2_bot_735/GndD DiffBn VSUBS OnBn
+ VDD openDVS_pixel2x2_bot
XopenDVS_pixel2x2_bot_702 openDVS_pixel2x2_bot_702/vpd[0] openDVS_pixel2x2_bot_702/vpd[1]
+ openDVS_pixel2x2_bot_702/vpd[3] openDVS_pixel2x2_bot_702/vpd[2] rowReadON[42] rowReadON[43]
+ RefrBp PrBp PrSFBp col_periphery_1x2_30/COL_LINE0 pixRst[60] pixRst[61] col_periphery_1x2_30/COL_LINE1
+ OffBn rowReadOFF[42] rowReadOFF[43] openDVS_pixel2x2_bot_703/GndD DiffBn VSUBS OnBn
+ VDD openDVS_pixel2x2_bot
XopenDVS_pixel2x2_bot_757 openDVS_pixel2x2_bot_757/vpd[0] openDVS_pixel2x2_bot_757/vpd[1]
+ openDVS_pixel2x2_bot_757/vpd[3] openDVS_pixel2x2_bot_757/vpd[2] rowReadON[46] rowReadON[47]
+ RefrBp PrBp PrSFBp col_periphery_1x2_21/COL_LINE0 pixRst[42] pixRst[43] col_periphery_1x2_21/COL_LINE1
+ OffBn rowReadOFF[46] rowReadOFF[47] openDVS_pixel2x2_bot_767/GndD DiffBn VSUBS OnBn
+ VDD openDVS_pixel2x2_bot
XopenDVS_pixel2x2_bot_724 openDVS_pixel2x2_bot_724/vpd[0] openDVS_pixel2x2_bot_724/vpd[1]
+ openDVS_pixel2x2_bot_724/vpd[3] openDVS_pixel2x2_bot_724/vpd[2] rowReadON[44] rowReadON[45]
+ RefrBp PrBp PrSFBp col_periphery_1x2_20/COL_LINE0 pixRst[40] pixRst[41] col_periphery_1x2_20/COL_LINE1
+ OffBn rowReadOFF[44] rowReadOFF[45] openDVS_pixel2x2_bot_735/GndD DiffBn VSUBS OnBn
+ VDD openDVS_pixel2x2_bot
XopenDVS_pixel2x2_bot_779 openDVS_pixel2x2_bot_779/vpd[0] openDVS_pixel2x2_bot_779/vpd[1]
+ openDVS_pixel2x2_bot_779/vpd[3] openDVS_pixel2x2_bot_779/vpd[2] rowReadON[48] rowReadON[49]
+ RefrBp PrBp PrSFBp col_periphery_1x2_11/COL_LINE0 pixRst[22] pixRst[23] col_periphery_1x2_11/COL_LINE1
+ OffBn rowReadOFF[48] rowReadOFF[49] openDVS_pixel2x2_bot_799/GndD DiffBn VSUBS OnBn
+ VDD openDVS_pixel2x2_bot
XopenDVS_pixel2x2_bot_746 openDVS_pixel2x2_bot_746/vpd[0] openDVS_pixel2x2_bot_746/vpd[1]
+ openDVS_pixel2x2_bot_746/vpd[3] openDVS_pixel2x2_bot_746/vpd[2] rowReadON[46] rowReadON[47]
+ RefrBp PrBp PrSFBp col_periphery_1x2_10/COL_LINE0 pixRst[20] pixRst[21] col_periphery_1x2_10/COL_LINE1
+ OffBn rowReadOFF[46] rowReadOFF[47] openDVS_pixel2x2_bot_767/GndD DiffBn VSUBS OnBn
+ VDD openDVS_pixel2x2_bot
XopenDVS_pixel2x2_bot_713 openDVS_pixel2x2_bot_713/vpd[0] openDVS_pixel2x2_bot_713/vpd[1]
+ openDVS_pixel2x2_bot_713/vpd[3] openDVS_pixel2x2_bot_713/vpd[2] rowReadON[44] rowReadON[45]
+ RefrBp PrBp PrSFBp col_periphery_1x2_9/COL_LINE0 pixRst[18] pixRst[19] col_periphery_1x2_9/COL_LINE1
+ OffBn rowReadOFF[44] rowReadOFF[45] openDVS_pixel2x2_bot_735/GndD DiffBn VSUBS OnBn
+ VDD openDVS_pixel2x2_bot
XopenDVS_pixel2x2_bot_768 openDVS_pixel2x2_bot_768/vpd[0] openDVS_pixel2x2_bot_768/vpd[1]
+ openDVS_pixel2x2_bot_768/vpd[3] openDVS_pixel2x2_bot_768/vpd[2] rowReadON[48] rowReadON[49]
+ RefrBp PrBp PrSFBp col_periphery_1x2_0/COL_LINE0 pixRst[0] pixRst[1] col_periphery_1x2_0/COL_LINE1
+ OffBn rowReadOFF[48] rowReadOFF[49] openDVS_pixel2x2_bot_799/GndD DiffBn VSUBS OnBn
+ VDD openDVS_pixel2x2_bot
XopenDVS_pixel2x2_bot_532 openDVS_pixel2x2_bot_532/vpd[0] openDVS_pixel2x2_bot_532/vpd[1]
+ openDVS_pixel2x2_bot_532/vpd[3] openDVS_pixel2x2_bot_532/vpd[2] rowReadON[32] rowReadON[33]
+ RefrBp PrBp PrSFBp col_periphery_1x2_20/COL_LINE0 pixRst[40] pixRst[41] col_periphery_1x2_20/COL_LINE1
+ OffBn rowReadOFF[32] rowReadOFF[33] openDVS_pixel2x2_bot_543/GndD DiffBn VSUBS OnBn
+ VDD openDVS_pixel2x2_bot
XopenDVS_pixel2x2_bot_521 openDVS_pixel2x2_bot_521/vpd[0] openDVS_pixel2x2_bot_521/vpd[1]
+ openDVS_pixel2x2_bot_521/vpd[3] openDVS_pixel2x2_bot_521/vpd[2] rowReadON[32] rowReadON[33]
+ RefrBp PrBp PrSFBp col_periphery_1x2_9/COL_LINE0 pixRst[18] pixRst[19] col_periphery_1x2_9/COL_LINE1
+ OffBn rowReadOFF[32] rowReadOFF[33] openDVS_pixel2x2_bot_543/GndD DiffBn VSUBS OnBn
+ VDD openDVS_pixel2x2_bot
XopenDVS_pixel2x2_bot_510 openDVS_pixel2x2_bot_510/vpd[0] openDVS_pixel2x2_bot_510/vpd[1]
+ openDVS_pixel2x2_bot_510/vpd[3] openDVS_pixel2x2_bot_510/vpd[2] rowReadON[30] rowReadON[31]
+ RefrBp PrBp PrSFBp col_periphery_1x2_30/COL_LINE0 pixRst[60] pixRst[61] col_periphery_1x2_30/COL_LINE1
+ OffBn rowReadOFF[30] rowReadOFF[31] openDVS_pixel2x2_bot_511/GndD DiffBn VSUBS OnBn
+ VDD openDVS_pixel2x2_bot
XopenDVS_pixel2x2_bot_543 openDVS_pixel2x2_bot_543/vpd[0] openDVS_pixel2x2_bot_543/vpd[1]
+ openDVS_pixel2x2_bot_543/vpd[3] openDVS_pixel2x2_bot_543/vpd[2] rowReadON[32] rowReadON[33]
+ RefrBp PrBp PrSFBp col_periphery_1x2_31/COL_LINE0 pixRst[62] pixRst[63] col_periphery_1x2_31/COL_LINE1
+ OffBn rowReadOFF[32] rowReadOFF[33] openDVS_pixel2x2_bot_543/GndD DiffBn VSUBS OnBn
+ VDD openDVS_pixel2x2_bot
XopenDVS_pixel2x2_bot_598 openDVS_pixel2x2_bot_598/vpd[0] openDVS_pixel2x2_bot_598/vpd[1]
+ openDVS_pixel2x2_bot_598/vpd[3] openDVS_pixel2x2_bot_598/vpd[2] rowReadON[36] rowReadON[37]
+ RefrBp PrBp PrSFBp col_periphery_1x2_22/COL_LINE0 pixRst[44] pixRst[45] col_periphery_1x2_22/COL_LINE1
+ OffBn rowReadOFF[36] rowReadOFF[37] openDVS_pixel2x2_bot_607/GndD DiffBn VSUBS OnBn
+ VDD openDVS_pixel2x2_bot
XopenDVS_pixel2x2_bot_565 openDVS_pixel2x2_bot_565/vpd[0] openDVS_pixel2x2_bot_565/vpd[1]
+ openDVS_pixel2x2_bot_565/vpd[3] openDVS_pixel2x2_bot_565/vpd[2] rowReadON[34] rowReadON[35]
+ RefrBp PrBp PrSFBp col_periphery_1x2_21/COL_LINE0 pixRst[42] pixRst[43] col_periphery_1x2_21/COL_LINE1
+ OffBn rowReadOFF[34] rowReadOFF[35] openDVS_pixel2x2_bot_575/GndD DiffBn VSUBS OnBn
+ VDD openDVS_pixel2x2_bot
XopenDVS_pixel2x2_bot_587 openDVS_pixel2x2_bot_587/vpd[0] openDVS_pixel2x2_bot_587/vpd[1]
+ openDVS_pixel2x2_bot_587/vpd[3] openDVS_pixel2x2_bot_587/vpd[2] rowReadON[36] rowReadON[37]
+ RefrBp PrBp PrSFBp col_periphery_1x2_11/COL_LINE0 pixRst[22] pixRst[23] col_periphery_1x2_11/COL_LINE1
+ OffBn rowReadOFF[36] rowReadOFF[37] openDVS_pixel2x2_bot_607/GndD DiffBn VSUBS OnBn
+ VDD openDVS_pixel2x2_bot
XopenDVS_pixel2x2_bot_554 openDVS_pixel2x2_bot_554/vpd[0] openDVS_pixel2x2_bot_554/vpd[1]
+ openDVS_pixel2x2_bot_554/vpd[3] openDVS_pixel2x2_bot_554/vpd[2] rowReadON[34] rowReadON[35]
+ RefrBp PrBp PrSFBp col_periphery_1x2_10/COL_LINE0 pixRst[20] pixRst[21] col_periphery_1x2_10/COL_LINE1
+ OffBn rowReadOFF[34] rowReadOFF[35] openDVS_pixel2x2_bot_575/GndD DiffBn VSUBS OnBn
+ VDD openDVS_pixel2x2_bot
XopenDVS_pixel2x2_bot_576 openDVS_pixel2x2_bot_576/vpd[0] openDVS_pixel2x2_bot_576/vpd[1]
+ openDVS_pixel2x2_bot_576/vpd[3] openDVS_pixel2x2_bot_576/vpd[2] rowReadON[36] rowReadON[37]
+ RefrBp PrBp PrSFBp col_periphery_1x2_0/COL_LINE0 pixRst[0] pixRst[1] col_periphery_1x2_0/COL_LINE1
+ OffBn rowReadOFF[36] rowReadOFF[37] openDVS_pixel2x2_bot_607/GndD DiffBn VSUBS OnBn
+ VDD openDVS_pixel2x2_bot
XopenDVS_pixel2x2_bot_373 openDVS_pixel2x2_bot_373/vpd[0] openDVS_pixel2x2_bot_373/vpd[1]
+ openDVS_pixel2x2_bot_373/vpd[3] openDVS_pixel2x2_bot_373/vpd[2] rowReadON[22] rowReadON[23]
+ RefrBp PrBp PrSFBp col_periphery_1x2_21/COL_LINE0 pixRst[42] pixRst[43] col_periphery_1x2_21/COL_LINE1
+ OffBn rowReadOFF[22] rowReadOFF[23] openDVS_pixel2x2_bot_383/GndD DiffBn VSUBS OnBn
+ VDD openDVS_pixel2x2_bot
XopenDVS_pixel2x2_bot_395 openDVS_pixel2x2_bot_395/vpd[0] openDVS_pixel2x2_bot_395/vpd[1]
+ openDVS_pixel2x2_bot_395/vpd[3] openDVS_pixel2x2_bot_395/vpd[2] rowReadON[24] rowReadON[25]
+ RefrBp PrBp PrSFBp col_periphery_1x2_11/COL_LINE0 pixRst[22] pixRst[23] col_periphery_1x2_11/COL_LINE1
+ OffBn rowReadOFF[24] rowReadOFF[25] openDVS_pixel2x2_bot_415/GndD DiffBn VSUBS OnBn
+ VDD openDVS_pixel2x2_bot
XopenDVS_pixel2x2_bot_362 openDVS_pixel2x2_bot_362/vpd[0] openDVS_pixel2x2_bot_362/vpd[1]
+ openDVS_pixel2x2_bot_362/vpd[3] openDVS_pixel2x2_bot_362/vpd[2] rowReadON[22] rowReadON[23]
+ RefrBp PrBp PrSFBp col_periphery_1x2_10/COL_LINE0 pixRst[20] pixRst[21] col_periphery_1x2_10/COL_LINE1
+ OffBn rowReadOFF[22] rowReadOFF[23] openDVS_pixel2x2_bot_383/GndD DiffBn VSUBS OnBn
+ VDD openDVS_pixel2x2_bot
XopenDVS_pixel2x2_bot_384 openDVS_pixel2x2_bot_384/vpd[0] openDVS_pixel2x2_bot_384/vpd[1]
+ openDVS_pixel2x2_bot_384/vpd[3] openDVS_pixel2x2_bot_384/vpd[2] rowReadON[24] rowReadON[25]
+ RefrBp PrBp PrSFBp col_periphery_1x2_0/COL_LINE0 pixRst[0] pixRst[1] col_periphery_1x2_0/COL_LINE1
+ OffBn rowReadOFF[24] rowReadOFF[25] openDVS_pixel2x2_bot_415/GndD DiffBn VSUBS OnBn
+ VDD openDVS_pixel2x2_bot
XopenDVS_pixel2x2_bot_340 openDVS_pixel2x2_bot_340/vpd[0] openDVS_pixel2x2_bot_340/vpd[1]
+ openDVS_pixel2x2_bot_340/vpd[3] openDVS_pixel2x2_bot_340/vpd[2] rowReadON[20] rowReadON[21]
+ RefrBp PrBp PrSFBp col_periphery_1x2_20/COL_LINE0 pixRst[40] pixRst[41] col_periphery_1x2_20/COL_LINE1
+ OffBn rowReadOFF[20] rowReadOFF[21] openDVS_pixel2x2_bot_351/GndD DiffBn VSUBS OnBn
+ VDD openDVS_pixel2x2_bot
XopenDVS_pixel2x2_bot_351 openDVS_pixel2x2_bot_351/vpd[0] openDVS_pixel2x2_bot_351/vpd[1]
+ openDVS_pixel2x2_bot_351/vpd[3] openDVS_pixel2x2_bot_351/vpd[2] rowReadON[20] rowReadON[21]
+ RefrBp PrBp PrSFBp col_periphery_1x2_31/COL_LINE0 pixRst[62] pixRst[63] col_periphery_1x2_31/COL_LINE1
+ OffBn rowReadOFF[20] rowReadOFF[21] openDVS_pixel2x2_bot_351/GndD DiffBn VSUBS OnBn
+ VDD openDVS_pixel2x2_bot
XopenDVS_pixel2x2_bot_170 openDVS_pixel2x2_bot_170/vpd[0] openDVS_pixel2x2_bot_170/vpd[1]
+ openDVS_pixel2x2_bot_170/vpd[3] openDVS_pixel2x2_bot_170/vpd[2] rowReadON[10] rowReadON[11]
+ RefrBp PrBp PrSFBp col_periphery_1x2_10/COL_LINE0 pixRst[20] pixRst[21] col_periphery_1x2_10/COL_LINE1
+ OffBn rowReadOFF[10] rowReadOFF[11] openDVS_pixel2x2_bot_191/GndD DiffBn VSUBS OnBn
+ VDD openDVS_pixel2x2_bot
XopenDVS_pixel2x2_bot_181 openDVS_pixel2x2_bot_181/vpd[0] openDVS_pixel2x2_bot_181/vpd[1]
+ openDVS_pixel2x2_bot_181/vpd[3] openDVS_pixel2x2_bot_181/vpd[2] rowReadON[10] rowReadON[11]
+ RefrBp PrBp PrSFBp col_periphery_1x2_21/COL_LINE0 pixRst[42] pixRst[43] col_periphery_1x2_21/COL_LINE1
+ OffBn rowReadOFF[10] rowReadOFF[11] openDVS_pixel2x2_bot_191/GndD DiffBn VSUBS OnBn
+ VDD openDVS_pixel2x2_bot
XopenDVS_pixel2x2_bot_192 openDVS_pixel2x2_bot_192/vpd[0] openDVS_pixel2x2_bot_192/vpd[1]
+ openDVS_pixel2x2_bot_192/vpd[3] openDVS_pixel2x2_bot_192/vpd[2] rowReadON[12] rowReadON[13]
+ RefrBp PrBp PrSFBp col_periphery_1x2_0/COL_LINE0 pixRst[0] pixRst[1] col_periphery_1x2_0/COL_LINE1
+ OffBn rowReadOFF[12] rowReadOFF[13] openDVS_pixel2x2_bot_223/GndD DiffBn VSUBS OnBn
+ VDD openDVS_pixel2x2_bot
XopenDVS_pixel2x2_bot_917 openDVS_pixel2x2_bot_917/vpd[0] openDVS_pixel2x2_bot_917/vpd[1]
+ openDVS_pixel2x2_bot_917/vpd[3] openDVS_pixel2x2_bot_917/vpd[2] rowReadON[56] rowReadON[57]
+ RefrBp PrBp PrSFBp col_periphery_1x2_21/COL_LINE0 pixRst[42] pixRst[43] col_periphery_1x2_21/COL_LINE1
+ OffBn rowReadOFF[56] rowReadOFF[57] openDVS_pixel2x2_bot_927/GndD DiffBn VSUBS OnBn
+ VDD openDVS_pixel2x2_bot
XopenDVS_pixel2x2_bot_939 openDVS_pixel2x2_bot_939/vpd[0] openDVS_pixel2x2_bot_939/vpd[1]
+ openDVS_pixel2x2_bot_939/vpd[3] openDVS_pixel2x2_bot_939/vpd[2] rowReadON[58] rowReadON[59]
+ RefrBp PrBp PrSFBp col_periphery_1x2_11/COL_LINE0 pixRst[22] pixRst[23] col_periphery_1x2_11/COL_LINE1
+ OffBn rowReadOFF[58] rowReadOFF[59] openDVS_pixel2x2_bot_959/GndD DiffBn VSUBS OnBn
+ VDD openDVS_pixel2x2_bot
XopenDVS_pixel2x2_bot_906 openDVS_pixel2x2_bot_906/vpd[0] openDVS_pixel2x2_bot_906/vpd[1]
+ openDVS_pixel2x2_bot_906/vpd[3] openDVS_pixel2x2_bot_906/vpd[2] rowReadON[56] rowReadON[57]
+ RefrBp PrBp PrSFBp col_periphery_1x2_10/COL_LINE0 pixRst[20] pixRst[21] col_periphery_1x2_10/COL_LINE1
+ OffBn rowReadOFF[56] rowReadOFF[57] openDVS_pixel2x2_bot_927/GndD DiffBn VSUBS OnBn
+ VDD openDVS_pixel2x2_bot
XopenDVS_pixel2x2_bot_928 openDVS_pixel2x2_bot_928/vpd[0] openDVS_pixel2x2_bot_928/vpd[1]
+ openDVS_pixel2x2_bot_928/vpd[3] openDVS_pixel2x2_bot_928/vpd[2] rowReadON[58] rowReadON[59]
+ RefrBp PrBp PrSFBp col_periphery_1x2_0/COL_LINE0 pixRst[0] pixRst[1] col_periphery_1x2_0/COL_LINE1
+ OffBn rowReadOFF[58] rowReadOFF[59] openDVS_pixel2x2_bot_959/GndD DiffBn VSUBS OnBn
+ VDD openDVS_pixel2x2_bot
XopenDVS_pixel2x2_bot_703 openDVS_pixel2x2_bot_703/vpd[0] openDVS_pixel2x2_bot_703/vpd[1]
+ openDVS_pixel2x2_bot_703/vpd[3] openDVS_pixel2x2_bot_703/vpd[2] rowReadON[42] rowReadON[43]
+ RefrBp PrBp PrSFBp col_periphery_1x2_31/COL_LINE0 pixRst[62] pixRst[63] col_periphery_1x2_31/COL_LINE1
+ OffBn rowReadOFF[42] rowReadOFF[43] openDVS_pixel2x2_bot_703/GndD DiffBn VSUBS OnBn
+ VDD openDVS_pixel2x2_bot
XopenDVS_pixel2x2_bot_758 openDVS_pixel2x2_bot_758/vpd[0] openDVS_pixel2x2_bot_758/vpd[1]
+ openDVS_pixel2x2_bot_758/vpd[3] openDVS_pixel2x2_bot_758/vpd[2] rowReadON[46] rowReadON[47]
+ RefrBp PrBp PrSFBp col_periphery_1x2_22/COL_LINE0 pixRst[44] pixRst[45] col_periphery_1x2_22/COL_LINE1
+ OffBn rowReadOFF[46] rowReadOFF[47] openDVS_pixel2x2_bot_767/GndD DiffBn VSUBS OnBn
+ VDD openDVS_pixel2x2_bot
XopenDVS_pixel2x2_bot_725 openDVS_pixel2x2_bot_725/vpd[0] openDVS_pixel2x2_bot_725/vpd[1]
+ openDVS_pixel2x2_bot_725/vpd[3] openDVS_pixel2x2_bot_725/vpd[2] rowReadON[44] rowReadON[45]
+ RefrBp PrBp PrSFBp col_periphery_1x2_21/COL_LINE0 pixRst[42] pixRst[43] col_periphery_1x2_21/COL_LINE1
+ OffBn rowReadOFF[44] rowReadOFF[45] openDVS_pixel2x2_bot_735/GndD DiffBn VSUBS OnBn
+ VDD openDVS_pixel2x2_bot
XopenDVS_pixel2x2_bot_747 openDVS_pixel2x2_bot_747/vpd[0] openDVS_pixel2x2_bot_747/vpd[1]
+ openDVS_pixel2x2_bot_747/vpd[3] openDVS_pixel2x2_bot_747/vpd[2] rowReadON[46] rowReadON[47]
+ RefrBp PrBp PrSFBp col_periphery_1x2_11/COL_LINE0 pixRst[22] pixRst[23] col_periphery_1x2_11/COL_LINE1
+ OffBn rowReadOFF[46] rowReadOFF[47] openDVS_pixel2x2_bot_767/GndD DiffBn VSUBS OnBn
+ VDD openDVS_pixel2x2_bot
XopenDVS_pixel2x2_bot_714 openDVS_pixel2x2_bot_714/vpd[0] openDVS_pixel2x2_bot_714/vpd[1]
+ openDVS_pixel2x2_bot_714/vpd[3] openDVS_pixel2x2_bot_714/vpd[2] rowReadON[44] rowReadON[45]
+ RefrBp PrBp PrSFBp col_periphery_1x2_10/COL_LINE0 pixRst[20] pixRst[21] col_periphery_1x2_10/COL_LINE1
+ OffBn rowReadOFF[44] rowReadOFF[45] openDVS_pixel2x2_bot_735/GndD DiffBn VSUBS OnBn
+ VDD openDVS_pixel2x2_bot
XopenDVS_pixel2x2_bot_769 openDVS_pixel2x2_bot_769/vpd[0] openDVS_pixel2x2_bot_769/vpd[1]
+ openDVS_pixel2x2_bot_769/vpd[3] openDVS_pixel2x2_bot_769/vpd[2] rowReadON[48] rowReadON[49]
+ RefrBp PrBp PrSFBp col_periphery_1x2_1/COL_LINE0 pixRst[2] pixRst[3] col_periphery_1x2_1/COL_LINE1
+ OffBn rowReadOFF[48] rowReadOFF[49] openDVS_pixel2x2_bot_799/GndD DiffBn VSUBS OnBn
+ VDD openDVS_pixel2x2_bot
XopenDVS_pixel2x2_bot_736 openDVS_pixel2x2_bot_736/vpd[0] openDVS_pixel2x2_bot_736/vpd[1]
+ openDVS_pixel2x2_bot_736/vpd[3] openDVS_pixel2x2_bot_736/vpd[2] rowReadON[46] rowReadON[47]
+ RefrBp PrBp PrSFBp col_periphery_1x2_0/COL_LINE0 pixRst[0] pixRst[1] col_periphery_1x2_0/COL_LINE1
+ OffBn rowReadOFF[46] rowReadOFF[47] openDVS_pixel2x2_bot_767/GndD DiffBn VSUBS OnBn
+ VDD openDVS_pixel2x2_bot
XopenDVS_pixel2x2_bot_599 openDVS_pixel2x2_bot_599/vpd[0] openDVS_pixel2x2_bot_599/vpd[1]
+ openDVS_pixel2x2_bot_599/vpd[3] openDVS_pixel2x2_bot_599/vpd[2] rowReadON[36] rowReadON[37]
+ RefrBp PrBp PrSFBp col_periphery_1x2_23/COL_LINE0 pixRst[46] pixRst[47] col_periphery_1x2_23/COL_LINE1
+ OffBn rowReadOFF[36] rowReadOFF[37] openDVS_pixel2x2_bot_607/GndD DiffBn VSUBS OnBn
+ VDD openDVS_pixel2x2_bot
XopenDVS_pixel2x2_bot_566 openDVS_pixel2x2_bot_566/vpd[0] openDVS_pixel2x2_bot_566/vpd[1]
+ openDVS_pixel2x2_bot_566/vpd[3] openDVS_pixel2x2_bot_566/vpd[2] rowReadON[34] rowReadON[35]
+ RefrBp PrBp PrSFBp col_periphery_1x2_22/COL_LINE0 pixRst[44] pixRst[45] col_periphery_1x2_22/COL_LINE1
+ OffBn rowReadOFF[34] rowReadOFF[35] openDVS_pixel2x2_bot_575/GndD DiffBn VSUBS OnBn
+ VDD openDVS_pixel2x2_bot
XopenDVS_pixel2x2_bot_533 openDVS_pixel2x2_bot_533/vpd[0] openDVS_pixel2x2_bot_533/vpd[1]
+ openDVS_pixel2x2_bot_533/vpd[3] openDVS_pixel2x2_bot_533/vpd[2] rowReadON[32] rowReadON[33]
+ RefrBp PrBp PrSFBp col_periphery_1x2_21/COL_LINE0 pixRst[42] pixRst[43] col_periphery_1x2_21/COL_LINE1
+ OffBn rowReadOFF[32] rowReadOFF[33] openDVS_pixel2x2_bot_543/GndD DiffBn VSUBS OnBn
+ VDD openDVS_pixel2x2_bot
XopenDVS_pixel2x2_bot_588 openDVS_pixel2x2_bot_588/vpd[0] openDVS_pixel2x2_bot_588/vpd[1]
+ openDVS_pixel2x2_bot_588/vpd[3] openDVS_pixel2x2_bot_588/vpd[2] rowReadON[36] rowReadON[37]
+ RefrBp PrBp PrSFBp col_periphery_1x2_12/COL_LINE0 pixRst[24] pixRst[25] col_periphery_1x2_12/COL_LINE1
+ OffBn rowReadOFF[36] rowReadOFF[37] openDVS_pixel2x2_bot_607/GndD DiffBn VSUBS OnBn
+ VDD openDVS_pixel2x2_bot
XopenDVS_pixel2x2_bot_555 openDVS_pixel2x2_bot_555/vpd[0] openDVS_pixel2x2_bot_555/vpd[1]
+ openDVS_pixel2x2_bot_555/vpd[3] openDVS_pixel2x2_bot_555/vpd[2] rowReadON[34] rowReadON[35]
+ RefrBp PrBp PrSFBp col_periphery_1x2_11/COL_LINE0 pixRst[22] pixRst[23] col_periphery_1x2_11/COL_LINE1
+ OffBn rowReadOFF[34] rowReadOFF[35] openDVS_pixel2x2_bot_575/GndD DiffBn VSUBS OnBn
+ VDD openDVS_pixel2x2_bot
XopenDVS_pixel2x2_bot_522 openDVS_pixel2x2_bot_522/vpd[0] openDVS_pixel2x2_bot_522/vpd[1]
+ openDVS_pixel2x2_bot_522/vpd[3] openDVS_pixel2x2_bot_522/vpd[2] rowReadON[32] rowReadON[33]
+ RefrBp PrBp PrSFBp col_periphery_1x2_10/COL_LINE0 pixRst[20] pixRst[21] col_periphery_1x2_10/COL_LINE1
+ OffBn rowReadOFF[32] rowReadOFF[33] openDVS_pixel2x2_bot_543/GndD DiffBn VSUBS OnBn
+ VDD openDVS_pixel2x2_bot
XopenDVS_pixel2x2_bot_577 openDVS_pixel2x2_bot_577/vpd[0] openDVS_pixel2x2_bot_577/vpd[1]
+ openDVS_pixel2x2_bot_577/vpd[3] openDVS_pixel2x2_bot_577/vpd[2] rowReadON[36] rowReadON[37]
+ RefrBp PrBp PrSFBp col_periphery_1x2_1/COL_LINE0 pixRst[2] pixRst[3] col_periphery_1x2_1/COL_LINE1
+ OffBn rowReadOFF[36] rowReadOFF[37] openDVS_pixel2x2_bot_607/GndD DiffBn VSUBS OnBn
+ VDD openDVS_pixel2x2_bot
XopenDVS_pixel2x2_bot_544 openDVS_pixel2x2_bot_544/vpd[0] openDVS_pixel2x2_bot_544/vpd[1]
+ openDVS_pixel2x2_bot_544/vpd[3] openDVS_pixel2x2_bot_544/vpd[2] rowReadON[34] rowReadON[35]
+ RefrBp PrBp PrSFBp col_periphery_1x2_0/COL_LINE0 pixRst[0] pixRst[1] col_periphery_1x2_0/COL_LINE1
+ OffBn rowReadOFF[34] rowReadOFF[35] openDVS_pixel2x2_bot_575/GndD DiffBn VSUBS OnBn
+ VDD openDVS_pixel2x2_bot
XopenDVS_pixel2x2_bot_511 openDVS_pixel2x2_bot_511/vpd[0] openDVS_pixel2x2_bot_511/vpd[1]
+ openDVS_pixel2x2_bot_511/vpd[3] openDVS_pixel2x2_bot_511/vpd[2] rowReadON[30] rowReadON[31]
+ RefrBp PrBp PrSFBp col_periphery_1x2_31/COL_LINE0 pixRst[62] pixRst[63] col_periphery_1x2_31/COL_LINE1
+ OffBn rowReadOFF[30] rowReadOFF[31] openDVS_pixel2x2_bot_511/GndD DiffBn VSUBS OnBn
+ VDD openDVS_pixel2x2_bot
XopenDVS_pixel2x2_bot_500 openDVS_pixel2x2_bot_500/vpd[0] openDVS_pixel2x2_bot_500/vpd[1]
+ openDVS_pixel2x2_bot_500/vpd[3] openDVS_pixel2x2_bot_500/vpd[2] rowReadON[30] rowReadON[31]
+ RefrBp PrBp PrSFBp col_periphery_1x2_20/COL_LINE0 pixRst[40] pixRst[41] col_periphery_1x2_20/COL_LINE1
+ OffBn rowReadOFF[30] rowReadOFF[31] openDVS_pixel2x2_bot_511/GndD DiffBn VSUBS OnBn
+ VDD openDVS_pixel2x2_bot
XopenDVS_pixel2x2_bot_374 openDVS_pixel2x2_bot_374/vpd[0] openDVS_pixel2x2_bot_374/vpd[1]
+ openDVS_pixel2x2_bot_374/vpd[3] openDVS_pixel2x2_bot_374/vpd[2] rowReadON[22] rowReadON[23]
+ RefrBp PrBp PrSFBp col_periphery_1x2_22/COL_LINE0 pixRst[44] pixRst[45] col_periphery_1x2_22/COL_LINE1
+ OffBn rowReadOFF[22] rowReadOFF[23] openDVS_pixel2x2_bot_383/GndD DiffBn VSUBS OnBn
+ VDD openDVS_pixel2x2_bot
XopenDVS_pixel2x2_bot_396 openDVS_pixel2x2_bot_396/vpd[0] openDVS_pixel2x2_bot_396/vpd[1]
+ openDVS_pixel2x2_bot_396/vpd[3] openDVS_pixel2x2_bot_396/vpd[2] rowReadON[24] rowReadON[25]
+ RefrBp PrBp PrSFBp col_periphery_1x2_12/COL_LINE0 pixRst[24] pixRst[25] col_periphery_1x2_12/COL_LINE1
+ OffBn rowReadOFF[24] rowReadOFF[25] openDVS_pixel2x2_bot_415/GndD DiffBn VSUBS OnBn
+ VDD openDVS_pixel2x2_bot
XopenDVS_pixel2x2_bot_363 openDVS_pixel2x2_bot_363/vpd[0] openDVS_pixel2x2_bot_363/vpd[1]
+ openDVS_pixel2x2_bot_363/vpd[3] openDVS_pixel2x2_bot_363/vpd[2] rowReadON[22] rowReadON[23]
+ RefrBp PrBp PrSFBp col_periphery_1x2_11/COL_LINE0 pixRst[22] pixRst[23] col_periphery_1x2_11/COL_LINE1
+ OffBn rowReadOFF[22] rowReadOFF[23] openDVS_pixel2x2_bot_383/GndD DiffBn VSUBS OnBn
+ VDD openDVS_pixel2x2_bot
XopenDVS_pixel2x2_bot_385 openDVS_pixel2x2_bot_385/vpd[0] openDVS_pixel2x2_bot_385/vpd[1]
+ openDVS_pixel2x2_bot_385/vpd[3] openDVS_pixel2x2_bot_385/vpd[2] rowReadON[24] rowReadON[25]
+ RefrBp PrBp PrSFBp col_periphery_1x2_1/COL_LINE0 pixRst[2] pixRst[3] col_periphery_1x2_1/COL_LINE1
+ OffBn rowReadOFF[24] rowReadOFF[25] openDVS_pixel2x2_bot_415/GndD DiffBn VSUBS OnBn
+ VDD openDVS_pixel2x2_bot
XopenDVS_pixel2x2_bot_352 openDVS_pixel2x2_bot_352/vpd[0] openDVS_pixel2x2_bot_352/vpd[1]
+ openDVS_pixel2x2_bot_352/vpd[3] openDVS_pixel2x2_bot_352/vpd[2] rowReadON[22] rowReadON[23]
+ RefrBp PrBp PrSFBp col_periphery_1x2_0/COL_LINE0 pixRst[0] pixRst[1] col_periphery_1x2_0/COL_LINE1
+ OffBn rowReadOFF[22] rowReadOFF[23] openDVS_pixel2x2_bot_383/GndD DiffBn VSUBS OnBn
+ VDD openDVS_pixel2x2_bot
XopenDVS_pixel2x2_bot_330 openDVS_pixel2x2_bot_330/vpd[0] openDVS_pixel2x2_bot_330/vpd[1]
+ openDVS_pixel2x2_bot_330/vpd[3] openDVS_pixel2x2_bot_330/vpd[2] rowReadON[20] rowReadON[21]
+ RefrBp PrBp PrSFBp col_periphery_1x2_10/COL_LINE0 pixRst[20] pixRst[21] col_periphery_1x2_10/COL_LINE1
+ OffBn rowReadOFF[20] rowReadOFF[21] openDVS_pixel2x2_bot_351/GndD DiffBn VSUBS OnBn
+ VDD openDVS_pixel2x2_bot
XopenDVS_pixel2x2_bot_341 openDVS_pixel2x2_bot_341/vpd[0] openDVS_pixel2x2_bot_341/vpd[1]
+ openDVS_pixel2x2_bot_341/vpd[3] openDVS_pixel2x2_bot_341/vpd[2] rowReadON[20] rowReadON[21]
+ RefrBp PrBp PrSFBp col_periphery_1x2_21/COL_LINE0 pixRst[42] pixRst[43] col_periphery_1x2_21/COL_LINE1
+ OffBn rowReadOFF[20] rowReadOFF[21] openDVS_pixel2x2_bot_351/GndD DiffBn VSUBS OnBn
+ VDD openDVS_pixel2x2_bot
XopenDVS_pixel2x2_bot_160 openDVS_pixel2x2_bot_160/vpd[0] openDVS_pixel2x2_bot_160/vpd[1]
+ openDVS_pixel2x2_bot_160/vpd[3] openDVS_pixel2x2_bot_160/vpd[2] rowReadON[10] rowReadON[11]
+ RefrBp PrBp PrSFBp col_periphery_1x2_0/COL_LINE0 pixRst[0] pixRst[1] col_periphery_1x2_0/COL_LINE1
+ OffBn rowReadOFF[10] rowReadOFF[11] openDVS_pixel2x2_bot_191/GndD DiffBn VSUBS OnBn
+ VDD openDVS_pixel2x2_bot
XopenDVS_pixel2x2_bot_171 openDVS_pixel2x2_bot_171/vpd[0] openDVS_pixel2x2_bot_171/vpd[1]
+ openDVS_pixel2x2_bot_171/vpd[3] openDVS_pixel2x2_bot_171/vpd[2] rowReadON[10] rowReadON[11]
+ RefrBp PrBp PrSFBp col_periphery_1x2_11/COL_LINE0 pixRst[22] pixRst[23] col_periphery_1x2_11/COL_LINE1
+ OffBn rowReadOFF[10] rowReadOFF[11] openDVS_pixel2x2_bot_191/GndD DiffBn VSUBS OnBn
+ VDD openDVS_pixel2x2_bot
XopenDVS_pixel2x2_bot_182 openDVS_pixel2x2_bot_182/vpd[0] openDVS_pixel2x2_bot_182/vpd[1]
+ openDVS_pixel2x2_bot_182/vpd[3] openDVS_pixel2x2_bot_182/vpd[2] rowReadON[10] rowReadON[11]
+ RefrBp PrBp PrSFBp col_periphery_1x2_22/COL_LINE0 pixRst[44] pixRst[45] col_periphery_1x2_22/COL_LINE1
+ OffBn rowReadOFF[10] rowReadOFF[11] openDVS_pixel2x2_bot_191/GndD DiffBn VSUBS OnBn
+ VDD openDVS_pixel2x2_bot
XopenDVS_pixel2x2_bot_193 openDVS_pixel2x2_bot_193/vpd[0] openDVS_pixel2x2_bot_193/vpd[1]
+ openDVS_pixel2x2_bot_193/vpd[3] openDVS_pixel2x2_bot_193/vpd[2] rowReadON[12] rowReadON[13]
+ RefrBp PrBp PrSFBp col_periphery_1x2_1/COL_LINE0 pixRst[2] pixRst[3] col_periphery_1x2_1/COL_LINE1
+ OffBn rowReadOFF[12] rowReadOFF[13] openDVS_pixel2x2_bot_223/GndD DiffBn VSUBS OnBn
+ VDD openDVS_pixel2x2_bot
XopenDVS_pixel2x2_bot_918 openDVS_pixel2x2_bot_918/vpd[0] openDVS_pixel2x2_bot_918/vpd[1]
+ openDVS_pixel2x2_bot_918/vpd[3] openDVS_pixel2x2_bot_918/vpd[2] rowReadON[56] rowReadON[57]
+ RefrBp PrBp PrSFBp col_periphery_1x2_22/COL_LINE0 pixRst[44] pixRst[45] col_periphery_1x2_22/COL_LINE1
+ OffBn rowReadOFF[56] rowReadOFF[57] openDVS_pixel2x2_bot_927/GndD DiffBn VSUBS OnBn
+ VDD openDVS_pixel2x2_bot
XopenDVS_pixel2x2_bot_907 openDVS_pixel2x2_bot_907/vpd[0] openDVS_pixel2x2_bot_907/vpd[1]
+ openDVS_pixel2x2_bot_907/vpd[3] openDVS_pixel2x2_bot_907/vpd[2] rowReadON[56] rowReadON[57]
+ RefrBp PrBp PrSFBp col_periphery_1x2_11/COL_LINE0 pixRst[22] pixRst[23] col_periphery_1x2_11/COL_LINE1
+ OffBn rowReadOFF[56] rowReadOFF[57] openDVS_pixel2x2_bot_927/GndD DiffBn VSUBS OnBn
+ VDD openDVS_pixel2x2_bot
XopenDVS_pixel2x2_bot_929 openDVS_pixel2x2_bot_929/vpd[0] openDVS_pixel2x2_bot_929/vpd[1]
+ openDVS_pixel2x2_bot_929/vpd[3] openDVS_pixel2x2_bot_929/vpd[2] rowReadON[58] rowReadON[59]
+ RefrBp PrBp PrSFBp col_periphery_1x2_1/COL_LINE0 pixRst[2] pixRst[3] col_periphery_1x2_1/COL_LINE1
+ OffBn rowReadOFF[58] rowReadOFF[59] openDVS_pixel2x2_bot_959/GndD DiffBn VSUBS OnBn
+ VDD openDVS_pixel2x2_bot
XopenDVS_pixel2x2_bot_759 openDVS_pixel2x2_bot_759/vpd[0] openDVS_pixel2x2_bot_759/vpd[1]
+ openDVS_pixel2x2_bot_759/vpd[3] openDVS_pixel2x2_bot_759/vpd[2] rowReadON[46] rowReadON[47]
+ RefrBp PrBp PrSFBp col_periphery_1x2_23/COL_LINE0 pixRst[46] pixRst[47] col_periphery_1x2_23/COL_LINE1
+ OffBn rowReadOFF[46] rowReadOFF[47] openDVS_pixel2x2_bot_767/GndD DiffBn VSUBS OnBn
+ VDD openDVS_pixel2x2_bot
XopenDVS_pixel2x2_bot_726 openDVS_pixel2x2_bot_726/vpd[0] openDVS_pixel2x2_bot_726/vpd[1]
+ openDVS_pixel2x2_bot_726/vpd[3] openDVS_pixel2x2_bot_726/vpd[2] rowReadON[44] rowReadON[45]
+ RefrBp PrBp PrSFBp col_periphery_1x2_22/COL_LINE0 pixRst[44] pixRst[45] col_periphery_1x2_22/COL_LINE1
+ OffBn rowReadOFF[44] rowReadOFF[45] openDVS_pixel2x2_bot_735/GndD DiffBn VSUBS OnBn
+ VDD openDVS_pixel2x2_bot
XopenDVS_pixel2x2_bot_748 openDVS_pixel2x2_bot_748/vpd[0] openDVS_pixel2x2_bot_748/vpd[1]
+ openDVS_pixel2x2_bot_748/vpd[3] openDVS_pixel2x2_bot_748/vpd[2] rowReadON[46] rowReadON[47]
+ RefrBp PrBp PrSFBp col_periphery_1x2_12/COL_LINE0 pixRst[24] pixRst[25] col_periphery_1x2_12/COL_LINE1
+ OffBn rowReadOFF[46] rowReadOFF[47] openDVS_pixel2x2_bot_767/GndD DiffBn VSUBS OnBn
+ VDD openDVS_pixel2x2_bot
XopenDVS_pixel2x2_bot_715 openDVS_pixel2x2_bot_715/vpd[0] openDVS_pixel2x2_bot_715/vpd[1]
+ openDVS_pixel2x2_bot_715/vpd[3] openDVS_pixel2x2_bot_715/vpd[2] rowReadON[44] rowReadON[45]
+ RefrBp PrBp PrSFBp col_periphery_1x2_11/COL_LINE0 pixRst[22] pixRst[23] col_periphery_1x2_11/COL_LINE1
+ OffBn rowReadOFF[44] rowReadOFF[45] openDVS_pixel2x2_bot_735/GndD DiffBn VSUBS OnBn
+ VDD openDVS_pixel2x2_bot
XopenDVS_pixel2x2_bot_737 openDVS_pixel2x2_bot_737/vpd[0] openDVS_pixel2x2_bot_737/vpd[1]
+ openDVS_pixel2x2_bot_737/vpd[3] openDVS_pixel2x2_bot_737/vpd[2] rowReadON[46] rowReadON[47]
+ RefrBp PrBp PrSFBp col_periphery_1x2_1/COL_LINE0 pixRst[2] pixRst[3] col_periphery_1x2_1/COL_LINE1
+ OffBn rowReadOFF[46] rowReadOFF[47] openDVS_pixel2x2_bot_767/GndD DiffBn VSUBS OnBn
+ VDD openDVS_pixel2x2_bot
XopenDVS_pixel2x2_bot_704 openDVS_pixel2x2_bot_704/vpd[0] openDVS_pixel2x2_bot_704/vpd[1]
+ openDVS_pixel2x2_bot_704/vpd[3] openDVS_pixel2x2_bot_704/vpd[2] rowReadON[44] rowReadON[45]
+ RefrBp PrBp PrSFBp col_periphery_1x2_0/COL_LINE0 pixRst[0] pixRst[1] col_periphery_1x2_0/COL_LINE1
+ OffBn rowReadOFF[44] rowReadOFF[45] openDVS_pixel2x2_bot_735/GndD DiffBn VSUBS OnBn
+ VDD openDVS_pixel2x2_bot
XopenDVS_pixel2x2_bot_567 openDVS_pixel2x2_bot_567/vpd[0] openDVS_pixel2x2_bot_567/vpd[1]
+ openDVS_pixel2x2_bot_567/vpd[3] openDVS_pixel2x2_bot_567/vpd[2] rowReadON[34] rowReadON[35]
+ RefrBp PrBp PrSFBp col_periphery_1x2_23/COL_LINE0 pixRst[46] pixRst[47] col_periphery_1x2_23/COL_LINE1
+ OffBn rowReadOFF[34] rowReadOFF[35] openDVS_pixel2x2_bot_575/GndD DiffBn VSUBS OnBn
+ VDD openDVS_pixel2x2_bot
XopenDVS_pixel2x2_bot_534 openDVS_pixel2x2_bot_534/vpd[0] openDVS_pixel2x2_bot_534/vpd[1]
+ openDVS_pixel2x2_bot_534/vpd[3] openDVS_pixel2x2_bot_534/vpd[2] rowReadON[32] rowReadON[33]
+ RefrBp PrBp PrSFBp col_periphery_1x2_22/COL_LINE0 pixRst[44] pixRst[45] col_periphery_1x2_22/COL_LINE1
+ OffBn rowReadOFF[32] rowReadOFF[33] openDVS_pixel2x2_bot_543/GndD DiffBn VSUBS OnBn
+ VDD openDVS_pixel2x2_bot
XopenDVS_pixel2x2_bot_589 openDVS_pixel2x2_bot_589/vpd[0] openDVS_pixel2x2_bot_589/vpd[1]
+ openDVS_pixel2x2_bot_589/vpd[3] openDVS_pixel2x2_bot_589/vpd[2] rowReadON[36] rowReadON[37]
+ RefrBp PrBp PrSFBp col_periphery_1x2_13/COL_LINE0 pixRst[26] pixRst[27] col_periphery_1x2_13/COL_LINE1
+ OffBn rowReadOFF[36] rowReadOFF[37] openDVS_pixel2x2_bot_607/GndD DiffBn VSUBS OnBn
+ VDD openDVS_pixel2x2_bot
XopenDVS_pixel2x2_bot_556 openDVS_pixel2x2_bot_556/vpd[0] openDVS_pixel2x2_bot_556/vpd[1]
+ openDVS_pixel2x2_bot_556/vpd[3] openDVS_pixel2x2_bot_556/vpd[2] rowReadON[34] rowReadON[35]
+ RefrBp PrBp PrSFBp col_periphery_1x2_12/COL_LINE0 pixRst[24] pixRst[25] col_periphery_1x2_12/COL_LINE1
+ OffBn rowReadOFF[34] rowReadOFF[35] openDVS_pixel2x2_bot_575/GndD DiffBn VSUBS OnBn
+ VDD openDVS_pixel2x2_bot
XopenDVS_pixel2x2_bot_523 openDVS_pixel2x2_bot_523/vpd[0] openDVS_pixel2x2_bot_523/vpd[1]
+ openDVS_pixel2x2_bot_523/vpd[3] openDVS_pixel2x2_bot_523/vpd[2] rowReadON[32] rowReadON[33]
+ RefrBp PrBp PrSFBp col_periphery_1x2_11/COL_LINE0 pixRst[22] pixRst[23] col_periphery_1x2_11/COL_LINE1
+ OffBn rowReadOFF[32] rowReadOFF[33] openDVS_pixel2x2_bot_543/GndD DiffBn VSUBS OnBn
+ VDD openDVS_pixel2x2_bot
XopenDVS_pixel2x2_bot_578 openDVS_pixel2x2_bot_578/vpd[0] openDVS_pixel2x2_bot_578/vpd[1]
+ openDVS_pixel2x2_bot_578/vpd[3] openDVS_pixel2x2_bot_578/vpd[2] rowReadON[36] rowReadON[37]
+ RefrBp PrBp PrSFBp col_periphery_1x2_2/COL_LINE0 pixRst[4] pixRst[5] col_periphery_1x2_2/COL_LINE1
+ OffBn rowReadOFF[36] rowReadOFF[37] openDVS_pixel2x2_bot_607/GndD DiffBn VSUBS OnBn
+ VDD openDVS_pixel2x2_bot
XopenDVS_pixel2x2_bot_545 openDVS_pixel2x2_bot_545/vpd[0] openDVS_pixel2x2_bot_545/vpd[1]
+ openDVS_pixel2x2_bot_545/vpd[3] openDVS_pixel2x2_bot_545/vpd[2] rowReadON[34] rowReadON[35]
+ RefrBp PrBp PrSFBp col_periphery_1x2_1/COL_LINE0 pixRst[2] pixRst[3] col_periphery_1x2_1/COL_LINE1
+ OffBn rowReadOFF[34] rowReadOFF[35] openDVS_pixel2x2_bot_575/GndD DiffBn VSUBS OnBn
+ VDD openDVS_pixel2x2_bot
XopenDVS_pixel2x2_bot_512 openDVS_pixel2x2_bot_512/vpd[0] openDVS_pixel2x2_bot_512/vpd[1]
+ openDVS_pixel2x2_bot_512/vpd[3] openDVS_pixel2x2_bot_512/vpd[2] rowReadON[32] rowReadON[33]
+ RefrBp PrBp PrSFBp col_periphery_1x2_0/COL_LINE0 pixRst[0] pixRst[1] col_periphery_1x2_0/COL_LINE1
+ OffBn rowReadOFF[32] rowReadOFF[33] openDVS_pixel2x2_bot_543/GndD DiffBn VSUBS OnBn
+ VDD openDVS_pixel2x2_bot
XopenDVS_pixel2x2_bot_501 openDVS_pixel2x2_bot_501/vpd[0] openDVS_pixel2x2_bot_501/vpd[1]
+ openDVS_pixel2x2_bot_501/vpd[3] openDVS_pixel2x2_bot_501/vpd[2] rowReadON[30] rowReadON[31]
+ RefrBp PrBp PrSFBp col_periphery_1x2_21/COL_LINE0 pixRst[42] pixRst[43] col_periphery_1x2_21/COL_LINE1
+ OffBn rowReadOFF[30] rowReadOFF[31] openDVS_pixel2x2_bot_511/GndD DiffBn VSUBS OnBn
+ VDD openDVS_pixel2x2_bot
XopenDVS_pixel2x2_bot_375 openDVS_pixel2x2_bot_375/vpd[0] openDVS_pixel2x2_bot_375/vpd[1]
+ openDVS_pixel2x2_bot_375/vpd[3] openDVS_pixel2x2_bot_375/vpd[2] rowReadON[22] rowReadON[23]
+ RefrBp PrBp PrSFBp col_periphery_1x2_23/COL_LINE0 pixRst[46] pixRst[47] col_periphery_1x2_23/COL_LINE1
+ OffBn rowReadOFF[22] rowReadOFF[23] openDVS_pixel2x2_bot_383/GndD DiffBn VSUBS OnBn
+ VDD openDVS_pixel2x2_bot
XopenDVS_pixel2x2_bot_397 openDVS_pixel2x2_bot_397/vpd[0] openDVS_pixel2x2_bot_397/vpd[1]
+ openDVS_pixel2x2_bot_397/vpd[3] openDVS_pixel2x2_bot_397/vpd[2] rowReadON[24] rowReadON[25]
+ RefrBp PrBp PrSFBp col_periphery_1x2_13/COL_LINE0 pixRst[26] pixRst[27] col_periphery_1x2_13/COL_LINE1
+ OffBn rowReadOFF[24] rowReadOFF[25] openDVS_pixel2x2_bot_415/GndD DiffBn VSUBS OnBn
+ VDD openDVS_pixel2x2_bot
XopenDVS_pixel2x2_bot_364 openDVS_pixel2x2_bot_364/vpd[0] openDVS_pixel2x2_bot_364/vpd[1]
+ openDVS_pixel2x2_bot_364/vpd[3] openDVS_pixel2x2_bot_364/vpd[2] rowReadON[22] rowReadON[23]
+ RefrBp PrBp PrSFBp col_periphery_1x2_12/COL_LINE0 pixRst[24] pixRst[25] col_periphery_1x2_12/COL_LINE1
+ OffBn rowReadOFF[22] rowReadOFF[23] openDVS_pixel2x2_bot_383/GndD DiffBn VSUBS OnBn
+ VDD openDVS_pixel2x2_bot
XopenDVS_pixel2x2_bot_386 openDVS_pixel2x2_bot_386/vpd[0] openDVS_pixel2x2_bot_386/vpd[1]
+ openDVS_pixel2x2_bot_386/vpd[3] openDVS_pixel2x2_bot_386/vpd[2] rowReadON[24] rowReadON[25]
+ RefrBp PrBp PrSFBp col_periphery_1x2_2/COL_LINE0 pixRst[4] pixRst[5] col_periphery_1x2_2/COL_LINE1
+ OffBn rowReadOFF[24] rowReadOFF[25] openDVS_pixel2x2_bot_415/GndD DiffBn VSUBS OnBn
+ VDD openDVS_pixel2x2_bot
XopenDVS_pixel2x2_bot_353 openDVS_pixel2x2_bot_353/vpd[0] openDVS_pixel2x2_bot_353/vpd[1]
+ openDVS_pixel2x2_bot_353/vpd[3] openDVS_pixel2x2_bot_353/vpd[2] rowReadON[22] rowReadON[23]
+ RefrBp PrBp PrSFBp col_periphery_1x2_1/COL_LINE0 pixRst[2] pixRst[3] col_periphery_1x2_1/COL_LINE1
+ OffBn rowReadOFF[22] rowReadOFF[23] openDVS_pixel2x2_bot_383/GndD DiffBn VSUBS OnBn
+ VDD openDVS_pixel2x2_bot
XopenDVS_pixel2x2_bot_320 openDVS_pixel2x2_bot_320/vpd[0] openDVS_pixel2x2_bot_320/vpd[1]
+ openDVS_pixel2x2_bot_320/vpd[3] openDVS_pixel2x2_bot_320/vpd[2] rowReadON[20] rowReadON[21]
+ RefrBp PrBp PrSFBp col_periphery_1x2_0/COL_LINE0 pixRst[0] pixRst[1] col_periphery_1x2_0/COL_LINE1
+ OffBn rowReadOFF[20] rowReadOFF[21] openDVS_pixel2x2_bot_351/GndD DiffBn VSUBS OnBn
+ VDD openDVS_pixel2x2_bot
XopenDVS_pixel2x2_bot_331 openDVS_pixel2x2_bot_331/vpd[0] openDVS_pixel2x2_bot_331/vpd[1]
+ openDVS_pixel2x2_bot_331/vpd[3] openDVS_pixel2x2_bot_331/vpd[2] rowReadON[20] rowReadON[21]
+ RefrBp PrBp PrSFBp col_periphery_1x2_11/COL_LINE0 pixRst[22] pixRst[23] col_periphery_1x2_11/COL_LINE1
+ OffBn rowReadOFF[20] rowReadOFF[21] openDVS_pixel2x2_bot_351/GndD DiffBn VSUBS OnBn
+ VDD openDVS_pixel2x2_bot
XopenDVS_pixel2x2_bot_342 openDVS_pixel2x2_bot_342/vpd[0] openDVS_pixel2x2_bot_342/vpd[1]
+ openDVS_pixel2x2_bot_342/vpd[3] openDVS_pixel2x2_bot_342/vpd[2] rowReadON[20] rowReadON[21]
+ RefrBp PrBp PrSFBp col_periphery_1x2_22/COL_LINE0 pixRst[44] pixRst[45] col_periphery_1x2_22/COL_LINE1
+ OffBn rowReadOFF[20] rowReadOFF[21] openDVS_pixel2x2_bot_351/GndD DiffBn VSUBS OnBn
+ VDD openDVS_pixel2x2_bot
XopenDVS_pixel2x2_bot_161 openDVS_pixel2x2_bot_161/vpd[0] openDVS_pixel2x2_bot_161/vpd[1]
+ openDVS_pixel2x2_bot_161/vpd[3] openDVS_pixel2x2_bot_161/vpd[2] rowReadON[10] rowReadON[11]
+ RefrBp PrBp PrSFBp col_periphery_1x2_1/COL_LINE0 pixRst[2] pixRst[3] col_periphery_1x2_1/COL_LINE1
+ OffBn rowReadOFF[10] rowReadOFF[11] openDVS_pixel2x2_bot_191/GndD DiffBn VSUBS OnBn
+ VDD openDVS_pixel2x2_bot
XopenDVS_pixel2x2_bot_172 openDVS_pixel2x2_bot_172/vpd[0] openDVS_pixel2x2_bot_172/vpd[1]
+ openDVS_pixel2x2_bot_172/vpd[3] openDVS_pixel2x2_bot_172/vpd[2] rowReadON[10] rowReadON[11]
+ RefrBp PrBp PrSFBp col_periphery_1x2_12/COL_LINE0 pixRst[24] pixRst[25] col_periphery_1x2_12/COL_LINE1
+ OffBn rowReadOFF[10] rowReadOFF[11] openDVS_pixel2x2_bot_191/GndD DiffBn VSUBS OnBn
+ VDD openDVS_pixel2x2_bot
XopenDVS_pixel2x2_bot_150 openDVS_pixel2x2_bot_150/vpd[0] openDVS_pixel2x2_bot_150/vpd[1]
+ openDVS_pixel2x2_bot_150/vpd[3] openDVS_pixel2x2_bot_150/vpd[2] rowReadON[8] rowReadON[9]
+ RefrBp PrBp PrSFBp col_periphery_1x2_22/COL_LINE0 pixRst[44] pixRst[45] col_periphery_1x2_22/COL_LINE1
+ OffBn rowReadOFF[8] rowReadOFF[9] openDVS_pixel2x2_bot_159/GndD DiffBn VSUBS OnBn
+ VDD openDVS_pixel2x2_bot
XopenDVS_pixel2x2_bot_183 openDVS_pixel2x2_bot_183/vpd[0] openDVS_pixel2x2_bot_183/vpd[1]
+ openDVS_pixel2x2_bot_183/vpd[3] openDVS_pixel2x2_bot_183/vpd[2] rowReadON[10] rowReadON[11]
+ RefrBp PrBp PrSFBp col_periphery_1x2_23/COL_LINE0 pixRst[46] pixRst[47] col_periphery_1x2_23/COL_LINE1
+ OffBn rowReadOFF[10] rowReadOFF[11] openDVS_pixel2x2_bot_191/GndD DiffBn VSUBS OnBn
+ VDD openDVS_pixel2x2_bot
XopenDVS_pixel2x2_bot_194 openDVS_pixel2x2_bot_194/vpd[0] openDVS_pixel2x2_bot_194/vpd[1]
+ openDVS_pixel2x2_bot_194/vpd[3] openDVS_pixel2x2_bot_194/vpd[2] rowReadON[12] rowReadON[13]
+ RefrBp PrBp PrSFBp col_periphery_1x2_2/COL_LINE0 pixRst[4] pixRst[5] col_periphery_1x2_2/COL_LINE1
+ OffBn rowReadOFF[12] rowReadOFF[13] openDVS_pixel2x2_bot_223/GndD DiffBn VSUBS OnBn
+ VDD openDVS_pixel2x2_bot
XopenDVS_pixel2x2_bot_919 openDVS_pixel2x2_bot_919/vpd[0] openDVS_pixel2x2_bot_919/vpd[1]
+ openDVS_pixel2x2_bot_919/vpd[3] openDVS_pixel2x2_bot_919/vpd[2] rowReadON[56] rowReadON[57]
+ RefrBp PrBp PrSFBp col_periphery_1x2_23/COL_LINE0 pixRst[46] pixRst[47] col_periphery_1x2_23/COL_LINE1
+ OffBn rowReadOFF[56] rowReadOFF[57] openDVS_pixel2x2_bot_927/GndD DiffBn VSUBS OnBn
+ VDD openDVS_pixel2x2_bot
XopenDVS_pixel2x2_bot_908 openDVS_pixel2x2_bot_908/vpd[0] openDVS_pixel2x2_bot_908/vpd[1]
+ openDVS_pixel2x2_bot_908/vpd[3] openDVS_pixel2x2_bot_908/vpd[2] rowReadON[56] rowReadON[57]
+ RefrBp PrBp PrSFBp col_periphery_1x2_12/COL_LINE0 pixRst[24] pixRst[25] col_periphery_1x2_12/COL_LINE1
+ OffBn rowReadOFF[56] rowReadOFF[57] openDVS_pixel2x2_bot_927/GndD DiffBn VSUBS OnBn
+ VDD openDVS_pixel2x2_bot
XopenDVS_pixel2x2_bot_727 openDVS_pixel2x2_bot_727/vpd[0] openDVS_pixel2x2_bot_727/vpd[1]
+ openDVS_pixel2x2_bot_727/vpd[3] openDVS_pixel2x2_bot_727/vpd[2] rowReadON[44] rowReadON[45]
+ RefrBp PrBp PrSFBp col_periphery_1x2_23/COL_LINE0 pixRst[46] pixRst[47] col_periphery_1x2_23/COL_LINE1
+ OffBn rowReadOFF[44] rowReadOFF[45] openDVS_pixel2x2_bot_735/GndD DiffBn VSUBS OnBn
+ VDD openDVS_pixel2x2_bot
XopenDVS_pixel2x2_bot_749 openDVS_pixel2x2_bot_749/vpd[0] openDVS_pixel2x2_bot_749/vpd[1]
+ openDVS_pixel2x2_bot_749/vpd[3] openDVS_pixel2x2_bot_749/vpd[2] rowReadON[46] rowReadON[47]
+ RefrBp PrBp PrSFBp col_periphery_1x2_13/COL_LINE0 pixRst[26] pixRst[27] col_periphery_1x2_13/COL_LINE1
+ OffBn rowReadOFF[46] rowReadOFF[47] openDVS_pixel2x2_bot_767/GndD DiffBn VSUBS OnBn
+ VDD openDVS_pixel2x2_bot
XopenDVS_pixel2x2_bot_716 openDVS_pixel2x2_bot_716/vpd[0] openDVS_pixel2x2_bot_716/vpd[1]
+ openDVS_pixel2x2_bot_716/vpd[3] openDVS_pixel2x2_bot_716/vpd[2] rowReadON[44] rowReadON[45]
+ RefrBp PrBp PrSFBp col_periphery_1x2_12/COL_LINE0 pixRst[24] pixRst[25] col_periphery_1x2_12/COL_LINE1
+ OffBn rowReadOFF[44] rowReadOFF[45] openDVS_pixel2x2_bot_735/GndD DiffBn VSUBS OnBn
+ VDD openDVS_pixel2x2_bot
XopenDVS_pixel2x2_bot_738 openDVS_pixel2x2_bot_738/vpd[0] openDVS_pixel2x2_bot_738/vpd[1]
+ openDVS_pixel2x2_bot_738/vpd[3] openDVS_pixel2x2_bot_738/vpd[2] rowReadON[46] rowReadON[47]
+ RefrBp PrBp PrSFBp col_periphery_1x2_2/COL_LINE0 pixRst[4] pixRst[5] col_periphery_1x2_2/COL_LINE1
+ OffBn rowReadOFF[46] rowReadOFF[47] openDVS_pixel2x2_bot_767/GndD DiffBn VSUBS OnBn
+ VDD openDVS_pixel2x2_bot
XopenDVS_pixel2x2_bot_705 openDVS_pixel2x2_bot_705/vpd[0] openDVS_pixel2x2_bot_705/vpd[1]
+ openDVS_pixel2x2_bot_705/vpd[3] openDVS_pixel2x2_bot_705/vpd[2] rowReadON[44] rowReadON[45]
+ RefrBp PrBp PrSFBp col_periphery_1x2_1/COL_LINE0 pixRst[2] pixRst[3] col_periphery_1x2_1/COL_LINE1
+ OffBn rowReadOFF[44] rowReadOFF[45] openDVS_pixel2x2_bot_735/GndD DiffBn VSUBS OnBn
+ VDD openDVS_pixel2x2_bot
XopenDVS_pixel2x2_bot_568 openDVS_pixel2x2_bot_568/vpd[0] openDVS_pixel2x2_bot_568/vpd[1]
+ openDVS_pixel2x2_bot_568/vpd[3] openDVS_pixel2x2_bot_568/vpd[2] rowReadON[34] rowReadON[35]
+ RefrBp PrBp PrSFBp col_periphery_1x2_24/COL_LINE0 pixRst[48] pixRst[49] col_periphery_1x2_24/COL_LINE1
+ OffBn rowReadOFF[34] rowReadOFF[35] openDVS_pixel2x2_bot_575/GndD DiffBn VSUBS OnBn
+ VDD openDVS_pixel2x2_bot
XopenDVS_pixel2x2_bot_535 openDVS_pixel2x2_bot_535/vpd[0] openDVS_pixel2x2_bot_535/vpd[1]
+ openDVS_pixel2x2_bot_535/vpd[3] openDVS_pixel2x2_bot_535/vpd[2] rowReadON[32] rowReadON[33]
+ RefrBp PrBp PrSFBp col_periphery_1x2_23/COL_LINE0 pixRst[46] pixRst[47] col_periphery_1x2_23/COL_LINE1
+ OffBn rowReadOFF[32] rowReadOFF[33] openDVS_pixel2x2_bot_543/GndD DiffBn VSUBS OnBn
+ VDD openDVS_pixel2x2_bot
XopenDVS_pixel2x2_bot_557 openDVS_pixel2x2_bot_557/vpd[0] openDVS_pixel2x2_bot_557/vpd[1]
+ openDVS_pixel2x2_bot_557/vpd[3] openDVS_pixel2x2_bot_557/vpd[2] rowReadON[34] rowReadON[35]
+ RefrBp PrBp PrSFBp col_periphery_1x2_13/COL_LINE0 pixRst[26] pixRst[27] col_periphery_1x2_13/COL_LINE1
+ OffBn rowReadOFF[34] rowReadOFF[35] openDVS_pixel2x2_bot_575/GndD DiffBn VSUBS OnBn
+ VDD openDVS_pixel2x2_bot
XopenDVS_pixel2x2_bot_524 openDVS_pixel2x2_bot_524/vpd[0] openDVS_pixel2x2_bot_524/vpd[1]
+ openDVS_pixel2x2_bot_524/vpd[3] openDVS_pixel2x2_bot_524/vpd[2] rowReadON[32] rowReadON[33]
+ RefrBp PrBp PrSFBp col_periphery_1x2_12/COL_LINE0 pixRst[24] pixRst[25] col_periphery_1x2_12/COL_LINE1
+ OffBn rowReadOFF[32] rowReadOFF[33] openDVS_pixel2x2_bot_543/GndD DiffBn VSUBS OnBn
+ VDD openDVS_pixel2x2_bot
XopenDVS_pixel2x2_bot_579 openDVS_pixel2x2_bot_579/vpd[0] openDVS_pixel2x2_bot_579/vpd[1]
+ openDVS_pixel2x2_bot_579/vpd[3] openDVS_pixel2x2_bot_579/vpd[2] rowReadON[36] rowReadON[37]
+ RefrBp PrBp PrSFBp col_periphery_1x2_3/COL_LINE0 pixRst[6] pixRst[7] col_periphery_1x2_3/COL_LINE1
+ OffBn rowReadOFF[36] rowReadOFF[37] openDVS_pixel2x2_bot_607/GndD DiffBn VSUBS OnBn
+ VDD openDVS_pixel2x2_bot
XopenDVS_pixel2x2_bot_546 openDVS_pixel2x2_bot_546/vpd[0] openDVS_pixel2x2_bot_546/vpd[1]
+ openDVS_pixel2x2_bot_546/vpd[3] openDVS_pixel2x2_bot_546/vpd[2] rowReadON[34] rowReadON[35]
+ RefrBp PrBp PrSFBp col_periphery_1x2_2/COL_LINE0 pixRst[4] pixRst[5] col_periphery_1x2_2/COL_LINE1
+ OffBn rowReadOFF[34] rowReadOFF[35] openDVS_pixel2x2_bot_575/GndD DiffBn VSUBS OnBn
+ VDD openDVS_pixel2x2_bot
XopenDVS_pixel2x2_bot_513 openDVS_pixel2x2_bot_513/vpd[0] openDVS_pixel2x2_bot_513/vpd[1]
+ openDVS_pixel2x2_bot_513/vpd[3] openDVS_pixel2x2_bot_513/vpd[2] rowReadON[32] rowReadON[33]
+ RefrBp PrBp PrSFBp col_periphery_1x2_1/COL_LINE0 pixRst[2] pixRst[3] col_periphery_1x2_1/COL_LINE1
+ OffBn rowReadOFF[32] rowReadOFF[33] openDVS_pixel2x2_bot_543/GndD DiffBn VSUBS OnBn
+ VDD openDVS_pixel2x2_bot
XopenDVS_pixel2x2_bot_502 openDVS_pixel2x2_bot_502/vpd[0] openDVS_pixel2x2_bot_502/vpd[1]
+ openDVS_pixel2x2_bot_502/vpd[3] openDVS_pixel2x2_bot_502/vpd[2] rowReadON[30] rowReadON[31]
+ RefrBp PrBp PrSFBp col_periphery_1x2_22/COL_LINE0 pixRst[44] pixRst[45] col_periphery_1x2_22/COL_LINE1
+ OffBn rowReadOFF[30] rowReadOFF[31] openDVS_pixel2x2_bot_511/GndD DiffBn VSUBS OnBn
+ VDD openDVS_pixel2x2_bot
XopenDVS_pixel2x2_bot_376 openDVS_pixel2x2_bot_376/vpd[0] openDVS_pixel2x2_bot_376/vpd[1]
+ openDVS_pixel2x2_bot_376/vpd[3] openDVS_pixel2x2_bot_376/vpd[2] rowReadON[22] rowReadON[23]
+ RefrBp PrBp PrSFBp col_periphery_1x2_24/COL_LINE0 pixRst[48] pixRst[49] col_periphery_1x2_24/COL_LINE1
+ OffBn rowReadOFF[22] rowReadOFF[23] openDVS_pixel2x2_bot_383/GndD DiffBn VSUBS OnBn
+ VDD openDVS_pixel2x2_bot
XopenDVS_pixel2x2_bot_398 openDVS_pixel2x2_bot_398/vpd[0] openDVS_pixel2x2_bot_398/vpd[1]
+ openDVS_pixel2x2_bot_398/vpd[3] openDVS_pixel2x2_bot_398/vpd[2] rowReadON[24] rowReadON[25]
+ RefrBp PrBp PrSFBp col_periphery_1x2_14/COL_LINE0 pixRst[28] pixRst[29] col_periphery_1x2_14/COL_LINE1
+ OffBn rowReadOFF[24] rowReadOFF[25] openDVS_pixel2x2_bot_415/GndD DiffBn VSUBS OnBn
+ VDD openDVS_pixel2x2_bot
XopenDVS_pixel2x2_bot_365 openDVS_pixel2x2_bot_365/vpd[0] openDVS_pixel2x2_bot_365/vpd[1]
+ openDVS_pixel2x2_bot_365/vpd[3] openDVS_pixel2x2_bot_365/vpd[2] rowReadON[22] rowReadON[23]
+ RefrBp PrBp PrSFBp col_periphery_1x2_13/COL_LINE0 pixRst[26] pixRst[27] col_periphery_1x2_13/COL_LINE1
+ OffBn rowReadOFF[22] rowReadOFF[23] openDVS_pixel2x2_bot_383/GndD DiffBn VSUBS OnBn
+ VDD openDVS_pixel2x2_bot
XopenDVS_pixel2x2_bot_387 openDVS_pixel2x2_bot_387/vpd[0] openDVS_pixel2x2_bot_387/vpd[1]
+ openDVS_pixel2x2_bot_387/vpd[3] openDVS_pixel2x2_bot_387/vpd[2] rowReadON[24] rowReadON[25]
+ RefrBp PrBp PrSFBp col_periphery_1x2_3/COL_LINE0 pixRst[6] pixRst[7] col_periphery_1x2_3/COL_LINE1
+ OffBn rowReadOFF[24] rowReadOFF[25] openDVS_pixel2x2_bot_415/GndD DiffBn VSUBS OnBn
+ VDD openDVS_pixel2x2_bot
XopenDVS_pixel2x2_bot_354 openDVS_pixel2x2_bot_354/vpd[0] openDVS_pixel2x2_bot_354/vpd[1]
+ openDVS_pixel2x2_bot_354/vpd[3] openDVS_pixel2x2_bot_354/vpd[2] rowReadON[22] rowReadON[23]
+ RefrBp PrBp PrSFBp col_periphery_1x2_2/COL_LINE0 pixRst[4] pixRst[5] col_periphery_1x2_2/COL_LINE1
+ OffBn rowReadOFF[22] rowReadOFF[23] openDVS_pixel2x2_bot_383/GndD DiffBn VSUBS OnBn
+ VDD openDVS_pixel2x2_bot
XopenDVS_pixel2x2_bot_321 openDVS_pixel2x2_bot_321/vpd[0] openDVS_pixel2x2_bot_321/vpd[1]
+ openDVS_pixel2x2_bot_321/vpd[3] openDVS_pixel2x2_bot_321/vpd[2] rowReadON[20] rowReadON[21]
+ RefrBp PrBp PrSFBp col_periphery_1x2_1/COL_LINE0 pixRst[2] pixRst[3] col_periphery_1x2_1/COL_LINE1
+ OffBn rowReadOFF[20] rowReadOFF[21] openDVS_pixel2x2_bot_351/GndD DiffBn VSUBS OnBn
+ VDD openDVS_pixel2x2_bot
XopenDVS_pixel2x2_bot_332 openDVS_pixel2x2_bot_332/vpd[0] openDVS_pixel2x2_bot_332/vpd[1]
+ openDVS_pixel2x2_bot_332/vpd[3] openDVS_pixel2x2_bot_332/vpd[2] rowReadON[20] rowReadON[21]
+ RefrBp PrBp PrSFBp col_periphery_1x2_12/COL_LINE0 pixRst[24] pixRst[25] col_periphery_1x2_12/COL_LINE1
+ OffBn rowReadOFF[20] rowReadOFF[21] openDVS_pixel2x2_bot_351/GndD DiffBn VSUBS OnBn
+ VDD openDVS_pixel2x2_bot
XopenDVS_pixel2x2_bot_310 openDVS_pixel2x2_bot_310/vpd[0] openDVS_pixel2x2_bot_310/vpd[1]
+ openDVS_pixel2x2_bot_310/vpd[3] openDVS_pixel2x2_bot_310/vpd[2] rowReadON[18] rowReadON[19]
+ RefrBp PrBp PrSFBp col_periphery_1x2_22/COL_LINE0 pixRst[44] pixRst[45] col_periphery_1x2_22/COL_LINE1
+ OffBn rowReadOFF[18] rowReadOFF[19] openDVS_pixel2x2_bot_319/GndD DiffBn VSUBS OnBn
+ VDD openDVS_pixel2x2_bot
XopenDVS_pixel2x2_bot_343 openDVS_pixel2x2_bot_343/vpd[0] openDVS_pixel2x2_bot_343/vpd[1]
+ openDVS_pixel2x2_bot_343/vpd[3] openDVS_pixel2x2_bot_343/vpd[2] rowReadON[20] rowReadON[21]
+ RefrBp PrBp PrSFBp col_periphery_1x2_23/COL_LINE0 pixRst[46] pixRst[47] col_periphery_1x2_23/COL_LINE1
+ OffBn rowReadOFF[20] rowReadOFF[21] openDVS_pixel2x2_bot_351/GndD DiffBn VSUBS OnBn
+ VDD openDVS_pixel2x2_bot
XopenDVS_pixel2x2_bot_162 openDVS_pixel2x2_bot_162/vpd[0] openDVS_pixel2x2_bot_162/vpd[1]
+ openDVS_pixel2x2_bot_162/vpd[3] openDVS_pixel2x2_bot_162/vpd[2] rowReadON[10] rowReadON[11]
+ RefrBp PrBp PrSFBp col_periphery_1x2_2/COL_LINE0 pixRst[4] pixRst[5] col_periphery_1x2_2/COL_LINE1
+ OffBn rowReadOFF[10] rowReadOFF[11] openDVS_pixel2x2_bot_191/GndD DiffBn VSUBS OnBn
+ VDD openDVS_pixel2x2_bot
XopenDVS_pixel2x2_bot_140 openDVS_pixel2x2_bot_140/vpd[0] openDVS_pixel2x2_bot_140/vpd[1]
+ openDVS_pixel2x2_bot_140/vpd[3] openDVS_pixel2x2_bot_140/vpd[2] rowReadON[8] rowReadON[9]
+ RefrBp PrBp PrSFBp col_periphery_1x2_12/COL_LINE0 pixRst[24] pixRst[25] col_periphery_1x2_12/COL_LINE1
+ OffBn rowReadOFF[8] rowReadOFF[9] openDVS_pixel2x2_bot_159/GndD DiffBn VSUBS OnBn
+ VDD openDVS_pixel2x2_bot
XopenDVS_pixel2x2_bot_173 openDVS_pixel2x2_bot_173/vpd[0] openDVS_pixel2x2_bot_173/vpd[1]
+ openDVS_pixel2x2_bot_173/vpd[3] openDVS_pixel2x2_bot_173/vpd[2] rowReadON[10] rowReadON[11]
+ RefrBp PrBp PrSFBp col_periphery_1x2_13/COL_LINE0 pixRst[26] pixRst[27] col_periphery_1x2_13/COL_LINE1
+ OffBn rowReadOFF[10] rowReadOFF[11] openDVS_pixel2x2_bot_191/GndD DiffBn VSUBS OnBn
+ VDD openDVS_pixel2x2_bot
XopenDVS_pixel2x2_bot_151 openDVS_pixel2x2_bot_151/vpd[0] openDVS_pixel2x2_bot_151/vpd[1]
+ openDVS_pixel2x2_bot_151/vpd[3] openDVS_pixel2x2_bot_151/vpd[2] rowReadON[8] rowReadON[9]
+ RefrBp PrBp PrSFBp col_periphery_1x2_23/COL_LINE0 pixRst[46] pixRst[47] col_periphery_1x2_23/COL_LINE1
+ OffBn rowReadOFF[8] rowReadOFF[9] openDVS_pixel2x2_bot_159/GndD DiffBn VSUBS OnBn
+ VDD openDVS_pixel2x2_bot
XopenDVS_pixel2x2_bot_184 openDVS_pixel2x2_bot_184/vpd[0] openDVS_pixel2x2_bot_184/vpd[1]
+ openDVS_pixel2x2_bot_184/vpd[3] openDVS_pixel2x2_bot_184/vpd[2] rowReadON[10] rowReadON[11]
+ RefrBp PrBp PrSFBp col_periphery_1x2_24/COL_LINE0 pixRst[48] pixRst[49] col_periphery_1x2_24/COL_LINE1
+ OffBn rowReadOFF[10] rowReadOFF[11] openDVS_pixel2x2_bot_191/GndD DiffBn VSUBS OnBn
+ VDD openDVS_pixel2x2_bot
XopenDVS_pixel2x2_bot_195 openDVS_pixel2x2_bot_195/vpd[0] openDVS_pixel2x2_bot_195/vpd[1]
+ openDVS_pixel2x2_bot_195/vpd[3] openDVS_pixel2x2_bot_195/vpd[2] rowReadON[12] rowReadON[13]
+ RefrBp PrBp PrSFBp col_periphery_1x2_3/COL_LINE0 pixRst[6] pixRst[7] col_periphery_1x2_3/COL_LINE1
+ OffBn rowReadOFF[12] rowReadOFF[13] openDVS_pixel2x2_bot_223/GndD DiffBn VSUBS OnBn
+ VDD openDVS_pixel2x2_bot
XopenDVS_pixel2x2_bot_909 openDVS_pixel2x2_bot_909/vpd[0] openDVS_pixel2x2_bot_909/vpd[1]
+ openDVS_pixel2x2_bot_909/vpd[3] openDVS_pixel2x2_bot_909/vpd[2] rowReadON[56] rowReadON[57]
+ RefrBp PrBp PrSFBp col_periphery_1x2_13/COL_LINE0 pixRst[26] pixRst[27] col_periphery_1x2_13/COL_LINE1
+ OffBn rowReadOFF[56] rowReadOFF[57] openDVS_pixel2x2_bot_927/GndD DiffBn VSUBS OnBn
+ VDD openDVS_pixel2x2_bot
XopenDVS_pixel2x2_bot_728 openDVS_pixel2x2_bot_728/vpd[0] openDVS_pixel2x2_bot_728/vpd[1]
+ openDVS_pixel2x2_bot_728/vpd[3] openDVS_pixel2x2_bot_728/vpd[2] rowReadON[44] rowReadON[45]
+ RefrBp PrBp PrSFBp col_periphery_1x2_24/COL_LINE0 pixRst[48] pixRst[49] col_periphery_1x2_24/COL_LINE1
+ OffBn rowReadOFF[44] rowReadOFF[45] openDVS_pixel2x2_bot_735/GndD DiffBn VSUBS OnBn
+ VDD openDVS_pixel2x2_bot
XopenDVS_pixel2x2_bot_717 openDVS_pixel2x2_bot_717/vpd[0] openDVS_pixel2x2_bot_717/vpd[1]
+ openDVS_pixel2x2_bot_717/vpd[3] openDVS_pixel2x2_bot_717/vpd[2] rowReadON[44] rowReadON[45]
+ RefrBp PrBp PrSFBp col_periphery_1x2_13/COL_LINE0 pixRst[26] pixRst[27] col_periphery_1x2_13/COL_LINE1
+ OffBn rowReadOFF[44] rowReadOFF[45] openDVS_pixel2x2_bot_735/GndD DiffBn VSUBS OnBn
+ VDD openDVS_pixel2x2_bot
XopenDVS_pixel2x2_bot_739 openDVS_pixel2x2_bot_739/vpd[0] openDVS_pixel2x2_bot_739/vpd[1]
+ openDVS_pixel2x2_bot_739/vpd[3] openDVS_pixel2x2_bot_739/vpd[2] rowReadON[46] rowReadON[47]
+ RefrBp PrBp PrSFBp col_periphery_1x2_3/COL_LINE0 pixRst[6] pixRst[7] col_periphery_1x2_3/COL_LINE1
+ OffBn rowReadOFF[46] rowReadOFF[47] openDVS_pixel2x2_bot_767/GndD DiffBn VSUBS OnBn
+ VDD openDVS_pixel2x2_bot
XopenDVS_pixel2x2_bot_706 openDVS_pixel2x2_bot_706/vpd[0] openDVS_pixel2x2_bot_706/vpd[1]
+ openDVS_pixel2x2_bot_706/vpd[3] openDVS_pixel2x2_bot_706/vpd[2] rowReadON[44] rowReadON[45]
+ RefrBp PrBp PrSFBp col_periphery_1x2_2/COL_LINE0 pixRst[4] pixRst[5] col_periphery_1x2_2/COL_LINE1
+ OffBn rowReadOFF[44] rowReadOFF[45] openDVS_pixel2x2_bot_735/GndD DiffBn VSUBS OnBn
+ VDD openDVS_pixel2x2_bot
XopenDVS_pixel2x2_bot_569 openDVS_pixel2x2_bot_569/vpd[0] openDVS_pixel2x2_bot_569/vpd[1]
+ openDVS_pixel2x2_bot_569/vpd[3] openDVS_pixel2x2_bot_569/vpd[2] rowReadON[34] rowReadON[35]
+ RefrBp PrBp PrSFBp col_periphery_1x2_25/COL_LINE0 pixRst[50] pixRst[51] col_periphery_1x2_25/COL_LINE1
+ OffBn rowReadOFF[34] rowReadOFF[35] openDVS_pixel2x2_bot_575/GndD DiffBn VSUBS OnBn
+ VDD openDVS_pixel2x2_bot
XopenDVS_pixel2x2_bot_536 openDVS_pixel2x2_bot_536/vpd[0] openDVS_pixel2x2_bot_536/vpd[1]
+ openDVS_pixel2x2_bot_536/vpd[3] openDVS_pixel2x2_bot_536/vpd[2] rowReadON[32] rowReadON[33]
+ RefrBp PrBp PrSFBp col_periphery_1x2_24/COL_LINE0 pixRst[48] pixRst[49] col_periphery_1x2_24/COL_LINE1
+ OffBn rowReadOFF[32] rowReadOFF[33] openDVS_pixel2x2_bot_543/GndD DiffBn VSUBS OnBn
+ VDD openDVS_pixel2x2_bot
XopenDVS_pixel2x2_bot_558 openDVS_pixel2x2_bot_558/vpd[0] openDVS_pixel2x2_bot_558/vpd[1]
+ openDVS_pixel2x2_bot_558/vpd[3] openDVS_pixel2x2_bot_558/vpd[2] rowReadON[34] rowReadON[35]
+ RefrBp PrBp PrSFBp col_periphery_1x2_14/COL_LINE0 pixRst[28] pixRst[29] col_periphery_1x2_14/COL_LINE1
+ OffBn rowReadOFF[34] rowReadOFF[35] openDVS_pixel2x2_bot_575/GndD DiffBn VSUBS OnBn
+ VDD openDVS_pixel2x2_bot
XopenDVS_pixel2x2_bot_525 openDVS_pixel2x2_bot_525/vpd[0] openDVS_pixel2x2_bot_525/vpd[1]
+ openDVS_pixel2x2_bot_525/vpd[3] openDVS_pixel2x2_bot_525/vpd[2] rowReadON[32] rowReadON[33]
+ RefrBp PrBp PrSFBp col_periphery_1x2_13/COL_LINE0 pixRst[26] pixRst[27] col_periphery_1x2_13/COL_LINE1
+ OffBn rowReadOFF[32] rowReadOFF[33] openDVS_pixel2x2_bot_543/GndD DiffBn VSUBS OnBn
+ VDD openDVS_pixel2x2_bot
XopenDVS_pixel2x2_bot_547 openDVS_pixel2x2_bot_547/vpd[0] openDVS_pixel2x2_bot_547/vpd[1]
+ openDVS_pixel2x2_bot_547/vpd[3] openDVS_pixel2x2_bot_547/vpd[2] rowReadON[34] rowReadON[35]
+ RefrBp PrBp PrSFBp col_periphery_1x2_3/COL_LINE0 pixRst[6] pixRst[7] col_periphery_1x2_3/COL_LINE1
+ OffBn rowReadOFF[34] rowReadOFF[35] openDVS_pixel2x2_bot_575/GndD DiffBn VSUBS OnBn
+ VDD openDVS_pixel2x2_bot
XopenDVS_pixel2x2_bot_514 openDVS_pixel2x2_bot_514/vpd[0] openDVS_pixel2x2_bot_514/vpd[1]
+ openDVS_pixel2x2_bot_514/vpd[3] openDVS_pixel2x2_bot_514/vpd[2] rowReadON[32] rowReadON[33]
+ RefrBp PrBp PrSFBp col_periphery_1x2_2/COL_LINE0 pixRst[4] pixRst[5] col_periphery_1x2_2/COL_LINE1
+ OffBn rowReadOFF[32] rowReadOFF[33] openDVS_pixel2x2_bot_543/GndD DiffBn VSUBS OnBn
+ VDD openDVS_pixel2x2_bot
XopenDVS_pixel2x2_bot_503 openDVS_pixel2x2_bot_503/vpd[0] openDVS_pixel2x2_bot_503/vpd[1]
+ openDVS_pixel2x2_bot_503/vpd[3] openDVS_pixel2x2_bot_503/vpd[2] rowReadON[30] rowReadON[31]
+ RefrBp PrBp PrSFBp col_periphery_1x2_23/COL_LINE0 pixRst[46] pixRst[47] col_periphery_1x2_23/COL_LINE1
+ OffBn rowReadOFF[30] rowReadOFF[31] openDVS_pixel2x2_bot_511/GndD DiffBn VSUBS OnBn
+ VDD openDVS_pixel2x2_bot
XopenDVS_pixel2x2_bot_377 openDVS_pixel2x2_bot_377/vpd[0] openDVS_pixel2x2_bot_377/vpd[1]
+ openDVS_pixel2x2_bot_377/vpd[3] openDVS_pixel2x2_bot_377/vpd[2] rowReadON[22] rowReadON[23]
+ RefrBp PrBp PrSFBp col_periphery_1x2_25/COL_LINE0 pixRst[50] pixRst[51] col_periphery_1x2_25/COL_LINE1
+ OffBn rowReadOFF[22] rowReadOFF[23] openDVS_pixel2x2_bot_383/GndD DiffBn VSUBS OnBn
+ VDD openDVS_pixel2x2_bot
XopenDVS_pixel2x2_bot_399 openDVS_pixel2x2_bot_399/vpd[0] openDVS_pixel2x2_bot_399/vpd[1]
+ openDVS_pixel2x2_bot_399/vpd[3] openDVS_pixel2x2_bot_399/vpd[2] rowReadON[24] rowReadON[25]
+ RefrBp PrBp PrSFBp col_periphery_1x2_15/COL_LINE0 pixRst[30] pixRst[31] col_periphery_1x2_15/COL_LINE1
+ OffBn rowReadOFF[24] rowReadOFF[25] openDVS_pixel2x2_bot_415/GndD DiffBn VSUBS OnBn
+ VDD openDVS_pixel2x2_bot
XopenDVS_pixel2x2_bot_366 openDVS_pixel2x2_bot_366/vpd[0] openDVS_pixel2x2_bot_366/vpd[1]
+ openDVS_pixel2x2_bot_366/vpd[3] openDVS_pixel2x2_bot_366/vpd[2] rowReadON[22] rowReadON[23]
+ RefrBp PrBp PrSFBp col_periphery_1x2_14/COL_LINE0 pixRst[28] pixRst[29] col_periphery_1x2_14/COL_LINE1
+ OffBn rowReadOFF[22] rowReadOFF[23] openDVS_pixel2x2_bot_383/GndD DiffBn VSUBS OnBn
+ VDD openDVS_pixel2x2_bot
XopenDVS_pixel2x2_bot_388 openDVS_pixel2x2_bot_388/vpd[0] openDVS_pixel2x2_bot_388/vpd[1]
+ openDVS_pixel2x2_bot_388/vpd[3] openDVS_pixel2x2_bot_388/vpd[2] rowReadON[24] rowReadON[25]
+ RefrBp PrBp PrSFBp col_periphery_1x2_4/COL_LINE0 pixRst[8] pixRst[9] col_periphery_1x2_4/COL_LINE1
+ OffBn rowReadOFF[24] rowReadOFF[25] openDVS_pixel2x2_bot_415/GndD DiffBn VSUBS OnBn
+ VDD openDVS_pixel2x2_bot
XopenDVS_pixel2x2_bot_355 openDVS_pixel2x2_bot_355/vpd[0] openDVS_pixel2x2_bot_355/vpd[1]
+ openDVS_pixel2x2_bot_355/vpd[3] openDVS_pixel2x2_bot_355/vpd[2] rowReadON[22] rowReadON[23]
+ RefrBp PrBp PrSFBp col_periphery_1x2_3/COL_LINE0 pixRst[6] pixRst[7] col_periphery_1x2_3/COL_LINE1
+ OffBn rowReadOFF[22] rowReadOFF[23] openDVS_pixel2x2_bot_383/GndD DiffBn VSUBS OnBn
+ VDD openDVS_pixel2x2_bot
XopenDVS_pixel2x2_bot_322 openDVS_pixel2x2_bot_322/vpd[0] openDVS_pixel2x2_bot_322/vpd[1]
+ openDVS_pixel2x2_bot_322/vpd[3] openDVS_pixel2x2_bot_322/vpd[2] rowReadON[20] rowReadON[21]
+ RefrBp PrBp PrSFBp col_periphery_1x2_2/COL_LINE0 pixRst[4] pixRst[5] col_periphery_1x2_2/COL_LINE1
+ OffBn rowReadOFF[20] rowReadOFF[21] openDVS_pixel2x2_bot_351/GndD DiffBn VSUBS OnBn
+ VDD openDVS_pixel2x2_bot
XopenDVS_pixel2x2_bot_300 openDVS_pixel2x2_bot_300/vpd[0] openDVS_pixel2x2_bot_300/vpd[1]
+ openDVS_pixel2x2_bot_300/vpd[3] openDVS_pixel2x2_bot_300/vpd[2] rowReadON[18] rowReadON[19]
+ RefrBp PrBp PrSFBp col_periphery_1x2_12/COL_LINE0 pixRst[24] pixRst[25] col_periphery_1x2_12/COL_LINE1
+ OffBn rowReadOFF[18] rowReadOFF[19] openDVS_pixel2x2_bot_319/GndD DiffBn VSUBS OnBn
+ VDD openDVS_pixel2x2_bot
XopenDVS_pixel2x2_bot_333 openDVS_pixel2x2_bot_333/vpd[0] openDVS_pixel2x2_bot_333/vpd[1]
+ openDVS_pixel2x2_bot_333/vpd[3] openDVS_pixel2x2_bot_333/vpd[2] rowReadON[20] rowReadON[21]
+ RefrBp PrBp PrSFBp col_periphery_1x2_13/COL_LINE0 pixRst[26] pixRst[27] col_periphery_1x2_13/COL_LINE1
+ OffBn rowReadOFF[20] rowReadOFF[21] openDVS_pixel2x2_bot_351/GndD DiffBn VSUBS OnBn
+ VDD openDVS_pixel2x2_bot
XopenDVS_pixel2x2_bot_311 openDVS_pixel2x2_bot_311/vpd[0] openDVS_pixel2x2_bot_311/vpd[1]
+ openDVS_pixel2x2_bot_311/vpd[3] openDVS_pixel2x2_bot_311/vpd[2] rowReadON[18] rowReadON[19]
+ RefrBp PrBp PrSFBp col_periphery_1x2_23/COL_LINE0 pixRst[46] pixRst[47] col_periphery_1x2_23/COL_LINE1
+ OffBn rowReadOFF[18] rowReadOFF[19] openDVS_pixel2x2_bot_319/GndD DiffBn VSUBS OnBn
+ VDD openDVS_pixel2x2_bot
XopenDVS_pixel2x2_bot_344 openDVS_pixel2x2_bot_344/vpd[0] openDVS_pixel2x2_bot_344/vpd[1]
+ openDVS_pixel2x2_bot_344/vpd[3] openDVS_pixel2x2_bot_344/vpd[2] rowReadON[20] rowReadON[21]
+ RefrBp PrBp PrSFBp col_periphery_1x2_24/COL_LINE0 pixRst[48] pixRst[49] col_periphery_1x2_24/COL_LINE1
+ OffBn rowReadOFF[20] rowReadOFF[21] openDVS_pixel2x2_bot_351/GndD DiffBn VSUBS OnBn
+ VDD openDVS_pixel2x2_bot
XopenDVS_pixel2x2_bot_163 openDVS_pixel2x2_bot_163/vpd[0] openDVS_pixel2x2_bot_163/vpd[1]
+ openDVS_pixel2x2_bot_163/vpd[3] openDVS_pixel2x2_bot_163/vpd[2] rowReadON[10] rowReadON[11]
+ RefrBp PrBp PrSFBp col_periphery_1x2_3/COL_LINE0 pixRst[6] pixRst[7] col_periphery_1x2_3/COL_LINE1
+ OffBn rowReadOFF[10] rowReadOFF[11] openDVS_pixel2x2_bot_191/GndD DiffBn VSUBS OnBn
+ VDD openDVS_pixel2x2_bot
XopenDVS_pixel2x2_bot_130 openDVS_pixel2x2_bot_130/vpd[0] openDVS_pixel2x2_bot_130/vpd[1]
+ openDVS_pixel2x2_bot_130/vpd[3] openDVS_pixel2x2_bot_130/vpd[2] rowReadON[8] rowReadON[9]
+ RefrBp PrBp PrSFBp col_periphery_1x2_2/COL_LINE0 pixRst[4] pixRst[5] col_periphery_1x2_2/COL_LINE1
+ OffBn rowReadOFF[8] rowReadOFF[9] openDVS_pixel2x2_bot_159/GndD DiffBn VSUBS OnBn
+ VDD openDVS_pixel2x2_bot
XopenDVS_pixel2x2_bot_141 openDVS_pixel2x2_bot_141/vpd[0] openDVS_pixel2x2_bot_141/vpd[1]
+ openDVS_pixel2x2_bot_141/vpd[3] openDVS_pixel2x2_bot_141/vpd[2] rowReadON[8] rowReadON[9]
+ RefrBp PrBp PrSFBp col_periphery_1x2_13/COL_LINE0 pixRst[26] pixRst[27] col_periphery_1x2_13/COL_LINE1
+ OffBn rowReadOFF[8] rowReadOFF[9] openDVS_pixel2x2_bot_159/GndD DiffBn VSUBS OnBn
+ VDD openDVS_pixel2x2_bot
XopenDVS_pixel2x2_bot_174 openDVS_pixel2x2_bot_174/vpd[0] openDVS_pixel2x2_bot_174/vpd[1]
+ openDVS_pixel2x2_bot_174/vpd[3] openDVS_pixel2x2_bot_174/vpd[2] rowReadON[10] rowReadON[11]
+ RefrBp PrBp PrSFBp col_periphery_1x2_14/COL_LINE0 pixRst[28] pixRst[29] col_periphery_1x2_14/COL_LINE1
+ OffBn rowReadOFF[10] rowReadOFF[11] openDVS_pixel2x2_bot_191/GndD DiffBn VSUBS OnBn
+ VDD openDVS_pixel2x2_bot
XopenDVS_pixel2x2_bot_152 openDVS_pixel2x2_bot_152/vpd[0] openDVS_pixel2x2_bot_152/vpd[1]
+ openDVS_pixel2x2_bot_152/vpd[3] openDVS_pixel2x2_bot_152/vpd[2] rowReadON[8] rowReadON[9]
+ RefrBp PrBp PrSFBp col_periphery_1x2_24/COL_LINE0 pixRst[48] pixRst[49] col_periphery_1x2_24/COL_LINE1
+ OffBn rowReadOFF[8] rowReadOFF[9] openDVS_pixel2x2_bot_159/GndD DiffBn VSUBS OnBn
+ VDD openDVS_pixel2x2_bot
XopenDVS_pixel2x2_bot_185 openDVS_pixel2x2_bot_185/vpd[0] openDVS_pixel2x2_bot_185/vpd[1]
+ openDVS_pixel2x2_bot_185/vpd[3] openDVS_pixel2x2_bot_185/vpd[2] rowReadON[10] rowReadON[11]
+ RefrBp PrBp PrSFBp col_periphery_1x2_25/COL_LINE0 pixRst[50] pixRst[51] col_periphery_1x2_25/COL_LINE1
+ OffBn rowReadOFF[10] rowReadOFF[11] openDVS_pixel2x2_bot_191/GndD DiffBn VSUBS OnBn
+ VDD openDVS_pixel2x2_bot
XopenDVS_pixel2x2_bot_196 openDVS_pixel2x2_bot_196/vpd[0] openDVS_pixel2x2_bot_196/vpd[1]
+ openDVS_pixel2x2_bot_196/vpd[3] openDVS_pixel2x2_bot_196/vpd[2] rowReadON[12] rowReadON[13]
+ RefrBp PrBp PrSFBp col_periphery_1x2_4/COL_LINE0 pixRst[8] pixRst[9] col_periphery_1x2_4/COL_LINE1
+ OffBn rowReadOFF[12] rowReadOFF[13] openDVS_pixel2x2_bot_223/GndD DiffBn VSUBS OnBn
+ VDD openDVS_pixel2x2_bot
XopenDVS_pixel2x2_bot_729 openDVS_pixel2x2_bot_729/vpd[0] openDVS_pixel2x2_bot_729/vpd[1]
+ openDVS_pixel2x2_bot_729/vpd[3] openDVS_pixel2x2_bot_729/vpd[2] rowReadON[44] rowReadON[45]
+ RefrBp PrBp PrSFBp col_periphery_1x2_25/COL_LINE0 pixRst[50] pixRst[51] col_periphery_1x2_25/COL_LINE1
+ OffBn rowReadOFF[44] rowReadOFF[45] openDVS_pixel2x2_bot_735/GndD DiffBn VSUBS OnBn
+ VDD openDVS_pixel2x2_bot
XopenDVS_pixel2x2_bot_718 openDVS_pixel2x2_bot_718/vpd[0] openDVS_pixel2x2_bot_718/vpd[1]
+ openDVS_pixel2x2_bot_718/vpd[3] openDVS_pixel2x2_bot_718/vpd[2] rowReadON[44] rowReadON[45]
+ RefrBp PrBp PrSFBp col_periphery_1x2_14/COL_LINE0 pixRst[28] pixRst[29] col_periphery_1x2_14/COL_LINE1
+ OffBn rowReadOFF[44] rowReadOFF[45] openDVS_pixel2x2_bot_735/GndD DiffBn VSUBS OnBn
+ VDD openDVS_pixel2x2_bot
XopenDVS_pixel2x2_bot_707 openDVS_pixel2x2_bot_707/vpd[0] openDVS_pixel2x2_bot_707/vpd[1]
+ openDVS_pixel2x2_bot_707/vpd[3] openDVS_pixel2x2_bot_707/vpd[2] rowReadON[44] rowReadON[45]
+ RefrBp PrBp PrSFBp col_periphery_1x2_3/COL_LINE0 pixRst[6] pixRst[7] col_periphery_1x2_3/COL_LINE1
+ OffBn rowReadOFF[44] rowReadOFF[45] openDVS_pixel2x2_bot_735/GndD DiffBn VSUBS OnBn
+ VDD openDVS_pixel2x2_bot
XopenDVS_pixel2x2_bot_537 openDVS_pixel2x2_bot_537/vpd[0] openDVS_pixel2x2_bot_537/vpd[1]
+ openDVS_pixel2x2_bot_537/vpd[3] openDVS_pixel2x2_bot_537/vpd[2] rowReadON[32] rowReadON[33]
+ RefrBp PrBp PrSFBp col_periphery_1x2_25/COL_LINE0 pixRst[50] pixRst[51] col_periphery_1x2_25/COL_LINE1
+ OffBn rowReadOFF[32] rowReadOFF[33] openDVS_pixel2x2_bot_543/GndD DiffBn VSUBS OnBn
+ VDD openDVS_pixel2x2_bot
XopenDVS_pixel2x2_bot_526 openDVS_pixel2x2_bot_526/vpd[0] openDVS_pixel2x2_bot_526/vpd[1]
+ openDVS_pixel2x2_bot_526/vpd[3] openDVS_pixel2x2_bot_526/vpd[2] rowReadON[32] rowReadON[33]
+ RefrBp PrBp PrSFBp col_periphery_1x2_14/COL_LINE0 pixRst[28] pixRst[29] col_periphery_1x2_14/COL_LINE1
+ OffBn rowReadOFF[32] rowReadOFF[33] openDVS_pixel2x2_bot_543/GndD DiffBn VSUBS OnBn
+ VDD openDVS_pixel2x2_bot
XopenDVS_pixel2x2_bot_515 openDVS_pixel2x2_bot_515/vpd[0] openDVS_pixel2x2_bot_515/vpd[1]
+ openDVS_pixel2x2_bot_515/vpd[3] openDVS_pixel2x2_bot_515/vpd[2] rowReadON[32] rowReadON[33]
+ RefrBp PrBp PrSFBp col_periphery_1x2_3/COL_LINE0 pixRst[6] pixRst[7] col_periphery_1x2_3/COL_LINE1
+ OffBn rowReadOFF[32] rowReadOFF[33] openDVS_pixel2x2_bot_543/GndD DiffBn VSUBS OnBn
+ VDD openDVS_pixel2x2_bot
XopenDVS_pixel2x2_bot_504 openDVS_pixel2x2_bot_504/vpd[0] openDVS_pixel2x2_bot_504/vpd[1]
+ openDVS_pixel2x2_bot_504/vpd[3] openDVS_pixel2x2_bot_504/vpd[2] rowReadON[30] rowReadON[31]
+ RefrBp PrBp PrSFBp col_periphery_1x2_24/COL_LINE0 pixRst[48] pixRst[49] col_periphery_1x2_24/COL_LINE1
+ OffBn rowReadOFF[30] rowReadOFF[31] openDVS_pixel2x2_bot_511/GndD DiffBn VSUBS OnBn
+ VDD openDVS_pixel2x2_bot
XopenDVS_pixel2x2_bot_559 openDVS_pixel2x2_bot_559/vpd[0] openDVS_pixel2x2_bot_559/vpd[1]
+ openDVS_pixel2x2_bot_559/vpd[3] openDVS_pixel2x2_bot_559/vpd[2] rowReadON[34] rowReadON[35]
+ RefrBp PrBp PrSFBp col_periphery_1x2_15/COL_LINE0 pixRst[30] pixRst[31] col_periphery_1x2_15/COL_LINE1
+ OffBn rowReadOFF[34] rowReadOFF[35] openDVS_pixel2x2_bot_575/GndD DiffBn VSUBS OnBn
+ VDD openDVS_pixel2x2_bot
XopenDVS_pixel2x2_bot_548 openDVS_pixel2x2_bot_548/vpd[0] openDVS_pixel2x2_bot_548/vpd[1]
+ openDVS_pixel2x2_bot_548/vpd[3] openDVS_pixel2x2_bot_548/vpd[2] rowReadON[34] rowReadON[35]
+ RefrBp PrBp PrSFBp col_periphery_1x2_4/COL_LINE0 pixRst[8] pixRst[9] col_periphery_1x2_4/COL_LINE1
+ OffBn rowReadOFF[34] rowReadOFF[35] openDVS_pixel2x2_bot_575/GndD DiffBn VSUBS OnBn
+ VDD openDVS_pixel2x2_bot
XopenDVS_pixel2x2_bot_378 openDVS_pixel2x2_bot_378/vpd[0] openDVS_pixel2x2_bot_378/vpd[1]
+ openDVS_pixel2x2_bot_378/vpd[3] openDVS_pixel2x2_bot_378/vpd[2] rowReadON[22] rowReadON[23]
+ RefrBp PrBp PrSFBp col_periphery_1x2_26/COL_LINE0 pixRst[52] pixRst[53] col_periphery_1x2_26/COL_LINE1
+ OffBn rowReadOFF[22] rowReadOFF[23] openDVS_pixel2x2_bot_383/GndD DiffBn VSUBS OnBn
+ VDD openDVS_pixel2x2_bot
XopenDVS_pixel2x2_bot_367 openDVS_pixel2x2_bot_367/vpd[0] openDVS_pixel2x2_bot_367/vpd[1]
+ openDVS_pixel2x2_bot_367/vpd[3] openDVS_pixel2x2_bot_367/vpd[2] rowReadON[22] rowReadON[23]
+ RefrBp PrBp PrSFBp col_periphery_1x2_15/COL_LINE0 pixRst[30] pixRst[31] col_periphery_1x2_15/COL_LINE1
+ OffBn rowReadOFF[22] rowReadOFF[23] openDVS_pixel2x2_bot_383/GndD DiffBn VSUBS OnBn
+ VDD openDVS_pixel2x2_bot
XopenDVS_pixel2x2_bot_389 openDVS_pixel2x2_bot_389/vpd[0] openDVS_pixel2x2_bot_389/vpd[1]
+ openDVS_pixel2x2_bot_389/vpd[3] openDVS_pixel2x2_bot_389/vpd[2] rowReadON[24] rowReadON[25]
+ RefrBp PrBp PrSFBp col_periphery_1x2_5/COL_LINE0 pixRst[10] pixRst[11] col_periphery_1x2_5/COL_LINE1
+ OffBn rowReadOFF[24] rowReadOFF[25] openDVS_pixel2x2_bot_415/GndD DiffBn VSUBS OnBn
+ VDD openDVS_pixel2x2_bot
XopenDVS_pixel2x2_bot_356 openDVS_pixel2x2_bot_356/vpd[0] openDVS_pixel2x2_bot_356/vpd[1]
+ openDVS_pixel2x2_bot_356/vpd[3] openDVS_pixel2x2_bot_356/vpd[2] rowReadON[22] rowReadON[23]
+ RefrBp PrBp PrSFBp col_periphery_1x2_4/COL_LINE0 pixRst[8] pixRst[9] col_periphery_1x2_4/COL_LINE1
+ OffBn rowReadOFF[22] rowReadOFF[23] openDVS_pixel2x2_bot_383/GndD DiffBn VSUBS OnBn
+ VDD openDVS_pixel2x2_bot
XopenDVS_pixel2x2_bot_323 openDVS_pixel2x2_bot_323/vpd[0] openDVS_pixel2x2_bot_323/vpd[1]
+ openDVS_pixel2x2_bot_323/vpd[3] openDVS_pixel2x2_bot_323/vpd[2] rowReadON[20] rowReadON[21]
+ RefrBp PrBp PrSFBp col_periphery_1x2_3/COL_LINE0 pixRst[6] pixRst[7] col_periphery_1x2_3/COL_LINE1
+ OffBn rowReadOFF[20] rowReadOFF[21] openDVS_pixel2x2_bot_351/GndD DiffBn VSUBS OnBn
+ VDD openDVS_pixel2x2_bot
XopenDVS_pixel2x2_bot_301 openDVS_pixel2x2_bot_301/vpd[0] openDVS_pixel2x2_bot_301/vpd[1]
+ openDVS_pixel2x2_bot_301/vpd[3] openDVS_pixel2x2_bot_301/vpd[2] rowReadON[18] rowReadON[19]
+ RefrBp PrBp PrSFBp col_periphery_1x2_13/COL_LINE0 pixRst[26] pixRst[27] col_periphery_1x2_13/COL_LINE1
+ OffBn rowReadOFF[18] rowReadOFF[19] openDVS_pixel2x2_bot_319/GndD DiffBn VSUBS OnBn
+ VDD openDVS_pixel2x2_bot
XopenDVS_pixel2x2_bot_334 openDVS_pixel2x2_bot_334/vpd[0] openDVS_pixel2x2_bot_334/vpd[1]
+ openDVS_pixel2x2_bot_334/vpd[3] openDVS_pixel2x2_bot_334/vpd[2] rowReadON[20] rowReadON[21]
+ RefrBp PrBp PrSFBp col_periphery_1x2_14/COL_LINE0 pixRst[28] pixRst[29] col_periphery_1x2_14/COL_LINE1
+ OffBn rowReadOFF[20] rowReadOFF[21] openDVS_pixel2x2_bot_351/GndD DiffBn VSUBS OnBn
+ VDD openDVS_pixel2x2_bot
XopenDVS_pixel2x2_bot_312 openDVS_pixel2x2_bot_312/vpd[0] openDVS_pixel2x2_bot_312/vpd[1]
+ openDVS_pixel2x2_bot_312/vpd[3] openDVS_pixel2x2_bot_312/vpd[2] rowReadON[18] rowReadON[19]
+ RefrBp PrBp PrSFBp col_periphery_1x2_24/COL_LINE0 pixRst[48] pixRst[49] col_periphery_1x2_24/COL_LINE1
+ OffBn rowReadOFF[18] rowReadOFF[19] openDVS_pixel2x2_bot_319/GndD DiffBn VSUBS OnBn
+ VDD openDVS_pixel2x2_bot
XopenDVS_pixel2x2_bot_345 openDVS_pixel2x2_bot_345/vpd[0] openDVS_pixel2x2_bot_345/vpd[1]
+ openDVS_pixel2x2_bot_345/vpd[3] openDVS_pixel2x2_bot_345/vpd[2] rowReadON[20] rowReadON[21]
+ RefrBp PrBp PrSFBp col_periphery_1x2_25/COL_LINE0 pixRst[50] pixRst[51] col_periphery_1x2_25/COL_LINE1
+ OffBn rowReadOFF[20] rowReadOFF[21] openDVS_pixel2x2_bot_351/GndD DiffBn VSUBS OnBn
+ VDD openDVS_pixel2x2_bot
XopenDVS_pixel2x2_bot_890 openDVS_pixel2x2_bot_890/vpd[0] openDVS_pixel2x2_bot_890/vpd[1]
+ openDVS_pixel2x2_bot_890/vpd[3] openDVS_pixel2x2_bot_890/vpd[2] rowReadON[54] rowReadON[55]
+ RefrBp PrBp PrSFBp col_periphery_1x2_26/COL_LINE0 pixRst[52] pixRst[53] col_periphery_1x2_26/COL_LINE1
+ OffBn rowReadOFF[54] rowReadOFF[55] openDVS_pixel2x2_bot_895/GndD DiffBn VSUBS OnBn
+ VDD openDVS_pixel2x2_bot
XopenDVS_pixel2x2_bot_164 openDVS_pixel2x2_bot_164/vpd[0] openDVS_pixel2x2_bot_164/vpd[1]
+ openDVS_pixel2x2_bot_164/vpd[3] openDVS_pixel2x2_bot_164/vpd[2] rowReadON[10] rowReadON[11]
+ RefrBp PrBp PrSFBp col_periphery_1x2_4/COL_LINE0 pixRst[8] pixRst[9] col_periphery_1x2_4/COL_LINE1
+ OffBn rowReadOFF[10] rowReadOFF[11] openDVS_pixel2x2_bot_191/GndD DiffBn VSUBS OnBn
+ VDD openDVS_pixel2x2_bot
XopenDVS_pixel2x2_bot_131 openDVS_pixel2x2_bot_131/vpd[0] openDVS_pixel2x2_bot_131/vpd[1]
+ openDVS_pixel2x2_bot_131/vpd[3] openDVS_pixel2x2_bot_131/vpd[2] rowReadON[8] rowReadON[9]
+ RefrBp PrBp PrSFBp col_periphery_1x2_3/COL_LINE0 pixRst[6] pixRst[7] col_periphery_1x2_3/COL_LINE1
+ OffBn rowReadOFF[8] rowReadOFF[9] openDVS_pixel2x2_bot_159/GndD DiffBn VSUBS OnBn
+ VDD openDVS_pixel2x2_bot
XopenDVS_pixel2x2_bot_142 openDVS_pixel2x2_bot_142/vpd[0] openDVS_pixel2x2_bot_142/vpd[1]
+ openDVS_pixel2x2_bot_142/vpd[3] openDVS_pixel2x2_bot_142/vpd[2] rowReadON[8] rowReadON[9]
+ RefrBp PrBp PrSFBp col_periphery_1x2_14/COL_LINE0 pixRst[28] pixRst[29] col_periphery_1x2_14/COL_LINE1
+ OffBn rowReadOFF[8] rowReadOFF[9] openDVS_pixel2x2_bot_159/GndD DiffBn VSUBS OnBn
+ VDD openDVS_pixel2x2_bot
XopenDVS_pixel2x2_bot_175 openDVS_pixel2x2_bot_175/vpd[0] openDVS_pixel2x2_bot_175/vpd[1]
+ openDVS_pixel2x2_bot_175/vpd[3] openDVS_pixel2x2_bot_175/vpd[2] rowReadON[10] rowReadON[11]
+ RefrBp PrBp PrSFBp col_periphery_1x2_15/COL_LINE0 pixRst[30] pixRst[31] col_periphery_1x2_15/COL_LINE1
+ OffBn rowReadOFF[10] rowReadOFF[11] openDVS_pixel2x2_bot_191/GndD DiffBn VSUBS OnBn
+ VDD openDVS_pixel2x2_bot
XopenDVS_pixel2x2_bot_120 openDVS_pixel2x2_bot_120/vpd[0] openDVS_pixel2x2_bot_120/vpd[1]
+ openDVS_pixel2x2_bot_120/vpd[3] openDVS_pixel2x2_bot_120/vpd[2] rowReadON[6] rowReadON[7]
+ RefrBp PrBp PrSFBp col_periphery_1x2_24/COL_LINE0 pixRst[48] pixRst[49] col_periphery_1x2_24/COL_LINE1
+ OffBn rowReadOFF[6] rowReadOFF[7] openDVS_pixel2x2_bot_99/GndD DiffBn VSUBS OnBn
+ VDD openDVS_pixel2x2_bot
XopenDVS_pixel2x2_bot_153 openDVS_pixel2x2_bot_153/vpd[0] openDVS_pixel2x2_bot_153/vpd[1]
+ openDVS_pixel2x2_bot_153/vpd[3] openDVS_pixel2x2_bot_153/vpd[2] rowReadON[8] rowReadON[9]
+ RefrBp PrBp PrSFBp col_periphery_1x2_25/COL_LINE0 pixRst[50] pixRst[51] col_periphery_1x2_25/COL_LINE1
+ OffBn rowReadOFF[8] rowReadOFF[9] openDVS_pixel2x2_bot_159/GndD DiffBn VSUBS OnBn
+ VDD openDVS_pixel2x2_bot
XopenDVS_pixel2x2_bot_186 openDVS_pixel2x2_bot_186/vpd[0] openDVS_pixel2x2_bot_186/vpd[1]
+ openDVS_pixel2x2_bot_186/vpd[3] openDVS_pixel2x2_bot_186/vpd[2] rowReadON[10] rowReadON[11]
+ RefrBp PrBp PrSFBp col_periphery_1x2_26/COL_LINE0 pixRst[52] pixRst[53] col_periphery_1x2_26/COL_LINE1
+ OffBn rowReadOFF[10] rowReadOFF[11] openDVS_pixel2x2_bot_191/GndD DiffBn VSUBS OnBn
+ VDD openDVS_pixel2x2_bot
XopenDVS_pixel2x2_bot_197 openDVS_pixel2x2_bot_197/vpd[0] openDVS_pixel2x2_bot_197/vpd[1]
+ openDVS_pixel2x2_bot_197/vpd[3] openDVS_pixel2x2_bot_197/vpd[2] rowReadON[12] rowReadON[13]
+ RefrBp PrBp PrSFBp col_periphery_1x2_5/COL_LINE0 pixRst[10] pixRst[11] col_periphery_1x2_5/COL_LINE1
+ OffBn rowReadOFF[12] rowReadOFF[13] openDVS_pixel2x2_bot_223/GndD DiffBn VSUBS OnBn
+ VDD openDVS_pixel2x2_bot
XopenDVS_pixel2x2_bot_719 openDVS_pixel2x2_bot_719/vpd[0] openDVS_pixel2x2_bot_719/vpd[1]
+ openDVS_pixel2x2_bot_719/vpd[3] openDVS_pixel2x2_bot_719/vpd[2] rowReadON[44] rowReadON[45]
+ RefrBp PrBp PrSFBp col_periphery_1x2_15/COL_LINE0 pixRst[30] pixRst[31] col_periphery_1x2_15/COL_LINE1
+ OffBn rowReadOFF[44] rowReadOFF[45] openDVS_pixel2x2_bot_735/GndD DiffBn VSUBS OnBn
+ VDD openDVS_pixel2x2_bot
XopenDVS_pixel2x2_bot_708 openDVS_pixel2x2_bot_708/vpd[0] openDVS_pixel2x2_bot_708/vpd[1]
+ openDVS_pixel2x2_bot_708/vpd[3] openDVS_pixel2x2_bot_708/vpd[2] rowReadON[44] rowReadON[45]
+ RefrBp PrBp PrSFBp col_periphery_1x2_4/COL_LINE0 pixRst[8] pixRst[9] col_periphery_1x2_4/COL_LINE1
+ OffBn rowReadOFF[44] rowReadOFF[45] openDVS_pixel2x2_bot_735/GndD DiffBn VSUBS OnBn
+ VDD openDVS_pixel2x2_bot
XopenDVS_pixel2x2_bot_538 openDVS_pixel2x2_bot_538/vpd[0] openDVS_pixel2x2_bot_538/vpd[1]
+ openDVS_pixel2x2_bot_538/vpd[3] openDVS_pixel2x2_bot_538/vpd[2] rowReadON[32] rowReadON[33]
+ RefrBp PrBp PrSFBp col_periphery_1x2_26/COL_LINE0 pixRst[52] pixRst[53] col_periphery_1x2_26/COL_LINE1
+ OffBn rowReadOFF[32] rowReadOFF[33] openDVS_pixel2x2_bot_543/GndD DiffBn VSUBS OnBn
+ VDD openDVS_pixel2x2_bot
XopenDVS_pixel2x2_bot_527 openDVS_pixel2x2_bot_527/vpd[0] openDVS_pixel2x2_bot_527/vpd[1]
+ openDVS_pixel2x2_bot_527/vpd[3] openDVS_pixel2x2_bot_527/vpd[2] rowReadON[32] rowReadON[33]
+ RefrBp PrBp PrSFBp col_periphery_1x2_15/COL_LINE0 pixRst[30] pixRst[31] col_periphery_1x2_15/COL_LINE1
+ OffBn rowReadOFF[32] rowReadOFF[33] openDVS_pixel2x2_bot_543/GndD DiffBn VSUBS OnBn
+ VDD openDVS_pixel2x2_bot
XopenDVS_pixel2x2_bot_549 openDVS_pixel2x2_bot_549/vpd[0] openDVS_pixel2x2_bot_549/vpd[1]
+ openDVS_pixel2x2_bot_549/vpd[3] openDVS_pixel2x2_bot_549/vpd[2] rowReadON[34] rowReadON[35]
+ RefrBp PrBp PrSFBp col_periphery_1x2_5/COL_LINE0 pixRst[10] pixRst[11] col_periphery_1x2_5/COL_LINE1
+ OffBn rowReadOFF[34] rowReadOFF[35] openDVS_pixel2x2_bot_575/GndD DiffBn VSUBS OnBn
+ VDD openDVS_pixel2x2_bot
XopenDVS_pixel2x2_bot_516 openDVS_pixel2x2_bot_516/vpd[0] openDVS_pixel2x2_bot_516/vpd[1]
+ openDVS_pixel2x2_bot_516/vpd[3] openDVS_pixel2x2_bot_516/vpd[2] rowReadON[32] rowReadON[33]
+ RefrBp PrBp PrSFBp col_periphery_1x2_4/COL_LINE0 pixRst[8] pixRst[9] col_periphery_1x2_4/COL_LINE1
+ OffBn rowReadOFF[32] rowReadOFF[33] openDVS_pixel2x2_bot_543/GndD DiffBn VSUBS OnBn
+ VDD openDVS_pixel2x2_bot
XopenDVS_pixel2x2_bot_505 openDVS_pixel2x2_bot_505/vpd[0] openDVS_pixel2x2_bot_505/vpd[1]
+ openDVS_pixel2x2_bot_505/vpd[3] openDVS_pixel2x2_bot_505/vpd[2] rowReadON[30] rowReadON[31]
+ RefrBp PrBp PrSFBp col_periphery_1x2_25/COL_LINE0 pixRst[50] pixRst[51] col_periphery_1x2_25/COL_LINE1
+ OffBn rowReadOFF[30] rowReadOFF[31] openDVS_pixel2x2_bot_511/GndD DiffBn VSUBS OnBn
+ VDD openDVS_pixel2x2_bot
XopenDVS_pixel2x2_bot_379 openDVS_pixel2x2_bot_379/vpd[0] openDVS_pixel2x2_bot_379/vpd[1]
+ openDVS_pixel2x2_bot_379/vpd[3] openDVS_pixel2x2_bot_379/vpd[2] rowReadON[22] rowReadON[23]
+ RefrBp PrBp PrSFBp col_periphery_1x2_27/COL_LINE0 pixRst[54] pixRst[55] col_periphery_1x2_27/COL_LINE1
+ OffBn rowReadOFF[22] rowReadOFF[23] openDVS_pixel2x2_bot_383/GndD DiffBn VSUBS OnBn
+ VDD openDVS_pixel2x2_bot
XopenDVS_pixel2x2_bot_368 openDVS_pixel2x2_bot_368/vpd[0] openDVS_pixel2x2_bot_368/vpd[1]
+ openDVS_pixel2x2_bot_368/vpd[3] openDVS_pixel2x2_bot_368/vpd[2] rowReadON[22] rowReadON[23]
+ RefrBp PrBp PrSFBp col_periphery_1x2_16/COL_LINE0 pixRst[32] pixRst[33] col_periphery_1x2_16/COL_LINE1
+ OffBn rowReadOFF[22] rowReadOFF[23] openDVS_pixel2x2_bot_383/GndD DiffBn VSUBS OnBn
+ VDD openDVS_pixel2x2_bot
XopenDVS_pixel2x2_bot_357 openDVS_pixel2x2_bot_357/vpd[0] openDVS_pixel2x2_bot_357/vpd[1]
+ openDVS_pixel2x2_bot_357/vpd[3] openDVS_pixel2x2_bot_357/vpd[2] rowReadON[22] rowReadON[23]
+ RefrBp PrBp PrSFBp col_periphery_1x2_5/COL_LINE0 pixRst[10] pixRst[11] col_periphery_1x2_5/COL_LINE1
+ OffBn rowReadOFF[22] rowReadOFF[23] openDVS_pixel2x2_bot_383/GndD DiffBn VSUBS OnBn
+ VDD openDVS_pixel2x2_bot
XopenDVS_pixel2x2_bot_324 openDVS_pixel2x2_bot_324/vpd[0] openDVS_pixel2x2_bot_324/vpd[1]
+ openDVS_pixel2x2_bot_324/vpd[3] openDVS_pixel2x2_bot_324/vpd[2] rowReadON[20] rowReadON[21]
+ RefrBp PrBp PrSFBp col_periphery_1x2_4/COL_LINE0 pixRst[8] pixRst[9] col_periphery_1x2_4/COL_LINE1
+ OffBn rowReadOFF[20] rowReadOFF[21] openDVS_pixel2x2_bot_351/GndD DiffBn VSUBS OnBn
+ VDD openDVS_pixel2x2_bot
XopenDVS_pixel2x2_bot_302 openDVS_pixel2x2_bot_302/vpd[0] openDVS_pixel2x2_bot_302/vpd[1]
+ openDVS_pixel2x2_bot_302/vpd[3] openDVS_pixel2x2_bot_302/vpd[2] rowReadON[18] rowReadON[19]
+ RefrBp PrBp PrSFBp col_periphery_1x2_14/COL_LINE0 pixRst[28] pixRst[29] col_periphery_1x2_14/COL_LINE1
+ OffBn rowReadOFF[18] rowReadOFF[19] openDVS_pixel2x2_bot_319/GndD DiffBn VSUBS OnBn
+ VDD openDVS_pixel2x2_bot
XopenDVS_pixel2x2_bot_335 openDVS_pixel2x2_bot_335/vpd[0] openDVS_pixel2x2_bot_335/vpd[1]
+ openDVS_pixel2x2_bot_335/vpd[3] openDVS_pixel2x2_bot_335/vpd[2] rowReadON[20] rowReadON[21]
+ RefrBp PrBp PrSFBp col_periphery_1x2_15/COL_LINE0 pixRst[30] pixRst[31] col_periphery_1x2_15/COL_LINE1
+ OffBn rowReadOFF[20] rowReadOFF[21] openDVS_pixel2x2_bot_351/GndD DiffBn VSUBS OnBn
+ VDD openDVS_pixel2x2_bot
XopenDVS_pixel2x2_bot_313 openDVS_pixel2x2_bot_313/vpd[0] openDVS_pixel2x2_bot_313/vpd[1]
+ openDVS_pixel2x2_bot_313/vpd[3] openDVS_pixel2x2_bot_313/vpd[2] rowReadON[18] rowReadON[19]
+ RefrBp PrBp PrSFBp col_periphery_1x2_25/COL_LINE0 pixRst[50] pixRst[51] col_periphery_1x2_25/COL_LINE1
+ OffBn rowReadOFF[18] rowReadOFF[19] openDVS_pixel2x2_bot_319/GndD DiffBn VSUBS OnBn
+ VDD openDVS_pixel2x2_bot
XopenDVS_pixel2x2_bot_346 openDVS_pixel2x2_bot_346/vpd[0] openDVS_pixel2x2_bot_346/vpd[1]
+ openDVS_pixel2x2_bot_346/vpd[3] openDVS_pixel2x2_bot_346/vpd[2] rowReadON[20] rowReadON[21]
+ RefrBp PrBp PrSFBp col_periphery_1x2_26/COL_LINE0 pixRst[52] pixRst[53] col_periphery_1x2_26/COL_LINE1
+ OffBn rowReadOFF[20] rowReadOFF[21] openDVS_pixel2x2_bot_351/GndD DiffBn VSUBS OnBn
+ VDD openDVS_pixel2x2_bot
XopenDVS_pixel2x2_bot_891 openDVS_pixel2x2_bot_891/vpd[0] openDVS_pixel2x2_bot_891/vpd[1]
+ openDVS_pixel2x2_bot_891/vpd[3] openDVS_pixel2x2_bot_891/vpd[2] rowReadON[54] rowReadON[55]
+ RefrBp PrBp PrSFBp col_periphery_1x2_27/COL_LINE0 pixRst[54] pixRst[55] col_periphery_1x2_27/COL_LINE1
+ OffBn rowReadOFF[54] rowReadOFF[55] openDVS_pixel2x2_bot_895/GndD DiffBn VSUBS OnBn
+ VDD openDVS_pixel2x2_bot
XopenDVS_pixel2x2_bot_880 openDVS_pixel2x2_bot_880/vpd[0] openDVS_pixel2x2_bot_880/vpd[1]
+ openDVS_pixel2x2_bot_880/vpd[3] openDVS_pixel2x2_bot_880/vpd[2] rowReadON[54] rowReadON[55]
+ RefrBp PrBp PrSFBp col_periphery_1x2_16/COL_LINE0 pixRst[32] pixRst[33] col_periphery_1x2_16/COL_LINE1
+ OffBn rowReadOFF[54] rowReadOFF[55] openDVS_pixel2x2_bot_895/GndD DiffBn VSUBS OnBn
+ VDD openDVS_pixel2x2_bot
XopenDVS_pixel2x2_bot_132 openDVS_pixel2x2_bot_132/vpd[0] openDVS_pixel2x2_bot_132/vpd[1]
+ openDVS_pixel2x2_bot_132/vpd[3] openDVS_pixel2x2_bot_132/vpd[2] rowReadON[8] rowReadON[9]
+ RefrBp PrBp PrSFBp col_periphery_1x2_4/COL_LINE0 pixRst[8] pixRst[9] col_periphery_1x2_4/COL_LINE1
+ OffBn rowReadOFF[8] rowReadOFF[9] openDVS_pixel2x2_bot_159/GndD DiffBn VSUBS OnBn
+ VDD openDVS_pixel2x2_bot
XopenDVS_pixel2x2_bot_165 openDVS_pixel2x2_bot_165/vpd[0] openDVS_pixel2x2_bot_165/vpd[1]
+ openDVS_pixel2x2_bot_165/vpd[3] openDVS_pixel2x2_bot_165/vpd[2] rowReadON[10] rowReadON[11]
+ RefrBp PrBp PrSFBp col_periphery_1x2_5/COL_LINE0 pixRst[10] pixRst[11] col_periphery_1x2_5/COL_LINE1
+ OffBn rowReadOFF[10] rowReadOFF[11] openDVS_pixel2x2_bot_191/GndD DiffBn VSUBS OnBn
+ VDD openDVS_pixel2x2_bot
XopenDVS_pixel2x2_bot_110 openDVS_pixel2x2_bot_110/vpd[0] openDVS_pixel2x2_bot_110/vpd[1]
+ openDVS_pixel2x2_bot_110/vpd[3] openDVS_pixel2x2_bot_110/vpd[2] rowReadON[6] rowReadON[7]
+ RefrBp PrBp PrSFBp col_periphery_1x2_14/COL_LINE0 pixRst[28] pixRst[29] col_periphery_1x2_14/COL_LINE1
+ OffBn rowReadOFF[6] rowReadOFF[7] openDVS_pixel2x2_bot_99/GndD DiffBn VSUBS OnBn
+ VDD openDVS_pixel2x2_bot
XopenDVS_pixel2x2_bot_143 openDVS_pixel2x2_bot_143/vpd[0] openDVS_pixel2x2_bot_143/vpd[1]
+ openDVS_pixel2x2_bot_143/vpd[3] openDVS_pixel2x2_bot_143/vpd[2] rowReadON[8] rowReadON[9]
+ RefrBp PrBp PrSFBp col_periphery_1x2_15/COL_LINE0 pixRst[30] pixRst[31] col_periphery_1x2_15/COL_LINE1
+ OffBn rowReadOFF[8] rowReadOFF[9] openDVS_pixel2x2_bot_159/GndD DiffBn VSUBS OnBn
+ VDD openDVS_pixel2x2_bot
XopenDVS_pixel2x2_bot_176 openDVS_pixel2x2_bot_176/vpd[0] openDVS_pixel2x2_bot_176/vpd[1]
+ openDVS_pixel2x2_bot_176/vpd[3] openDVS_pixel2x2_bot_176/vpd[2] rowReadON[10] rowReadON[11]
+ RefrBp PrBp PrSFBp col_periphery_1x2_16/COL_LINE0 pixRst[32] pixRst[33] col_periphery_1x2_16/COL_LINE1
+ OffBn rowReadOFF[10] rowReadOFF[11] openDVS_pixel2x2_bot_191/GndD DiffBn VSUBS OnBn
+ VDD openDVS_pixel2x2_bot
XopenDVS_pixel2x2_bot_121 openDVS_pixel2x2_bot_121/vpd[0] openDVS_pixel2x2_bot_121/vpd[1]
+ openDVS_pixel2x2_bot_121/vpd[3] openDVS_pixel2x2_bot_121/vpd[2] rowReadON[6] rowReadON[7]
+ RefrBp PrBp PrSFBp col_periphery_1x2_25/COL_LINE0 pixRst[50] pixRst[51] col_periphery_1x2_25/COL_LINE1
+ OffBn rowReadOFF[6] rowReadOFF[7] openDVS_pixel2x2_bot_99/GndD DiffBn VSUBS OnBn
+ VDD openDVS_pixel2x2_bot
XopenDVS_pixel2x2_bot_154 openDVS_pixel2x2_bot_154/vpd[0] openDVS_pixel2x2_bot_154/vpd[1]
+ openDVS_pixel2x2_bot_154/vpd[3] openDVS_pixel2x2_bot_154/vpd[2] rowReadON[8] rowReadON[9]
+ RefrBp PrBp PrSFBp col_periphery_1x2_26/COL_LINE0 pixRst[52] pixRst[53] col_periphery_1x2_26/COL_LINE1
+ OffBn rowReadOFF[8] rowReadOFF[9] openDVS_pixel2x2_bot_159/GndD DiffBn VSUBS OnBn
+ VDD openDVS_pixel2x2_bot
XopenDVS_pixel2x2_bot_187 openDVS_pixel2x2_bot_187/vpd[0] openDVS_pixel2x2_bot_187/vpd[1]
+ openDVS_pixel2x2_bot_187/vpd[3] openDVS_pixel2x2_bot_187/vpd[2] rowReadON[10] rowReadON[11]
+ RefrBp PrBp PrSFBp col_periphery_1x2_27/COL_LINE0 pixRst[54] pixRst[55] col_periphery_1x2_27/COL_LINE1
+ OffBn rowReadOFF[10] rowReadOFF[11] openDVS_pixel2x2_bot_191/GndD DiffBn VSUBS OnBn
+ VDD openDVS_pixel2x2_bot
XopenDVS_pixel2x2_bot_198 openDVS_pixel2x2_bot_198/vpd[0] openDVS_pixel2x2_bot_198/vpd[1]
+ openDVS_pixel2x2_bot_198/vpd[3] openDVS_pixel2x2_bot_198/vpd[2] rowReadON[12] rowReadON[13]
+ RefrBp PrBp PrSFBp col_periphery_1x2_6/COL_LINE0 pixRst[12] pixRst[13] col_periphery_1x2_6/COL_LINE1
+ OffBn rowReadOFF[12] rowReadOFF[13] openDVS_pixel2x2_bot_223/GndD DiffBn VSUBS OnBn
+ VDD openDVS_pixel2x2_bot
XopenDVS_pixel2x2_bot_709 openDVS_pixel2x2_bot_709/vpd[0] openDVS_pixel2x2_bot_709/vpd[1]
+ openDVS_pixel2x2_bot_709/vpd[3] openDVS_pixel2x2_bot_709/vpd[2] rowReadON[44] rowReadON[45]
+ RefrBp PrBp PrSFBp col_periphery_1x2_5/COL_LINE0 pixRst[10] pixRst[11] col_periphery_1x2_5/COL_LINE1
+ OffBn rowReadOFF[44] rowReadOFF[45] openDVS_pixel2x2_bot_735/GndD DiffBn VSUBS OnBn
+ VDD openDVS_pixel2x2_bot
XopenDVS_pixel2x2_bot_539 openDVS_pixel2x2_bot_539/vpd[0] openDVS_pixel2x2_bot_539/vpd[1]
+ openDVS_pixel2x2_bot_539/vpd[3] openDVS_pixel2x2_bot_539/vpd[2] rowReadON[32] rowReadON[33]
+ RefrBp PrBp PrSFBp col_periphery_1x2_27/COL_LINE0 pixRst[54] pixRst[55] col_periphery_1x2_27/COL_LINE1
+ OffBn rowReadOFF[32] rowReadOFF[33] openDVS_pixel2x2_bot_543/GndD DiffBn VSUBS OnBn
+ VDD openDVS_pixel2x2_bot
XopenDVS_pixel2x2_bot_528 openDVS_pixel2x2_bot_528/vpd[0] openDVS_pixel2x2_bot_528/vpd[1]
+ openDVS_pixel2x2_bot_528/vpd[3] openDVS_pixel2x2_bot_528/vpd[2] rowReadON[32] rowReadON[33]
+ RefrBp PrBp PrSFBp col_periphery_1x2_16/COL_LINE0 pixRst[32] pixRst[33] col_periphery_1x2_16/COL_LINE1
+ OffBn rowReadOFF[32] rowReadOFF[33] openDVS_pixel2x2_bot_543/GndD DiffBn VSUBS OnBn
+ VDD openDVS_pixel2x2_bot
XopenDVS_pixel2x2_bot_517 openDVS_pixel2x2_bot_517/vpd[0] openDVS_pixel2x2_bot_517/vpd[1]
+ openDVS_pixel2x2_bot_517/vpd[3] openDVS_pixel2x2_bot_517/vpd[2] rowReadON[32] rowReadON[33]
+ RefrBp PrBp PrSFBp col_periphery_1x2_5/COL_LINE0 pixRst[10] pixRst[11] col_periphery_1x2_5/COL_LINE1
+ OffBn rowReadOFF[32] rowReadOFF[33] openDVS_pixel2x2_bot_543/GndD DiffBn VSUBS OnBn
+ VDD openDVS_pixel2x2_bot
XopenDVS_pixel2x2_bot_506 openDVS_pixel2x2_bot_506/vpd[0] openDVS_pixel2x2_bot_506/vpd[1]
+ openDVS_pixel2x2_bot_506/vpd[3] openDVS_pixel2x2_bot_506/vpd[2] rowReadON[30] rowReadON[31]
+ RefrBp PrBp PrSFBp col_periphery_1x2_26/COL_LINE0 pixRst[52] pixRst[53] col_periphery_1x2_26/COL_LINE1
+ OffBn rowReadOFF[30] rowReadOFF[31] openDVS_pixel2x2_bot_511/GndD DiffBn VSUBS OnBn
+ VDD openDVS_pixel2x2_bot
XopenDVS_pixel2x2_bot_303 openDVS_pixel2x2_bot_303/vpd[0] openDVS_pixel2x2_bot_303/vpd[1]
+ openDVS_pixel2x2_bot_303/vpd[3] openDVS_pixel2x2_bot_303/vpd[2] rowReadON[18] rowReadON[19]
+ RefrBp PrBp PrSFBp col_periphery_1x2_15/COL_LINE0 pixRst[30] pixRst[31] col_periphery_1x2_15/COL_LINE1
+ OffBn rowReadOFF[18] rowReadOFF[19] openDVS_pixel2x2_bot_319/GndD DiffBn VSUBS OnBn
+ VDD openDVS_pixel2x2_bot
XopenDVS_pixel2x2_bot_369 openDVS_pixel2x2_bot_369/vpd[0] openDVS_pixel2x2_bot_369/vpd[1]
+ openDVS_pixel2x2_bot_369/vpd[3] openDVS_pixel2x2_bot_369/vpd[2] rowReadON[22] rowReadON[23]
+ RefrBp PrBp PrSFBp col_periphery_1x2_17/COL_LINE0 pixRst[34] pixRst[35] col_periphery_1x2_17/COL_LINE1
+ OffBn rowReadOFF[22] rowReadOFF[23] openDVS_pixel2x2_bot_383/GndD DiffBn VSUBS OnBn
+ VDD openDVS_pixel2x2_bot
XopenDVS_pixel2x2_bot_358 openDVS_pixel2x2_bot_358/vpd[0] openDVS_pixel2x2_bot_358/vpd[1]
+ openDVS_pixel2x2_bot_358/vpd[3] openDVS_pixel2x2_bot_358/vpd[2] rowReadON[22] rowReadON[23]
+ RefrBp PrBp PrSFBp col_periphery_1x2_6/COL_LINE0 pixRst[12] pixRst[13] col_periphery_1x2_6/COL_LINE1
+ OffBn rowReadOFF[22] rowReadOFF[23] openDVS_pixel2x2_bot_383/GndD DiffBn VSUBS OnBn
+ VDD openDVS_pixel2x2_bot
XopenDVS_pixel2x2_bot_325 openDVS_pixel2x2_bot_325/vpd[0] openDVS_pixel2x2_bot_325/vpd[1]
+ openDVS_pixel2x2_bot_325/vpd[3] openDVS_pixel2x2_bot_325/vpd[2] rowReadON[20] rowReadON[21]
+ RefrBp PrBp PrSFBp col_periphery_1x2_5/COL_LINE0 pixRst[10] pixRst[11] col_periphery_1x2_5/COL_LINE1
+ OffBn rowReadOFF[20] rowReadOFF[21] openDVS_pixel2x2_bot_351/GndD DiffBn VSUBS OnBn
+ VDD openDVS_pixel2x2_bot
XopenDVS_pixel2x2_bot_336 openDVS_pixel2x2_bot_336/vpd[0] openDVS_pixel2x2_bot_336/vpd[1]
+ openDVS_pixel2x2_bot_336/vpd[3] openDVS_pixel2x2_bot_336/vpd[2] rowReadON[20] rowReadON[21]
+ RefrBp PrBp PrSFBp col_periphery_1x2_16/COL_LINE0 pixRst[32] pixRst[33] col_periphery_1x2_16/COL_LINE1
+ OffBn rowReadOFF[20] rowReadOFF[21] openDVS_pixel2x2_bot_351/GndD DiffBn VSUBS OnBn
+ VDD openDVS_pixel2x2_bot
XopenDVS_pixel2x2_bot_314 openDVS_pixel2x2_bot_314/vpd[0] openDVS_pixel2x2_bot_314/vpd[1]
+ openDVS_pixel2x2_bot_314/vpd[3] openDVS_pixel2x2_bot_314/vpd[2] rowReadON[18] rowReadON[19]
+ RefrBp PrBp PrSFBp col_periphery_1x2_26/COL_LINE0 pixRst[52] pixRst[53] col_periphery_1x2_26/COL_LINE1
+ OffBn rowReadOFF[18] rowReadOFF[19] openDVS_pixel2x2_bot_319/GndD DiffBn VSUBS OnBn
+ VDD openDVS_pixel2x2_bot
XopenDVS_pixel2x2_bot_347 openDVS_pixel2x2_bot_347/vpd[0] openDVS_pixel2x2_bot_347/vpd[1]
+ openDVS_pixel2x2_bot_347/vpd[3] openDVS_pixel2x2_bot_347/vpd[2] rowReadON[20] rowReadON[21]
+ RefrBp PrBp PrSFBp col_periphery_1x2_27/COL_LINE0 pixRst[54] pixRst[55] col_periphery_1x2_27/COL_LINE1
+ OffBn rowReadOFF[20] rowReadOFF[21] openDVS_pixel2x2_bot_351/GndD DiffBn VSUBS OnBn
+ VDD openDVS_pixel2x2_bot
XopenDVS_pixel2x2_bot_892 openDVS_pixel2x2_bot_892/vpd[0] openDVS_pixel2x2_bot_892/vpd[1]
+ openDVS_pixel2x2_bot_892/vpd[3] openDVS_pixel2x2_bot_892/vpd[2] rowReadON[54] rowReadON[55]
+ RefrBp PrBp PrSFBp col_periphery_1x2_28/COL_LINE0 pixRst[56] pixRst[57] col_periphery_1x2_28/COL_LINE1
+ OffBn rowReadOFF[54] rowReadOFF[55] openDVS_pixel2x2_bot_895/GndD DiffBn VSUBS OnBn
+ VDD openDVS_pixel2x2_bot
XopenDVS_pixel2x2_bot_881 openDVS_pixel2x2_bot_881/vpd[0] openDVS_pixel2x2_bot_881/vpd[1]
+ openDVS_pixel2x2_bot_881/vpd[3] openDVS_pixel2x2_bot_881/vpd[2] rowReadON[54] rowReadON[55]
+ RefrBp PrBp PrSFBp col_periphery_1x2_17/COL_LINE0 pixRst[34] pixRst[35] col_periphery_1x2_17/COL_LINE1
+ OffBn rowReadOFF[54] rowReadOFF[55] openDVS_pixel2x2_bot_895/GndD DiffBn VSUBS OnBn
+ VDD openDVS_pixel2x2_bot
XopenDVS_pixel2x2_bot_870 openDVS_pixel2x2_bot_870/vpd[0] openDVS_pixel2x2_bot_870/vpd[1]
+ openDVS_pixel2x2_bot_870/vpd[3] openDVS_pixel2x2_bot_870/vpd[2] rowReadON[54] rowReadON[55]
+ RefrBp PrBp PrSFBp col_periphery_1x2_6/COL_LINE0 pixRst[12] pixRst[13] col_periphery_1x2_6/COL_LINE1
+ OffBn rowReadOFF[54] rowReadOFF[55] openDVS_pixel2x2_bot_895/GndD DiffBn VSUBS OnBn
+ VDD openDVS_pixel2x2_bot
XopenDVS_pixel2x2_bot_133 openDVS_pixel2x2_bot_133/vpd[0] openDVS_pixel2x2_bot_133/vpd[1]
+ openDVS_pixel2x2_bot_133/vpd[3] openDVS_pixel2x2_bot_133/vpd[2] rowReadON[8] rowReadON[9]
+ RefrBp PrBp PrSFBp col_periphery_1x2_5/COL_LINE0 pixRst[10] pixRst[11] col_periphery_1x2_5/COL_LINE1
+ OffBn rowReadOFF[8] rowReadOFF[9] openDVS_pixel2x2_bot_159/GndD DiffBn VSUBS OnBn
+ VDD openDVS_pixel2x2_bot
XopenDVS_pixel2x2_bot_100 openDVS_pixel2x2_bot_100/vpd[0] openDVS_pixel2x2_bot_100/vpd[1]
+ openDVS_pixel2x2_bot_100/vpd[3] openDVS_pixel2x2_bot_100/vpd[2] rowReadON[6] rowReadON[7]
+ RefrBp PrBp PrSFBp col_periphery_1x2_4/COL_LINE0 pixRst[8] pixRst[9] col_periphery_1x2_4/COL_LINE1
+ OffBn rowReadOFF[6] rowReadOFF[7] openDVS_pixel2x2_bot_99/GndD DiffBn VSUBS OnBn
+ VDD openDVS_pixel2x2_bot
XopenDVS_pixel2x2_bot_166 openDVS_pixel2x2_bot_166/vpd[0] openDVS_pixel2x2_bot_166/vpd[1]
+ openDVS_pixel2x2_bot_166/vpd[3] openDVS_pixel2x2_bot_166/vpd[2] rowReadON[10] rowReadON[11]
+ RefrBp PrBp PrSFBp col_periphery_1x2_6/COL_LINE0 pixRst[12] pixRst[13] col_periphery_1x2_6/COL_LINE1
+ OffBn rowReadOFF[10] rowReadOFF[11] openDVS_pixel2x2_bot_191/GndD DiffBn VSUBS OnBn
+ VDD openDVS_pixel2x2_bot
XopenDVS_pixel2x2_bot_111 openDVS_pixel2x2_bot_111/vpd[0] openDVS_pixel2x2_bot_111/vpd[1]
+ openDVS_pixel2x2_bot_111/vpd[3] openDVS_pixel2x2_bot_111/vpd[2] rowReadON[6] rowReadON[7]
+ RefrBp PrBp PrSFBp col_periphery_1x2_15/COL_LINE0 pixRst[30] pixRst[31] col_periphery_1x2_15/COL_LINE1
+ OffBn rowReadOFF[6] rowReadOFF[7] openDVS_pixel2x2_bot_99/GndD DiffBn VSUBS OnBn
+ VDD openDVS_pixel2x2_bot
XopenDVS_pixel2x2_bot_144 openDVS_pixel2x2_bot_144/vpd[0] openDVS_pixel2x2_bot_144/vpd[1]
+ openDVS_pixel2x2_bot_144/vpd[3] openDVS_pixel2x2_bot_144/vpd[2] rowReadON[8] rowReadON[9]
+ RefrBp PrBp PrSFBp col_periphery_1x2_16/COL_LINE0 pixRst[32] pixRst[33] col_periphery_1x2_16/COL_LINE1
+ OffBn rowReadOFF[8] rowReadOFF[9] openDVS_pixel2x2_bot_159/GndD DiffBn VSUBS OnBn
+ VDD openDVS_pixel2x2_bot
XopenDVS_pixel2x2_bot_177 openDVS_pixel2x2_bot_177/vpd[0] openDVS_pixel2x2_bot_177/vpd[1]
+ openDVS_pixel2x2_bot_177/vpd[3] openDVS_pixel2x2_bot_177/vpd[2] rowReadON[10] rowReadON[11]
+ RefrBp PrBp PrSFBp col_periphery_1x2_17/COL_LINE0 pixRst[34] pixRst[35] col_periphery_1x2_17/COL_LINE1
+ OffBn rowReadOFF[10] rowReadOFF[11] openDVS_pixel2x2_bot_191/GndD DiffBn VSUBS OnBn
+ VDD openDVS_pixel2x2_bot
XopenDVS_pixel2x2_bot_122 openDVS_pixel2x2_bot_122/vpd[0] openDVS_pixel2x2_bot_122/vpd[1]
+ openDVS_pixel2x2_bot_122/vpd[3] openDVS_pixel2x2_bot_122/vpd[2] rowReadON[6] rowReadON[7]
+ RefrBp PrBp PrSFBp col_periphery_1x2_26/COL_LINE0 pixRst[52] pixRst[53] col_periphery_1x2_26/COL_LINE1
+ OffBn rowReadOFF[6] rowReadOFF[7] openDVS_pixel2x2_bot_99/GndD DiffBn VSUBS OnBn
+ VDD openDVS_pixel2x2_bot
XopenDVS_pixel2x2_bot_155 openDVS_pixel2x2_bot_155/vpd[0] openDVS_pixel2x2_bot_155/vpd[1]
+ openDVS_pixel2x2_bot_155/vpd[3] openDVS_pixel2x2_bot_155/vpd[2] rowReadON[8] rowReadON[9]
+ RefrBp PrBp PrSFBp col_periphery_1x2_27/COL_LINE0 pixRst[54] pixRst[55] col_periphery_1x2_27/COL_LINE1
+ OffBn rowReadOFF[8] rowReadOFF[9] openDVS_pixel2x2_bot_159/GndD DiffBn VSUBS OnBn
+ VDD openDVS_pixel2x2_bot
XopenDVS_pixel2x2_bot_188 openDVS_pixel2x2_bot_188/vpd[0] openDVS_pixel2x2_bot_188/vpd[1]
+ openDVS_pixel2x2_bot_188/vpd[3] openDVS_pixel2x2_bot_188/vpd[2] rowReadON[10] rowReadON[11]
+ RefrBp PrBp PrSFBp col_periphery_1x2_28/COL_LINE0 pixRst[56] pixRst[57] col_periphery_1x2_28/COL_LINE1
+ OffBn rowReadOFF[10] rowReadOFF[11] openDVS_pixel2x2_bot_191/GndD DiffBn VSUBS OnBn
+ VDD openDVS_pixel2x2_bot
XopenDVS_pixel2x2_bot_199 openDVS_pixel2x2_bot_199/vpd[0] openDVS_pixel2x2_bot_199/vpd[1]
+ openDVS_pixel2x2_bot_199/vpd[3] openDVS_pixel2x2_bot_199/vpd[2] rowReadON[12] rowReadON[13]
+ RefrBp PrBp PrSFBp col_periphery_1x2_7/COL_LINE0 pixRst[14] pixRst[15] col_periphery_1x2_7/COL_LINE1
+ OffBn rowReadOFF[12] rowReadOFF[13] openDVS_pixel2x2_bot_223/GndD DiffBn VSUBS OnBn
+ VDD openDVS_pixel2x2_bot
XopenDVS_pixel2x2_bot_529 openDVS_pixel2x2_bot_529/vpd[0] openDVS_pixel2x2_bot_529/vpd[1]
+ openDVS_pixel2x2_bot_529/vpd[3] openDVS_pixel2x2_bot_529/vpd[2] rowReadON[32] rowReadON[33]
+ RefrBp PrBp PrSFBp col_periphery_1x2_17/COL_LINE0 pixRst[34] pixRst[35] col_periphery_1x2_17/COL_LINE1
+ OffBn rowReadOFF[32] rowReadOFF[33] openDVS_pixel2x2_bot_543/GndD DiffBn VSUBS OnBn
+ VDD openDVS_pixel2x2_bot
XopenDVS_pixel2x2_bot_518 openDVS_pixel2x2_bot_518/vpd[0] openDVS_pixel2x2_bot_518/vpd[1]
+ openDVS_pixel2x2_bot_518/vpd[3] openDVS_pixel2x2_bot_518/vpd[2] rowReadON[32] rowReadON[33]
+ RefrBp PrBp PrSFBp col_periphery_1x2_6/COL_LINE0 pixRst[12] pixRst[13] col_periphery_1x2_6/COL_LINE1
+ OffBn rowReadOFF[32] rowReadOFF[33] openDVS_pixel2x2_bot_543/GndD DiffBn VSUBS OnBn
+ VDD openDVS_pixel2x2_bot
XopenDVS_pixel2x2_bot_507 openDVS_pixel2x2_bot_507/vpd[0] openDVS_pixel2x2_bot_507/vpd[1]
+ openDVS_pixel2x2_bot_507/vpd[3] openDVS_pixel2x2_bot_507/vpd[2] rowReadON[30] rowReadON[31]
+ RefrBp PrBp PrSFBp col_periphery_1x2_27/COL_LINE0 pixRst[54] pixRst[55] col_periphery_1x2_27/COL_LINE1
+ OffBn rowReadOFF[30] rowReadOFF[31] openDVS_pixel2x2_bot_511/GndD DiffBn VSUBS OnBn
+ VDD openDVS_pixel2x2_bot
XopenDVS_pixel2x2_bot_359 openDVS_pixel2x2_bot_359/vpd[0] openDVS_pixel2x2_bot_359/vpd[1]
+ openDVS_pixel2x2_bot_359/vpd[3] openDVS_pixel2x2_bot_359/vpd[2] rowReadON[22] rowReadON[23]
+ RefrBp PrBp PrSFBp col_periphery_1x2_7/COL_LINE0 pixRst[14] pixRst[15] col_periphery_1x2_7/COL_LINE1
+ OffBn rowReadOFF[22] rowReadOFF[23] openDVS_pixel2x2_bot_383/GndD DiffBn VSUBS OnBn
+ VDD openDVS_pixel2x2_bot
XopenDVS_pixel2x2_bot_326 openDVS_pixel2x2_bot_326/vpd[0] openDVS_pixel2x2_bot_326/vpd[1]
+ openDVS_pixel2x2_bot_326/vpd[3] openDVS_pixel2x2_bot_326/vpd[2] rowReadON[20] rowReadON[21]
+ RefrBp PrBp PrSFBp col_periphery_1x2_6/COL_LINE0 pixRst[12] pixRst[13] col_periphery_1x2_6/COL_LINE1
+ OffBn rowReadOFF[20] rowReadOFF[21] openDVS_pixel2x2_bot_351/GndD DiffBn VSUBS OnBn
+ VDD openDVS_pixel2x2_bot
XopenDVS_pixel2x2_bot_304 openDVS_pixel2x2_bot_304/vpd[0] openDVS_pixel2x2_bot_304/vpd[1]
+ openDVS_pixel2x2_bot_304/vpd[3] openDVS_pixel2x2_bot_304/vpd[2] rowReadON[18] rowReadON[19]
+ RefrBp PrBp PrSFBp col_periphery_1x2_16/COL_LINE0 pixRst[32] pixRst[33] col_periphery_1x2_16/COL_LINE1
+ OffBn rowReadOFF[18] rowReadOFF[19] openDVS_pixel2x2_bot_319/GndD DiffBn VSUBS OnBn
+ VDD openDVS_pixel2x2_bot
XopenDVS_pixel2x2_bot_337 openDVS_pixel2x2_bot_337/vpd[0] openDVS_pixel2x2_bot_337/vpd[1]
+ openDVS_pixel2x2_bot_337/vpd[3] openDVS_pixel2x2_bot_337/vpd[2] rowReadON[20] rowReadON[21]
+ RefrBp PrBp PrSFBp col_periphery_1x2_17/COL_LINE0 pixRst[34] pixRst[35] col_periphery_1x2_17/COL_LINE1
+ OffBn rowReadOFF[20] rowReadOFF[21] openDVS_pixel2x2_bot_351/GndD DiffBn VSUBS OnBn
+ VDD openDVS_pixel2x2_bot
XopenDVS_pixel2x2_bot_315 openDVS_pixel2x2_bot_315/vpd[0] openDVS_pixel2x2_bot_315/vpd[1]
+ openDVS_pixel2x2_bot_315/vpd[3] openDVS_pixel2x2_bot_315/vpd[2] rowReadON[18] rowReadON[19]
+ RefrBp PrBp PrSFBp col_periphery_1x2_27/COL_LINE0 pixRst[54] pixRst[55] col_periphery_1x2_27/COL_LINE1
+ OffBn rowReadOFF[18] rowReadOFF[19] openDVS_pixel2x2_bot_319/GndD DiffBn VSUBS OnBn
+ VDD openDVS_pixel2x2_bot
XopenDVS_pixel2x2_bot_348 openDVS_pixel2x2_bot_348/vpd[0] openDVS_pixel2x2_bot_348/vpd[1]
+ openDVS_pixel2x2_bot_348/vpd[3] openDVS_pixel2x2_bot_348/vpd[2] rowReadON[20] rowReadON[21]
+ RefrBp PrBp PrSFBp col_periphery_1x2_28/COL_LINE0 pixRst[56] pixRst[57] col_periphery_1x2_28/COL_LINE1
+ OffBn rowReadOFF[20] rowReadOFF[21] openDVS_pixel2x2_bot_351/GndD DiffBn VSUBS OnBn
+ VDD openDVS_pixel2x2_bot
XopenDVS_pixel2x2_bot_893 openDVS_pixel2x2_bot_893/vpd[0] openDVS_pixel2x2_bot_893/vpd[1]
+ openDVS_pixel2x2_bot_893/vpd[3] openDVS_pixel2x2_bot_893/vpd[2] rowReadON[54] rowReadON[55]
+ RefrBp PrBp PrSFBp col_periphery_1x2_29/COL_LINE0 pixRst[58] pixRst[59] col_periphery_1x2_29/COL_LINE1
+ OffBn rowReadOFF[54] rowReadOFF[55] openDVS_pixel2x2_bot_895/GndD DiffBn VSUBS OnBn
+ VDD openDVS_pixel2x2_bot
XopenDVS_pixel2x2_bot_860 openDVS_pixel2x2_bot_860/vpd[0] openDVS_pixel2x2_bot_860/vpd[1]
+ openDVS_pixel2x2_bot_860/vpd[3] openDVS_pixel2x2_bot_860/vpd[2] rowReadON[52] rowReadON[53]
+ RefrBp PrBp PrSFBp col_periphery_1x2_28/COL_LINE0 pixRst[56] pixRst[57] col_periphery_1x2_28/COL_LINE1
+ OffBn rowReadOFF[52] rowReadOFF[53] openDVS_pixel2x2_bot_863/GndD DiffBn VSUBS OnBn
+ VDD openDVS_pixel2x2_bot
XopenDVS_pixel2x2_bot_882 openDVS_pixel2x2_bot_882/vpd[0] openDVS_pixel2x2_bot_882/vpd[1]
+ openDVS_pixel2x2_bot_882/vpd[3] openDVS_pixel2x2_bot_882/vpd[2] rowReadON[54] rowReadON[55]
+ RefrBp PrBp PrSFBp col_periphery_1x2_18/COL_LINE0 pixRst[36] pixRst[37] col_periphery_1x2_18/COL_LINE1
+ OffBn rowReadOFF[54] rowReadOFF[55] openDVS_pixel2x2_bot_895/GndD DiffBn VSUBS OnBn
+ VDD openDVS_pixel2x2_bot
XopenDVS_pixel2x2_bot_871 openDVS_pixel2x2_bot_871/vpd[0] openDVS_pixel2x2_bot_871/vpd[1]
+ openDVS_pixel2x2_bot_871/vpd[3] openDVS_pixel2x2_bot_871/vpd[2] rowReadON[54] rowReadON[55]
+ RefrBp PrBp PrSFBp col_periphery_1x2_7/COL_LINE0 pixRst[14] pixRst[15] col_periphery_1x2_7/COL_LINE1
+ OffBn rowReadOFF[54] rowReadOFF[55] openDVS_pixel2x2_bot_895/GndD DiffBn VSUBS OnBn
+ VDD openDVS_pixel2x2_bot
XopenDVS_pixel2x2_bot_101 openDVS_pixel2x2_bot_101/vpd[0] openDVS_pixel2x2_bot_101/vpd[1]
+ openDVS_pixel2x2_bot_101/vpd[3] openDVS_pixel2x2_bot_101/vpd[2] rowReadON[6] rowReadON[7]
+ RefrBp PrBp PrSFBp col_periphery_1x2_5/COL_LINE0 pixRst[10] pixRst[11] col_periphery_1x2_5/COL_LINE1
+ OffBn rowReadOFF[6] rowReadOFF[7] openDVS_pixel2x2_bot_99/GndD DiffBn VSUBS OnBn
+ VDD openDVS_pixel2x2_bot
XopenDVS_pixel2x2_bot_134 openDVS_pixel2x2_bot_134/vpd[0] openDVS_pixel2x2_bot_134/vpd[1]
+ openDVS_pixel2x2_bot_134/vpd[3] openDVS_pixel2x2_bot_134/vpd[2] rowReadON[8] rowReadON[9]
+ RefrBp PrBp PrSFBp col_periphery_1x2_6/COL_LINE0 pixRst[12] pixRst[13] col_periphery_1x2_6/COL_LINE1
+ OffBn rowReadOFF[8] rowReadOFF[9] openDVS_pixel2x2_bot_159/GndD DiffBn VSUBS OnBn
+ VDD openDVS_pixel2x2_bot
XopenDVS_pixel2x2_bot_167 openDVS_pixel2x2_bot_167/vpd[0] openDVS_pixel2x2_bot_167/vpd[1]
+ openDVS_pixel2x2_bot_167/vpd[3] openDVS_pixel2x2_bot_167/vpd[2] rowReadON[10] rowReadON[11]
+ RefrBp PrBp PrSFBp col_periphery_1x2_7/COL_LINE0 pixRst[14] pixRst[15] col_periphery_1x2_7/COL_LINE1
+ OffBn rowReadOFF[10] rowReadOFF[11] openDVS_pixel2x2_bot_191/GndD DiffBn VSUBS OnBn
+ VDD openDVS_pixel2x2_bot
XopenDVS_pixel2x2_bot_112 openDVS_pixel2x2_bot_112/vpd[0] openDVS_pixel2x2_bot_112/vpd[1]
+ openDVS_pixel2x2_bot_112/vpd[3] openDVS_pixel2x2_bot_112/vpd[2] rowReadON[6] rowReadON[7]
+ RefrBp PrBp PrSFBp col_periphery_1x2_16/COL_LINE0 pixRst[32] pixRst[33] col_periphery_1x2_16/COL_LINE1
+ OffBn rowReadOFF[6] rowReadOFF[7] openDVS_pixel2x2_bot_99/GndD DiffBn VSUBS OnBn
+ VDD openDVS_pixel2x2_bot
XopenDVS_pixel2x2_bot_145 openDVS_pixel2x2_bot_145/vpd[0] openDVS_pixel2x2_bot_145/vpd[1]
+ openDVS_pixel2x2_bot_145/vpd[3] openDVS_pixel2x2_bot_145/vpd[2] rowReadON[8] rowReadON[9]
+ RefrBp PrBp PrSFBp col_periphery_1x2_17/COL_LINE0 pixRst[34] pixRst[35] col_periphery_1x2_17/COL_LINE1
+ OffBn rowReadOFF[8] rowReadOFF[9] openDVS_pixel2x2_bot_159/GndD DiffBn VSUBS OnBn
+ VDD openDVS_pixel2x2_bot
XopenDVS_pixel2x2_bot_178 openDVS_pixel2x2_bot_178/vpd[0] openDVS_pixel2x2_bot_178/vpd[1]
+ openDVS_pixel2x2_bot_178/vpd[3] openDVS_pixel2x2_bot_178/vpd[2] rowReadON[10] rowReadON[11]
+ RefrBp PrBp PrSFBp col_periphery_1x2_18/COL_LINE0 pixRst[36] pixRst[37] col_periphery_1x2_18/COL_LINE1
+ OffBn rowReadOFF[10] rowReadOFF[11] openDVS_pixel2x2_bot_191/GndD DiffBn VSUBS OnBn
+ VDD openDVS_pixel2x2_bot
XopenDVS_pixel2x2_bot_123 openDVS_pixel2x2_bot_123/vpd[0] openDVS_pixel2x2_bot_123/vpd[1]
+ openDVS_pixel2x2_bot_123/vpd[3] openDVS_pixel2x2_bot_123/vpd[2] rowReadON[6] rowReadON[7]
+ RefrBp PrBp PrSFBp col_periphery_1x2_27/COL_LINE0 pixRst[54] pixRst[55] col_periphery_1x2_27/COL_LINE1
+ OffBn rowReadOFF[6] rowReadOFF[7] openDVS_pixel2x2_bot_99/GndD DiffBn VSUBS OnBn
+ VDD openDVS_pixel2x2_bot
XopenDVS_pixel2x2_bot_156 openDVS_pixel2x2_bot_156/vpd[0] openDVS_pixel2x2_bot_156/vpd[1]
+ openDVS_pixel2x2_bot_156/vpd[3] openDVS_pixel2x2_bot_156/vpd[2] rowReadON[8] rowReadON[9]
+ RefrBp PrBp PrSFBp col_periphery_1x2_28/COL_LINE0 pixRst[56] pixRst[57] col_periphery_1x2_28/COL_LINE1
+ OffBn rowReadOFF[8] rowReadOFF[9] openDVS_pixel2x2_bot_159/GndD DiffBn VSUBS OnBn
+ VDD openDVS_pixel2x2_bot
XopenDVS_pixel2x2_bot_189 openDVS_pixel2x2_bot_189/vpd[0] openDVS_pixel2x2_bot_189/vpd[1]
+ openDVS_pixel2x2_bot_189/vpd[3] openDVS_pixel2x2_bot_189/vpd[2] rowReadON[10] rowReadON[11]
+ RefrBp PrBp PrSFBp col_periphery_1x2_29/COL_LINE0 pixRst[58] pixRst[59] col_periphery_1x2_29/COL_LINE1
+ OffBn rowReadOFF[10] rowReadOFF[11] openDVS_pixel2x2_bot_191/GndD DiffBn VSUBS OnBn
+ VDD openDVS_pixel2x2_bot
XopenDVS_pixel2x2_bot_690 openDVS_pixel2x2_bot_690/vpd[0] openDVS_pixel2x2_bot_690/vpd[1]
+ openDVS_pixel2x2_bot_690/vpd[3] openDVS_pixel2x2_bot_690/vpd[2] rowReadON[42] rowReadON[43]
+ RefrBp PrBp PrSFBp col_periphery_1x2_18/COL_LINE0 pixRst[36] pixRst[37] col_periphery_1x2_18/COL_LINE1
+ OffBn rowReadOFF[42] rowReadOFF[43] openDVS_pixel2x2_bot_703/GndD DiffBn VSUBS OnBn
+ VDD openDVS_pixel2x2_bot
XopenDVS_pixel2x2_bot_519 openDVS_pixel2x2_bot_519/vpd[0] openDVS_pixel2x2_bot_519/vpd[1]
+ openDVS_pixel2x2_bot_519/vpd[3] openDVS_pixel2x2_bot_519/vpd[2] rowReadON[32] rowReadON[33]
+ RefrBp PrBp PrSFBp col_periphery_1x2_7/COL_LINE0 pixRst[14] pixRst[15] col_periphery_1x2_7/COL_LINE1
+ OffBn rowReadOFF[32] rowReadOFF[33] openDVS_pixel2x2_bot_543/GndD DiffBn VSUBS OnBn
+ VDD openDVS_pixel2x2_bot
XopenDVS_pixel2x2_bot_508 openDVS_pixel2x2_bot_508/vpd[0] openDVS_pixel2x2_bot_508/vpd[1]
+ openDVS_pixel2x2_bot_508/vpd[3] openDVS_pixel2x2_bot_508/vpd[2] rowReadON[30] rowReadON[31]
+ RefrBp PrBp PrSFBp col_periphery_1x2_28/COL_LINE0 pixRst[56] pixRst[57] col_periphery_1x2_28/COL_LINE1
+ OffBn rowReadOFF[30] rowReadOFF[31] openDVS_pixel2x2_bot_511/GndD DiffBn VSUBS OnBn
+ VDD openDVS_pixel2x2_bot
Xcol_periphery_1x2_30 pixRst[61] col_periphery_1x2_30/COL_LINE0 col_periphery_1x2_30/COL_LINE1
+ nDETECT col_periphery_1x2_9/VDD DETECT VTHRESH voutn[60] VSUBS NCHARGE voutn[61]
+ pixRst[60] col_periphery_1x2
XopenDVS_pixel2x2_bot_327 openDVS_pixel2x2_bot_327/vpd[0] openDVS_pixel2x2_bot_327/vpd[1]
+ openDVS_pixel2x2_bot_327/vpd[3] openDVS_pixel2x2_bot_327/vpd[2] rowReadON[20] rowReadON[21]
+ RefrBp PrBp PrSFBp col_periphery_1x2_7/COL_LINE0 pixRst[14] pixRst[15] col_periphery_1x2_7/COL_LINE1
+ OffBn rowReadOFF[20] rowReadOFF[21] openDVS_pixel2x2_bot_351/GndD DiffBn VSUBS OnBn
+ VDD openDVS_pixel2x2_bot
XopenDVS_pixel2x2_bot_305 openDVS_pixel2x2_bot_305/vpd[0] openDVS_pixel2x2_bot_305/vpd[1]
+ openDVS_pixel2x2_bot_305/vpd[3] openDVS_pixel2x2_bot_305/vpd[2] rowReadON[18] rowReadON[19]
+ RefrBp PrBp PrSFBp col_periphery_1x2_17/COL_LINE0 pixRst[34] pixRst[35] col_periphery_1x2_17/COL_LINE1
+ OffBn rowReadOFF[18] rowReadOFF[19] openDVS_pixel2x2_bot_319/GndD DiffBn VSUBS OnBn
+ VDD openDVS_pixel2x2_bot
XopenDVS_pixel2x2_bot_338 openDVS_pixel2x2_bot_338/vpd[0] openDVS_pixel2x2_bot_338/vpd[1]
+ openDVS_pixel2x2_bot_338/vpd[3] openDVS_pixel2x2_bot_338/vpd[2] rowReadON[20] rowReadON[21]
+ RefrBp PrBp PrSFBp col_periphery_1x2_18/COL_LINE0 pixRst[36] pixRst[37] col_periphery_1x2_18/COL_LINE1
+ OffBn rowReadOFF[20] rowReadOFF[21] openDVS_pixel2x2_bot_351/GndD DiffBn VSUBS OnBn
+ VDD openDVS_pixel2x2_bot
XopenDVS_pixel2x2_bot_316 openDVS_pixel2x2_bot_316/vpd[0] openDVS_pixel2x2_bot_316/vpd[1]
+ openDVS_pixel2x2_bot_316/vpd[3] openDVS_pixel2x2_bot_316/vpd[2] rowReadON[18] rowReadON[19]
+ RefrBp PrBp PrSFBp col_periphery_1x2_28/COL_LINE0 pixRst[56] pixRst[57] col_periphery_1x2_28/COL_LINE1
+ OffBn rowReadOFF[18] rowReadOFF[19] openDVS_pixel2x2_bot_319/GndD DiffBn VSUBS OnBn
+ VDD openDVS_pixel2x2_bot
XopenDVS_pixel2x2_bot_349 openDVS_pixel2x2_bot_349/vpd[0] openDVS_pixel2x2_bot_349/vpd[1]
+ openDVS_pixel2x2_bot_349/vpd[3] openDVS_pixel2x2_bot_349/vpd[2] rowReadON[20] rowReadON[21]
+ RefrBp PrBp PrSFBp col_periphery_1x2_29/COL_LINE0 pixRst[58] pixRst[59] col_periphery_1x2_29/COL_LINE1
+ OffBn rowReadOFF[20] rowReadOFF[21] openDVS_pixel2x2_bot_351/GndD DiffBn VSUBS OnBn
+ VDD openDVS_pixel2x2_bot
XopenDVS_pixel2x2_bot_894 openDVS_pixel2x2_bot_894/vpd[0] openDVS_pixel2x2_bot_894/vpd[1]
+ openDVS_pixel2x2_bot_894/vpd[3] openDVS_pixel2x2_bot_894/vpd[2] rowReadON[54] rowReadON[55]
+ RefrBp PrBp PrSFBp col_periphery_1x2_30/COL_LINE0 pixRst[60] pixRst[61] col_periphery_1x2_30/COL_LINE1
+ OffBn rowReadOFF[54] rowReadOFF[55] openDVS_pixel2x2_bot_895/GndD DiffBn VSUBS OnBn
+ VDD openDVS_pixel2x2_bot
XopenDVS_pixel2x2_bot_861 openDVS_pixel2x2_bot_861/vpd[0] openDVS_pixel2x2_bot_861/vpd[1]
+ openDVS_pixel2x2_bot_861/vpd[3] openDVS_pixel2x2_bot_861/vpd[2] rowReadON[52] rowReadON[53]
+ RefrBp PrBp PrSFBp col_periphery_1x2_29/COL_LINE0 pixRst[58] pixRst[59] col_periphery_1x2_29/COL_LINE1
+ OffBn rowReadOFF[52] rowReadOFF[53] openDVS_pixel2x2_bot_863/GndD DiffBn VSUBS OnBn
+ VDD openDVS_pixel2x2_bot
XopenDVS_pixel2x2_bot_883 openDVS_pixel2x2_bot_883/vpd[0] openDVS_pixel2x2_bot_883/vpd[1]
+ openDVS_pixel2x2_bot_883/vpd[3] openDVS_pixel2x2_bot_883/vpd[2] rowReadON[54] rowReadON[55]
+ RefrBp PrBp PrSFBp col_periphery_1x2_19/COL_LINE0 pixRst[38] pixRst[39] col_periphery_1x2_19/COL_LINE1
+ OffBn rowReadOFF[54] rowReadOFF[55] openDVS_pixel2x2_bot_895/GndD DiffBn VSUBS OnBn
+ VDD openDVS_pixel2x2_bot
XopenDVS_pixel2x2_bot_850 openDVS_pixel2x2_bot_850/vpd[0] openDVS_pixel2x2_bot_850/vpd[1]
+ openDVS_pixel2x2_bot_850/vpd[3] openDVS_pixel2x2_bot_850/vpd[2] rowReadON[52] rowReadON[53]
+ RefrBp PrBp PrSFBp col_periphery_1x2_18/COL_LINE0 pixRst[36] pixRst[37] col_periphery_1x2_18/COL_LINE1
+ OffBn rowReadOFF[52] rowReadOFF[53] openDVS_pixel2x2_bot_863/GndD DiffBn VSUBS OnBn
+ VDD openDVS_pixel2x2_bot
XopenDVS_pixel2x2_bot_872 openDVS_pixel2x2_bot_872/vpd[0] openDVS_pixel2x2_bot_872/vpd[1]
+ openDVS_pixel2x2_bot_872/vpd[3] openDVS_pixel2x2_bot_872/vpd[2] rowReadON[54] rowReadON[55]
+ RefrBp PrBp PrSFBp col_periphery_1x2_8/COL_LINE0 pixRst[16] pixRst[17] col_periphery_1x2_8/COL_LINE1
+ OffBn rowReadOFF[54] rowReadOFF[55] openDVS_pixel2x2_bot_895/GndD DiffBn VSUBS OnBn
+ VDD openDVS_pixel2x2_bot
XopenDVS_pixel2x2_bot_102 openDVS_pixel2x2_bot_102/vpd[0] openDVS_pixel2x2_bot_102/vpd[1]
+ openDVS_pixel2x2_bot_102/vpd[3] openDVS_pixel2x2_bot_102/vpd[2] rowReadON[6] rowReadON[7]
+ RefrBp PrBp PrSFBp col_periphery_1x2_6/COL_LINE0 pixRst[12] pixRst[13] col_periphery_1x2_6/COL_LINE1
+ OffBn rowReadOFF[6] rowReadOFF[7] openDVS_pixel2x2_bot_99/GndD DiffBn VSUBS OnBn
+ VDD openDVS_pixel2x2_bot
XopenDVS_pixel2x2_bot_135 openDVS_pixel2x2_bot_135/vpd[0] openDVS_pixel2x2_bot_135/vpd[1]
+ openDVS_pixel2x2_bot_135/vpd[3] openDVS_pixel2x2_bot_135/vpd[2] rowReadON[8] rowReadON[9]
+ RefrBp PrBp PrSFBp col_periphery_1x2_7/COL_LINE0 pixRst[14] pixRst[15] col_periphery_1x2_7/COL_LINE1
+ OffBn rowReadOFF[8] rowReadOFF[9] openDVS_pixel2x2_bot_159/GndD DiffBn VSUBS OnBn
+ VDD openDVS_pixel2x2_bot
XopenDVS_pixel2x2_bot_168 openDVS_pixel2x2_bot_168/vpd[0] openDVS_pixel2x2_bot_168/vpd[1]
+ openDVS_pixel2x2_bot_168/vpd[3] openDVS_pixel2x2_bot_168/vpd[2] rowReadON[10] rowReadON[11]
+ RefrBp PrBp PrSFBp col_periphery_1x2_8/COL_LINE0 pixRst[16] pixRst[17] col_periphery_1x2_8/COL_LINE1
+ OffBn rowReadOFF[10] rowReadOFF[11] openDVS_pixel2x2_bot_191/GndD DiffBn VSUBS OnBn
+ VDD openDVS_pixel2x2_bot
XopenDVS_pixel2x2_bot_113 openDVS_pixel2x2_bot_113/vpd[0] openDVS_pixel2x2_bot_113/vpd[1]
+ openDVS_pixel2x2_bot_113/vpd[3] openDVS_pixel2x2_bot_113/vpd[2] rowReadON[6] rowReadON[7]
+ RefrBp PrBp PrSFBp col_periphery_1x2_17/COL_LINE0 pixRst[34] pixRst[35] col_periphery_1x2_17/COL_LINE1
+ OffBn rowReadOFF[6] rowReadOFF[7] openDVS_pixel2x2_bot_99/GndD DiffBn VSUBS OnBn
+ VDD openDVS_pixel2x2_bot
XopenDVS_pixel2x2_bot_146 openDVS_pixel2x2_bot_146/vpd[0] openDVS_pixel2x2_bot_146/vpd[1]
+ openDVS_pixel2x2_bot_146/vpd[3] openDVS_pixel2x2_bot_146/vpd[2] rowReadON[8] rowReadON[9]
+ RefrBp PrBp PrSFBp col_periphery_1x2_18/COL_LINE0 pixRst[36] pixRst[37] col_periphery_1x2_18/COL_LINE1
+ OffBn rowReadOFF[8] rowReadOFF[9] openDVS_pixel2x2_bot_159/GndD DiffBn VSUBS OnBn
+ VDD openDVS_pixel2x2_bot
XopenDVS_pixel2x2_bot_179 openDVS_pixel2x2_bot_179/vpd[0] openDVS_pixel2x2_bot_179/vpd[1]
+ openDVS_pixel2x2_bot_179/vpd[3] openDVS_pixel2x2_bot_179/vpd[2] rowReadON[10] rowReadON[11]
+ RefrBp PrBp PrSFBp col_periphery_1x2_19/COL_LINE0 pixRst[38] pixRst[39] col_periphery_1x2_19/COL_LINE1
+ OffBn rowReadOFF[10] rowReadOFF[11] openDVS_pixel2x2_bot_191/GndD DiffBn VSUBS OnBn
+ VDD openDVS_pixel2x2_bot
XopenDVS_pixel2x2_bot_124 openDVS_pixel2x2_bot_124/vpd[0] openDVS_pixel2x2_bot_124/vpd[1]
+ openDVS_pixel2x2_bot_124/vpd[3] openDVS_pixel2x2_bot_124/vpd[2] rowReadON[6] rowReadON[7]
+ RefrBp PrBp PrSFBp col_periphery_1x2_28/COL_LINE0 pixRst[56] pixRst[57] col_periphery_1x2_28/COL_LINE1
+ OffBn rowReadOFF[6] rowReadOFF[7] openDVS_pixel2x2_bot_99/GndD DiffBn VSUBS OnBn
+ VDD openDVS_pixel2x2_bot
XopenDVS_pixel2x2_bot_157 openDVS_pixel2x2_bot_157/vpd[0] openDVS_pixel2x2_bot_157/vpd[1]
+ openDVS_pixel2x2_bot_157/vpd[3] openDVS_pixel2x2_bot_157/vpd[2] rowReadON[8] rowReadON[9]
+ RefrBp PrBp PrSFBp col_periphery_1x2_29/COL_LINE0 pixRst[58] pixRst[59] col_periphery_1x2_29/COL_LINE1
+ OffBn rowReadOFF[8] rowReadOFF[9] openDVS_pixel2x2_bot_159/GndD DiffBn VSUBS OnBn
+ VDD openDVS_pixel2x2_bot
XopenDVS_pixel2x2_bot_691 openDVS_pixel2x2_bot_691/vpd[0] openDVS_pixel2x2_bot_691/vpd[1]
+ openDVS_pixel2x2_bot_691/vpd[3] openDVS_pixel2x2_bot_691/vpd[2] rowReadON[42] rowReadON[43]
+ RefrBp PrBp PrSFBp col_periphery_1x2_19/COL_LINE0 pixRst[38] pixRst[39] col_periphery_1x2_19/COL_LINE1
+ OffBn rowReadOFF[42] rowReadOFF[43] openDVS_pixel2x2_bot_703/GndD DiffBn VSUBS OnBn
+ VDD openDVS_pixel2x2_bot
XopenDVS_pixel2x2_bot_680 openDVS_pixel2x2_bot_680/vpd[0] openDVS_pixel2x2_bot_680/vpd[1]
+ openDVS_pixel2x2_bot_680/vpd[3] openDVS_pixel2x2_bot_680/vpd[2] rowReadON[42] rowReadON[43]
+ RefrBp PrBp PrSFBp col_periphery_1x2_8/COL_LINE0 pixRst[16] pixRst[17] col_periphery_1x2_8/COL_LINE1
+ OffBn rowReadOFF[42] rowReadOFF[43] openDVS_pixel2x2_bot_703/GndD DiffBn VSUBS OnBn
+ VDD openDVS_pixel2x2_bot
XopenDVS_pixel2x2_bot_1020 openDVS_pixel2x2_bot_1020/vpd[0] openDVS_pixel2x2_bot_1020/vpd[1]
+ openDVS_pixel2x2_bot_1020/vpd[3] openDVS_pixel2x2_bot_1020/vpd[2] rowReadON[62]
+ rowReadON[63] RefrBp PrBp PrSFBp col_periphery_1x2_28/COL_LINE0 pixRst[56] pixRst[57]
+ col_periphery_1x2_28/COL_LINE1 OffBn rowReadOFF[62] rowReadOFF[63] openDVS_pixel2x2_bot_999/GndD
+ DiffBn VSUBS OnBn VDD openDVS_pixel2x2_bot
XopenDVS_pixel2x2_bot_509 openDVS_pixel2x2_bot_509/vpd[0] openDVS_pixel2x2_bot_509/vpd[1]
+ openDVS_pixel2x2_bot_509/vpd[3] openDVS_pixel2x2_bot_509/vpd[2] rowReadON[30] rowReadON[31]
+ RefrBp PrBp PrSFBp col_periphery_1x2_29/COL_LINE0 pixRst[58] pixRst[59] col_periphery_1x2_29/COL_LINE1
+ OffBn rowReadOFF[30] rowReadOFF[31] openDVS_pixel2x2_bot_511/GndD DiffBn VSUBS OnBn
+ VDD openDVS_pixel2x2_bot
Xcol_periphery_1x2_31 pixRst[63] col_periphery_1x2_31/COL_LINE0 col_periphery_1x2_31/COL_LINE1
+ nDETECT col_periphery_1x2_9/VDD DETECT VTHRESH voutn[62] VSUBS NCHARGE voutn[63]
+ pixRst[62] col_periphery_1x2
Xcol_periphery_1x2_20 pixRst[41] col_periphery_1x2_20/COL_LINE0 col_periphery_1x2_20/COL_LINE1
+ nDETECT col_periphery_1x2_9/VDD DETECT VTHRESH voutn[40] VSUBS NCHARGE voutn[41]
+ pixRst[40] col_periphery_1x2
XopenDVS_pixel2x2_bot_328 openDVS_pixel2x2_bot_328/vpd[0] openDVS_pixel2x2_bot_328/vpd[1]
+ openDVS_pixel2x2_bot_328/vpd[3] openDVS_pixel2x2_bot_328/vpd[2] rowReadON[20] rowReadON[21]
+ RefrBp PrBp PrSFBp col_periphery_1x2_8/COL_LINE0 pixRst[16] pixRst[17] col_periphery_1x2_8/COL_LINE1
+ OffBn rowReadOFF[20] rowReadOFF[21] openDVS_pixel2x2_bot_351/GndD DiffBn VSUBS OnBn
+ VDD openDVS_pixel2x2_bot
XopenDVS_pixel2x2_bot_306 openDVS_pixel2x2_bot_306/vpd[0] openDVS_pixel2x2_bot_306/vpd[1]
+ openDVS_pixel2x2_bot_306/vpd[3] openDVS_pixel2x2_bot_306/vpd[2] rowReadON[18] rowReadON[19]
+ RefrBp PrBp PrSFBp col_periphery_1x2_18/COL_LINE0 pixRst[36] pixRst[37] col_periphery_1x2_18/COL_LINE1
+ OffBn rowReadOFF[18] rowReadOFF[19] openDVS_pixel2x2_bot_319/GndD DiffBn VSUBS OnBn
+ VDD openDVS_pixel2x2_bot
XopenDVS_pixel2x2_bot_339 openDVS_pixel2x2_bot_339/vpd[0] openDVS_pixel2x2_bot_339/vpd[1]
+ openDVS_pixel2x2_bot_339/vpd[3] openDVS_pixel2x2_bot_339/vpd[2] rowReadON[20] rowReadON[21]
+ RefrBp PrBp PrSFBp col_periphery_1x2_19/COL_LINE0 pixRst[38] pixRst[39] col_periphery_1x2_19/COL_LINE1
+ OffBn rowReadOFF[20] rowReadOFF[21] openDVS_pixel2x2_bot_351/GndD DiffBn VSUBS OnBn
+ VDD openDVS_pixel2x2_bot
XopenDVS_pixel2x2_bot_317 openDVS_pixel2x2_bot_317/vpd[0] openDVS_pixel2x2_bot_317/vpd[1]
+ openDVS_pixel2x2_bot_317/vpd[3] openDVS_pixel2x2_bot_317/vpd[2] rowReadON[18] rowReadON[19]
+ RefrBp PrBp PrSFBp col_periphery_1x2_29/COL_LINE0 pixRst[58] pixRst[59] col_periphery_1x2_29/COL_LINE1
+ OffBn rowReadOFF[18] rowReadOFF[19] openDVS_pixel2x2_bot_319/GndD DiffBn VSUBS OnBn
+ VDD openDVS_pixel2x2_bot
XopenDVS_pixel2x2_bot_895 openDVS_pixel2x2_bot_895/vpd[0] openDVS_pixel2x2_bot_895/vpd[1]
+ openDVS_pixel2x2_bot_895/vpd[3] openDVS_pixel2x2_bot_895/vpd[2] rowReadON[54] rowReadON[55]
+ RefrBp PrBp PrSFBp col_periphery_1x2_31/COL_LINE0 pixRst[62] pixRst[63] col_periphery_1x2_31/COL_LINE1
+ OffBn rowReadOFF[54] rowReadOFF[55] openDVS_pixel2x2_bot_895/GndD DiffBn VSUBS OnBn
+ VDD openDVS_pixel2x2_bot
XopenDVS_pixel2x2_bot_862 openDVS_pixel2x2_bot_862/vpd[0] openDVS_pixel2x2_bot_862/vpd[1]
+ openDVS_pixel2x2_bot_862/vpd[3] openDVS_pixel2x2_bot_862/vpd[2] rowReadON[52] rowReadON[53]
+ RefrBp PrBp PrSFBp col_periphery_1x2_30/COL_LINE0 pixRst[60] pixRst[61] col_periphery_1x2_30/COL_LINE1
+ OffBn rowReadOFF[52] rowReadOFF[53] openDVS_pixel2x2_bot_863/GndD DiffBn VSUBS OnBn
+ VDD openDVS_pixel2x2_bot
XopenDVS_pixel2x2_bot_884 openDVS_pixel2x2_bot_884/vpd[0] openDVS_pixel2x2_bot_884/vpd[1]
+ openDVS_pixel2x2_bot_884/vpd[3] openDVS_pixel2x2_bot_884/vpd[2] rowReadON[54] rowReadON[55]
+ RefrBp PrBp PrSFBp col_periphery_1x2_20/COL_LINE0 pixRst[40] pixRst[41] col_periphery_1x2_20/COL_LINE1
+ OffBn rowReadOFF[54] rowReadOFF[55] openDVS_pixel2x2_bot_895/GndD DiffBn VSUBS OnBn
+ VDD openDVS_pixel2x2_bot
XopenDVS_pixel2x2_bot_851 openDVS_pixel2x2_bot_851/vpd[0] openDVS_pixel2x2_bot_851/vpd[1]
+ openDVS_pixel2x2_bot_851/vpd[3] openDVS_pixel2x2_bot_851/vpd[2] rowReadON[52] rowReadON[53]
+ RefrBp PrBp PrSFBp col_periphery_1x2_19/COL_LINE0 pixRst[38] pixRst[39] col_periphery_1x2_19/COL_LINE1
+ OffBn rowReadOFF[52] rowReadOFF[53] openDVS_pixel2x2_bot_863/GndD DiffBn VSUBS OnBn
+ VDD openDVS_pixel2x2_bot
XopenDVS_pixel2x2_bot_873 openDVS_pixel2x2_bot_873/vpd[0] openDVS_pixel2x2_bot_873/vpd[1]
+ openDVS_pixel2x2_bot_873/vpd[3] openDVS_pixel2x2_bot_873/vpd[2] rowReadON[54] rowReadON[55]
+ RefrBp PrBp PrSFBp col_periphery_1x2_9/COL_LINE0 pixRst[18] pixRst[19] col_periphery_1x2_9/COL_LINE1
+ OffBn rowReadOFF[54] rowReadOFF[55] openDVS_pixel2x2_bot_895/GndD DiffBn VSUBS OnBn
+ VDD openDVS_pixel2x2_bot
XopenDVS_pixel2x2_bot_840 openDVS_pixel2x2_bot_840/vpd[0] openDVS_pixel2x2_bot_840/vpd[1]
+ openDVS_pixel2x2_bot_840/vpd[3] openDVS_pixel2x2_bot_840/vpd[2] rowReadON[52] rowReadON[53]
+ RefrBp PrBp PrSFBp col_periphery_1x2_8/COL_LINE0 pixRst[16] pixRst[17] col_periphery_1x2_8/COL_LINE1
+ OffBn rowReadOFF[52] rowReadOFF[53] openDVS_pixel2x2_bot_863/GndD DiffBn VSUBS OnBn
+ VDD openDVS_pixel2x2_bot
XopenDVS_pixel2x2_bot_103 openDVS_pixel2x2_bot_103/vpd[0] openDVS_pixel2x2_bot_103/vpd[1]
+ openDVS_pixel2x2_bot_103/vpd[3] openDVS_pixel2x2_bot_103/vpd[2] rowReadON[6] rowReadON[7]
+ RefrBp PrBp PrSFBp col_periphery_1x2_7/COL_LINE0 pixRst[14] pixRst[15] col_periphery_1x2_7/COL_LINE1
+ OffBn rowReadOFF[6] rowReadOFF[7] openDVS_pixel2x2_bot_99/GndD DiffBn VSUBS OnBn
+ VDD openDVS_pixel2x2_bot
XopenDVS_pixel2x2_bot_136 openDVS_pixel2x2_bot_136/vpd[0] openDVS_pixel2x2_bot_136/vpd[1]
+ openDVS_pixel2x2_bot_136/vpd[3] openDVS_pixel2x2_bot_136/vpd[2] rowReadON[8] rowReadON[9]
+ RefrBp PrBp PrSFBp col_periphery_1x2_8/COL_LINE0 pixRst[16] pixRst[17] col_periphery_1x2_8/COL_LINE1
+ OffBn rowReadOFF[8] rowReadOFF[9] openDVS_pixel2x2_bot_159/GndD DiffBn VSUBS OnBn
+ VDD openDVS_pixel2x2_bot
XopenDVS_pixel2x2_bot_169 openDVS_pixel2x2_bot_169/vpd[0] openDVS_pixel2x2_bot_169/vpd[1]
+ openDVS_pixel2x2_bot_169/vpd[3] openDVS_pixel2x2_bot_169/vpd[2] rowReadON[10] rowReadON[11]
+ RefrBp PrBp PrSFBp col_periphery_1x2_9/COL_LINE0 pixRst[18] pixRst[19] col_periphery_1x2_9/COL_LINE1
+ OffBn rowReadOFF[10] rowReadOFF[11] openDVS_pixel2x2_bot_191/GndD DiffBn VSUBS OnBn
+ VDD openDVS_pixel2x2_bot
XopenDVS_pixel2x2_bot_114 openDVS_pixel2x2_bot_114/vpd[0] openDVS_pixel2x2_bot_114/vpd[1]
+ openDVS_pixel2x2_bot_114/vpd[3] openDVS_pixel2x2_bot_114/vpd[2] rowReadON[6] rowReadON[7]
+ RefrBp PrBp PrSFBp col_periphery_1x2_18/COL_LINE0 pixRst[36] pixRst[37] col_periphery_1x2_18/COL_LINE1
+ OffBn rowReadOFF[6] rowReadOFF[7] openDVS_pixel2x2_bot_99/GndD DiffBn VSUBS OnBn
+ VDD openDVS_pixel2x2_bot
XopenDVS_pixel2x2_bot_147 openDVS_pixel2x2_bot_147/vpd[0] openDVS_pixel2x2_bot_147/vpd[1]
+ openDVS_pixel2x2_bot_147/vpd[3] openDVS_pixel2x2_bot_147/vpd[2] rowReadON[8] rowReadON[9]
+ RefrBp PrBp PrSFBp col_periphery_1x2_19/COL_LINE0 pixRst[38] pixRst[39] col_periphery_1x2_19/COL_LINE1
+ OffBn rowReadOFF[8] rowReadOFF[9] openDVS_pixel2x2_bot_159/GndD DiffBn VSUBS OnBn
+ VDD openDVS_pixel2x2_bot
XopenDVS_pixel2x2_bot_125 openDVS_pixel2x2_bot_125/vpd[0] openDVS_pixel2x2_bot_125/vpd[1]
+ openDVS_pixel2x2_bot_125/vpd[3] openDVS_pixel2x2_bot_125/vpd[2] rowReadON[6] rowReadON[7]
+ RefrBp PrBp PrSFBp col_periphery_1x2_29/COL_LINE0 pixRst[58] pixRst[59] col_periphery_1x2_29/COL_LINE1
+ OffBn rowReadOFF[6] rowReadOFF[7] openDVS_pixel2x2_bot_99/GndD DiffBn VSUBS OnBn
+ VDD openDVS_pixel2x2_bot
XopenDVS_pixel2x2_bot_158 openDVS_pixel2x2_bot_158/vpd[0] openDVS_pixel2x2_bot_158/vpd[1]
+ openDVS_pixel2x2_bot_158/vpd[3] openDVS_pixel2x2_bot_158/vpd[2] rowReadON[8] rowReadON[9]
+ RefrBp PrBp PrSFBp col_periphery_1x2_30/COL_LINE0 pixRst[60] pixRst[61] col_periphery_1x2_30/COL_LINE1
+ OffBn rowReadOFF[8] rowReadOFF[9] openDVS_pixel2x2_bot_159/GndD DiffBn VSUBS OnBn
+ VDD openDVS_pixel2x2_bot
XopenDVS_pixel2x2_bot_692 openDVS_pixel2x2_bot_692/vpd[0] openDVS_pixel2x2_bot_692/vpd[1]
+ openDVS_pixel2x2_bot_692/vpd[3] openDVS_pixel2x2_bot_692/vpd[2] rowReadON[42] rowReadON[43]
+ RefrBp PrBp PrSFBp col_periphery_1x2_20/COL_LINE0 pixRst[40] pixRst[41] col_periphery_1x2_20/COL_LINE1
+ OffBn rowReadOFF[42] rowReadOFF[43] openDVS_pixel2x2_bot_703/GndD DiffBn VSUBS OnBn
+ VDD openDVS_pixel2x2_bot
XopenDVS_pixel2x2_bot_681 openDVS_pixel2x2_bot_681/vpd[0] openDVS_pixel2x2_bot_681/vpd[1]
+ openDVS_pixel2x2_bot_681/vpd[3] openDVS_pixel2x2_bot_681/vpd[2] rowReadON[42] rowReadON[43]
+ RefrBp PrBp PrSFBp col_periphery_1x2_9/COL_LINE0 pixRst[18] pixRst[19] col_periphery_1x2_9/COL_LINE1
+ OffBn rowReadOFF[42] rowReadOFF[43] openDVS_pixel2x2_bot_703/GndD DiffBn VSUBS OnBn
+ VDD openDVS_pixel2x2_bot
XopenDVS_pixel2x2_bot_670 openDVS_pixel2x2_bot_670/vpd[0] openDVS_pixel2x2_bot_670/vpd[1]
+ openDVS_pixel2x2_bot_670/vpd[3] openDVS_pixel2x2_bot_670/vpd[2] rowReadON[40] rowReadON[41]
+ RefrBp PrBp PrSFBp col_periphery_1x2_30/COL_LINE0 pixRst[60] pixRst[61] col_periphery_1x2_30/COL_LINE1
+ OffBn rowReadOFF[40] rowReadOFF[41] openDVS_pixel2x2_bot_671/GndD DiffBn VSUBS OnBn
+ VDD openDVS_pixel2x2_bot
XopenDVS_pixel2x2_bot_90 openDVS_pixel2x2_bot_90/vpd[0] openDVS_pixel2x2_bot_90/vpd[1]
+ openDVS_pixel2x2_bot_90/vpd[3] openDVS_pixel2x2_bot_90/vpd[2] rowReadON[4] rowReadON[5]
+ RefrBp PrBp PrSFBp col_periphery_1x2_26/COL_LINE0 pixRst[52] pixRst[53] col_periphery_1x2_26/COL_LINE1
+ OffBn rowReadOFF[4] rowReadOFF[5] openDVS_pixel2x2_bot_95/GndD DiffBn VSUBS OnBn
+ VDD openDVS_pixel2x2_bot
XopenDVS_pixel2x2_bot_1021 openDVS_pixel2x2_bot_1021/vpd[0] openDVS_pixel2x2_bot_1021/vpd[1]
+ openDVS_pixel2x2_bot_1021/vpd[3] openDVS_pixel2x2_bot_1021/vpd[2] rowReadON[62]
+ rowReadON[63] RefrBp PrBp PrSFBp col_periphery_1x2_29/COL_LINE0 pixRst[58] pixRst[59]
+ col_periphery_1x2_29/COL_LINE1 OffBn rowReadOFF[62] rowReadOFF[63] openDVS_pixel2x2_bot_999/GndD
+ DiffBn VSUBS OnBn VDD openDVS_pixel2x2_bot
XopenDVS_pixel2x2_bot_1010 openDVS_pixel2x2_bot_1010/vpd[0] openDVS_pixel2x2_bot_1010/vpd[1]
+ openDVS_pixel2x2_bot_1010/vpd[3] openDVS_pixel2x2_bot_1010/vpd[2] rowReadON[62]
+ rowReadON[63] RefrBp PrBp PrSFBp col_periphery_1x2_18/COL_LINE0 pixRst[36] pixRst[37]
+ col_periphery_1x2_18/COL_LINE1 OffBn rowReadOFF[62] rowReadOFF[63] openDVS_pixel2x2_bot_999/GndD
+ DiffBn VSUBS OnBn VDD openDVS_pixel2x2_bot
Xcol_periphery_1x2_21 pixRst[43] col_periphery_1x2_21/COL_LINE0 col_periphery_1x2_21/COL_LINE1
+ nDETECT col_periphery_1x2_9/VDD DETECT VTHRESH voutn[42] VSUBS NCHARGE voutn[43]
+ pixRst[42] col_periphery_1x2
Xcol_periphery_1x2_10 pixRst[21] col_periphery_1x2_10/COL_LINE0 col_periphery_1x2_10/COL_LINE1
+ nDETECT col_periphery_1x2_9/VDD DETECT VTHRESH voutn[20] VSUBS NCHARGE voutn[21]
+ pixRst[20] col_periphery_1x2
XopenDVS_pixel2x2_bot_329 openDVS_pixel2x2_bot_329/vpd[0] openDVS_pixel2x2_bot_329/vpd[1]
+ openDVS_pixel2x2_bot_329/vpd[3] openDVS_pixel2x2_bot_329/vpd[2] rowReadON[20] rowReadON[21]
+ RefrBp PrBp PrSFBp col_periphery_1x2_9/COL_LINE0 pixRst[18] pixRst[19] col_periphery_1x2_9/COL_LINE1
+ OffBn rowReadOFF[20] rowReadOFF[21] openDVS_pixel2x2_bot_351/GndD DiffBn VSUBS OnBn
+ VDD openDVS_pixel2x2_bot
XopenDVS_pixel2x2_bot_307 openDVS_pixel2x2_bot_307/vpd[0] openDVS_pixel2x2_bot_307/vpd[1]
+ openDVS_pixel2x2_bot_307/vpd[3] openDVS_pixel2x2_bot_307/vpd[2] rowReadON[18] rowReadON[19]
+ RefrBp PrBp PrSFBp col_periphery_1x2_19/COL_LINE0 pixRst[38] pixRst[39] col_periphery_1x2_19/COL_LINE1
+ OffBn rowReadOFF[18] rowReadOFF[19] openDVS_pixel2x2_bot_319/GndD DiffBn VSUBS OnBn
+ VDD openDVS_pixel2x2_bot
XopenDVS_pixel2x2_bot_318 openDVS_pixel2x2_bot_318/vpd[0] openDVS_pixel2x2_bot_318/vpd[1]
+ openDVS_pixel2x2_bot_318/vpd[3] openDVS_pixel2x2_bot_318/vpd[2] rowReadON[18] rowReadON[19]
+ RefrBp PrBp PrSFBp col_periphery_1x2_30/COL_LINE0 pixRst[60] pixRst[61] col_periphery_1x2_30/COL_LINE1
+ OffBn rowReadOFF[18] rowReadOFF[19] openDVS_pixel2x2_bot_319/GndD DiffBn VSUBS OnBn
+ VDD openDVS_pixel2x2_bot
XopenDVS_pixel2x2_bot_863 openDVS_pixel2x2_bot_863/vpd[0] openDVS_pixel2x2_bot_863/vpd[1]
+ openDVS_pixel2x2_bot_863/vpd[3] openDVS_pixel2x2_bot_863/vpd[2] rowReadON[52] rowReadON[53]
+ RefrBp PrBp PrSFBp col_periphery_1x2_31/COL_LINE0 pixRst[62] pixRst[63] col_periphery_1x2_31/COL_LINE1
+ OffBn rowReadOFF[52] rowReadOFF[53] openDVS_pixel2x2_bot_863/GndD DiffBn VSUBS OnBn
+ VDD openDVS_pixel2x2_bot
XopenDVS_pixel2x2_bot_885 openDVS_pixel2x2_bot_885/vpd[0] openDVS_pixel2x2_bot_885/vpd[1]
+ openDVS_pixel2x2_bot_885/vpd[3] openDVS_pixel2x2_bot_885/vpd[2] rowReadON[54] rowReadON[55]
+ RefrBp PrBp PrSFBp col_periphery_1x2_21/COL_LINE0 pixRst[42] pixRst[43] col_periphery_1x2_21/COL_LINE1
+ OffBn rowReadOFF[54] rowReadOFF[55] openDVS_pixel2x2_bot_895/GndD DiffBn VSUBS OnBn
+ VDD openDVS_pixel2x2_bot
XopenDVS_pixel2x2_bot_852 openDVS_pixel2x2_bot_852/vpd[0] openDVS_pixel2x2_bot_852/vpd[1]
+ openDVS_pixel2x2_bot_852/vpd[3] openDVS_pixel2x2_bot_852/vpd[2] rowReadON[52] rowReadON[53]
+ RefrBp PrBp PrSFBp col_periphery_1x2_20/COL_LINE0 pixRst[40] pixRst[41] col_periphery_1x2_20/COL_LINE1
+ OffBn rowReadOFF[52] rowReadOFF[53] openDVS_pixel2x2_bot_863/GndD DiffBn VSUBS OnBn
+ VDD openDVS_pixel2x2_bot
XopenDVS_pixel2x2_bot_874 openDVS_pixel2x2_bot_874/vpd[0] openDVS_pixel2x2_bot_874/vpd[1]
+ openDVS_pixel2x2_bot_874/vpd[3] openDVS_pixel2x2_bot_874/vpd[2] rowReadON[54] rowReadON[55]
+ RefrBp PrBp PrSFBp col_periphery_1x2_10/COL_LINE0 pixRst[20] pixRst[21] col_periphery_1x2_10/COL_LINE1
+ OffBn rowReadOFF[54] rowReadOFF[55] openDVS_pixel2x2_bot_895/GndD DiffBn VSUBS OnBn
+ VDD openDVS_pixel2x2_bot
XopenDVS_pixel2x2_bot_841 openDVS_pixel2x2_bot_841/vpd[0] openDVS_pixel2x2_bot_841/vpd[1]
+ openDVS_pixel2x2_bot_841/vpd[3] openDVS_pixel2x2_bot_841/vpd[2] rowReadON[52] rowReadON[53]
+ RefrBp PrBp PrSFBp col_periphery_1x2_9/COL_LINE0 pixRst[18] pixRst[19] col_periphery_1x2_9/COL_LINE1
+ OffBn rowReadOFF[52] rowReadOFF[53] openDVS_pixel2x2_bot_863/GndD DiffBn VSUBS OnBn
+ VDD openDVS_pixel2x2_bot
XopenDVS_pixel2x2_bot_896 openDVS_pixel2x2_bot_896/vpd[0] openDVS_pixel2x2_bot_896/vpd[1]
+ openDVS_pixel2x2_bot_896/vpd[3] openDVS_pixel2x2_bot_896/vpd[2] rowReadON[56] rowReadON[57]
+ RefrBp PrBp PrSFBp col_periphery_1x2_0/COL_LINE0 pixRst[0] pixRst[1] col_periphery_1x2_0/COL_LINE1
+ OffBn rowReadOFF[56] rowReadOFF[57] openDVS_pixel2x2_bot_927/GndD DiffBn VSUBS OnBn
+ VDD openDVS_pixel2x2_bot
XopenDVS_pixel2x2_bot_830 openDVS_pixel2x2_bot_830/vpd[0] openDVS_pixel2x2_bot_830/vpd[1]
+ openDVS_pixel2x2_bot_830/vpd[3] openDVS_pixel2x2_bot_830/vpd[2] rowReadON[50] rowReadON[51]
+ RefrBp PrBp PrSFBp col_periphery_1x2_30/COL_LINE0 pixRst[60] pixRst[61] col_periphery_1x2_30/COL_LINE1
+ OffBn rowReadOFF[50] rowReadOFF[51] openDVS_pixel2x2_bot_831/GndD DiffBn VSUBS OnBn
+ VDD openDVS_pixel2x2_bot
XopenDVS_pixel2x2_bot_104 openDVS_pixel2x2_bot_104/vpd[0] openDVS_pixel2x2_bot_104/vpd[1]
+ openDVS_pixel2x2_bot_104/vpd[3] openDVS_pixel2x2_bot_104/vpd[2] rowReadON[6] rowReadON[7]
+ RefrBp PrBp PrSFBp col_periphery_1x2_8/COL_LINE0 pixRst[16] pixRst[17] col_periphery_1x2_8/COL_LINE1
+ OffBn rowReadOFF[6] rowReadOFF[7] openDVS_pixel2x2_bot_99/GndD DiffBn VSUBS OnBn
+ VDD openDVS_pixel2x2_bot
XopenDVS_pixel2x2_bot_137 openDVS_pixel2x2_bot_137/vpd[0] openDVS_pixel2x2_bot_137/vpd[1]
+ openDVS_pixel2x2_bot_137/vpd[3] openDVS_pixel2x2_bot_137/vpd[2] rowReadON[8] rowReadON[9]
+ RefrBp PrBp PrSFBp col_periphery_1x2_9/COL_LINE0 pixRst[18] pixRst[19] col_periphery_1x2_9/COL_LINE1
+ OffBn rowReadOFF[8] rowReadOFF[9] openDVS_pixel2x2_bot_159/GndD DiffBn VSUBS OnBn
+ VDD openDVS_pixel2x2_bot
XopenDVS_pixel2x2_bot_115 openDVS_pixel2x2_bot_115/vpd[0] openDVS_pixel2x2_bot_115/vpd[1]
+ openDVS_pixel2x2_bot_115/vpd[3] openDVS_pixel2x2_bot_115/vpd[2] rowReadON[6] rowReadON[7]
+ RefrBp PrBp PrSFBp col_periphery_1x2_19/COL_LINE0 pixRst[38] pixRst[39] col_periphery_1x2_19/COL_LINE1
+ OffBn rowReadOFF[6] rowReadOFF[7] openDVS_pixel2x2_bot_99/GndD DiffBn VSUBS OnBn
+ VDD openDVS_pixel2x2_bot
XopenDVS_pixel2x2_bot_148 openDVS_pixel2x2_bot_148/vpd[0] openDVS_pixel2x2_bot_148/vpd[1]
+ openDVS_pixel2x2_bot_148/vpd[3] openDVS_pixel2x2_bot_148/vpd[2] rowReadON[8] rowReadON[9]
+ RefrBp PrBp PrSFBp col_periphery_1x2_20/COL_LINE0 pixRst[40] pixRst[41] col_periphery_1x2_20/COL_LINE1
+ OffBn rowReadOFF[8] rowReadOFF[9] openDVS_pixel2x2_bot_159/GndD DiffBn VSUBS OnBn
+ VDD openDVS_pixel2x2_bot
XopenDVS_pixel2x2_bot_126 openDVS_pixel2x2_bot_126/vpd[0] openDVS_pixel2x2_bot_126/vpd[1]
+ openDVS_pixel2x2_bot_126/vpd[3] openDVS_pixel2x2_bot_126/vpd[2] rowReadON[6] rowReadON[7]
+ RefrBp PrBp PrSFBp col_periphery_1x2_30/COL_LINE0 pixRst[60] pixRst[61] col_periphery_1x2_30/COL_LINE1
+ OffBn rowReadOFF[6] rowReadOFF[7] openDVS_pixel2x2_bot_99/GndD DiffBn VSUBS OnBn
+ VDD openDVS_pixel2x2_bot
XopenDVS_pixel2x2_bot_159 openDVS_pixel2x2_bot_159/vpd[0] openDVS_pixel2x2_bot_159/vpd[1]
+ openDVS_pixel2x2_bot_159/vpd[3] openDVS_pixel2x2_bot_159/vpd[2] rowReadON[8] rowReadON[9]
+ RefrBp PrBp PrSFBp col_periphery_1x2_31/COL_LINE0 pixRst[62] pixRst[63] col_periphery_1x2_31/COL_LINE1
+ OffBn rowReadOFF[8] rowReadOFF[9] openDVS_pixel2x2_bot_159/GndD DiffBn VSUBS OnBn
+ VDD openDVS_pixel2x2_bot
XopenDVS_pixel2x2_bot_693 openDVS_pixel2x2_bot_693/vpd[0] openDVS_pixel2x2_bot_693/vpd[1]
+ openDVS_pixel2x2_bot_693/vpd[3] openDVS_pixel2x2_bot_693/vpd[2] rowReadON[42] rowReadON[43]
+ RefrBp PrBp PrSFBp col_periphery_1x2_21/COL_LINE0 pixRst[42] pixRst[43] col_periphery_1x2_21/COL_LINE1
+ OffBn rowReadOFF[42] rowReadOFF[43] openDVS_pixel2x2_bot_703/GndD DiffBn VSUBS OnBn
+ VDD openDVS_pixel2x2_bot
XopenDVS_pixel2x2_bot_682 openDVS_pixel2x2_bot_682/vpd[0] openDVS_pixel2x2_bot_682/vpd[1]
+ openDVS_pixel2x2_bot_682/vpd[3] openDVS_pixel2x2_bot_682/vpd[2] rowReadON[42] rowReadON[43]
+ RefrBp PrBp PrSFBp col_periphery_1x2_10/COL_LINE0 pixRst[20] pixRst[21] col_periphery_1x2_10/COL_LINE1
+ OffBn rowReadOFF[42] rowReadOFF[43] openDVS_pixel2x2_bot_703/GndD DiffBn VSUBS OnBn
+ VDD openDVS_pixel2x2_bot
XopenDVS_pixel2x2_bot_671 openDVS_pixel2x2_bot_671/vpd[0] openDVS_pixel2x2_bot_671/vpd[1]
+ openDVS_pixel2x2_bot_671/vpd[3] openDVS_pixel2x2_bot_671/vpd[2] rowReadON[40] rowReadON[41]
+ RefrBp PrBp PrSFBp col_periphery_1x2_31/COL_LINE0 pixRst[62] pixRst[63] col_periphery_1x2_31/COL_LINE1
+ OffBn rowReadOFF[40] rowReadOFF[41] openDVS_pixel2x2_bot_671/GndD DiffBn VSUBS OnBn
+ VDD openDVS_pixel2x2_bot
XopenDVS_pixel2x2_bot_660 openDVS_pixel2x2_bot_660/vpd[0] openDVS_pixel2x2_bot_660/vpd[1]
+ openDVS_pixel2x2_bot_660/vpd[3] openDVS_pixel2x2_bot_660/vpd[2] rowReadON[40] rowReadON[41]
+ RefrBp PrBp PrSFBp col_periphery_1x2_20/COL_LINE0 pixRst[40] pixRst[41] col_periphery_1x2_20/COL_LINE1
+ OffBn rowReadOFF[40] rowReadOFF[41] openDVS_pixel2x2_bot_671/GndD DiffBn VSUBS OnBn
+ VDD openDVS_pixel2x2_bot
XopenDVS_pixel2x2_bot_80 openDVS_pixel2x2_bot_80/vpd[0] openDVS_pixel2x2_bot_80/vpd[1]
+ openDVS_pixel2x2_bot_80/vpd[3] openDVS_pixel2x2_bot_80/vpd[2] rowReadON[4] rowReadON[5]
+ RefrBp PrBp PrSFBp col_periphery_1x2_16/COL_LINE0 pixRst[32] pixRst[33] col_periphery_1x2_16/COL_LINE1
+ OffBn rowReadOFF[4] rowReadOFF[5] openDVS_pixel2x2_bot_95/GndD DiffBn VSUBS OnBn
+ VDD openDVS_pixel2x2_bot
XopenDVS_pixel2x2_bot_91 openDVS_pixel2x2_bot_91/vpd[0] openDVS_pixel2x2_bot_91/vpd[1]
+ openDVS_pixel2x2_bot_91/vpd[3] openDVS_pixel2x2_bot_91/vpd[2] rowReadON[4] rowReadON[5]
+ RefrBp PrBp PrSFBp col_periphery_1x2_27/COL_LINE0 pixRst[54] pixRst[55] col_periphery_1x2_27/COL_LINE1
+ OffBn rowReadOFF[4] rowReadOFF[5] openDVS_pixel2x2_bot_95/GndD DiffBn VSUBS OnBn
+ VDD openDVS_pixel2x2_bot
XopenDVS_pixel2x2_bot_1022 openDVS_pixel2x2_bot_1022/vpd[0] openDVS_pixel2x2_bot_1022/vpd[1]
+ openDVS_pixel2x2_bot_1022/vpd[3] openDVS_pixel2x2_bot_1022/vpd[2] rowReadON[62]
+ rowReadON[63] RefrBp PrBp PrSFBp col_periphery_1x2_30/COL_LINE0 pixRst[60] pixRst[61]
+ col_periphery_1x2_30/COL_LINE1 OffBn rowReadOFF[62] rowReadOFF[63] openDVS_pixel2x2_bot_999/GndD
+ DiffBn VSUBS OnBn VDD openDVS_pixel2x2_bot
XopenDVS_pixel2x2_bot_1011 openDVS_pixel2x2_bot_1011/vpd[0] openDVS_pixel2x2_bot_1011/vpd[1]
+ openDVS_pixel2x2_bot_1011/vpd[3] openDVS_pixel2x2_bot_1011/vpd[2] rowReadON[62]
+ rowReadON[63] RefrBp PrBp PrSFBp col_periphery_1x2_19/COL_LINE0 pixRst[38] pixRst[39]
+ col_periphery_1x2_19/COL_LINE1 OffBn rowReadOFF[62] rowReadOFF[63] openDVS_pixel2x2_bot_999/GndD
+ DiffBn VSUBS OnBn VDD openDVS_pixel2x2_bot
XopenDVS_pixel2x2_bot_1000 openDVS_pixel2x2_bot_1000/vpd[0] openDVS_pixel2x2_bot_1000/vpd[1]
+ openDVS_pixel2x2_bot_1000/vpd[3] openDVS_pixel2x2_bot_1000/vpd[2] rowReadON[62]
+ rowReadON[63] RefrBp PrBp PrSFBp col_periphery_1x2_8/COL_LINE0 pixRst[16] pixRst[17]
+ col_periphery_1x2_8/COL_LINE1 OffBn rowReadOFF[62] rowReadOFF[63] openDVS_pixel2x2_bot_999/GndD
+ DiffBn VSUBS OnBn VDD openDVS_pixel2x2_bot
XopenDVS_pixel2x2_bot_490 openDVS_pixel2x2_bot_490/vpd[0] openDVS_pixel2x2_bot_490/vpd[1]
+ openDVS_pixel2x2_bot_490/vpd[3] openDVS_pixel2x2_bot_490/vpd[2] rowReadON[30] rowReadON[31]
+ RefrBp PrBp PrSFBp col_periphery_1x2_10/COL_LINE0 pixRst[20] pixRst[21] col_periphery_1x2_10/COL_LINE1
+ OffBn rowReadOFF[30] rowReadOFF[31] openDVS_pixel2x2_bot_511/GndD DiffBn VSUBS OnBn
+ VDD openDVS_pixel2x2_bot
Xcol_periphery_1x2_22 pixRst[45] col_periphery_1x2_22/COL_LINE0 col_periphery_1x2_22/COL_LINE1
+ nDETECT col_periphery_1x2_9/VDD DETECT VTHRESH voutn[44] VSUBS NCHARGE voutn[45]
+ pixRst[44] col_periphery_1x2
Xcol_periphery_1x2_11 pixRst[23] col_periphery_1x2_11/COL_LINE0 col_periphery_1x2_11/COL_LINE1
+ nDETECT col_periphery_1x2_9/VDD DETECT VTHRESH voutn[22] VSUBS NCHARGE voutn[23]
+ pixRst[22] col_periphery_1x2
XopenDVS_pixel2x2_bot_0 openDVS_pixel2x2_bot_0/vpd[0] openDVS_pixel2x2_bot_0/vpd[1]
+ openDVS_pixel2x2_bot_0/vpd[3] openDVS_pixel2x2_bot_0/vpd[2] rowReadON[0] rowReadON[1]
+ RefrBp PrBp PrSFBp col_periphery_1x2_0/COL_LINE0 pixRst[0] pixRst[1] col_periphery_1x2_0/COL_LINE1
+ OffBn rowReadOFF[0] rowReadOFF[1] GND DiffBn VSUBS OnBn VDD openDVS_pixel2x2_bot
XopenDVS_pixel2x2_bot_308 openDVS_pixel2x2_bot_308/vpd[0] openDVS_pixel2x2_bot_308/vpd[1]
+ openDVS_pixel2x2_bot_308/vpd[3] openDVS_pixel2x2_bot_308/vpd[2] rowReadON[18] rowReadON[19]
+ RefrBp PrBp PrSFBp col_periphery_1x2_20/COL_LINE0 pixRst[40] pixRst[41] col_periphery_1x2_20/COL_LINE1
+ OffBn rowReadOFF[18] rowReadOFF[19] openDVS_pixel2x2_bot_319/GndD DiffBn VSUBS OnBn
+ VDD openDVS_pixel2x2_bot
XopenDVS_pixel2x2_bot_319 openDVS_pixel2x2_bot_319/vpd[0] openDVS_pixel2x2_bot_319/vpd[1]
+ openDVS_pixel2x2_bot_319/vpd[3] openDVS_pixel2x2_bot_319/vpd[2] rowReadON[18] rowReadON[19]
+ RefrBp PrBp PrSFBp col_periphery_1x2_31/COL_LINE0 pixRst[62] pixRst[63] col_periphery_1x2_31/COL_LINE1
+ OffBn rowReadOFF[18] rowReadOFF[19] openDVS_pixel2x2_bot_319/GndD DiffBn VSUBS OnBn
+ VDD openDVS_pixel2x2_bot
XopenDVS_pixel2x2_bot_853 openDVS_pixel2x2_bot_853/vpd[0] openDVS_pixel2x2_bot_853/vpd[1]
+ openDVS_pixel2x2_bot_853/vpd[3] openDVS_pixel2x2_bot_853/vpd[2] rowReadON[52] rowReadON[53]
+ RefrBp PrBp PrSFBp col_periphery_1x2_21/COL_LINE0 pixRst[42] pixRst[43] col_periphery_1x2_21/COL_LINE1
+ OffBn rowReadOFF[52] rowReadOFF[53] openDVS_pixel2x2_bot_863/GndD DiffBn VSUBS OnBn
+ VDD openDVS_pixel2x2_bot
XopenDVS_pixel2x2_bot_875 openDVS_pixel2x2_bot_875/vpd[0] openDVS_pixel2x2_bot_875/vpd[1]
+ openDVS_pixel2x2_bot_875/vpd[3] openDVS_pixel2x2_bot_875/vpd[2] rowReadON[54] rowReadON[55]
+ RefrBp PrBp PrSFBp col_periphery_1x2_11/COL_LINE0 pixRst[22] pixRst[23] col_periphery_1x2_11/COL_LINE1
+ OffBn rowReadOFF[54] rowReadOFF[55] openDVS_pixel2x2_bot_895/GndD DiffBn VSUBS OnBn
+ VDD openDVS_pixel2x2_bot
XopenDVS_pixel2x2_bot_842 openDVS_pixel2x2_bot_842/vpd[0] openDVS_pixel2x2_bot_842/vpd[1]
+ openDVS_pixel2x2_bot_842/vpd[3] openDVS_pixel2x2_bot_842/vpd[2] rowReadON[52] rowReadON[53]
+ RefrBp PrBp PrSFBp col_periphery_1x2_10/COL_LINE0 pixRst[20] pixRst[21] col_periphery_1x2_10/COL_LINE1
+ OffBn rowReadOFF[52] rowReadOFF[53] openDVS_pixel2x2_bot_863/GndD DiffBn VSUBS OnBn
+ VDD openDVS_pixel2x2_bot
XopenDVS_pixel2x2_bot_864 openDVS_pixel2x2_bot_864/vpd[0] openDVS_pixel2x2_bot_864/vpd[1]
+ openDVS_pixel2x2_bot_864/vpd[3] openDVS_pixel2x2_bot_864/vpd[2] rowReadON[54] rowReadON[55]
+ RefrBp PrBp PrSFBp col_periphery_1x2_0/COL_LINE0 pixRst[0] pixRst[1] col_periphery_1x2_0/COL_LINE1
+ OffBn rowReadOFF[54] rowReadOFF[55] openDVS_pixel2x2_bot_895/GndD DiffBn VSUBS OnBn
+ VDD openDVS_pixel2x2_bot
XopenDVS_pixel2x2_bot_831 openDVS_pixel2x2_bot_831/vpd[0] openDVS_pixel2x2_bot_831/vpd[1]
+ openDVS_pixel2x2_bot_831/vpd[3] openDVS_pixel2x2_bot_831/vpd[2] rowReadON[50] rowReadON[51]
+ RefrBp PrBp PrSFBp col_periphery_1x2_31/COL_LINE0 pixRst[62] pixRst[63] col_periphery_1x2_31/COL_LINE1
+ OffBn rowReadOFF[50] rowReadOFF[51] openDVS_pixel2x2_bot_831/GndD DiffBn VSUBS OnBn
+ VDD openDVS_pixel2x2_bot
XopenDVS_pixel2x2_bot_820 openDVS_pixel2x2_bot_820/vpd[0] openDVS_pixel2x2_bot_820/vpd[1]
+ openDVS_pixel2x2_bot_820/vpd[3] openDVS_pixel2x2_bot_820/vpd[2] rowReadON[50] rowReadON[51]
+ RefrBp PrBp PrSFBp col_periphery_1x2_20/COL_LINE0 pixRst[40] pixRst[41] col_periphery_1x2_20/COL_LINE1
+ OffBn rowReadOFF[50] rowReadOFF[51] openDVS_pixel2x2_bot_831/GndD DiffBn VSUBS OnBn
+ VDD openDVS_pixel2x2_bot
XopenDVS_pixel2x2_bot_886 openDVS_pixel2x2_bot_886/vpd[0] openDVS_pixel2x2_bot_886/vpd[1]
+ openDVS_pixel2x2_bot_886/vpd[3] openDVS_pixel2x2_bot_886/vpd[2] rowReadON[54] rowReadON[55]
+ RefrBp PrBp PrSFBp col_periphery_1x2_22/COL_LINE0 pixRst[44] pixRst[45] col_periphery_1x2_22/COL_LINE1
+ OffBn rowReadOFF[54] rowReadOFF[55] openDVS_pixel2x2_bot_895/GndD DiffBn VSUBS OnBn
+ VDD openDVS_pixel2x2_bot
XopenDVS_pixel2x2_bot_897 openDVS_pixel2x2_bot_897/vpd[0] openDVS_pixel2x2_bot_897/vpd[1]
+ openDVS_pixel2x2_bot_897/vpd[3] openDVS_pixel2x2_bot_897/vpd[2] rowReadON[56] rowReadON[57]
+ RefrBp PrBp PrSFBp col_periphery_1x2_1/COL_LINE0 pixRst[2] pixRst[3] col_periphery_1x2_1/COL_LINE1
+ OffBn rowReadOFF[56] rowReadOFF[57] openDVS_pixel2x2_bot_927/GndD DiffBn VSUBS OnBn
+ VDD openDVS_pixel2x2_bot
XopenDVS_pixel2x2_bot_105 openDVS_pixel2x2_bot_105/vpd[0] openDVS_pixel2x2_bot_105/vpd[1]
+ openDVS_pixel2x2_bot_105/vpd[3] openDVS_pixel2x2_bot_105/vpd[2] rowReadON[6] rowReadON[7]
+ RefrBp PrBp PrSFBp col_periphery_1x2_9/COL_LINE0 pixRst[18] pixRst[19] col_periphery_1x2_9/COL_LINE1
+ OffBn rowReadOFF[6] rowReadOFF[7] openDVS_pixel2x2_bot_99/GndD DiffBn VSUBS OnBn
+ VDD openDVS_pixel2x2_bot
XopenDVS_pixel2x2_bot_138 openDVS_pixel2x2_bot_138/vpd[0] openDVS_pixel2x2_bot_138/vpd[1]
+ openDVS_pixel2x2_bot_138/vpd[3] openDVS_pixel2x2_bot_138/vpd[2] rowReadON[8] rowReadON[9]
+ RefrBp PrBp PrSFBp col_periphery_1x2_10/COL_LINE0 pixRst[20] pixRst[21] col_periphery_1x2_10/COL_LINE1
+ OffBn rowReadOFF[8] rowReadOFF[9] openDVS_pixel2x2_bot_159/GndD DiffBn VSUBS OnBn
+ VDD openDVS_pixel2x2_bot
XopenDVS_pixel2x2_bot_116 openDVS_pixel2x2_bot_116/vpd[0] openDVS_pixel2x2_bot_116/vpd[1]
+ openDVS_pixel2x2_bot_116/vpd[3] openDVS_pixel2x2_bot_116/vpd[2] rowReadON[6] rowReadON[7]
+ RefrBp PrBp PrSFBp col_periphery_1x2_20/COL_LINE0 pixRst[40] pixRst[41] col_periphery_1x2_20/COL_LINE1
+ OffBn rowReadOFF[6] rowReadOFF[7] openDVS_pixel2x2_bot_99/GndD DiffBn VSUBS OnBn
+ VDD openDVS_pixel2x2_bot
XopenDVS_pixel2x2_bot_149 openDVS_pixel2x2_bot_149/vpd[0] openDVS_pixel2x2_bot_149/vpd[1]
+ openDVS_pixel2x2_bot_149/vpd[3] openDVS_pixel2x2_bot_149/vpd[2] rowReadON[8] rowReadON[9]
+ RefrBp PrBp PrSFBp col_periphery_1x2_21/COL_LINE0 pixRst[42] pixRst[43] col_periphery_1x2_21/COL_LINE1
+ OffBn rowReadOFF[8] rowReadOFF[9] openDVS_pixel2x2_bot_159/GndD DiffBn VSUBS OnBn
+ VDD openDVS_pixel2x2_bot
XopenDVS_pixel2x2_bot_127 openDVS_pixel2x2_bot_127/vpd[0] openDVS_pixel2x2_bot_127/vpd[1]
+ openDVS_pixel2x2_bot_127/vpd[3] openDVS_pixel2x2_bot_127/vpd[2] rowReadON[6] rowReadON[7]
+ RefrBp PrBp PrSFBp col_periphery_1x2_31/COL_LINE0 pixRst[62] pixRst[63] col_periphery_1x2_31/COL_LINE1
+ OffBn rowReadOFF[6] rowReadOFF[7] openDVS_pixel2x2_bot_99/GndD DiffBn VSUBS OnBn
+ VDD openDVS_pixel2x2_bot
XopenDVS_pixel2x2_bot_694 openDVS_pixel2x2_bot_694/vpd[0] openDVS_pixel2x2_bot_694/vpd[1]
+ openDVS_pixel2x2_bot_694/vpd[3] openDVS_pixel2x2_bot_694/vpd[2] rowReadON[42] rowReadON[43]
+ RefrBp PrBp PrSFBp col_periphery_1x2_22/COL_LINE0 pixRst[44] pixRst[45] col_periphery_1x2_22/COL_LINE1
+ OffBn rowReadOFF[42] rowReadOFF[43] openDVS_pixel2x2_bot_703/GndD DiffBn VSUBS OnBn
+ VDD openDVS_pixel2x2_bot
XopenDVS_pixel2x2_bot_683 openDVS_pixel2x2_bot_683/vpd[0] openDVS_pixel2x2_bot_683/vpd[1]
+ openDVS_pixel2x2_bot_683/vpd[3] openDVS_pixel2x2_bot_683/vpd[2] rowReadON[42] rowReadON[43]
+ RefrBp PrBp PrSFBp col_periphery_1x2_11/COL_LINE0 pixRst[22] pixRst[23] col_periphery_1x2_11/COL_LINE1
+ OffBn rowReadOFF[42] rowReadOFF[43] openDVS_pixel2x2_bot_703/GndD DiffBn VSUBS OnBn
+ VDD openDVS_pixel2x2_bot
XopenDVS_pixel2x2_bot_672 openDVS_pixel2x2_bot_672/vpd[0] openDVS_pixel2x2_bot_672/vpd[1]
+ openDVS_pixel2x2_bot_672/vpd[3] openDVS_pixel2x2_bot_672/vpd[2] rowReadON[42] rowReadON[43]
+ RefrBp PrBp PrSFBp col_periphery_1x2_0/COL_LINE0 pixRst[0] pixRst[1] col_periphery_1x2_0/COL_LINE1
+ OffBn rowReadOFF[42] rowReadOFF[43] openDVS_pixel2x2_bot_703/GndD DiffBn VSUBS OnBn
+ VDD openDVS_pixel2x2_bot
XopenDVS_pixel2x2_bot_661 openDVS_pixel2x2_bot_661/vpd[0] openDVS_pixel2x2_bot_661/vpd[1]
+ openDVS_pixel2x2_bot_661/vpd[3] openDVS_pixel2x2_bot_661/vpd[2] rowReadON[40] rowReadON[41]
+ RefrBp PrBp PrSFBp col_periphery_1x2_21/COL_LINE0 pixRst[42] pixRst[43] col_periphery_1x2_21/COL_LINE1
+ OffBn rowReadOFF[40] rowReadOFF[41] openDVS_pixel2x2_bot_671/GndD DiffBn VSUBS OnBn
+ VDD openDVS_pixel2x2_bot
XopenDVS_pixel2x2_bot_650 openDVS_pixel2x2_bot_650/vpd[0] openDVS_pixel2x2_bot_650/vpd[1]
+ openDVS_pixel2x2_bot_650/vpd[3] openDVS_pixel2x2_bot_650/vpd[2] rowReadON[40] rowReadON[41]
+ RefrBp PrBp PrSFBp col_periphery_1x2_10/COL_LINE0 pixRst[20] pixRst[21] col_periphery_1x2_10/COL_LINE1
+ OffBn rowReadOFF[40] rowReadOFF[41] openDVS_pixel2x2_bot_671/GndD DiffBn VSUBS OnBn
+ VDD openDVS_pixel2x2_bot
XopenDVS_pixel2x2_bot_70 openDVS_pixel2x2_bot_70/vpd[0] openDVS_pixel2x2_bot_70/vpd[1]
+ openDVS_pixel2x2_bot_70/vpd[3] openDVS_pixel2x2_bot_70/vpd[2] rowReadON[4] rowReadON[5]
+ RefrBp PrBp PrSFBp col_periphery_1x2_6/COL_LINE0 pixRst[12] pixRst[13] col_periphery_1x2_6/COL_LINE1
+ OffBn rowReadOFF[4] rowReadOFF[5] openDVS_pixel2x2_bot_95/GndD DiffBn VSUBS OnBn
+ VDD openDVS_pixel2x2_bot
XopenDVS_pixel2x2_bot_81 openDVS_pixel2x2_bot_81/vpd[0] openDVS_pixel2x2_bot_81/vpd[1]
+ openDVS_pixel2x2_bot_81/vpd[3] openDVS_pixel2x2_bot_81/vpd[2] rowReadON[4] rowReadON[5]
+ RefrBp PrBp PrSFBp col_periphery_1x2_17/COL_LINE0 pixRst[34] pixRst[35] col_periphery_1x2_17/COL_LINE1
+ OffBn rowReadOFF[4] rowReadOFF[5] openDVS_pixel2x2_bot_95/GndD DiffBn VSUBS OnBn
+ VDD openDVS_pixel2x2_bot
XopenDVS_pixel2x2_bot_92 openDVS_pixel2x2_bot_92/vpd[0] openDVS_pixel2x2_bot_92/vpd[1]
+ openDVS_pixel2x2_bot_92/vpd[3] openDVS_pixel2x2_bot_92/vpd[2] rowReadON[4] rowReadON[5]
+ RefrBp PrBp PrSFBp col_periphery_1x2_28/COL_LINE0 pixRst[56] pixRst[57] col_periphery_1x2_28/COL_LINE1
+ OffBn rowReadOFF[4] rowReadOFF[5] openDVS_pixel2x2_bot_95/GndD DiffBn VSUBS OnBn
+ VDD openDVS_pixel2x2_bot
XopenDVS_pixel2x2_bot_1023 openDVS_pixel2x2_bot_1023/vpd[0] openDVS_pixel2x2_bot_1023/vpd[1]
+ openDVS_pixel2x2_bot_1023/vpd[3] openDVS_pixel2x2_bot_1023/vpd[2] rowReadON[62]
+ rowReadON[63] RefrBp PrBp PrSFBp col_periphery_1x2_31/COL_LINE0 pixRst[62] pixRst[63]
+ col_periphery_1x2_31/COL_LINE1 OffBn rowReadOFF[62] rowReadOFF[63] openDVS_pixel2x2_bot_999/GndD
+ DiffBn VSUBS OnBn VDD openDVS_pixel2x2_bot
XopenDVS_pixel2x2_bot_1012 openDVS_pixel2x2_bot_1012/vpd[0] openDVS_pixel2x2_bot_1012/vpd[1]
+ openDVS_pixel2x2_bot_1012/vpd[3] openDVS_pixel2x2_bot_1012/vpd[2] rowReadON[62]
+ rowReadON[63] RefrBp PrBp PrSFBp col_periphery_1x2_20/COL_LINE0 pixRst[40] pixRst[41]
+ col_periphery_1x2_20/COL_LINE1 OffBn rowReadOFF[62] rowReadOFF[63] openDVS_pixel2x2_bot_999/GndD
+ DiffBn VSUBS OnBn VDD openDVS_pixel2x2_bot
XopenDVS_pixel2x2_bot_1001 openDVS_pixel2x2_bot_1001/vpd[0] openDVS_pixel2x2_bot_1001/vpd[1]
+ openDVS_pixel2x2_bot_1001/vpd[3] openDVS_pixel2x2_bot_1001/vpd[2] rowReadON[62]
+ rowReadON[63] RefrBp PrBp PrSFBp col_periphery_1x2_9/COL_LINE0 pixRst[18] pixRst[19]
+ col_periphery_1x2_9/COL_LINE1 OffBn rowReadOFF[62] rowReadOFF[63] openDVS_pixel2x2_bot_999/GndD
+ DiffBn VSUBS OnBn VDD openDVS_pixel2x2_bot
XopenDVS_pixel2x2_bot_491 openDVS_pixel2x2_bot_491/vpd[0] openDVS_pixel2x2_bot_491/vpd[1]
+ openDVS_pixel2x2_bot_491/vpd[3] openDVS_pixel2x2_bot_491/vpd[2] rowReadON[30] rowReadON[31]
+ RefrBp PrBp PrSFBp col_periphery_1x2_11/COL_LINE0 pixRst[22] pixRst[23] col_periphery_1x2_11/COL_LINE1
+ OffBn rowReadOFF[30] rowReadOFF[31] openDVS_pixel2x2_bot_511/GndD DiffBn VSUBS OnBn
+ VDD openDVS_pixel2x2_bot
XopenDVS_pixel2x2_bot_480 openDVS_pixel2x2_bot_480/vpd[0] openDVS_pixel2x2_bot_480/vpd[1]
+ openDVS_pixel2x2_bot_480/vpd[3] openDVS_pixel2x2_bot_480/vpd[2] rowReadON[30] rowReadON[31]
+ RefrBp PrBp PrSFBp col_periphery_1x2_0/COL_LINE0 pixRst[0] pixRst[1] col_periphery_1x2_0/COL_LINE1
+ OffBn rowReadOFF[30] rowReadOFF[31] openDVS_pixel2x2_bot_511/GndD DiffBn VSUBS OnBn
+ VDD openDVS_pixel2x2_bot
Xcol_periphery_1x2_23 pixRst[47] col_periphery_1x2_23/COL_LINE0 col_periphery_1x2_23/COL_LINE1
+ nDETECT col_periphery_1x2_9/VDD DETECT VTHRESH voutn[46] VSUBS NCHARGE voutn[47]
+ pixRst[46] col_periphery_1x2
Xcol_periphery_1x2_12 pixRst[25] col_periphery_1x2_12/COL_LINE0 col_periphery_1x2_12/COL_LINE1
+ nDETECT col_periphery_1x2_9/VDD DETECT VTHRESH voutn[24] VSUBS NCHARGE voutn[25]
+ pixRst[24] col_periphery_1x2
XopenDVS_pixel2x2_bot_1 openDVS_pixel2x2_bot_1/vpd[0] openDVS_pixel2x2_bot_1/vpd[1]
+ openDVS_pixel2x2_bot_1/vpd[3] openDVS_pixel2x2_bot_1/vpd[2] rowReadON[0] rowReadON[1]
+ RefrBp PrBp PrSFBp col_periphery_1x2_1/COL_LINE0 pixRst[2] pixRst[3] col_periphery_1x2_1/COL_LINE1
+ OffBn rowReadOFF[0] rowReadOFF[1] GND DiffBn VSUBS OnBn VDD openDVS_pixel2x2_bot
XopenDVS_pixel2x2_bot_309 openDVS_pixel2x2_bot_309/vpd[0] openDVS_pixel2x2_bot_309/vpd[1]
+ openDVS_pixel2x2_bot_309/vpd[3] openDVS_pixel2x2_bot_309/vpd[2] rowReadON[18] rowReadON[19]
+ RefrBp PrBp PrSFBp col_periphery_1x2_21/COL_LINE0 pixRst[42] pixRst[43] col_periphery_1x2_21/COL_LINE1
+ OffBn rowReadOFF[18] rowReadOFF[19] openDVS_pixel2x2_bot_319/GndD DiffBn VSUBS OnBn
+ VDD openDVS_pixel2x2_bot
XopenDVS_pixel2x2_bot_887 openDVS_pixel2x2_bot_887/vpd[0] openDVS_pixel2x2_bot_887/vpd[1]
+ openDVS_pixel2x2_bot_887/vpd[3] openDVS_pixel2x2_bot_887/vpd[2] rowReadON[54] rowReadON[55]
+ RefrBp PrBp PrSFBp col_periphery_1x2_23/COL_LINE0 pixRst[46] pixRst[47] col_periphery_1x2_23/COL_LINE1
+ OffBn rowReadOFF[54] rowReadOFF[55] openDVS_pixel2x2_bot_895/GndD DiffBn VSUBS OnBn
+ VDD openDVS_pixel2x2_bot
XopenDVS_pixel2x2_bot_854 openDVS_pixel2x2_bot_854/vpd[0] openDVS_pixel2x2_bot_854/vpd[1]
+ openDVS_pixel2x2_bot_854/vpd[3] openDVS_pixel2x2_bot_854/vpd[2] rowReadON[52] rowReadON[53]
+ RefrBp PrBp PrSFBp col_periphery_1x2_22/COL_LINE0 pixRst[44] pixRst[45] col_periphery_1x2_22/COL_LINE1
+ OffBn rowReadOFF[52] rowReadOFF[53] openDVS_pixel2x2_bot_863/GndD DiffBn VSUBS OnBn
+ VDD openDVS_pixel2x2_bot
XopenDVS_pixel2x2_bot_876 openDVS_pixel2x2_bot_876/vpd[0] openDVS_pixel2x2_bot_876/vpd[1]
+ openDVS_pixel2x2_bot_876/vpd[3] openDVS_pixel2x2_bot_876/vpd[2] rowReadON[54] rowReadON[55]
+ RefrBp PrBp PrSFBp col_periphery_1x2_12/COL_LINE0 pixRst[24] pixRst[25] col_periphery_1x2_12/COL_LINE1
+ OffBn rowReadOFF[54] rowReadOFF[55] openDVS_pixel2x2_bot_895/GndD DiffBn VSUBS OnBn
+ VDD openDVS_pixel2x2_bot
XopenDVS_pixel2x2_bot_843 openDVS_pixel2x2_bot_843/vpd[0] openDVS_pixel2x2_bot_843/vpd[1]
+ openDVS_pixel2x2_bot_843/vpd[3] openDVS_pixel2x2_bot_843/vpd[2] rowReadON[52] rowReadON[53]
+ RefrBp PrBp PrSFBp col_periphery_1x2_11/COL_LINE0 pixRst[22] pixRst[23] col_periphery_1x2_11/COL_LINE1
+ OffBn rowReadOFF[52] rowReadOFF[53] openDVS_pixel2x2_bot_863/GndD DiffBn VSUBS OnBn
+ VDD openDVS_pixel2x2_bot
XopenDVS_pixel2x2_bot_898 openDVS_pixel2x2_bot_898/vpd[0] openDVS_pixel2x2_bot_898/vpd[1]
+ openDVS_pixel2x2_bot_898/vpd[3] openDVS_pixel2x2_bot_898/vpd[2] rowReadON[56] rowReadON[57]
+ RefrBp PrBp PrSFBp col_periphery_1x2_2/COL_LINE0 pixRst[4] pixRst[5] col_periphery_1x2_2/COL_LINE1
+ OffBn rowReadOFF[56] rowReadOFF[57] openDVS_pixel2x2_bot_927/GndD DiffBn VSUBS OnBn
+ VDD openDVS_pixel2x2_bot
XopenDVS_pixel2x2_bot_865 openDVS_pixel2x2_bot_865/vpd[0] openDVS_pixel2x2_bot_865/vpd[1]
+ openDVS_pixel2x2_bot_865/vpd[3] openDVS_pixel2x2_bot_865/vpd[2] rowReadON[54] rowReadON[55]
+ RefrBp PrBp PrSFBp col_periphery_1x2_1/COL_LINE0 pixRst[2] pixRst[3] col_periphery_1x2_1/COL_LINE1
+ OffBn rowReadOFF[54] rowReadOFF[55] openDVS_pixel2x2_bot_895/GndD DiffBn VSUBS OnBn
+ VDD openDVS_pixel2x2_bot
XopenDVS_pixel2x2_bot_832 openDVS_pixel2x2_bot_832/vpd[0] openDVS_pixel2x2_bot_832/vpd[1]
+ openDVS_pixel2x2_bot_832/vpd[3] openDVS_pixel2x2_bot_832/vpd[2] rowReadON[52] rowReadON[53]
+ RefrBp PrBp PrSFBp col_periphery_1x2_0/COL_LINE0 pixRst[0] pixRst[1] col_periphery_1x2_0/COL_LINE1
+ OffBn rowReadOFF[52] rowReadOFF[53] openDVS_pixel2x2_bot_863/GndD DiffBn VSUBS OnBn
+ VDD openDVS_pixel2x2_bot
XopenDVS_pixel2x2_bot_821 openDVS_pixel2x2_bot_821/vpd[0] openDVS_pixel2x2_bot_821/vpd[1]
+ openDVS_pixel2x2_bot_821/vpd[3] openDVS_pixel2x2_bot_821/vpd[2] rowReadON[50] rowReadON[51]
+ RefrBp PrBp PrSFBp col_periphery_1x2_21/COL_LINE0 pixRst[42] pixRst[43] col_periphery_1x2_21/COL_LINE1
+ OffBn rowReadOFF[50] rowReadOFF[51] openDVS_pixel2x2_bot_831/GndD DiffBn VSUBS OnBn
+ VDD openDVS_pixel2x2_bot
XopenDVS_pixel2x2_bot_810 openDVS_pixel2x2_bot_810/vpd[0] openDVS_pixel2x2_bot_810/vpd[1]
+ openDVS_pixel2x2_bot_810/vpd[3] openDVS_pixel2x2_bot_810/vpd[2] rowReadON[50] rowReadON[51]
+ RefrBp PrBp PrSFBp col_periphery_1x2_10/COL_LINE0 pixRst[20] pixRst[21] col_periphery_1x2_10/COL_LINE1
+ OffBn rowReadOFF[50] rowReadOFF[51] openDVS_pixel2x2_bot_831/GndD DiffBn VSUBS OnBn
+ VDD openDVS_pixel2x2_bot
XopenDVS_pixel2x2_bot_128 openDVS_pixel2x2_bot_128/vpd[0] openDVS_pixel2x2_bot_128/vpd[1]
+ openDVS_pixel2x2_bot_128/vpd[3] openDVS_pixel2x2_bot_128/vpd[2] rowReadON[8] rowReadON[9]
+ RefrBp PrBp PrSFBp col_periphery_1x2_0/COL_LINE0 pixRst[0] pixRst[1] col_periphery_1x2_0/COL_LINE1
+ OffBn rowReadOFF[8] rowReadOFF[9] openDVS_pixel2x2_bot_159/GndD DiffBn VSUBS OnBn
+ VDD openDVS_pixel2x2_bot
XopenDVS_pixel2x2_bot_106 openDVS_pixel2x2_bot_106/vpd[0] openDVS_pixel2x2_bot_106/vpd[1]
+ openDVS_pixel2x2_bot_106/vpd[3] openDVS_pixel2x2_bot_106/vpd[2] rowReadON[6] rowReadON[7]
+ RefrBp PrBp PrSFBp col_periphery_1x2_10/COL_LINE0 pixRst[20] pixRst[21] col_periphery_1x2_10/COL_LINE1
+ OffBn rowReadOFF[6] rowReadOFF[7] openDVS_pixel2x2_bot_99/GndD DiffBn VSUBS OnBn
+ VDD openDVS_pixel2x2_bot
XopenDVS_pixel2x2_bot_139 openDVS_pixel2x2_bot_139/vpd[0] openDVS_pixel2x2_bot_139/vpd[1]
+ openDVS_pixel2x2_bot_139/vpd[3] openDVS_pixel2x2_bot_139/vpd[2] rowReadON[8] rowReadON[9]
+ RefrBp PrBp PrSFBp col_periphery_1x2_11/COL_LINE0 pixRst[22] pixRst[23] col_periphery_1x2_11/COL_LINE1
+ OffBn rowReadOFF[8] rowReadOFF[9] openDVS_pixel2x2_bot_159/GndD DiffBn VSUBS OnBn
+ VDD openDVS_pixel2x2_bot
XopenDVS_pixel2x2_bot_117 openDVS_pixel2x2_bot_117/vpd[0] openDVS_pixel2x2_bot_117/vpd[1]
+ openDVS_pixel2x2_bot_117/vpd[3] openDVS_pixel2x2_bot_117/vpd[2] rowReadON[6] rowReadON[7]
+ RefrBp PrBp PrSFBp col_periphery_1x2_21/COL_LINE0 pixRst[42] pixRst[43] col_periphery_1x2_21/COL_LINE1
+ OffBn rowReadOFF[6] rowReadOFF[7] openDVS_pixel2x2_bot_99/GndD DiffBn VSUBS OnBn
+ VDD openDVS_pixel2x2_bot
XopenDVS_pixel2x2_bot_695 openDVS_pixel2x2_bot_695/vpd[0] openDVS_pixel2x2_bot_695/vpd[1]
+ openDVS_pixel2x2_bot_695/vpd[3] openDVS_pixel2x2_bot_695/vpd[2] rowReadON[42] rowReadON[43]
+ RefrBp PrBp PrSFBp col_periphery_1x2_23/COL_LINE0 pixRst[46] pixRst[47] col_periphery_1x2_23/COL_LINE1
+ OffBn rowReadOFF[42] rowReadOFF[43] openDVS_pixel2x2_bot_703/GndD DiffBn VSUBS OnBn
+ VDD openDVS_pixel2x2_bot
XopenDVS_pixel2x2_bot_684 openDVS_pixel2x2_bot_684/vpd[0] openDVS_pixel2x2_bot_684/vpd[1]
+ openDVS_pixel2x2_bot_684/vpd[3] openDVS_pixel2x2_bot_684/vpd[2] rowReadON[42] rowReadON[43]
+ RefrBp PrBp PrSFBp col_periphery_1x2_12/COL_LINE0 pixRst[24] pixRst[25] col_periphery_1x2_12/COL_LINE1
+ OffBn rowReadOFF[42] rowReadOFF[43] openDVS_pixel2x2_bot_703/GndD DiffBn VSUBS OnBn
+ VDD openDVS_pixel2x2_bot
XopenDVS_pixel2x2_bot_673 openDVS_pixel2x2_bot_673/vpd[0] openDVS_pixel2x2_bot_673/vpd[1]
+ openDVS_pixel2x2_bot_673/vpd[3] openDVS_pixel2x2_bot_673/vpd[2] rowReadON[42] rowReadON[43]
+ RefrBp PrBp PrSFBp col_periphery_1x2_1/COL_LINE0 pixRst[2] pixRst[3] col_periphery_1x2_1/COL_LINE1
+ OffBn rowReadOFF[42] rowReadOFF[43] openDVS_pixel2x2_bot_703/GndD DiffBn VSUBS OnBn
+ VDD openDVS_pixel2x2_bot
XopenDVS_pixel2x2_bot_662 openDVS_pixel2x2_bot_662/vpd[0] openDVS_pixel2x2_bot_662/vpd[1]
+ openDVS_pixel2x2_bot_662/vpd[3] openDVS_pixel2x2_bot_662/vpd[2] rowReadON[40] rowReadON[41]
+ RefrBp PrBp PrSFBp col_periphery_1x2_22/COL_LINE0 pixRst[44] pixRst[45] col_periphery_1x2_22/COL_LINE1
+ OffBn rowReadOFF[40] rowReadOFF[41] openDVS_pixel2x2_bot_671/GndD DiffBn VSUBS OnBn
+ VDD openDVS_pixel2x2_bot
XopenDVS_pixel2x2_bot_651 openDVS_pixel2x2_bot_651/vpd[0] openDVS_pixel2x2_bot_651/vpd[1]
+ openDVS_pixel2x2_bot_651/vpd[3] openDVS_pixel2x2_bot_651/vpd[2] rowReadON[40] rowReadON[41]
+ RefrBp PrBp PrSFBp col_periphery_1x2_11/COL_LINE0 pixRst[22] pixRst[23] col_periphery_1x2_11/COL_LINE1
+ OffBn rowReadOFF[40] rowReadOFF[41] openDVS_pixel2x2_bot_671/GndD DiffBn VSUBS OnBn
+ VDD openDVS_pixel2x2_bot
XopenDVS_pixel2x2_bot_640 openDVS_pixel2x2_bot_640/vpd[0] openDVS_pixel2x2_bot_640/vpd[1]
+ openDVS_pixel2x2_bot_640/vpd[3] openDVS_pixel2x2_bot_640/vpd[2] rowReadON[40] rowReadON[41]
+ RefrBp PrBp PrSFBp col_periphery_1x2_0/COL_LINE0 pixRst[0] pixRst[1] col_periphery_1x2_0/COL_LINE1
+ OffBn rowReadOFF[40] rowReadOFF[41] openDVS_pixel2x2_bot_671/GndD DiffBn VSUBS OnBn
+ VDD openDVS_pixel2x2_bot
XopenDVS_pixel2x2_bot_71 openDVS_pixel2x2_bot_71/vpd[0] openDVS_pixel2x2_bot_71/vpd[1]
+ openDVS_pixel2x2_bot_71/vpd[3] openDVS_pixel2x2_bot_71/vpd[2] rowReadON[4] rowReadON[5]
+ RefrBp PrBp PrSFBp col_periphery_1x2_7/COL_LINE0 pixRst[14] pixRst[15] col_periphery_1x2_7/COL_LINE1
+ OffBn rowReadOFF[4] rowReadOFF[5] openDVS_pixel2x2_bot_95/GndD DiffBn VSUBS OnBn
+ VDD openDVS_pixel2x2_bot
XopenDVS_pixel2x2_bot_82 openDVS_pixel2x2_bot_82/vpd[0] openDVS_pixel2x2_bot_82/vpd[1]
+ openDVS_pixel2x2_bot_82/vpd[3] openDVS_pixel2x2_bot_82/vpd[2] rowReadON[4] rowReadON[5]
+ RefrBp PrBp PrSFBp col_periphery_1x2_18/COL_LINE0 pixRst[36] pixRst[37] col_periphery_1x2_18/COL_LINE1
+ OffBn rowReadOFF[4] rowReadOFF[5] openDVS_pixel2x2_bot_95/GndD DiffBn VSUBS OnBn
+ VDD openDVS_pixel2x2_bot
XopenDVS_pixel2x2_bot_60 openDVS_pixel2x2_bot_60/vpd[0] openDVS_pixel2x2_bot_60/vpd[1]
+ openDVS_pixel2x2_bot_60/vpd[3] openDVS_pixel2x2_bot_60/vpd[2] rowReadON[2] rowReadON[3]
+ RefrBp PrBp PrSFBp col_periphery_1x2_28/COL_LINE0 pixRst[56] pixRst[57] col_periphery_1x2_28/COL_LINE1
+ OffBn rowReadOFF[2] rowReadOFF[3] openDVS_pixel2x2_bot_63/GndD DiffBn VSUBS OnBn
+ VDD openDVS_pixel2x2_bot
XopenDVS_pixel2x2_bot_93 openDVS_pixel2x2_bot_93/vpd[0] openDVS_pixel2x2_bot_93/vpd[1]
+ openDVS_pixel2x2_bot_93/vpd[3] openDVS_pixel2x2_bot_93/vpd[2] rowReadON[4] rowReadON[5]
+ RefrBp PrBp PrSFBp col_periphery_1x2_29/COL_LINE0 pixRst[58] pixRst[59] col_periphery_1x2_29/COL_LINE1
+ OffBn rowReadOFF[4] rowReadOFF[5] openDVS_pixel2x2_bot_95/GndD DiffBn VSUBS OnBn
+ VDD openDVS_pixel2x2_bot
XopenDVS_pixel2x2_bot_1013 openDVS_pixel2x2_bot_1013/vpd[0] openDVS_pixel2x2_bot_1013/vpd[1]
+ openDVS_pixel2x2_bot_1013/vpd[3] openDVS_pixel2x2_bot_1013/vpd[2] rowReadON[62]
+ rowReadON[63] RefrBp PrBp PrSFBp col_periphery_1x2_21/COL_LINE0 pixRst[42] pixRst[43]
+ col_periphery_1x2_21/COL_LINE1 OffBn rowReadOFF[62] rowReadOFF[63] openDVS_pixel2x2_bot_999/GndD
+ DiffBn VSUBS OnBn VDD openDVS_pixel2x2_bot
XopenDVS_pixel2x2_bot_1002 openDVS_pixel2x2_bot_1002/vpd[0] openDVS_pixel2x2_bot_1002/vpd[1]
+ openDVS_pixel2x2_bot_1002/vpd[3] openDVS_pixel2x2_bot_1002/vpd[2] rowReadON[62]
+ rowReadON[63] RefrBp PrBp PrSFBp col_periphery_1x2_10/COL_LINE0 pixRst[20] pixRst[21]
+ col_periphery_1x2_10/COL_LINE1 OffBn rowReadOFF[62] rowReadOFF[63] openDVS_pixel2x2_bot_999/GndD
+ DiffBn VSUBS OnBn VDD openDVS_pixel2x2_bot
XopenDVS_pixel2x2_bot_470 openDVS_pixel2x2_bot_470/vpd[0] openDVS_pixel2x2_bot_470/vpd[1]
+ openDVS_pixel2x2_bot_470/vpd[3] openDVS_pixel2x2_bot_470/vpd[2] rowReadON[28] rowReadON[29]
+ RefrBp PrBp PrSFBp col_periphery_1x2_22/COL_LINE0 pixRst[44] pixRst[45] col_periphery_1x2_22/COL_LINE1
+ OffBn rowReadOFF[28] rowReadOFF[29] openDVS_pixel2x2_bot_479/GndD DiffBn VSUBS OnBn
+ VDD openDVS_pixel2x2_bot
XopenDVS_pixel2x2_bot_492 openDVS_pixel2x2_bot_492/vpd[0] openDVS_pixel2x2_bot_492/vpd[1]
+ openDVS_pixel2x2_bot_492/vpd[3] openDVS_pixel2x2_bot_492/vpd[2] rowReadON[30] rowReadON[31]
+ RefrBp PrBp PrSFBp col_periphery_1x2_12/COL_LINE0 pixRst[24] pixRst[25] col_periphery_1x2_12/COL_LINE1
+ OffBn rowReadOFF[30] rowReadOFF[31] openDVS_pixel2x2_bot_511/GndD DiffBn VSUBS OnBn
+ VDD openDVS_pixel2x2_bot
XopenDVS_pixel2x2_bot_481 openDVS_pixel2x2_bot_481/vpd[0] openDVS_pixel2x2_bot_481/vpd[1]
+ openDVS_pixel2x2_bot_481/vpd[3] openDVS_pixel2x2_bot_481/vpd[2] rowReadON[30] rowReadON[31]
+ RefrBp PrBp PrSFBp col_periphery_1x2_1/COL_LINE0 pixRst[2] pixRst[3] col_periphery_1x2_1/COL_LINE1
+ OffBn rowReadOFF[30] rowReadOFF[31] openDVS_pixel2x2_bot_511/GndD DiffBn VSUBS OnBn
+ VDD openDVS_pixel2x2_bot
Xcol_periphery_1x2_24 pixRst[49] col_periphery_1x2_24/COL_LINE0 col_periphery_1x2_24/COL_LINE1
+ nDETECT col_periphery_1x2_9/VDD DETECT VTHRESH voutn[48] VSUBS NCHARGE voutn[49]
+ pixRst[48] col_periphery_1x2
Xcol_periphery_1x2_13 pixRst[27] col_periphery_1x2_13/COL_LINE0 col_periphery_1x2_13/COL_LINE1
+ nDETECT col_periphery_1x2_9/VDD DETECT VTHRESH voutn[26] VSUBS NCHARGE voutn[27]
+ pixRst[26] col_periphery_1x2
XopenDVS_pixel2x2_bot_2 openDVS_pixel2x2_bot_2/vpd[0] openDVS_pixel2x2_bot_2/vpd[1]
+ openDVS_pixel2x2_bot_2/vpd[3] openDVS_pixel2x2_bot_2/vpd[2] rowReadON[0] rowReadON[1]
+ RefrBp PrBp PrSFBp col_periphery_1x2_2/COL_LINE0 pixRst[4] pixRst[5] col_periphery_1x2_2/COL_LINE1
+ OffBn rowReadOFF[0] rowReadOFF[1] GND DiffBn VSUBS OnBn VDD openDVS_pixel2x2_bot
XopenDVS_pixel2x2_bot_888 openDVS_pixel2x2_bot_888/vpd[0] openDVS_pixel2x2_bot_888/vpd[1]
+ openDVS_pixel2x2_bot_888/vpd[3] openDVS_pixel2x2_bot_888/vpd[2] rowReadON[54] rowReadON[55]
+ RefrBp PrBp PrSFBp col_periphery_1x2_24/COL_LINE0 pixRst[48] pixRst[49] col_periphery_1x2_24/COL_LINE1
+ OffBn rowReadOFF[54] rowReadOFF[55] openDVS_pixel2x2_bot_895/GndD DiffBn VSUBS OnBn
+ VDD openDVS_pixel2x2_bot
XopenDVS_pixel2x2_bot_855 openDVS_pixel2x2_bot_855/vpd[0] openDVS_pixel2x2_bot_855/vpd[1]
+ openDVS_pixel2x2_bot_855/vpd[3] openDVS_pixel2x2_bot_855/vpd[2] rowReadON[52] rowReadON[53]
+ RefrBp PrBp PrSFBp col_periphery_1x2_23/COL_LINE0 pixRst[46] pixRst[47] col_periphery_1x2_23/COL_LINE1
+ OffBn rowReadOFF[52] rowReadOFF[53] openDVS_pixel2x2_bot_863/GndD DiffBn VSUBS OnBn
+ VDD openDVS_pixel2x2_bot
XopenDVS_pixel2x2_bot_877 openDVS_pixel2x2_bot_877/vpd[0] openDVS_pixel2x2_bot_877/vpd[1]
+ openDVS_pixel2x2_bot_877/vpd[3] openDVS_pixel2x2_bot_877/vpd[2] rowReadON[54] rowReadON[55]
+ RefrBp PrBp PrSFBp col_periphery_1x2_13/COL_LINE0 pixRst[26] pixRst[27] col_periphery_1x2_13/COL_LINE1
+ OffBn rowReadOFF[54] rowReadOFF[55] openDVS_pixel2x2_bot_895/GndD DiffBn VSUBS OnBn
+ VDD openDVS_pixel2x2_bot
XopenDVS_pixel2x2_bot_844 openDVS_pixel2x2_bot_844/vpd[0] openDVS_pixel2x2_bot_844/vpd[1]
+ openDVS_pixel2x2_bot_844/vpd[3] openDVS_pixel2x2_bot_844/vpd[2] rowReadON[52] rowReadON[53]
+ RefrBp PrBp PrSFBp col_periphery_1x2_12/COL_LINE0 pixRst[24] pixRst[25] col_periphery_1x2_12/COL_LINE1
+ OffBn rowReadOFF[52] rowReadOFF[53] openDVS_pixel2x2_bot_863/GndD DiffBn VSUBS OnBn
+ VDD openDVS_pixel2x2_bot
XopenDVS_pixel2x2_bot_899 openDVS_pixel2x2_bot_899/vpd[0] openDVS_pixel2x2_bot_899/vpd[1]
+ openDVS_pixel2x2_bot_899/vpd[3] openDVS_pixel2x2_bot_899/vpd[2] rowReadON[56] rowReadON[57]
+ RefrBp PrBp PrSFBp col_periphery_1x2_3/COL_LINE0 pixRst[6] pixRst[7] col_periphery_1x2_3/COL_LINE1
+ OffBn rowReadOFF[56] rowReadOFF[57] openDVS_pixel2x2_bot_927/GndD DiffBn VSUBS OnBn
+ VDD openDVS_pixel2x2_bot
XopenDVS_pixel2x2_bot_866 openDVS_pixel2x2_bot_866/vpd[0] openDVS_pixel2x2_bot_866/vpd[1]
+ openDVS_pixel2x2_bot_866/vpd[3] openDVS_pixel2x2_bot_866/vpd[2] rowReadON[54] rowReadON[55]
+ RefrBp PrBp PrSFBp col_periphery_1x2_2/COL_LINE0 pixRst[4] pixRst[5] col_periphery_1x2_2/COL_LINE1
+ OffBn rowReadOFF[54] rowReadOFF[55] openDVS_pixel2x2_bot_895/GndD DiffBn VSUBS OnBn
+ VDD openDVS_pixel2x2_bot
XopenDVS_pixel2x2_bot_833 openDVS_pixel2x2_bot_833/vpd[0] openDVS_pixel2x2_bot_833/vpd[1]
+ openDVS_pixel2x2_bot_833/vpd[3] openDVS_pixel2x2_bot_833/vpd[2] rowReadON[52] rowReadON[53]
+ RefrBp PrBp PrSFBp col_periphery_1x2_1/COL_LINE0 pixRst[2] pixRst[3] col_periphery_1x2_1/COL_LINE1
+ OffBn rowReadOFF[52] rowReadOFF[53] openDVS_pixel2x2_bot_863/GndD DiffBn VSUBS OnBn
+ VDD openDVS_pixel2x2_bot
XopenDVS_pixel2x2_bot_822 openDVS_pixel2x2_bot_822/vpd[0] openDVS_pixel2x2_bot_822/vpd[1]
+ openDVS_pixel2x2_bot_822/vpd[3] openDVS_pixel2x2_bot_822/vpd[2] rowReadON[50] rowReadON[51]
+ RefrBp PrBp PrSFBp col_periphery_1x2_22/COL_LINE0 pixRst[44] pixRst[45] col_periphery_1x2_22/COL_LINE1
+ OffBn rowReadOFF[50] rowReadOFF[51] openDVS_pixel2x2_bot_831/GndD DiffBn VSUBS OnBn
+ VDD openDVS_pixel2x2_bot
XopenDVS_pixel2x2_bot_811 openDVS_pixel2x2_bot_811/vpd[0] openDVS_pixel2x2_bot_811/vpd[1]
+ openDVS_pixel2x2_bot_811/vpd[3] openDVS_pixel2x2_bot_811/vpd[2] rowReadON[50] rowReadON[51]
+ RefrBp PrBp PrSFBp col_periphery_1x2_11/COL_LINE0 pixRst[22] pixRst[23] col_periphery_1x2_11/COL_LINE1
+ OffBn rowReadOFF[50] rowReadOFF[51] openDVS_pixel2x2_bot_831/GndD DiffBn VSUBS OnBn
+ VDD openDVS_pixel2x2_bot
XopenDVS_pixel2x2_bot_800 openDVS_pixel2x2_bot_800/vpd[0] openDVS_pixel2x2_bot_800/vpd[1]
+ openDVS_pixel2x2_bot_800/vpd[3] openDVS_pixel2x2_bot_800/vpd[2] rowReadON[50] rowReadON[51]
+ RefrBp PrBp PrSFBp col_periphery_1x2_0/COL_LINE0 pixRst[0] pixRst[1] col_periphery_1x2_0/COL_LINE1
+ OffBn rowReadOFF[50] rowReadOFF[51] openDVS_pixel2x2_bot_831/GndD DiffBn VSUBS OnBn
+ VDD openDVS_pixel2x2_bot
XopenDVS_pixel2x2_bot_630 openDVS_pixel2x2_bot_630/vpd[0] openDVS_pixel2x2_bot_630/vpd[1]
+ openDVS_pixel2x2_bot_630/vpd[3] openDVS_pixel2x2_bot_630/vpd[2] rowReadON[38] rowReadON[39]
+ RefrBp PrBp PrSFBp col_periphery_1x2_22/COL_LINE0 pixRst[44] pixRst[45] col_periphery_1x2_22/COL_LINE1
+ OffBn rowReadOFF[38] rowReadOFF[39] openDVS_pixel2x2_bot_639/GndD DiffBn VSUBS OnBn
+ VDD openDVS_pixel2x2_bot
XopenDVS_pixel2x2_bot_641 openDVS_pixel2x2_bot_641/vpd[0] openDVS_pixel2x2_bot_641/vpd[1]
+ openDVS_pixel2x2_bot_641/vpd[3] openDVS_pixel2x2_bot_641/vpd[2] rowReadON[40] rowReadON[41]
+ RefrBp PrBp PrSFBp col_periphery_1x2_1/COL_LINE0 pixRst[2] pixRst[3] col_periphery_1x2_1/COL_LINE1
+ OffBn rowReadOFF[40] rowReadOFF[41] openDVS_pixel2x2_bot_671/GndD DiffBn VSUBS OnBn
+ VDD openDVS_pixel2x2_bot
XopenDVS_pixel2x2_bot_129 openDVS_pixel2x2_bot_129/vpd[0] openDVS_pixel2x2_bot_129/vpd[1]
+ openDVS_pixel2x2_bot_129/vpd[3] openDVS_pixel2x2_bot_129/vpd[2] rowReadON[8] rowReadON[9]
+ RefrBp PrBp PrSFBp col_periphery_1x2_1/COL_LINE0 pixRst[2] pixRst[3] col_periphery_1x2_1/COL_LINE1
+ OffBn rowReadOFF[8] rowReadOFF[9] openDVS_pixel2x2_bot_159/GndD DiffBn VSUBS OnBn
+ VDD openDVS_pixel2x2_bot
XopenDVS_pixel2x2_bot_107 openDVS_pixel2x2_bot_107/vpd[0] openDVS_pixel2x2_bot_107/vpd[1]
+ openDVS_pixel2x2_bot_107/vpd[3] openDVS_pixel2x2_bot_107/vpd[2] rowReadON[6] rowReadON[7]
+ RefrBp PrBp PrSFBp col_periphery_1x2_11/COL_LINE0 pixRst[22] pixRst[23] col_periphery_1x2_11/COL_LINE1
+ OffBn rowReadOFF[6] rowReadOFF[7] openDVS_pixel2x2_bot_99/GndD DiffBn VSUBS OnBn
+ VDD openDVS_pixel2x2_bot
XopenDVS_pixel2x2_bot_118 openDVS_pixel2x2_bot_118/vpd[0] openDVS_pixel2x2_bot_118/vpd[1]
+ openDVS_pixel2x2_bot_118/vpd[3] openDVS_pixel2x2_bot_118/vpd[2] rowReadON[6] rowReadON[7]
+ RefrBp PrBp PrSFBp col_periphery_1x2_22/COL_LINE0 pixRst[44] pixRst[45] col_periphery_1x2_22/COL_LINE1
+ OffBn rowReadOFF[6] rowReadOFF[7] openDVS_pixel2x2_bot_99/GndD DiffBn VSUBS OnBn
+ VDD openDVS_pixel2x2_bot
XopenDVS_pixel2x2_bot_696 openDVS_pixel2x2_bot_696/vpd[0] openDVS_pixel2x2_bot_696/vpd[1]
+ openDVS_pixel2x2_bot_696/vpd[3] openDVS_pixel2x2_bot_696/vpd[2] rowReadON[42] rowReadON[43]
+ RefrBp PrBp PrSFBp col_periphery_1x2_24/COL_LINE0 pixRst[48] pixRst[49] col_periphery_1x2_24/COL_LINE1
+ OffBn rowReadOFF[42] rowReadOFF[43] openDVS_pixel2x2_bot_703/GndD DiffBn VSUBS OnBn
+ VDD openDVS_pixel2x2_bot
XopenDVS_pixel2x2_bot_685 openDVS_pixel2x2_bot_685/vpd[0] openDVS_pixel2x2_bot_685/vpd[1]
+ openDVS_pixel2x2_bot_685/vpd[3] openDVS_pixel2x2_bot_685/vpd[2] rowReadON[42] rowReadON[43]
+ RefrBp PrBp PrSFBp col_periphery_1x2_13/COL_LINE0 pixRst[26] pixRst[27] col_periphery_1x2_13/COL_LINE1
+ OffBn rowReadOFF[42] rowReadOFF[43] openDVS_pixel2x2_bot_703/GndD DiffBn VSUBS OnBn
+ VDD openDVS_pixel2x2_bot
XopenDVS_pixel2x2_bot_674 openDVS_pixel2x2_bot_674/vpd[0] openDVS_pixel2x2_bot_674/vpd[1]
+ openDVS_pixel2x2_bot_674/vpd[3] openDVS_pixel2x2_bot_674/vpd[2] rowReadON[42] rowReadON[43]
+ RefrBp PrBp PrSFBp col_periphery_1x2_2/COL_LINE0 pixRst[4] pixRst[5] col_periphery_1x2_2/COL_LINE1
+ OffBn rowReadOFF[42] rowReadOFF[43] openDVS_pixel2x2_bot_703/GndD DiffBn VSUBS OnBn
+ VDD openDVS_pixel2x2_bot
XopenDVS_pixel2x2_bot_663 openDVS_pixel2x2_bot_663/vpd[0] openDVS_pixel2x2_bot_663/vpd[1]
+ openDVS_pixel2x2_bot_663/vpd[3] openDVS_pixel2x2_bot_663/vpd[2] rowReadON[40] rowReadON[41]
+ RefrBp PrBp PrSFBp col_periphery_1x2_23/COL_LINE0 pixRst[46] pixRst[47] col_periphery_1x2_23/COL_LINE1
+ OffBn rowReadOFF[40] rowReadOFF[41] openDVS_pixel2x2_bot_671/GndD DiffBn VSUBS OnBn
+ VDD openDVS_pixel2x2_bot
XopenDVS_pixel2x2_bot_652 openDVS_pixel2x2_bot_652/vpd[0] openDVS_pixel2x2_bot_652/vpd[1]
+ openDVS_pixel2x2_bot_652/vpd[3] openDVS_pixel2x2_bot_652/vpd[2] rowReadON[40] rowReadON[41]
+ RefrBp PrBp PrSFBp col_periphery_1x2_12/COL_LINE0 pixRst[24] pixRst[25] col_periphery_1x2_12/COL_LINE1
+ OffBn rowReadOFF[40] rowReadOFF[41] openDVS_pixel2x2_bot_671/GndD DiffBn VSUBS OnBn
+ VDD openDVS_pixel2x2_bot
XopenDVS_pixel2x2_bot_72 openDVS_pixel2x2_bot_72/vpd[0] openDVS_pixel2x2_bot_72/vpd[1]
+ openDVS_pixel2x2_bot_72/vpd[3] openDVS_pixel2x2_bot_72/vpd[2] rowReadON[4] rowReadON[5]
+ RefrBp PrBp PrSFBp col_periphery_1x2_8/COL_LINE0 pixRst[16] pixRst[17] col_periphery_1x2_8/COL_LINE1
+ OffBn rowReadOFF[4] rowReadOFF[5] openDVS_pixel2x2_bot_95/GndD DiffBn VSUBS OnBn
+ VDD openDVS_pixel2x2_bot
XopenDVS_pixel2x2_bot_50 openDVS_pixel2x2_bot_50/vpd[0] openDVS_pixel2x2_bot_50/vpd[1]
+ openDVS_pixel2x2_bot_50/vpd[3] openDVS_pixel2x2_bot_50/vpd[2] rowReadON[2] rowReadON[3]
+ RefrBp PrBp PrSFBp col_periphery_1x2_18/COL_LINE0 pixRst[36] pixRst[37] col_periphery_1x2_18/COL_LINE1
+ OffBn rowReadOFF[2] rowReadOFF[3] openDVS_pixel2x2_bot_63/GndD DiffBn VSUBS OnBn
+ VDD openDVS_pixel2x2_bot
XopenDVS_pixel2x2_bot_83 openDVS_pixel2x2_bot_83/vpd[0] openDVS_pixel2x2_bot_83/vpd[1]
+ openDVS_pixel2x2_bot_83/vpd[3] openDVS_pixel2x2_bot_83/vpd[2] rowReadON[4] rowReadON[5]
+ RefrBp PrBp PrSFBp col_periphery_1x2_19/COL_LINE0 pixRst[38] pixRst[39] col_periphery_1x2_19/COL_LINE1
+ OffBn rowReadOFF[4] rowReadOFF[5] openDVS_pixel2x2_bot_95/GndD DiffBn VSUBS OnBn
+ VDD openDVS_pixel2x2_bot
XopenDVS_pixel2x2_bot_61 openDVS_pixel2x2_bot_61/vpd[0] openDVS_pixel2x2_bot_61/vpd[1]
+ openDVS_pixel2x2_bot_61/vpd[3] openDVS_pixel2x2_bot_61/vpd[2] rowReadON[2] rowReadON[3]
+ RefrBp PrBp PrSFBp col_periphery_1x2_29/COL_LINE0 pixRst[58] pixRst[59] col_periphery_1x2_29/COL_LINE1
+ OffBn rowReadOFF[2] rowReadOFF[3] openDVS_pixel2x2_bot_63/GndD DiffBn VSUBS OnBn
+ VDD openDVS_pixel2x2_bot
XopenDVS_pixel2x2_bot_94 openDVS_pixel2x2_bot_94/vpd[0] openDVS_pixel2x2_bot_94/vpd[1]
+ openDVS_pixel2x2_bot_94/vpd[3] openDVS_pixel2x2_bot_94/vpd[2] rowReadON[4] rowReadON[5]
+ RefrBp PrBp PrSFBp col_periphery_1x2_30/COL_LINE0 pixRst[60] pixRst[61] col_periphery_1x2_30/COL_LINE1
+ OffBn rowReadOFF[4] rowReadOFF[5] openDVS_pixel2x2_bot_95/GndD DiffBn VSUBS OnBn
+ VDD openDVS_pixel2x2_bot
XopenDVS_pixel2x2_bot_1014 openDVS_pixel2x2_bot_1014/vpd[0] openDVS_pixel2x2_bot_1014/vpd[1]
+ openDVS_pixel2x2_bot_1014/vpd[3] openDVS_pixel2x2_bot_1014/vpd[2] rowReadON[62]
+ rowReadON[63] RefrBp PrBp PrSFBp col_periphery_1x2_22/COL_LINE0 pixRst[44] pixRst[45]
+ col_periphery_1x2_22/COL_LINE1 OffBn rowReadOFF[62] rowReadOFF[63] openDVS_pixel2x2_bot_999/GndD
+ DiffBn VSUBS OnBn VDD openDVS_pixel2x2_bot
XopenDVS_pixel2x2_bot_1003 openDVS_pixel2x2_bot_1003/vpd[0] openDVS_pixel2x2_bot_1003/vpd[1]
+ openDVS_pixel2x2_bot_1003/vpd[3] openDVS_pixel2x2_bot_1003/vpd[2] rowReadON[62]
+ rowReadON[63] RefrBp PrBp PrSFBp col_periphery_1x2_11/COL_LINE0 pixRst[22] pixRst[23]
+ col_periphery_1x2_11/COL_LINE1 OffBn rowReadOFF[62] rowReadOFF[63] openDVS_pixel2x2_bot_999/GndD
+ DiffBn VSUBS OnBn VDD openDVS_pixel2x2_bot
XopenDVS_pixel2x2_bot_471 openDVS_pixel2x2_bot_471/vpd[0] openDVS_pixel2x2_bot_471/vpd[1]
+ openDVS_pixel2x2_bot_471/vpd[3] openDVS_pixel2x2_bot_471/vpd[2] rowReadON[28] rowReadON[29]
+ RefrBp PrBp PrSFBp col_periphery_1x2_23/COL_LINE0 pixRst[46] pixRst[47] col_periphery_1x2_23/COL_LINE1
+ OffBn rowReadOFF[28] rowReadOFF[29] openDVS_pixel2x2_bot_479/GndD DiffBn VSUBS OnBn
+ VDD openDVS_pixel2x2_bot
XopenDVS_pixel2x2_bot_493 openDVS_pixel2x2_bot_493/vpd[0] openDVS_pixel2x2_bot_493/vpd[1]
+ openDVS_pixel2x2_bot_493/vpd[3] openDVS_pixel2x2_bot_493/vpd[2] rowReadON[30] rowReadON[31]
+ RefrBp PrBp PrSFBp col_periphery_1x2_13/COL_LINE0 pixRst[26] pixRst[27] col_periphery_1x2_13/COL_LINE1
+ OffBn rowReadOFF[30] rowReadOFF[31] openDVS_pixel2x2_bot_511/GndD DiffBn VSUBS OnBn
+ VDD openDVS_pixel2x2_bot
XopenDVS_pixel2x2_bot_460 openDVS_pixel2x2_bot_460/vpd[0] openDVS_pixel2x2_bot_460/vpd[1]
+ openDVS_pixel2x2_bot_460/vpd[3] openDVS_pixel2x2_bot_460/vpd[2] rowReadON[28] rowReadON[29]
+ RefrBp PrBp PrSFBp col_periphery_1x2_12/COL_LINE0 pixRst[24] pixRst[25] col_periphery_1x2_12/COL_LINE1
+ OffBn rowReadOFF[28] rowReadOFF[29] openDVS_pixel2x2_bot_479/GndD DiffBn VSUBS OnBn
+ VDD openDVS_pixel2x2_bot
XopenDVS_pixel2x2_bot_482 openDVS_pixel2x2_bot_482/vpd[0] openDVS_pixel2x2_bot_482/vpd[1]
+ openDVS_pixel2x2_bot_482/vpd[3] openDVS_pixel2x2_bot_482/vpd[2] rowReadON[30] rowReadON[31]
+ RefrBp PrBp PrSFBp col_periphery_1x2_2/COL_LINE0 pixRst[4] pixRst[5] col_periphery_1x2_2/COL_LINE1
+ OffBn rowReadOFF[30] rowReadOFF[31] openDVS_pixel2x2_bot_511/GndD DiffBn VSUBS OnBn
+ VDD openDVS_pixel2x2_bot
XopenDVS_pixel2x2_bot_290 openDVS_pixel2x2_bot_290/vpd[0] openDVS_pixel2x2_bot_290/vpd[1]
+ openDVS_pixel2x2_bot_290/vpd[3] openDVS_pixel2x2_bot_290/vpd[2] rowReadON[18] rowReadON[19]
+ RefrBp PrBp PrSFBp col_periphery_1x2_2/COL_LINE0 pixRst[4] pixRst[5] col_periphery_1x2_2/COL_LINE1
+ OffBn rowReadOFF[18] rowReadOFF[19] openDVS_pixel2x2_bot_319/GndD DiffBn VSUBS OnBn
+ VDD openDVS_pixel2x2_bot
Xcol_periphery_1x2_25 pixRst[51] col_periphery_1x2_25/COL_LINE0 col_periphery_1x2_25/COL_LINE1
+ nDETECT col_periphery_1x2_9/VDD DETECT VTHRESH voutn[50] VSUBS NCHARGE voutn[51]
+ pixRst[50] col_periphery_1x2
Xcol_periphery_1x2_14 pixRst[29] col_periphery_1x2_14/COL_LINE0 col_periphery_1x2_14/COL_LINE1
+ nDETECT col_periphery_1x2_9/VDD DETECT VTHRESH voutn[28] VSUBS NCHARGE voutn[29]
+ pixRst[28] col_periphery_1x2
XopenDVS_pixel2x2_bot_3 openDVS_pixel2x2_bot_3/vpd[0] openDVS_pixel2x2_bot_3/vpd[1]
+ openDVS_pixel2x2_bot_3/vpd[3] openDVS_pixel2x2_bot_3/vpd[2] rowReadON[0] rowReadON[1]
+ RefrBp PrBp PrSFBp col_periphery_1x2_3/COL_LINE0 pixRst[6] pixRst[7] col_periphery_1x2_3/COL_LINE1
+ OffBn rowReadOFF[0] rowReadOFF[1] GND DiffBn VSUBS OnBn VDD openDVS_pixel2x2_bot
XopenDVS_pixel2x2_bot_889 openDVS_pixel2x2_bot_889/vpd[0] openDVS_pixel2x2_bot_889/vpd[1]
+ openDVS_pixel2x2_bot_889/vpd[3] openDVS_pixel2x2_bot_889/vpd[2] rowReadON[54] rowReadON[55]
+ RefrBp PrBp PrSFBp col_periphery_1x2_25/COL_LINE0 pixRst[50] pixRst[51] col_periphery_1x2_25/COL_LINE1
+ OffBn rowReadOFF[54] rowReadOFF[55] openDVS_pixel2x2_bot_895/GndD DiffBn VSUBS OnBn
+ VDD openDVS_pixel2x2_bot
XopenDVS_pixel2x2_bot_856 openDVS_pixel2x2_bot_856/vpd[0] openDVS_pixel2x2_bot_856/vpd[1]
+ openDVS_pixel2x2_bot_856/vpd[3] openDVS_pixel2x2_bot_856/vpd[2] rowReadON[52] rowReadON[53]
+ RefrBp PrBp PrSFBp col_periphery_1x2_24/COL_LINE0 pixRst[48] pixRst[49] col_periphery_1x2_24/COL_LINE1
+ OffBn rowReadOFF[52] rowReadOFF[53] openDVS_pixel2x2_bot_863/GndD DiffBn VSUBS OnBn
+ VDD openDVS_pixel2x2_bot
XopenDVS_pixel2x2_bot_878 openDVS_pixel2x2_bot_878/vpd[0] openDVS_pixel2x2_bot_878/vpd[1]
+ openDVS_pixel2x2_bot_878/vpd[3] openDVS_pixel2x2_bot_878/vpd[2] rowReadON[54] rowReadON[55]
+ RefrBp PrBp PrSFBp col_periphery_1x2_14/COL_LINE0 pixRst[28] pixRst[29] col_periphery_1x2_14/COL_LINE1
+ OffBn rowReadOFF[54] rowReadOFF[55] openDVS_pixel2x2_bot_895/GndD DiffBn VSUBS OnBn
+ VDD openDVS_pixel2x2_bot
XopenDVS_pixel2x2_bot_845 openDVS_pixel2x2_bot_845/vpd[0] openDVS_pixel2x2_bot_845/vpd[1]
+ openDVS_pixel2x2_bot_845/vpd[3] openDVS_pixel2x2_bot_845/vpd[2] rowReadON[52] rowReadON[53]
+ RefrBp PrBp PrSFBp col_periphery_1x2_13/COL_LINE0 pixRst[26] pixRst[27] col_periphery_1x2_13/COL_LINE1
+ OffBn rowReadOFF[52] rowReadOFF[53] openDVS_pixel2x2_bot_863/GndD DiffBn VSUBS OnBn
+ VDD openDVS_pixel2x2_bot
XopenDVS_pixel2x2_bot_867 openDVS_pixel2x2_bot_867/vpd[0] openDVS_pixel2x2_bot_867/vpd[1]
+ openDVS_pixel2x2_bot_867/vpd[3] openDVS_pixel2x2_bot_867/vpd[2] rowReadON[54] rowReadON[55]
+ RefrBp PrBp PrSFBp col_periphery_1x2_3/COL_LINE0 pixRst[6] pixRst[7] col_periphery_1x2_3/COL_LINE1
+ OffBn rowReadOFF[54] rowReadOFF[55] openDVS_pixel2x2_bot_895/GndD DiffBn VSUBS OnBn
+ VDD openDVS_pixel2x2_bot
XopenDVS_pixel2x2_bot_834 openDVS_pixel2x2_bot_834/vpd[0] openDVS_pixel2x2_bot_834/vpd[1]
+ openDVS_pixel2x2_bot_834/vpd[3] openDVS_pixel2x2_bot_834/vpd[2] rowReadON[52] rowReadON[53]
+ RefrBp PrBp PrSFBp col_periphery_1x2_2/COL_LINE0 pixRst[4] pixRst[5] col_periphery_1x2_2/COL_LINE1
+ OffBn rowReadOFF[52] rowReadOFF[53] openDVS_pixel2x2_bot_863/GndD DiffBn VSUBS OnBn
+ VDD openDVS_pixel2x2_bot
XopenDVS_pixel2x2_bot_823 openDVS_pixel2x2_bot_823/vpd[0] openDVS_pixel2x2_bot_823/vpd[1]
+ openDVS_pixel2x2_bot_823/vpd[3] openDVS_pixel2x2_bot_823/vpd[2] rowReadON[50] rowReadON[51]
+ RefrBp PrBp PrSFBp col_periphery_1x2_23/COL_LINE0 pixRst[46] pixRst[47] col_periphery_1x2_23/COL_LINE1
+ OffBn rowReadOFF[50] rowReadOFF[51] openDVS_pixel2x2_bot_831/GndD DiffBn VSUBS OnBn
+ VDD openDVS_pixel2x2_bot
XopenDVS_pixel2x2_bot_812 openDVS_pixel2x2_bot_812/vpd[0] openDVS_pixel2x2_bot_812/vpd[1]
+ openDVS_pixel2x2_bot_812/vpd[3] openDVS_pixel2x2_bot_812/vpd[2] rowReadON[50] rowReadON[51]
+ RefrBp PrBp PrSFBp col_periphery_1x2_12/COL_LINE0 pixRst[24] pixRst[25] col_periphery_1x2_12/COL_LINE1
+ OffBn rowReadOFF[50] rowReadOFF[51] openDVS_pixel2x2_bot_831/GndD DiffBn VSUBS OnBn
+ VDD openDVS_pixel2x2_bot
XopenDVS_pixel2x2_bot_801 openDVS_pixel2x2_bot_801/vpd[0] openDVS_pixel2x2_bot_801/vpd[1]
+ openDVS_pixel2x2_bot_801/vpd[3] openDVS_pixel2x2_bot_801/vpd[2] rowReadON[50] rowReadON[51]
+ RefrBp PrBp PrSFBp col_periphery_1x2_1/COL_LINE0 pixRst[2] pixRst[3] col_periphery_1x2_1/COL_LINE1
+ OffBn rowReadOFF[50] rowReadOFF[51] openDVS_pixel2x2_bot_831/GndD DiffBn VSUBS OnBn
+ VDD openDVS_pixel2x2_bot
XopenDVS_pixel2x2_bot_108 openDVS_pixel2x2_bot_108/vpd[0] openDVS_pixel2x2_bot_108/vpd[1]
+ openDVS_pixel2x2_bot_108/vpd[3] openDVS_pixel2x2_bot_108/vpd[2] rowReadON[6] rowReadON[7]
+ RefrBp PrBp PrSFBp col_periphery_1x2_12/COL_LINE0 pixRst[24] pixRst[25] col_periphery_1x2_12/COL_LINE1
+ OffBn rowReadOFF[6] rowReadOFF[7] openDVS_pixel2x2_bot_99/GndD DiffBn VSUBS OnBn
+ VDD openDVS_pixel2x2_bot
XopenDVS_pixel2x2_bot_119 openDVS_pixel2x2_bot_119/vpd[0] openDVS_pixel2x2_bot_119/vpd[1]
+ openDVS_pixel2x2_bot_119/vpd[3] openDVS_pixel2x2_bot_119/vpd[2] rowReadON[6] rowReadON[7]
+ RefrBp PrBp PrSFBp col_periphery_1x2_23/COL_LINE0 pixRst[46] pixRst[47] col_periphery_1x2_23/COL_LINE1
+ OffBn rowReadOFF[6] rowReadOFF[7] openDVS_pixel2x2_bot_99/GndD DiffBn VSUBS OnBn
+ VDD openDVS_pixel2x2_bot
XopenDVS_pixel2x2_bot_697 openDVS_pixel2x2_bot_697/vpd[0] openDVS_pixel2x2_bot_697/vpd[1]
+ openDVS_pixel2x2_bot_697/vpd[3] openDVS_pixel2x2_bot_697/vpd[2] rowReadON[42] rowReadON[43]
+ RefrBp PrBp PrSFBp col_periphery_1x2_25/COL_LINE0 pixRst[50] pixRst[51] col_periphery_1x2_25/COL_LINE1
+ OffBn rowReadOFF[42] rowReadOFF[43] openDVS_pixel2x2_bot_703/GndD DiffBn VSUBS OnBn
+ VDD openDVS_pixel2x2_bot
XopenDVS_pixel2x2_bot_686 openDVS_pixel2x2_bot_686/vpd[0] openDVS_pixel2x2_bot_686/vpd[1]
+ openDVS_pixel2x2_bot_686/vpd[3] openDVS_pixel2x2_bot_686/vpd[2] rowReadON[42] rowReadON[43]
+ RefrBp PrBp PrSFBp col_periphery_1x2_14/COL_LINE0 pixRst[28] pixRst[29] col_periphery_1x2_14/COL_LINE1
+ OffBn rowReadOFF[42] rowReadOFF[43] openDVS_pixel2x2_bot_703/GndD DiffBn VSUBS OnBn
+ VDD openDVS_pixel2x2_bot
XopenDVS_pixel2x2_bot_675 openDVS_pixel2x2_bot_675/vpd[0] openDVS_pixel2x2_bot_675/vpd[1]
+ openDVS_pixel2x2_bot_675/vpd[3] openDVS_pixel2x2_bot_675/vpd[2] rowReadON[42] rowReadON[43]
+ RefrBp PrBp PrSFBp col_periphery_1x2_3/COL_LINE0 pixRst[6] pixRst[7] col_periphery_1x2_3/COL_LINE1
+ OffBn rowReadOFF[42] rowReadOFF[43] openDVS_pixel2x2_bot_703/GndD DiffBn VSUBS OnBn
+ VDD openDVS_pixel2x2_bot
XopenDVS_pixel2x2_bot_664 openDVS_pixel2x2_bot_664/vpd[0] openDVS_pixel2x2_bot_664/vpd[1]
+ openDVS_pixel2x2_bot_664/vpd[3] openDVS_pixel2x2_bot_664/vpd[2] rowReadON[40] rowReadON[41]
+ RefrBp PrBp PrSFBp col_periphery_1x2_24/COL_LINE0 pixRst[48] pixRst[49] col_periphery_1x2_24/COL_LINE1
+ OffBn rowReadOFF[40] rowReadOFF[41] openDVS_pixel2x2_bot_671/GndD DiffBn VSUBS OnBn
+ VDD openDVS_pixel2x2_bot
XopenDVS_pixel2x2_bot_631 openDVS_pixel2x2_bot_631/vpd[0] openDVS_pixel2x2_bot_631/vpd[1]
+ openDVS_pixel2x2_bot_631/vpd[3] openDVS_pixel2x2_bot_631/vpd[2] rowReadON[38] rowReadON[39]
+ RefrBp PrBp PrSFBp col_periphery_1x2_23/COL_LINE0 pixRst[46] pixRst[47] col_periphery_1x2_23/COL_LINE1
+ OffBn rowReadOFF[38] rowReadOFF[39] openDVS_pixel2x2_bot_639/GndD DiffBn VSUBS OnBn
+ VDD openDVS_pixel2x2_bot
XopenDVS_pixel2x2_bot_653 openDVS_pixel2x2_bot_653/vpd[0] openDVS_pixel2x2_bot_653/vpd[1]
+ openDVS_pixel2x2_bot_653/vpd[3] openDVS_pixel2x2_bot_653/vpd[2] rowReadON[40] rowReadON[41]
+ RefrBp PrBp PrSFBp col_periphery_1x2_13/COL_LINE0 pixRst[26] pixRst[27] col_periphery_1x2_13/COL_LINE1
+ OffBn rowReadOFF[40] rowReadOFF[41] openDVS_pixel2x2_bot_671/GndD DiffBn VSUBS OnBn
+ VDD openDVS_pixel2x2_bot
XopenDVS_pixel2x2_bot_620 openDVS_pixel2x2_bot_620/vpd[0] openDVS_pixel2x2_bot_620/vpd[1]
+ openDVS_pixel2x2_bot_620/vpd[3] openDVS_pixel2x2_bot_620/vpd[2] rowReadON[38] rowReadON[39]
+ RefrBp PrBp PrSFBp col_periphery_1x2_12/COL_LINE0 pixRst[24] pixRst[25] col_periphery_1x2_12/COL_LINE1
+ OffBn rowReadOFF[38] rowReadOFF[39] openDVS_pixel2x2_bot_639/GndD DiffBn VSUBS OnBn
+ VDD openDVS_pixel2x2_bot
XopenDVS_pixel2x2_bot_642 openDVS_pixel2x2_bot_642/vpd[0] openDVS_pixel2x2_bot_642/vpd[1]
+ openDVS_pixel2x2_bot_642/vpd[3] openDVS_pixel2x2_bot_642/vpd[2] rowReadON[40] rowReadON[41]
+ RefrBp PrBp PrSFBp col_periphery_1x2_2/COL_LINE0 pixRst[4] pixRst[5] col_periphery_1x2_2/COL_LINE1
+ OffBn rowReadOFF[40] rowReadOFF[41] openDVS_pixel2x2_bot_671/GndD DiffBn VSUBS OnBn
+ VDD openDVS_pixel2x2_bot
XopenDVS_pixel2x2_bot_40 openDVS_pixel2x2_bot_40/vpd[0] openDVS_pixel2x2_bot_40/vpd[1]
+ openDVS_pixel2x2_bot_40/vpd[3] openDVS_pixel2x2_bot_40/vpd[2] rowReadON[2] rowReadON[3]
+ RefrBp PrBp PrSFBp col_periphery_1x2_8/COL_LINE0 pixRst[16] pixRst[17] col_periphery_1x2_8/COL_LINE1
+ OffBn rowReadOFF[2] rowReadOFF[3] openDVS_pixel2x2_bot_63/GndD DiffBn VSUBS OnBn
+ VDD openDVS_pixel2x2_bot
XopenDVS_pixel2x2_bot_73 openDVS_pixel2x2_bot_73/vpd[0] openDVS_pixel2x2_bot_73/vpd[1]
+ openDVS_pixel2x2_bot_73/vpd[3] openDVS_pixel2x2_bot_73/vpd[2] rowReadON[4] rowReadON[5]
+ RefrBp PrBp PrSFBp col_periphery_1x2_9/COL_LINE0 pixRst[18] pixRst[19] col_periphery_1x2_9/COL_LINE1
+ OffBn rowReadOFF[4] rowReadOFF[5] openDVS_pixel2x2_bot_95/GndD DiffBn VSUBS OnBn
+ VDD openDVS_pixel2x2_bot
XopenDVS_pixel2x2_bot_51 openDVS_pixel2x2_bot_51/vpd[0] openDVS_pixel2x2_bot_51/vpd[1]
+ openDVS_pixel2x2_bot_51/vpd[3] openDVS_pixel2x2_bot_51/vpd[2] rowReadON[2] rowReadON[3]
+ RefrBp PrBp PrSFBp col_periphery_1x2_19/COL_LINE0 pixRst[38] pixRst[39] col_periphery_1x2_19/COL_LINE1
+ OffBn rowReadOFF[2] rowReadOFF[3] openDVS_pixel2x2_bot_63/GndD DiffBn VSUBS OnBn
+ VDD openDVS_pixel2x2_bot
XopenDVS_pixel2x2_bot_84 openDVS_pixel2x2_bot_84/vpd[0] openDVS_pixel2x2_bot_84/vpd[1]
+ openDVS_pixel2x2_bot_84/vpd[3] openDVS_pixel2x2_bot_84/vpd[2] rowReadON[4] rowReadON[5]
+ RefrBp PrBp PrSFBp col_periphery_1x2_20/COL_LINE0 pixRst[40] pixRst[41] col_periphery_1x2_20/COL_LINE1
+ OffBn rowReadOFF[4] rowReadOFF[5] openDVS_pixel2x2_bot_95/GndD DiffBn VSUBS OnBn
+ VDD openDVS_pixel2x2_bot
XopenDVS_pixel2x2_bot_62 openDVS_pixel2x2_bot_62/vpd[0] openDVS_pixel2x2_bot_62/vpd[1]
+ openDVS_pixel2x2_bot_62/vpd[3] openDVS_pixel2x2_bot_62/vpd[2] rowReadON[2] rowReadON[3]
+ RefrBp PrBp PrSFBp col_periphery_1x2_30/COL_LINE0 pixRst[60] pixRst[61] col_periphery_1x2_30/COL_LINE1
+ OffBn rowReadOFF[2] rowReadOFF[3] openDVS_pixel2x2_bot_63/GndD DiffBn VSUBS OnBn
+ VDD openDVS_pixel2x2_bot
XopenDVS_pixel2x2_bot_95 openDVS_pixel2x2_bot_95/vpd[0] openDVS_pixel2x2_bot_95/vpd[1]
+ openDVS_pixel2x2_bot_95/vpd[3] openDVS_pixel2x2_bot_95/vpd[2] rowReadON[4] rowReadON[5]
+ RefrBp PrBp PrSFBp col_periphery_1x2_31/COL_LINE0 pixRst[62] pixRst[63] col_periphery_1x2_31/COL_LINE1
+ OffBn rowReadOFF[4] rowReadOFF[5] openDVS_pixel2x2_bot_95/GndD DiffBn VSUBS OnBn
+ VDD openDVS_pixel2x2_bot
XopenDVS_pixel2x2_bot_1015 openDVS_pixel2x2_bot_1015/vpd[0] openDVS_pixel2x2_bot_1015/vpd[1]
+ openDVS_pixel2x2_bot_1015/vpd[3] openDVS_pixel2x2_bot_1015/vpd[2] rowReadON[62]
+ rowReadON[63] RefrBp PrBp PrSFBp col_periphery_1x2_23/COL_LINE0 pixRst[46] pixRst[47]
+ col_periphery_1x2_23/COL_LINE1 OffBn rowReadOFF[62] rowReadOFF[63] openDVS_pixel2x2_bot_999/GndD
+ DiffBn VSUBS OnBn VDD openDVS_pixel2x2_bot
XopenDVS_pixel2x2_bot_1004 openDVS_pixel2x2_bot_1004/vpd[0] openDVS_pixel2x2_bot_1004/vpd[1]
+ openDVS_pixel2x2_bot_1004/vpd[3] openDVS_pixel2x2_bot_1004/vpd[2] rowReadON[62]
+ rowReadON[63] RefrBp PrBp PrSFBp col_periphery_1x2_12/COL_LINE0 pixRst[24] pixRst[25]
+ col_periphery_1x2_12/COL_LINE1 OffBn rowReadOFF[62] rowReadOFF[63] openDVS_pixel2x2_bot_999/GndD
+ DiffBn VSUBS OnBn VDD openDVS_pixel2x2_bot
XopenDVS_pixel2x2_bot_472 openDVS_pixel2x2_bot_472/vpd[0] openDVS_pixel2x2_bot_472/vpd[1]
+ openDVS_pixel2x2_bot_472/vpd[3] openDVS_pixel2x2_bot_472/vpd[2] rowReadON[28] rowReadON[29]
+ RefrBp PrBp PrSFBp col_periphery_1x2_24/COL_LINE0 pixRst[48] pixRst[49] col_periphery_1x2_24/COL_LINE1
+ OffBn rowReadOFF[28] rowReadOFF[29] openDVS_pixel2x2_bot_479/GndD DiffBn VSUBS OnBn
+ VDD openDVS_pixel2x2_bot
XopenDVS_pixel2x2_bot_494 openDVS_pixel2x2_bot_494/vpd[0] openDVS_pixel2x2_bot_494/vpd[1]
+ openDVS_pixel2x2_bot_494/vpd[3] openDVS_pixel2x2_bot_494/vpd[2] rowReadON[30] rowReadON[31]
+ RefrBp PrBp PrSFBp col_periphery_1x2_14/COL_LINE0 pixRst[28] pixRst[29] col_periphery_1x2_14/COL_LINE1
+ OffBn rowReadOFF[30] rowReadOFF[31] openDVS_pixel2x2_bot_511/GndD DiffBn VSUBS OnBn
+ VDD openDVS_pixel2x2_bot
XopenDVS_pixel2x2_bot_461 openDVS_pixel2x2_bot_461/vpd[0] openDVS_pixel2x2_bot_461/vpd[1]
+ openDVS_pixel2x2_bot_461/vpd[3] openDVS_pixel2x2_bot_461/vpd[2] rowReadON[28] rowReadON[29]
+ RefrBp PrBp PrSFBp col_periphery_1x2_13/COL_LINE0 pixRst[26] pixRst[27] col_periphery_1x2_13/COL_LINE1
+ OffBn rowReadOFF[28] rowReadOFF[29] openDVS_pixel2x2_bot_479/GndD DiffBn VSUBS OnBn
+ VDD openDVS_pixel2x2_bot
XopenDVS_pixel2x2_bot_483 openDVS_pixel2x2_bot_483/vpd[0] openDVS_pixel2x2_bot_483/vpd[1]
+ openDVS_pixel2x2_bot_483/vpd[3] openDVS_pixel2x2_bot_483/vpd[2] rowReadON[30] rowReadON[31]
+ RefrBp PrBp PrSFBp col_periphery_1x2_3/COL_LINE0 pixRst[6] pixRst[7] col_periphery_1x2_3/COL_LINE1
+ OffBn rowReadOFF[30] rowReadOFF[31] openDVS_pixel2x2_bot_511/GndD DiffBn VSUBS OnBn
+ VDD openDVS_pixel2x2_bot
XopenDVS_pixel2x2_bot_450 openDVS_pixel2x2_bot_450/vpd[0] openDVS_pixel2x2_bot_450/vpd[1]
+ openDVS_pixel2x2_bot_450/vpd[3] openDVS_pixel2x2_bot_450/vpd[2] rowReadON[28] rowReadON[29]
+ RefrBp PrBp PrSFBp col_periphery_1x2_2/COL_LINE0 pixRst[4] pixRst[5] col_periphery_1x2_2/COL_LINE1
+ OffBn rowReadOFF[28] rowReadOFF[29] openDVS_pixel2x2_bot_479/GndD DiffBn VSUBS OnBn
+ VDD openDVS_pixel2x2_bot
XopenDVS_pixel2x2_bot_291 openDVS_pixel2x2_bot_291/vpd[0] openDVS_pixel2x2_bot_291/vpd[1]
+ openDVS_pixel2x2_bot_291/vpd[3] openDVS_pixel2x2_bot_291/vpd[2] rowReadON[18] rowReadON[19]
+ RefrBp PrBp PrSFBp col_periphery_1x2_3/COL_LINE0 pixRst[6] pixRst[7] col_periphery_1x2_3/COL_LINE1
+ OffBn rowReadOFF[18] rowReadOFF[19] openDVS_pixel2x2_bot_319/GndD DiffBn VSUBS OnBn
+ VDD openDVS_pixel2x2_bot
XopenDVS_pixel2x2_bot_280 openDVS_pixel2x2_bot_280/vpd[0] openDVS_pixel2x2_bot_280/vpd[1]
+ openDVS_pixel2x2_bot_280/vpd[3] openDVS_pixel2x2_bot_280/vpd[2] rowReadON[16] rowReadON[17]
+ RefrBp PrBp PrSFBp col_periphery_1x2_24/COL_LINE0 pixRst[48] pixRst[49] col_periphery_1x2_24/COL_LINE1
+ OffBn rowReadOFF[16] rowReadOFF[17] openDVS_pixel2x2_bot_287/GndD DiffBn VSUBS OnBn
+ VDD openDVS_pixel2x2_bot
Xcol_periphery_1x2_26 pixRst[53] col_periphery_1x2_26/COL_LINE0 col_periphery_1x2_26/COL_LINE1
+ nDETECT col_periphery_1x2_9/VDD DETECT VTHRESH voutn[52] VSUBS NCHARGE voutn[53]
+ pixRst[52] col_periphery_1x2
Xcol_periphery_1x2_15 pixRst[31] col_periphery_1x2_15/COL_LINE0 col_periphery_1x2_15/COL_LINE1
+ nDETECT col_periphery_1x2_9/VDD DETECT VTHRESH voutn[30] VSUBS NCHARGE voutn[31]
+ pixRst[30] col_periphery_1x2
XopenDVS_pixel2x2_bot_4 openDVS_pixel2x2_bot_4/vpd[0] openDVS_pixel2x2_bot_4/vpd[1]
+ openDVS_pixel2x2_bot_4/vpd[3] openDVS_pixel2x2_bot_4/vpd[2] rowReadON[0] rowReadON[1]
+ RefrBp PrBp PrSFBp col_periphery_1x2_4/COL_LINE0 pixRst[8] pixRst[9] col_periphery_1x2_4/COL_LINE1
+ OffBn rowReadOFF[0] rowReadOFF[1] GND DiffBn VSUBS OnBn VDD openDVS_pixel2x2_bot
XopenDVS_pixel2x2_bot_857 openDVS_pixel2x2_bot_857/vpd[0] openDVS_pixel2x2_bot_857/vpd[1]
+ openDVS_pixel2x2_bot_857/vpd[3] openDVS_pixel2x2_bot_857/vpd[2] rowReadON[52] rowReadON[53]
+ RefrBp PrBp PrSFBp col_periphery_1x2_25/COL_LINE0 pixRst[50] pixRst[51] col_periphery_1x2_25/COL_LINE1
+ OffBn rowReadOFF[52] rowReadOFF[53] openDVS_pixel2x2_bot_863/GndD DiffBn VSUBS OnBn
+ VDD openDVS_pixel2x2_bot
XopenDVS_pixel2x2_bot_879 openDVS_pixel2x2_bot_879/vpd[0] openDVS_pixel2x2_bot_879/vpd[1]
+ openDVS_pixel2x2_bot_879/vpd[3] openDVS_pixel2x2_bot_879/vpd[2] rowReadON[54] rowReadON[55]
+ RefrBp PrBp PrSFBp col_periphery_1x2_15/COL_LINE0 pixRst[30] pixRst[31] col_periphery_1x2_15/COL_LINE1
+ OffBn rowReadOFF[54] rowReadOFF[55] openDVS_pixel2x2_bot_895/GndD DiffBn VSUBS OnBn
+ VDD openDVS_pixel2x2_bot
XopenDVS_pixel2x2_bot_846 openDVS_pixel2x2_bot_846/vpd[0] openDVS_pixel2x2_bot_846/vpd[1]
+ openDVS_pixel2x2_bot_846/vpd[3] openDVS_pixel2x2_bot_846/vpd[2] rowReadON[52] rowReadON[53]
+ RefrBp PrBp PrSFBp col_periphery_1x2_14/COL_LINE0 pixRst[28] pixRst[29] col_periphery_1x2_14/COL_LINE1
+ OffBn rowReadOFF[52] rowReadOFF[53] openDVS_pixel2x2_bot_863/GndD DiffBn VSUBS OnBn
+ VDD openDVS_pixel2x2_bot
XopenDVS_pixel2x2_bot_868 openDVS_pixel2x2_bot_868/vpd[0] openDVS_pixel2x2_bot_868/vpd[1]
+ openDVS_pixel2x2_bot_868/vpd[3] openDVS_pixel2x2_bot_868/vpd[2] rowReadON[54] rowReadON[55]
+ RefrBp PrBp PrSFBp col_periphery_1x2_4/COL_LINE0 pixRst[8] pixRst[9] col_periphery_1x2_4/COL_LINE1
+ OffBn rowReadOFF[54] rowReadOFF[55] openDVS_pixel2x2_bot_895/GndD DiffBn VSUBS OnBn
+ VDD openDVS_pixel2x2_bot
XopenDVS_pixel2x2_bot_835 openDVS_pixel2x2_bot_835/vpd[0] openDVS_pixel2x2_bot_835/vpd[1]
+ openDVS_pixel2x2_bot_835/vpd[3] openDVS_pixel2x2_bot_835/vpd[2] rowReadON[52] rowReadON[53]
+ RefrBp PrBp PrSFBp col_periphery_1x2_3/COL_LINE0 pixRst[6] pixRst[7] col_periphery_1x2_3/COL_LINE1
+ OffBn rowReadOFF[52] rowReadOFF[53] openDVS_pixel2x2_bot_863/GndD DiffBn VSUBS OnBn
+ VDD openDVS_pixel2x2_bot
XopenDVS_pixel2x2_bot_824 openDVS_pixel2x2_bot_824/vpd[0] openDVS_pixel2x2_bot_824/vpd[1]
+ openDVS_pixel2x2_bot_824/vpd[3] openDVS_pixel2x2_bot_824/vpd[2] rowReadON[50] rowReadON[51]
+ RefrBp PrBp PrSFBp col_periphery_1x2_24/COL_LINE0 pixRst[48] pixRst[49] col_periphery_1x2_24/COL_LINE1
+ OffBn rowReadOFF[50] rowReadOFF[51] openDVS_pixel2x2_bot_831/GndD DiffBn VSUBS OnBn
+ VDD openDVS_pixel2x2_bot
XopenDVS_pixel2x2_bot_813 openDVS_pixel2x2_bot_813/vpd[0] openDVS_pixel2x2_bot_813/vpd[1]
+ openDVS_pixel2x2_bot_813/vpd[3] openDVS_pixel2x2_bot_813/vpd[2] rowReadON[50] rowReadON[51]
+ RefrBp PrBp PrSFBp col_periphery_1x2_13/COL_LINE0 pixRst[26] pixRst[27] col_periphery_1x2_13/COL_LINE1
+ OffBn rowReadOFF[50] rowReadOFF[51] openDVS_pixel2x2_bot_831/GndD DiffBn VSUBS OnBn
+ VDD openDVS_pixel2x2_bot
XopenDVS_pixel2x2_bot_802 openDVS_pixel2x2_bot_802/vpd[0] openDVS_pixel2x2_bot_802/vpd[1]
+ openDVS_pixel2x2_bot_802/vpd[3] openDVS_pixel2x2_bot_802/vpd[2] rowReadON[50] rowReadON[51]
+ RefrBp PrBp PrSFBp col_periphery_1x2_2/COL_LINE0 pixRst[4] pixRst[5] col_periphery_1x2_2/COL_LINE1
+ OffBn rowReadOFF[50] rowReadOFF[51] openDVS_pixel2x2_bot_831/GndD DiffBn VSUBS OnBn
+ VDD openDVS_pixel2x2_bot
XopenDVS_pixel2x2_bot_109 openDVS_pixel2x2_bot_109/vpd[0] openDVS_pixel2x2_bot_109/vpd[1]
+ openDVS_pixel2x2_bot_109/vpd[3] openDVS_pixel2x2_bot_109/vpd[2] rowReadON[6] rowReadON[7]
+ RefrBp PrBp PrSFBp col_periphery_1x2_13/COL_LINE0 pixRst[26] pixRst[27] col_periphery_1x2_13/COL_LINE1
+ OffBn rowReadOFF[6] rowReadOFF[7] openDVS_pixel2x2_bot_99/GndD DiffBn VSUBS OnBn
+ VDD openDVS_pixel2x2_bot
XopenDVS_pixel2x2_bot_698 openDVS_pixel2x2_bot_698/vpd[0] openDVS_pixel2x2_bot_698/vpd[1]
+ openDVS_pixel2x2_bot_698/vpd[3] openDVS_pixel2x2_bot_698/vpd[2] rowReadON[42] rowReadON[43]
+ RefrBp PrBp PrSFBp col_periphery_1x2_26/COL_LINE0 pixRst[52] pixRst[53] col_periphery_1x2_26/COL_LINE1
+ OffBn rowReadOFF[42] rowReadOFF[43] openDVS_pixel2x2_bot_703/GndD DiffBn VSUBS OnBn
+ VDD openDVS_pixel2x2_bot
XopenDVS_pixel2x2_bot_687 openDVS_pixel2x2_bot_687/vpd[0] openDVS_pixel2x2_bot_687/vpd[1]
+ openDVS_pixel2x2_bot_687/vpd[3] openDVS_pixel2x2_bot_687/vpd[2] rowReadON[42] rowReadON[43]
+ RefrBp PrBp PrSFBp col_periphery_1x2_15/COL_LINE0 pixRst[30] pixRst[31] col_periphery_1x2_15/COL_LINE1
+ OffBn rowReadOFF[42] rowReadOFF[43] openDVS_pixel2x2_bot_703/GndD DiffBn VSUBS OnBn
+ VDD openDVS_pixel2x2_bot
XopenDVS_pixel2x2_bot_676 openDVS_pixel2x2_bot_676/vpd[0] openDVS_pixel2x2_bot_676/vpd[1]
+ openDVS_pixel2x2_bot_676/vpd[3] openDVS_pixel2x2_bot_676/vpd[2] rowReadON[42] rowReadON[43]
+ RefrBp PrBp PrSFBp col_periphery_1x2_4/COL_LINE0 pixRst[8] pixRst[9] col_periphery_1x2_4/COL_LINE1
+ OffBn rowReadOFF[42] rowReadOFF[43] openDVS_pixel2x2_bot_703/GndD DiffBn VSUBS OnBn
+ VDD openDVS_pixel2x2_bot
XopenDVS_pixel2x2_bot_665 openDVS_pixel2x2_bot_665/vpd[0] openDVS_pixel2x2_bot_665/vpd[1]
+ openDVS_pixel2x2_bot_665/vpd[3] openDVS_pixel2x2_bot_665/vpd[2] rowReadON[40] rowReadON[41]
+ RefrBp PrBp PrSFBp col_periphery_1x2_25/COL_LINE0 pixRst[50] pixRst[51] col_periphery_1x2_25/COL_LINE1
+ OffBn rowReadOFF[40] rowReadOFF[41] openDVS_pixel2x2_bot_671/GndD DiffBn VSUBS OnBn
+ VDD openDVS_pixel2x2_bot
XopenDVS_pixel2x2_bot_632 openDVS_pixel2x2_bot_632/vpd[0] openDVS_pixel2x2_bot_632/vpd[1]
+ openDVS_pixel2x2_bot_632/vpd[3] openDVS_pixel2x2_bot_632/vpd[2] rowReadON[38] rowReadON[39]
+ RefrBp PrBp PrSFBp col_periphery_1x2_24/COL_LINE0 pixRst[48] pixRst[49] col_periphery_1x2_24/COL_LINE1
+ OffBn rowReadOFF[38] rowReadOFF[39] openDVS_pixel2x2_bot_639/GndD DiffBn VSUBS OnBn
+ VDD openDVS_pixel2x2_bot
XopenDVS_pixel2x2_bot_654 openDVS_pixel2x2_bot_654/vpd[0] openDVS_pixel2x2_bot_654/vpd[1]
+ openDVS_pixel2x2_bot_654/vpd[3] openDVS_pixel2x2_bot_654/vpd[2] rowReadON[40] rowReadON[41]
+ RefrBp PrBp PrSFBp col_periphery_1x2_14/COL_LINE0 pixRst[28] pixRst[29] col_periphery_1x2_14/COL_LINE1
+ OffBn rowReadOFF[40] rowReadOFF[41] openDVS_pixel2x2_bot_671/GndD DiffBn VSUBS OnBn
+ VDD openDVS_pixel2x2_bot
XopenDVS_pixel2x2_bot_621 openDVS_pixel2x2_bot_621/vpd[0] openDVS_pixel2x2_bot_621/vpd[1]
+ openDVS_pixel2x2_bot_621/vpd[3] openDVS_pixel2x2_bot_621/vpd[2] rowReadON[38] rowReadON[39]
+ RefrBp PrBp PrSFBp col_periphery_1x2_13/COL_LINE0 pixRst[26] pixRst[27] col_periphery_1x2_13/COL_LINE1
+ OffBn rowReadOFF[38] rowReadOFF[39] openDVS_pixel2x2_bot_639/GndD DiffBn VSUBS OnBn
+ VDD openDVS_pixel2x2_bot
XopenDVS_pixel2x2_bot_643 openDVS_pixel2x2_bot_643/vpd[0] openDVS_pixel2x2_bot_643/vpd[1]
+ openDVS_pixel2x2_bot_643/vpd[3] openDVS_pixel2x2_bot_643/vpd[2] rowReadON[40] rowReadON[41]
+ RefrBp PrBp PrSFBp col_periphery_1x2_3/COL_LINE0 pixRst[6] pixRst[7] col_periphery_1x2_3/COL_LINE1
+ OffBn rowReadOFF[40] rowReadOFF[41] openDVS_pixel2x2_bot_671/GndD DiffBn VSUBS OnBn
+ VDD openDVS_pixel2x2_bot
XopenDVS_pixel2x2_bot_610 openDVS_pixel2x2_bot_610/vpd[0] openDVS_pixel2x2_bot_610/vpd[1]
+ openDVS_pixel2x2_bot_610/vpd[3] openDVS_pixel2x2_bot_610/vpd[2] rowReadON[38] rowReadON[39]
+ RefrBp PrBp PrSFBp col_periphery_1x2_2/COL_LINE0 pixRst[4] pixRst[5] col_periphery_1x2_2/COL_LINE1
+ OffBn rowReadOFF[38] rowReadOFF[39] openDVS_pixel2x2_bot_639/GndD DiffBn VSUBS OnBn
+ VDD openDVS_pixel2x2_bot
XopenDVS_pixel2x2_bot_96 openDVS_pixel2x2_bot_96/vpd[0] openDVS_pixel2x2_bot_96/vpd[1]
+ openDVS_pixel2x2_bot_96/vpd[3] openDVS_pixel2x2_bot_96/vpd[2] rowReadON[6] rowReadON[7]
+ RefrBp PrBp PrSFBp col_periphery_1x2_0/COL_LINE0 pixRst[0] pixRst[1] col_periphery_1x2_0/COL_LINE1
+ OffBn rowReadOFF[6] rowReadOFF[7] openDVS_pixel2x2_bot_99/GndD DiffBn VSUBS OnBn
+ VDD openDVS_pixel2x2_bot
XopenDVS_pixel2x2_bot_30 openDVS_pixel2x2_bot_30/vpd[0] openDVS_pixel2x2_bot_30/vpd[1]
+ openDVS_pixel2x2_bot_30/vpd[3] openDVS_pixel2x2_bot_30/vpd[2] rowReadON[0] rowReadON[1]
+ RefrBp PrBp PrSFBp col_periphery_1x2_30/COL_LINE0 pixRst[60] pixRst[61] col_periphery_1x2_30/COL_LINE1
+ OffBn rowReadOFF[0] rowReadOFF[1] GND DiffBn VSUBS OnBn VDD openDVS_pixel2x2_bot
XopenDVS_pixel2x2_bot_41 openDVS_pixel2x2_bot_41/vpd[0] openDVS_pixel2x2_bot_41/vpd[1]
+ openDVS_pixel2x2_bot_41/vpd[3] openDVS_pixel2x2_bot_41/vpd[2] rowReadON[2] rowReadON[3]
+ RefrBp PrBp PrSFBp col_periphery_1x2_9/COL_LINE0 pixRst[18] pixRst[19] col_periphery_1x2_9/COL_LINE1
+ OffBn rowReadOFF[2] rowReadOFF[3] openDVS_pixel2x2_bot_63/GndD DiffBn VSUBS OnBn
+ VDD openDVS_pixel2x2_bot
XopenDVS_pixel2x2_bot_74 openDVS_pixel2x2_bot_74/vpd[0] openDVS_pixel2x2_bot_74/vpd[1]
+ openDVS_pixel2x2_bot_74/vpd[3] openDVS_pixel2x2_bot_74/vpd[2] rowReadON[4] rowReadON[5]
+ RefrBp PrBp PrSFBp col_periphery_1x2_10/COL_LINE0 pixRst[20] pixRst[21] col_periphery_1x2_10/COL_LINE1
+ OffBn rowReadOFF[4] rowReadOFF[5] openDVS_pixel2x2_bot_95/GndD DiffBn VSUBS OnBn
+ VDD openDVS_pixel2x2_bot
XopenDVS_pixel2x2_bot_52 openDVS_pixel2x2_bot_52/vpd[0] openDVS_pixel2x2_bot_52/vpd[1]
+ openDVS_pixel2x2_bot_52/vpd[3] openDVS_pixel2x2_bot_52/vpd[2] rowReadON[2] rowReadON[3]
+ RefrBp PrBp PrSFBp col_periphery_1x2_20/COL_LINE0 pixRst[40] pixRst[41] col_periphery_1x2_20/COL_LINE1
+ OffBn rowReadOFF[2] rowReadOFF[3] openDVS_pixel2x2_bot_63/GndD DiffBn VSUBS OnBn
+ VDD openDVS_pixel2x2_bot
XopenDVS_pixel2x2_bot_85 openDVS_pixel2x2_bot_85/vpd[0] openDVS_pixel2x2_bot_85/vpd[1]
+ openDVS_pixel2x2_bot_85/vpd[3] openDVS_pixel2x2_bot_85/vpd[2] rowReadON[4] rowReadON[5]
+ RefrBp PrBp PrSFBp col_periphery_1x2_21/COL_LINE0 pixRst[42] pixRst[43] col_periphery_1x2_21/COL_LINE1
+ OffBn rowReadOFF[4] rowReadOFF[5] openDVS_pixel2x2_bot_95/GndD DiffBn VSUBS OnBn
+ VDD openDVS_pixel2x2_bot
XopenDVS_pixel2x2_bot_63 openDVS_pixel2x2_bot_63/vpd[0] openDVS_pixel2x2_bot_63/vpd[1]
+ openDVS_pixel2x2_bot_63/vpd[3] openDVS_pixel2x2_bot_63/vpd[2] rowReadON[2] rowReadON[3]
+ RefrBp PrBp PrSFBp col_periphery_1x2_31/COL_LINE0 pixRst[62] pixRst[63] col_periphery_1x2_31/COL_LINE1
+ OffBn rowReadOFF[2] rowReadOFF[3] openDVS_pixel2x2_bot_63/GndD DiffBn VSUBS OnBn
+ VDD openDVS_pixel2x2_bot
XopenDVS_pixel2x2_bot_1016 openDVS_pixel2x2_bot_1016/vpd[0] openDVS_pixel2x2_bot_1016/vpd[1]
+ openDVS_pixel2x2_bot_1016/vpd[3] openDVS_pixel2x2_bot_1016/vpd[2] rowReadON[62]
+ rowReadON[63] RefrBp PrBp PrSFBp col_periphery_1x2_24/COL_LINE0 pixRst[48] pixRst[49]
+ col_periphery_1x2_24/COL_LINE1 OffBn rowReadOFF[62] rowReadOFF[63] openDVS_pixel2x2_bot_999/GndD
+ DiffBn VSUBS OnBn VDD openDVS_pixel2x2_bot
XopenDVS_pixel2x2_bot_1005 openDVS_pixel2x2_bot_1005/vpd[0] openDVS_pixel2x2_bot_1005/vpd[1]
+ openDVS_pixel2x2_bot_1005/vpd[3] openDVS_pixel2x2_bot_1005/vpd[2] rowReadON[62]
+ rowReadON[63] RefrBp PrBp PrSFBp col_periphery_1x2_13/COL_LINE0 pixRst[26] pixRst[27]
+ col_periphery_1x2_13/COL_LINE1 OffBn rowReadOFF[62] rowReadOFF[63] openDVS_pixel2x2_bot_999/GndD
+ DiffBn VSUBS OnBn VDD openDVS_pixel2x2_bot
XopenDVS_pixel2x2_bot_473 openDVS_pixel2x2_bot_473/vpd[0] openDVS_pixel2x2_bot_473/vpd[1]
+ openDVS_pixel2x2_bot_473/vpd[3] openDVS_pixel2x2_bot_473/vpd[2] rowReadON[28] rowReadON[29]
+ RefrBp PrBp PrSFBp col_periphery_1x2_25/COL_LINE0 pixRst[50] pixRst[51] col_periphery_1x2_25/COL_LINE1
+ OffBn rowReadOFF[28] rowReadOFF[29] openDVS_pixel2x2_bot_479/GndD DiffBn VSUBS OnBn
+ VDD openDVS_pixel2x2_bot
XopenDVS_pixel2x2_bot_440 openDVS_pixel2x2_bot_440/vpd[0] openDVS_pixel2x2_bot_440/vpd[1]
+ openDVS_pixel2x2_bot_440/vpd[3] openDVS_pixel2x2_bot_440/vpd[2] rowReadON[26] rowReadON[27]
+ RefrBp PrBp PrSFBp col_periphery_1x2_24/COL_LINE0 pixRst[48] pixRst[49] col_periphery_1x2_24/COL_LINE1
+ OffBn rowReadOFF[26] rowReadOFF[27] openDVS_pixel2x2_bot_447/GndD DiffBn VSUBS OnBn
+ VDD openDVS_pixel2x2_bot
XopenDVS_pixel2x2_bot_495 openDVS_pixel2x2_bot_495/vpd[0] openDVS_pixel2x2_bot_495/vpd[1]
+ openDVS_pixel2x2_bot_495/vpd[3] openDVS_pixel2x2_bot_495/vpd[2] rowReadON[30] rowReadON[31]
+ RefrBp PrBp PrSFBp col_periphery_1x2_15/COL_LINE0 pixRst[30] pixRst[31] col_periphery_1x2_15/COL_LINE1
+ OffBn rowReadOFF[30] rowReadOFF[31] openDVS_pixel2x2_bot_511/GndD DiffBn VSUBS OnBn
+ VDD openDVS_pixel2x2_bot
XopenDVS_pixel2x2_bot_462 openDVS_pixel2x2_bot_462/vpd[0] openDVS_pixel2x2_bot_462/vpd[1]
+ openDVS_pixel2x2_bot_462/vpd[3] openDVS_pixel2x2_bot_462/vpd[2] rowReadON[28] rowReadON[29]
+ RefrBp PrBp PrSFBp col_periphery_1x2_14/COL_LINE0 pixRst[28] pixRst[29] col_periphery_1x2_14/COL_LINE1
+ OffBn rowReadOFF[28] rowReadOFF[29] openDVS_pixel2x2_bot_479/GndD DiffBn VSUBS OnBn
+ VDD openDVS_pixel2x2_bot
XopenDVS_pixel2x2_bot_484 openDVS_pixel2x2_bot_484/vpd[0] openDVS_pixel2x2_bot_484/vpd[1]
+ openDVS_pixel2x2_bot_484/vpd[3] openDVS_pixel2x2_bot_484/vpd[2] rowReadON[30] rowReadON[31]
+ RefrBp PrBp PrSFBp col_periphery_1x2_4/COL_LINE0 pixRst[8] pixRst[9] col_periphery_1x2_4/COL_LINE1
+ OffBn rowReadOFF[30] rowReadOFF[31] openDVS_pixel2x2_bot_511/GndD DiffBn VSUBS OnBn
+ VDD openDVS_pixel2x2_bot
XopenDVS_pixel2x2_bot_451 openDVS_pixel2x2_bot_451/vpd[0] openDVS_pixel2x2_bot_451/vpd[1]
+ openDVS_pixel2x2_bot_451/vpd[3] openDVS_pixel2x2_bot_451/vpd[2] rowReadON[28] rowReadON[29]
+ RefrBp PrBp PrSFBp col_periphery_1x2_3/COL_LINE0 pixRst[6] pixRst[7] col_periphery_1x2_3/COL_LINE1
+ OffBn rowReadOFF[28] rowReadOFF[29] openDVS_pixel2x2_bot_479/GndD DiffBn VSUBS OnBn
+ VDD openDVS_pixel2x2_bot
XopenDVS_pixel2x2_bot_292 openDVS_pixel2x2_bot_292/vpd[0] openDVS_pixel2x2_bot_292/vpd[1]
+ openDVS_pixel2x2_bot_292/vpd[3] openDVS_pixel2x2_bot_292/vpd[2] rowReadON[18] rowReadON[19]
+ RefrBp PrBp PrSFBp col_periphery_1x2_4/COL_LINE0 pixRst[8] pixRst[9] col_periphery_1x2_4/COL_LINE1
+ OffBn rowReadOFF[18] rowReadOFF[19] openDVS_pixel2x2_bot_319/GndD DiffBn VSUBS OnBn
+ VDD openDVS_pixel2x2_bot
XopenDVS_pixel2x2_bot_270 openDVS_pixel2x2_bot_270/vpd[0] openDVS_pixel2x2_bot_270/vpd[1]
+ openDVS_pixel2x2_bot_270/vpd[3] openDVS_pixel2x2_bot_270/vpd[2] rowReadON[16] rowReadON[17]
+ RefrBp PrBp PrSFBp col_periphery_1x2_14/COL_LINE0 pixRst[28] pixRst[29] col_periphery_1x2_14/COL_LINE1
+ OffBn rowReadOFF[16] rowReadOFF[17] openDVS_pixel2x2_bot_287/GndD DiffBn VSUBS OnBn
+ VDD openDVS_pixel2x2_bot
XopenDVS_pixel2x2_bot_281 openDVS_pixel2x2_bot_281/vpd[0] openDVS_pixel2x2_bot_281/vpd[1]
+ openDVS_pixel2x2_bot_281/vpd[3] openDVS_pixel2x2_bot_281/vpd[2] rowReadON[16] rowReadON[17]
+ RefrBp PrBp PrSFBp col_periphery_1x2_25/COL_LINE0 pixRst[50] pixRst[51] col_periphery_1x2_25/COL_LINE1
+ OffBn rowReadOFF[16] rowReadOFF[17] openDVS_pixel2x2_bot_287/GndD DiffBn VSUBS OnBn
+ VDD openDVS_pixel2x2_bot
Xcol_periphery_1x2_27 pixRst[55] col_periphery_1x2_27/COL_LINE0 col_periphery_1x2_27/COL_LINE1
+ nDETECT col_periphery_1x2_9/VDD DETECT VTHRESH voutn[54] VSUBS NCHARGE voutn[55]
+ pixRst[54] col_periphery_1x2
Xcol_periphery_1x2_16 pixRst[33] col_periphery_1x2_16/COL_LINE0 col_periphery_1x2_16/COL_LINE1
+ nDETECT col_periphery_1x2_9/VDD DETECT VTHRESH voutn[32] VSUBS NCHARGE voutn[33]
+ pixRst[32] col_periphery_1x2
XopenDVS_pixel2x2_bot_5 openDVS_pixel2x2_bot_5/vpd[0] openDVS_pixel2x2_bot_5/vpd[1]
+ openDVS_pixel2x2_bot_5/vpd[3] openDVS_pixel2x2_bot_5/vpd[2] rowReadON[0] rowReadON[1]
+ RefrBp PrBp PrSFBp col_periphery_1x2_5/COL_LINE0 pixRst[10] pixRst[11] col_periphery_1x2_5/COL_LINE1
+ OffBn rowReadOFF[0] rowReadOFF[1] GND DiffBn VSUBS OnBn VDD openDVS_pixel2x2_bot
XopenDVS_pixel2x2_bot_858 openDVS_pixel2x2_bot_858/vpd[0] openDVS_pixel2x2_bot_858/vpd[1]
+ openDVS_pixel2x2_bot_858/vpd[3] openDVS_pixel2x2_bot_858/vpd[2] rowReadON[52] rowReadON[53]
+ RefrBp PrBp PrSFBp col_periphery_1x2_26/COL_LINE0 pixRst[52] pixRst[53] col_periphery_1x2_26/COL_LINE1
+ OffBn rowReadOFF[52] rowReadOFF[53] openDVS_pixel2x2_bot_863/GndD DiffBn VSUBS OnBn
+ VDD openDVS_pixel2x2_bot
XopenDVS_pixel2x2_bot_847 openDVS_pixel2x2_bot_847/vpd[0] openDVS_pixel2x2_bot_847/vpd[1]
+ openDVS_pixel2x2_bot_847/vpd[3] openDVS_pixel2x2_bot_847/vpd[2] rowReadON[52] rowReadON[53]
+ RefrBp PrBp PrSFBp col_periphery_1x2_15/COL_LINE0 pixRst[30] pixRst[31] col_periphery_1x2_15/COL_LINE1
+ OffBn rowReadOFF[52] rowReadOFF[53] openDVS_pixel2x2_bot_863/GndD DiffBn VSUBS OnBn
+ VDD openDVS_pixel2x2_bot
XopenDVS_pixel2x2_bot_869 openDVS_pixel2x2_bot_869/vpd[0] openDVS_pixel2x2_bot_869/vpd[1]
+ openDVS_pixel2x2_bot_869/vpd[3] openDVS_pixel2x2_bot_869/vpd[2] rowReadON[54] rowReadON[55]
+ RefrBp PrBp PrSFBp col_periphery_1x2_5/COL_LINE0 pixRst[10] pixRst[11] col_periphery_1x2_5/COL_LINE1
+ OffBn rowReadOFF[54] rowReadOFF[55] openDVS_pixel2x2_bot_895/GndD DiffBn VSUBS OnBn
+ VDD openDVS_pixel2x2_bot
XopenDVS_pixel2x2_bot_836 openDVS_pixel2x2_bot_836/vpd[0] openDVS_pixel2x2_bot_836/vpd[1]
+ openDVS_pixel2x2_bot_836/vpd[3] openDVS_pixel2x2_bot_836/vpd[2] rowReadON[52] rowReadON[53]
+ RefrBp PrBp PrSFBp col_periphery_1x2_4/COL_LINE0 pixRst[8] pixRst[9] col_periphery_1x2_4/COL_LINE1
+ OffBn rowReadOFF[52] rowReadOFF[53] openDVS_pixel2x2_bot_863/GndD DiffBn VSUBS OnBn
+ VDD openDVS_pixel2x2_bot
XopenDVS_pixel2x2_bot_825 openDVS_pixel2x2_bot_825/vpd[0] openDVS_pixel2x2_bot_825/vpd[1]
+ openDVS_pixel2x2_bot_825/vpd[3] openDVS_pixel2x2_bot_825/vpd[2] rowReadON[50] rowReadON[51]
+ RefrBp PrBp PrSFBp col_periphery_1x2_25/COL_LINE0 pixRst[50] pixRst[51] col_periphery_1x2_25/COL_LINE1
+ OffBn rowReadOFF[50] rowReadOFF[51] openDVS_pixel2x2_bot_831/GndD DiffBn VSUBS OnBn
+ VDD openDVS_pixel2x2_bot
XopenDVS_pixel2x2_bot_814 openDVS_pixel2x2_bot_814/vpd[0] openDVS_pixel2x2_bot_814/vpd[1]
+ openDVS_pixel2x2_bot_814/vpd[3] openDVS_pixel2x2_bot_814/vpd[2] rowReadON[50] rowReadON[51]
+ RefrBp PrBp PrSFBp col_periphery_1x2_14/COL_LINE0 pixRst[28] pixRst[29] col_periphery_1x2_14/COL_LINE1
+ OffBn rowReadOFF[50] rowReadOFF[51] openDVS_pixel2x2_bot_831/GndD DiffBn VSUBS OnBn
+ VDD openDVS_pixel2x2_bot
XopenDVS_pixel2x2_bot_803 openDVS_pixel2x2_bot_803/vpd[0] openDVS_pixel2x2_bot_803/vpd[1]
+ openDVS_pixel2x2_bot_803/vpd[3] openDVS_pixel2x2_bot_803/vpd[2] rowReadON[50] rowReadON[51]
+ RefrBp PrBp PrSFBp col_periphery_1x2_3/COL_LINE0 pixRst[6] pixRst[7] col_periphery_1x2_3/COL_LINE1
+ OffBn rowReadOFF[50] rowReadOFF[51] openDVS_pixel2x2_bot_831/GndD DiffBn VSUBS OnBn
+ VDD openDVS_pixel2x2_bot
XopenDVS_pixel2x2_bot_699 openDVS_pixel2x2_bot_699/vpd[0] openDVS_pixel2x2_bot_699/vpd[1]
+ openDVS_pixel2x2_bot_699/vpd[3] openDVS_pixel2x2_bot_699/vpd[2] rowReadON[42] rowReadON[43]
+ RefrBp PrBp PrSFBp col_periphery_1x2_27/COL_LINE0 pixRst[54] pixRst[55] col_periphery_1x2_27/COL_LINE1
+ OffBn rowReadOFF[42] rowReadOFF[43] openDVS_pixel2x2_bot_703/GndD DiffBn VSUBS OnBn
+ VDD openDVS_pixel2x2_bot
XopenDVS_pixel2x2_bot_688 openDVS_pixel2x2_bot_688/vpd[0] openDVS_pixel2x2_bot_688/vpd[1]
+ openDVS_pixel2x2_bot_688/vpd[3] openDVS_pixel2x2_bot_688/vpd[2] rowReadON[42] rowReadON[43]
+ RefrBp PrBp PrSFBp col_periphery_1x2_16/COL_LINE0 pixRst[32] pixRst[33] col_periphery_1x2_16/COL_LINE1
+ OffBn rowReadOFF[42] rowReadOFF[43] openDVS_pixel2x2_bot_703/GndD DiffBn VSUBS OnBn
+ VDD openDVS_pixel2x2_bot
XopenDVS_pixel2x2_bot_677 openDVS_pixel2x2_bot_677/vpd[0] openDVS_pixel2x2_bot_677/vpd[1]
+ openDVS_pixel2x2_bot_677/vpd[3] openDVS_pixel2x2_bot_677/vpd[2] rowReadON[42] rowReadON[43]
+ RefrBp PrBp PrSFBp col_periphery_1x2_5/COL_LINE0 pixRst[10] pixRst[11] col_periphery_1x2_5/COL_LINE1
+ OffBn rowReadOFF[42] rowReadOFF[43] openDVS_pixel2x2_bot_703/GndD DiffBn VSUBS OnBn
+ VDD openDVS_pixel2x2_bot
XopenDVS_pixel2x2_bot_666 openDVS_pixel2x2_bot_666/vpd[0] openDVS_pixel2x2_bot_666/vpd[1]
+ openDVS_pixel2x2_bot_666/vpd[3] openDVS_pixel2x2_bot_666/vpd[2] rowReadON[40] rowReadON[41]
+ RefrBp PrBp PrSFBp col_periphery_1x2_26/COL_LINE0 pixRst[52] pixRst[53] col_periphery_1x2_26/COL_LINE1
+ OffBn rowReadOFF[40] rowReadOFF[41] openDVS_pixel2x2_bot_671/GndD DiffBn VSUBS OnBn
+ VDD openDVS_pixel2x2_bot
XopenDVS_pixel2x2_bot_633 openDVS_pixel2x2_bot_633/vpd[0] openDVS_pixel2x2_bot_633/vpd[1]
+ openDVS_pixel2x2_bot_633/vpd[3] openDVS_pixel2x2_bot_633/vpd[2] rowReadON[38] rowReadON[39]
+ RefrBp PrBp PrSFBp col_periphery_1x2_25/COL_LINE0 pixRst[50] pixRst[51] col_periphery_1x2_25/COL_LINE1
+ OffBn rowReadOFF[38] rowReadOFF[39] openDVS_pixel2x2_bot_639/GndD DiffBn VSUBS OnBn
+ VDD openDVS_pixel2x2_bot
XopenDVS_pixel2x2_bot_600 openDVS_pixel2x2_bot_600/vpd[0] openDVS_pixel2x2_bot_600/vpd[1]
+ openDVS_pixel2x2_bot_600/vpd[3] openDVS_pixel2x2_bot_600/vpd[2] rowReadON[36] rowReadON[37]
+ RefrBp PrBp PrSFBp col_periphery_1x2_24/COL_LINE0 pixRst[48] pixRst[49] col_periphery_1x2_24/COL_LINE1
+ OffBn rowReadOFF[36] rowReadOFF[37] openDVS_pixel2x2_bot_607/GndD DiffBn VSUBS OnBn
+ VDD openDVS_pixel2x2_bot
XopenDVS_pixel2x2_bot_655 openDVS_pixel2x2_bot_655/vpd[0] openDVS_pixel2x2_bot_655/vpd[1]
+ openDVS_pixel2x2_bot_655/vpd[3] openDVS_pixel2x2_bot_655/vpd[2] rowReadON[40] rowReadON[41]
+ RefrBp PrBp PrSFBp col_periphery_1x2_15/COL_LINE0 pixRst[30] pixRst[31] col_periphery_1x2_15/COL_LINE1
+ OffBn rowReadOFF[40] rowReadOFF[41] openDVS_pixel2x2_bot_671/GndD DiffBn VSUBS OnBn
+ VDD openDVS_pixel2x2_bot
XopenDVS_pixel2x2_bot_622 openDVS_pixel2x2_bot_622/vpd[0] openDVS_pixel2x2_bot_622/vpd[1]
+ openDVS_pixel2x2_bot_622/vpd[3] openDVS_pixel2x2_bot_622/vpd[2] rowReadON[38] rowReadON[39]
+ RefrBp PrBp PrSFBp col_periphery_1x2_14/COL_LINE0 pixRst[28] pixRst[29] col_periphery_1x2_14/COL_LINE1
+ OffBn rowReadOFF[38] rowReadOFF[39] openDVS_pixel2x2_bot_639/GndD DiffBn VSUBS OnBn
+ VDD openDVS_pixel2x2_bot
XopenDVS_pixel2x2_bot_644 openDVS_pixel2x2_bot_644/vpd[0] openDVS_pixel2x2_bot_644/vpd[1]
+ openDVS_pixel2x2_bot_644/vpd[3] openDVS_pixel2x2_bot_644/vpd[2] rowReadON[40] rowReadON[41]
+ RefrBp PrBp PrSFBp col_periphery_1x2_4/COL_LINE0 pixRst[8] pixRst[9] col_periphery_1x2_4/COL_LINE1
+ OffBn rowReadOFF[40] rowReadOFF[41] openDVS_pixel2x2_bot_671/GndD DiffBn VSUBS OnBn
+ VDD openDVS_pixel2x2_bot
XopenDVS_pixel2x2_bot_611 openDVS_pixel2x2_bot_611/vpd[0] openDVS_pixel2x2_bot_611/vpd[1]
+ openDVS_pixel2x2_bot_611/vpd[3] openDVS_pixel2x2_bot_611/vpd[2] rowReadON[38] rowReadON[39]
+ RefrBp PrBp PrSFBp col_periphery_1x2_3/COL_LINE0 pixRst[6] pixRst[7] col_periphery_1x2_3/COL_LINE1
+ OffBn rowReadOFF[38] rowReadOFF[39] openDVS_pixel2x2_bot_639/GndD DiffBn VSUBS OnBn
+ VDD openDVS_pixel2x2_bot
XopenDVS_pixel2x2_bot_64 openDVS_pixel2x2_bot_64/vpd[0] openDVS_pixel2x2_bot_64/vpd[1]
+ openDVS_pixel2x2_bot_64/vpd[3] openDVS_pixel2x2_bot_64/vpd[2] rowReadON[4] rowReadON[5]
+ RefrBp PrBp PrSFBp col_periphery_1x2_0/COL_LINE0 pixRst[0] pixRst[1] col_periphery_1x2_0/COL_LINE1
+ OffBn rowReadOFF[4] rowReadOFF[5] openDVS_pixel2x2_bot_95/GndD DiffBn VSUBS OnBn
+ VDD openDVS_pixel2x2_bot
XopenDVS_pixel2x2_bot_31 openDVS_pixel2x2_bot_31/vpd[0] openDVS_pixel2x2_bot_31/vpd[1]
+ openDVS_pixel2x2_bot_31/vpd[3] openDVS_pixel2x2_bot_31/vpd[2] rowReadON[0] rowReadON[1]
+ RefrBp PrBp PrSFBp col_periphery_1x2_31/COL_LINE0 pixRst[62] pixRst[63] col_periphery_1x2_31/COL_LINE1
+ OffBn rowReadOFF[0] rowReadOFF[1] GND DiffBn VSUBS OnBn VDD openDVS_pixel2x2_bot
XopenDVS_pixel2x2_bot_20 openDVS_pixel2x2_bot_20/vpd[0] openDVS_pixel2x2_bot_20/vpd[1]
+ openDVS_pixel2x2_bot_20/vpd[3] openDVS_pixel2x2_bot_20/vpd[2] rowReadON[0] rowReadON[1]
+ RefrBp PrBp PrSFBp col_periphery_1x2_20/COL_LINE0 pixRst[40] pixRst[41] col_periphery_1x2_20/COL_LINE1
+ OffBn rowReadOFF[0] rowReadOFF[1] GND DiffBn VSUBS OnBn VDD openDVS_pixel2x2_bot
XopenDVS_pixel2x2_bot_42 openDVS_pixel2x2_bot_42/vpd[0] openDVS_pixel2x2_bot_42/vpd[1]
+ openDVS_pixel2x2_bot_42/vpd[3] openDVS_pixel2x2_bot_42/vpd[2] rowReadON[2] rowReadON[3]
+ RefrBp PrBp PrSFBp col_periphery_1x2_10/COL_LINE0 pixRst[20] pixRst[21] col_periphery_1x2_10/COL_LINE1
+ OffBn rowReadOFF[2] rowReadOFF[3] openDVS_pixel2x2_bot_63/GndD DiffBn VSUBS OnBn
+ VDD openDVS_pixel2x2_bot
XopenDVS_pixel2x2_bot_75 openDVS_pixel2x2_bot_75/vpd[0] openDVS_pixel2x2_bot_75/vpd[1]
+ openDVS_pixel2x2_bot_75/vpd[3] openDVS_pixel2x2_bot_75/vpd[2] rowReadON[4] rowReadON[5]
+ RefrBp PrBp PrSFBp col_periphery_1x2_11/COL_LINE0 pixRst[22] pixRst[23] col_periphery_1x2_11/COL_LINE1
+ OffBn rowReadOFF[4] rowReadOFF[5] openDVS_pixel2x2_bot_95/GndD DiffBn VSUBS OnBn
+ VDD openDVS_pixel2x2_bot
XopenDVS_pixel2x2_bot_53 openDVS_pixel2x2_bot_53/vpd[0] openDVS_pixel2x2_bot_53/vpd[1]
+ openDVS_pixel2x2_bot_53/vpd[3] openDVS_pixel2x2_bot_53/vpd[2] rowReadON[2] rowReadON[3]
+ RefrBp PrBp PrSFBp col_periphery_1x2_21/COL_LINE0 pixRst[42] pixRst[43] col_periphery_1x2_21/COL_LINE1
+ OffBn rowReadOFF[2] rowReadOFF[3] openDVS_pixel2x2_bot_63/GndD DiffBn VSUBS OnBn
+ VDD openDVS_pixel2x2_bot
XopenDVS_pixel2x2_bot_97 openDVS_pixel2x2_bot_97/vpd[0] openDVS_pixel2x2_bot_97/vpd[1]
+ openDVS_pixel2x2_bot_97/vpd[3] openDVS_pixel2x2_bot_97/vpd[2] rowReadON[6] rowReadON[7]
+ RefrBp PrBp PrSFBp col_periphery_1x2_1/COL_LINE0 pixRst[2] pixRst[3] col_periphery_1x2_1/COL_LINE1
+ OffBn rowReadOFF[6] rowReadOFF[7] openDVS_pixel2x2_bot_99/GndD DiffBn VSUBS OnBn
+ VDD openDVS_pixel2x2_bot
XopenDVS_pixel2x2_bot_86 openDVS_pixel2x2_bot_86/vpd[0] openDVS_pixel2x2_bot_86/vpd[1]
+ openDVS_pixel2x2_bot_86/vpd[3] openDVS_pixel2x2_bot_86/vpd[2] rowReadON[4] rowReadON[5]
+ RefrBp PrBp PrSFBp col_periphery_1x2_22/COL_LINE0 pixRst[44] pixRst[45] col_periphery_1x2_22/COL_LINE1
+ OffBn rowReadOFF[4] rowReadOFF[5] openDVS_pixel2x2_bot_95/GndD DiffBn VSUBS OnBn
+ VDD openDVS_pixel2x2_bot
XopenDVS_pixel2x2_bot_1017 openDVS_pixel2x2_bot_1017/vpd[0] openDVS_pixel2x2_bot_1017/vpd[1]
+ openDVS_pixel2x2_bot_1017/vpd[3] openDVS_pixel2x2_bot_1017/vpd[2] rowReadON[62]
+ rowReadON[63] RefrBp PrBp PrSFBp col_periphery_1x2_25/COL_LINE0 pixRst[50] pixRst[51]
+ col_periphery_1x2_25/COL_LINE1 OffBn rowReadOFF[62] rowReadOFF[63] openDVS_pixel2x2_bot_999/GndD
+ DiffBn VSUBS OnBn VDD openDVS_pixel2x2_bot
XopenDVS_pixel2x2_bot_1006 openDVS_pixel2x2_bot_1006/vpd[0] openDVS_pixel2x2_bot_1006/vpd[1]
+ openDVS_pixel2x2_bot_1006/vpd[3] openDVS_pixel2x2_bot_1006/vpd[2] rowReadON[62]
+ rowReadON[63] RefrBp PrBp PrSFBp col_periphery_1x2_14/COL_LINE0 pixRst[28] pixRst[29]
+ col_periphery_1x2_14/COL_LINE1 OffBn rowReadOFF[62] rowReadOFF[63] openDVS_pixel2x2_bot_999/GndD
+ DiffBn VSUBS OnBn VDD openDVS_pixel2x2_bot
XopenDVS_pixel2x2_bot_474 openDVS_pixel2x2_bot_474/vpd[0] openDVS_pixel2x2_bot_474/vpd[1]
+ openDVS_pixel2x2_bot_474/vpd[3] openDVS_pixel2x2_bot_474/vpd[2] rowReadON[28] rowReadON[29]
+ RefrBp PrBp PrSFBp col_periphery_1x2_26/COL_LINE0 pixRst[52] pixRst[53] col_periphery_1x2_26/COL_LINE1
+ OffBn rowReadOFF[28] rowReadOFF[29] openDVS_pixel2x2_bot_479/GndD DiffBn VSUBS OnBn
+ VDD openDVS_pixel2x2_bot
XopenDVS_pixel2x2_bot_441 openDVS_pixel2x2_bot_441/vpd[0] openDVS_pixel2x2_bot_441/vpd[1]
+ openDVS_pixel2x2_bot_441/vpd[3] openDVS_pixel2x2_bot_441/vpd[2] rowReadON[26] rowReadON[27]
+ RefrBp PrBp PrSFBp col_periphery_1x2_25/COL_LINE0 pixRst[50] pixRst[51] col_periphery_1x2_25/COL_LINE1
+ OffBn rowReadOFF[26] rowReadOFF[27] openDVS_pixel2x2_bot_447/GndD DiffBn VSUBS OnBn
+ VDD openDVS_pixel2x2_bot
XopenDVS_pixel2x2_bot_496 openDVS_pixel2x2_bot_496/vpd[0] openDVS_pixel2x2_bot_496/vpd[1]
+ openDVS_pixel2x2_bot_496/vpd[3] openDVS_pixel2x2_bot_496/vpd[2] rowReadON[30] rowReadON[31]
+ RefrBp PrBp PrSFBp col_periphery_1x2_16/COL_LINE0 pixRst[32] pixRst[33] col_periphery_1x2_16/COL_LINE1
+ OffBn rowReadOFF[30] rowReadOFF[31] openDVS_pixel2x2_bot_511/GndD DiffBn VSUBS OnBn
+ VDD openDVS_pixel2x2_bot
XopenDVS_pixel2x2_bot_463 openDVS_pixel2x2_bot_463/vpd[0] openDVS_pixel2x2_bot_463/vpd[1]
+ openDVS_pixel2x2_bot_463/vpd[3] openDVS_pixel2x2_bot_463/vpd[2] rowReadON[28] rowReadON[29]
+ RefrBp PrBp PrSFBp col_periphery_1x2_15/COL_LINE0 pixRst[30] pixRst[31] col_periphery_1x2_15/COL_LINE1
+ OffBn rowReadOFF[28] rowReadOFF[29] openDVS_pixel2x2_bot_479/GndD DiffBn VSUBS OnBn
+ VDD openDVS_pixel2x2_bot
XopenDVS_pixel2x2_bot_430 openDVS_pixel2x2_bot_430/vpd[0] openDVS_pixel2x2_bot_430/vpd[1]
+ openDVS_pixel2x2_bot_430/vpd[3] openDVS_pixel2x2_bot_430/vpd[2] rowReadON[26] rowReadON[27]
+ RefrBp PrBp PrSFBp col_periphery_1x2_14/COL_LINE0 pixRst[28] pixRst[29] col_periphery_1x2_14/COL_LINE1
+ OffBn rowReadOFF[26] rowReadOFF[27] openDVS_pixel2x2_bot_447/GndD DiffBn VSUBS OnBn
+ VDD openDVS_pixel2x2_bot
XopenDVS_pixel2x2_bot_485 openDVS_pixel2x2_bot_485/vpd[0] openDVS_pixel2x2_bot_485/vpd[1]
+ openDVS_pixel2x2_bot_485/vpd[3] openDVS_pixel2x2_bot_485/vpd[2] rowReadON[30] rowReadON[31]
+ RefrBp PrBp PrSFBp col_periphery_1x2_5/COL_LINE0 pixRst[10] pixRst[11] col_periphery_1x2_5/COL_LINE1
+ OffBn rowReadOFF[30] rowReadOFF[31] openDVS_pixel2x2_bot_511/GndD DiffBn VSUBS OnBn
+ VDD openDVS_pixel2x2_bot
XopenDVS_pixel2x2_bot_452 openDVS_pixel2x2_bot_452/vpd[0] openDVS_pixel2x2_bot_452/vpd[1]
+ openDVS_pixel2x2_bot_452/vpd[3] openDVS_pixel2x2_bot_452/vpd[2] rowReadON[28] rowReadON[29]
+ RefrBp PrBp PrSFBp col_periphery_1x2_4/COL_LINE0 pixRst[8] pixRst[9] col_periphery_1x2_4/COL_LINE1
+ OffBn rowReadOFF[28] rowReadOFF[29] openDVS_pixel2x2_bot_479/GndD DiffBn VSUBS OnBn
+ VDD openDVS_pixel2x2_bot
XopenDVS_pixel2x2_bot_260 openDVS_pixel2x2_bot_260/vpd[0] openDVS_pixel2x2_bot_260/vpd[1]
+ openDVS_pixel2x2_bot_260/vpd[3] openDVS_pixel2x2_bot_260/vpd[2] rowReadON[16] rowReadON[17]
+ RefrBp PrBp PrSFBp col_periphery_1x2_4/COL_LINE0 pixRst[8] pixRst[9] col_periphery_1x2_4/COL_LINE1
+ OffBn rowReadOFF[16] rowReadOFF[17] openDVS_pixel2x2_bot_287/GndD DiffBn VSUBS OnBn
+ VDD openDVS_pixel2x2_bot
XopenDVS_pixel2x2_bot_271 openDVS_pixel2x2_bot_271/vpd[0] openDVS_pixel2x2_bot_271/vpd[1]
+ openDVS_pixel2x2_bot_271/vpd[3] openDVS_pixel2x2_bot_271/vpd[2] rowReadON[16] rowReadON[17]
+ RefrBp PrBp PrSFBp col_periphery_1x2_15/COL_LINE0 pixRst[30] pixRst[31] col_periphery_1x2_15/COL_LINE1
+ OffBn rowReadOFF[16] rowReadOFF[17] openDVS_pixel2x2_bot_287/GndD DiffBn VSUBS OnBn
+ VDD openDVS_pixel2x2_bot
XopenDVS_pixel2x2_bot_282 openDVS_pixel2x2_bot_282/vpd[0] openDVS_pixel2x2_bot_282/vpd[1]
+ openDVS_pixel2x2_bot_282/vpd[3] openDVS_pixel2x2_bot_282/vpd[2] rowReadON[16] rowReadON[17]
+ RefrBp PrBp PrSFBp col_periphery_1x2_26/COL_LINE0 pixRst[52] pixRst[53] col_periphery_1x2_26/COL_LINE1
+ OffBn rowReadOFF[16] rowReadOFF[17] openDVS_pixel2x2_bot_287/GndD DiffBn VSUBS OnBn
+ VDD openDVS_pixel2x2_bot
XopenDVS_pixel2x2_bot_293 openDVS_pixel2x2_bot_293/vpd[0] openDVS_pixel2x2_bot_293/vpd[1]
+ openDVS_pixel2x2_bot_293/vpd[3] openDVS_pixel2x2_bot_293/vpd[2] rowReadON[18] rowReadON[19]
+ RefrBp PrBp PrSFBp col_periphery_1x2_5/COL_LINE0 pixRst[10] pixRst[11] col_periphery_1x2_5/COL_LINE1
+ OffBn rowReadOFF[18] rowReadOFF[19] openDVS_pixel2x2_bot_319/GndD DiffBn VSUBS OnBn
+ VDD openDVS_pixel2x2_bot
Xcol_periphery_1x2_28 pixRst[57] col_periphery_1x2_28/COL_LINE0 col_periphery_1x2_28/COL_LINE1
+ nDETECT col_periphery_1x2_9/VDD DETECT VTHRESH voutn[56] VSUBS NCHARGE voutn[57]
+ pixRst[56] col_periphery_1x2
Xcol_periphery_1x2_17 pixRst[35] col_periphery_1x2_17/COL_LINE0 col_periphery_1x2_17/COL_LINE1
+ nDETECT col_periphery_1x2_9/VDD DETECT VTHRESH voutn[34] VSUBS NCHARGE voutn[35]
+ pixRst[34] col_periphery_1x2
XopenDVS_pixel2x2_bot_6 openDVS_pixel2x2_bot_6/vpd[0] openDVS_pixel2x2_bot_6/vpd[1]
+ openDVS_pixel2x2_bot_6/vpd[3] openDVS_pixel2x2_bot_6/vpd[2] rowReadON[0] rowReadON[1]
+ RefrBp PrBp PrSFBp col_periphery_1x2_6/COL_LINE0 pixRst[12] pixRst[13] col_periphery_1x2_6/COL_LINE1
+ OffBn rowReadOFF[0] rowReadOFF[1] GND DiffBn VSUBS OnBn VDD openDVS_pixel2x2_bot
XopenDVS_pixel2x2_bot_859 openDVS_pixel2x2_bot_859/vpd[0] openDVS_pixel2x2_bot_859/vpd[1]
+ openDVS_pixel2x2_bot_859/vpd[3] openDVS_pixel2x2_bot_859/vpd[2] rowReadON[52] rowReadON[53]
+ RefrBp PrBp PrSFBp col_periphery_1x2_27/COL_LINE0 pixRst[54] pixRst[55] col_periphery_1x2_27/COL_LINE1
+ OffBn rowReadOFF[52] rowReadOFF[53] openDVS_pixel2x2_bot_863/GndD DiffBn VSUBS OnBn
+ VDD openDVS_pixel2x2_bot
XopenDVS_pixel2x2_bot_848 openDVS_pixel2x2_bot_848/vpd[0] openDVS_pixel2x2_bot_848/vpd[1]
+ openDVS_pixel2x2_bot_848/vpd[3] openDVS_pixel2x2_bot_848/vpd[2] rowReadON[52] rowReadON[53]
+ RefrBp PrBp PrSFBp col_periphery_1x2_16/COL_LINE0 pixRst[32] pixRst[33] col_periphery_1x2_16/COL_LINE1
+ OffBn rowReadOFF[52] rowReadOFF[53] openDVS_pixel2x2_bot_863/GndD DiffBn VSUBS OnBn
+ VDD openDVS_pixel2x2_bot
XopenDVS_pixel2x2_bot_837 openDVS_pixel2x2_bot_837/vpd[0] openDVS_pixel2x2_bot_837/vpd[1]
+ openDVS_pixel2x2_bot_837/vpd[3] openDVS_pixel2x2_bot_837/vpd[2] rowReadON[52] rowReadON[53]
+ RefrBp PrBp PrSFBp col_periphery_1x2_5/COL_LINE0 pixRst[10] pixRst[11] col_periphery_1x2_5/COL_LINE1
+ OffBn rowReadOFF[52] rowReadOFF[53] openDVS_pixel2x2_bot_863/GndD DiffBn VSUBS OnBn
+ VDD openDVS_pixel2x2_bot
XopenDVS_pixel2x2_bot_826 openDVS_pixel2x2_bot_826/vpd[0] openDVS_pixel2x2_bot_826/vpd[1]
+ openDVS_pixel2x2_bot_826/vpd[3] openDVS_pixel2x2_bot_826/vpd[2] rowReadON[50] rowReadON[51]
+ RefrBp PrBp PrSFBp col_periphery_1x2_26/COL_LINE0 pixRst[52] pixRst[53] col_periphery_1x2_26/COL_LINE1
+ OffBn rowReadOFF[50] rowReadOFF[51] openDVS_pixel2x2_bot_831/GndD DiffBn VSUBS OnBn
+ VDD openDVS_pixel2x2_bot
XopenDVS_pixel2x2_bot_815 openDVS_pixel2x2_bot_815/vpd[0] openDVS_pixel2x2_bot_815/vpd[1]
+ openDVS_pixel2x2_bot_815/vpd[3] openDVS_pixel2x2_bot_815/vpd[2] rowReadON[50] rowReadON[51]
+ RefrBp PrBp PrSFBp col_periphery_1x2_15/COL_LINE0 pixRst[30] pixRst[31] col_periphery_1x2_15/COL_LINE1
+ OffBn rowReadOFF[50] rowReadOFF[51] openDVS_pixel2x2_bot_831/GndD DiffBn VSUBS OnBn
+ VDD openDVS_pixel2x2_bot
XopenDVS_pixel2x2_bot_804 openDVS_pixel2x2_bot_804/vpd[0] openDVS_pixel2x2_bot_804/vpd[1]
+ openDVS_pixel2x2_bot_804/vpd[3] openDVS_pixel2x2_bot_804/vpd[2] rowReadON[50] rowReadON[51]
+ RefrBp PrBp PrSFBp col_periphery_1x2_4/COL_LINE0 pixRst[8] pixRst[9] col_periphery_1x2_4/COL_LINE1
+ OffBn rowReadOFF[50] rowReadOFF[51] openDVS_pixel2x2_bot_831/GndD DiffBn VSUBS OnBn
+ VDD openDVS_pixel2x2_bot
XopenDVS_pixel2x2_bot_689 openDVS_pixel2x2_bot_689/vpd[0] openDVS_pixel2x2_bot_689/vpd[1]
+ openDVS_pixel2x2_bot_689/vpd[3] openDVS_pixel2x2_bot_689/vpd[2] rowReadON[42] rowReadON[43]
+ RefrBp PrBp PrSFBp col_periphery_1x2_17/COL_LINE0 pixRst[34] pixRst[35] col_periphery_1x2_17/COL_LINE1
+ OffBn rowReadOFF[42] rowReadOFF[43] openDVS_pixel2x2_bot_703/GndD DiffBn VSUBS OnBn
+ VDD openDVS_pixel2x2_bot
XopenDVS_pixel2x2_bot_678 openDVS_pixel2x2_bot_678/vpd[0] openDVS_pixel2x2_bot_678/vpd[1]
+ openDVS_pixel2x2_bot_678/vpd[3] openDVS_pixel2x2_bot_678/vpd[2] rowReadON[42] rowReadON[43]
+ RefrBp PrBp PrSFBp col_periphery_1x2_6/COL_LINE0 pixRst[12] pixRst[13] col_periphery_1x2_6/COL_LINE1
+ OffBn rowReadOFF[42] rowReadOFF[43] openDVS_pixel2x2_bot_703/GndD DiffBn VSUBS OnBn
+ VDD openDVS_pixel2x2_bot
XopenDVS_pixel2x2_bot_667 openDVS_pixel2x2_bot_667/vpd[0] openDVS_pixel2x2_bot_667/vpd[1]
+ openDVS_pixel2x2_bot_667/vpd[3] openDVS_pixel2x2_bot_667/vpd[2] rowReadON[40] rowReadON[41]
+ RefrBp PrBp PrSFBp col_periphery_1x2_27/COL_LINE0 pixRst[54] pixRst[55] col_periphery_1x2_27/COL_LINE1
+ OffBn rowReadOFF[40] rowReadOFF[41] openDVS_pixel2x2_bot_671/GndD DiffBn VSUBS OnBn
+ VDD openDVS_pixel2x2_bot
XopenDVS_pixel2x2_bot_634 openDVS_pixel2x2_bot_634/vpd[0] openDVS_pixel2x2_bot_634/vpd[1]
+ openDVS_pixel2x2_bot_634/vpd[3] openDVS_pixel2x2_bot_634/vpd[2] rowReadON[38] rowReadON[39]
+ RefrBp PrBp PrSFBp col_periphery_1x2_26/COL_LINE0 pixRst[52] pixRst[53] col_periphery_1x2_26/COL_LINE1
+ OffBn rowReadOFF[38] rowReadOFF[39] openDVS_pixel2x2_bot_639/GndD DiffBn VSUBS OnBn
+ VDD openDVS_pixel2x2_bot
XopenDVS_pixel2x2_bot_601 openDVS_pixel2x2_bot_601/vpd[0] openDVS_pixel2x2_bot_601/vpd[1]
+ openDVS_pixel2x2_bot_601/vpd[3] openDVS_pixel2x2_bot_601/vpd[2] rowReadON[36] rowReadON[37]
+ RefrBp PrBp PrSFBp col_periphery_1x2_25/COL_LINE0 pixRst[50] pixRst[51] col_periphery_1x2_25/COL_LINE1
+ OffBn rowReadOFF[36] rowReadOFF[37] openDVS_pixel2x2_bot_607/GndD DiffBn VSUBS OnBn
+ VDD openDVS_pixel2x2_bot
XopenDVS_pixel2x2_bot_656 openDVS_pixel2x2_bot_656/vpd[0] openDVS_pixel2x2_bot_656/vpd[1]
+ openDVS_pixel2x2_bot_656/vpd[3] openDVS_pixel2x2_bot_656/vpd[2] rowReadON[40] rowReadON[41]
+ RefrBp PrBp PrSFBp col_periphery_1x2_16/COL_LINE0 pixRst[32] pixRst[33] col_periphery_1x2_16/COL_LINE1
+ OffBn rowReadOFF[40] rowReadOFF[41] openDVS_pixel2x2_bot_671/GndD DiffBn VSUBS OnBn
+ VDD openDVS_pixel2x2_bot
XopenDVS_pixel2x2_bot_623 openDVS_pixel2x2_bot_623/vpd[0] openDVS_pixel2x2_bot_623/vpd[1]
+ openDVS_pixel2x2_bot_623/vpd[3] openDVS_pixel2x2_bot_623/vpd[2] rowReadON[38] rowReadON[39]
+ RefrBp PrBp PrSFBp col_periphery_1x2_15/COL_LINE0 pixRst[30] pixRst[31] col_periphery_1x2_15/COL_LINE1
+ OffBn rowReadOFF[38] rowReadOFF[39] openDVS_pixel2x2_bot_639/GndD DiffBn VSUBS OnBn
+ VDD openDVS_pixel2x2_bot
XopenDVS_pixel2x2_bot_645 openDVS_pixel2x2_bot_645/vpd[0] openDVS_pixel2x2_bot_645/vpd[1]
+ openDVS_pixel2x2_bot_645/vpd[3] openDVS_pixel2x2_bot_645/vpd[2] rowReadON[40] rowReadON[41]
+ RefrBp PrBp PrSFBp col_periphery_1x2_5/COL_LINE0 pixRst[10] pixRst[11] col_periphery_1x2_5/COL_LINE1
+ OffBn rowReadOFF[40] rowReadOFF[41] openDVS_pixel2x2_bot_671/GndD DiffBn VSUBS OnBn
+ VDD openDVS_pixel2x2_bot
XopenDVS_pixel2x2_bot_612 openDVS_pixel2x2_bot_612/vpd[0] openDVS_pixel2x2_bot_612/vpd[1]
+ openDVS_pixel2x2_bot_612/vpd[3] openDVS_pixel2x2_bot_612/vpd[2] rowReadON[38] rowReadON[39]
+ RefrBp PrBp PrSFBp col_periphery_1x2_4/COL_LINE0 pixRst[8] pixRst[9] col_periphery_1x2_4/COL_LINE1
+ OffBn rowReadOFF[38] rowReadOFF[39] openDVS_pixel2x2_bot_639/GndD DiffBn VSUBS OnBn
+ VDD openDVS_pixel2x2_bot
XopenDVS_pixel2x2_bot_98 openDVS_pixel2x2_bot_98/vpd[0] openDVS_pixel2x2_bot_98/vpd[1]
+ openDVS_pixel2x2_bot_98/vpd[3] openDVS_pixel2x2_bot_98/vpd[2] rowReadON[6] rowReadON[7]
+ RefrBp PrBp PrSFBp col_periphery_1x2_2/COL_LINE0 pixRst[4] pixRst[5] col_periphery_1x2_2/COL_LINE1
+ OffBn rowReadOFF[6] rowReadOFF[7] openDVS_pixel2x2_bot_99/GndD DiffBn VSUBS OnBn
+ VDD openDVS_pixel2x2_bot
XopenDVS_pixel2x2_bot_65 openDVS_pixel2x2_bot_65/vpd[0] openDVS_pixel2x2_bot_65/vpd[1]
+ openDVS_pixel2x2_bot_65/vpd[3] openDVS_pixel2x2_bot_65/vpd[2] rowReadON[4] rowReadON[5]
+ RefrBp PrBp PrSFBp col_periphery_1x2_1/COL_LINE0 pixRst[2] pixRst[3] col_periphery_1x2_1/COL_LINE1
+ OffBn rowReadOFF[4] rowReadOFF[5] openDVS_pixel2x2_bot_95/GndD DiffBn VSUBS OnBn
+ VDD openDVS_pixel2x2_bot
XopenDVS_pixel2x2_bot_32 openDVS_pixel2x2_bot_32/vpd[0] openDVS_pixel2x2_bot_32/vpd[1]
+ openDVS_pixel2x2_bot_32/vpd[3] openDVS_pixel2x2_bot_32/vpd[2] rowReadON[2] rowReadON[3]
+ RefrBp PrBp PrSFBp col_periphery_1x2_0/COL_LINE0 pixRst[0] pixRst[1] col_periphery_1x2_0/COL_LINE1
+ OffBn rowReadOFF[2] rowReadOFF[3] openDVS_pixel2x2_bot_63/GndD DiffBn VSUBS OnBn
+ VDD openDVS_pixel2x2_bot
XopenDVS_pixel2x2_bot_21 openDVS_pixel2x2_bot_21/vpd[0] openDVS_pixel2x2_bot_21/vpd[1]
+ openDVS_pixel2x2_bot_21/vpd[3] openDVS_pixel2x2_bot_21/vpd[2] rowReadON[0] rowReadON[1]
+ RefrBp PrBp PrSFBp col_periphery_1x2_21/COL_LINE0 pixRst[42] pixRst[43] col_periphery_1x2_21/COL_LINE1
+ OffBn rowReadOFF[0] rowReadOFF[1] GND DiffBn VSUBS OnBn VDD openDVS_pixel2x2_bot
XopenDVS_pixel2x2_bot_10 openDVS_pixel2x2_bot_10/vpd[0] openDVS_pixel2x2_bot_10/vpd[1]
+ openDVS_pixel2x2_bot_10/vpd[3] openDVS_pixel2x2_bot_10/vpd[2] rowReadON[0] rowReadON[1]
+ RefrBp PrBp PrSFBp col_periphery_1x2_10/COL_LINE0 pixRst[20] pixRst[21] col_periphery_1x2_10/COL_LINE1
+ OffBn rowReadOFF[0] rowReadOFF[1] GND DiffBn VSUBS OnBn VDD openDVS_pixel2x2_bot
XopenDVS_pixel2x2_bot_43 openDVS_pixel2x2_bot_43/vpd[0] openDVS_pixel2x2_bot_43/vpd[1]
+ openDVS_pixel2x2_bot_43/vpd[3] openDVS_pixel2x2_bot_43/vpd[2] rowReadON[2] rowReadON[3]
+ RefrBp PrBp PrSFBp col_periphery_1x2_11/COL_LINE0 pixRst[22] pixRst[23] col_periphery_1x2_11/COL_LINE1
+ OffBn rowReadOFF[2] rowReadOFF[3] openDVS_pixel2x2_bot_63/GndD DiffBn VSUBS OnBn
+ VDD openDVS_pixel2x2_bot
XopenDVS_pixel2x2_bot_76 openDVS_pixel2x2_bot_76/vpd[0] openDVS_pixel2x2_bot_76/vpd[1]
+ openDVS_pixel2x2_bot_76/vpd[3] openDVS_pixel2x2_bot_76/vpd[2] rowReadON[4] rowReadON[5]
+ RefrBp PrBp PrSFBp col_periphery_1x2_12/COL_LINE0 pixRst[24] pixRst[25] col_periphery_1x2_12/COL_LINE1
+ OffBn rowReadOFF[4] rowReadOFF[5] openDVS_pixel2x2_bot_95/GndD DiffBn VSUBS OnBn
+ VDD openDVS_pixel2x2_bot
XopenDVS_pixel2x2_bot_54 openDVS_pixel2x2_bot_54/vpd[0] openDVS_pixel2x2_bot_54/vpd[1]
+ openDVS_pixel2x2_bot_54/vpd[3] openDVS_pixel2x2_bot_54/vpd[2] rowReadON[2] rowReadON[3]
+ RefrBp PrBp PrSFBp col_periphery_1x2_22/COL_LINE0 pixRst[44] pixRst[45] col_periphery_1x2_22/COL_LINE1
+ OffBn rowReadOFF[2] rowReadOFF[3] openDVS_pixel2x2_bot_63/GndD DiffBn VSUBS OnBn
+ VDD openDVS_pixel2x2_bot
XopenDVS_pixel2x2_bot_87 openDVS_pixel2x2_bot_87/vpd[0] openDVS_pixel2x2_bot_87/vpd[1]
+ openDVS_pixel2x2_bot_87/vpd[3] openDVS_pixel2x2_bot_87/vpd[2] rowReadON[4] rowReadON[5]
+ RefrBp PrBp PrSFBp col_periphery_1x2_23/COL_LINE0 pixRst[46] pixRst[47] col_periphery_1x2_23/COL_LINE1
+ OffBn rowReadOFF[4] rowReadOFF[5] openDVS_pixel2x2_bot_95/GndD DiffBn VSUBS OnBn
+ VDD openDVS_pixel2x2_bot
XopenDVS_pixel2x2_bot_1018 openDVS_pixel2x2_bot_1018/vpd[0] openDVS_pixel2x2_bot_1018/vpd[1]
+ openDVS_pixel2x2_bot_1018/vpd[3] openDVS_pixel2x2_bot_1018/vpd[2] rowReadON[62]
+ rowReadON[63] RefrBp PrBp PrSFBp col_periphery_1x2_26/COL_LINE0 pixRst[52] pixRst[53]
+ col_periphery_1x2_26/COL_LINE1 OffBn rowReadOFF[62] rowReadOFF[63] openDVS_pixel2x2_bot_999/GndD
+ DiffBn VSUBS OnBn VDD openDVS_pixel2x2_bot
XopenDVS_pixel2x2_bot_1007 openDVS_pixel2x2_bot_1007/vpd[0] openDVS_pixel2x2_bot_1007/vpd[1]
+ openDVS_pixel2x2_bot_1007/vpd[3] openDVS_pixel2x2_bot_1007/vpd[2] rowReadON[62]
+ rowReadON[63] RefrBp PrBp PrSFBp col_periphery_1x2_15/COL_LINE0 pixRst[30] pixRst[31]
+ col_periphery_1x2_15/COL_LINE1 OffBn rowReadOFF[62] rowReadOFF[63] openDVS_pixel2x2_bot_999/GndD
+ DiffBn VSUBS OnBn VDD openDVS_pixel2x2_bot
XopenDVS_pixel2x2_bot_475 openDVS_pixel2x2_bot_475/vpd[0] openDVS_pixel2x2_bot_475/vpd[1]
+ openDVS_pixel2x2_bot_475/vpd[3] openDVS_pixel2x2_bot_475/vpd[2] rowReadON[28] rowReadON[29]
+ RefrBp PrBp PrSFBp col_periphery_1x2_27/COL_LINE0 pixRst[54] pixRst[55] col_periphery_1x2_27/COL_LINE1
+ OffBn rowReadOFF[28] rowReadOFF[29] openDVS_pixel2x2_bot_479/GndD DiffBn VSUBS OnBn
+ VDD openDVS_pixel2x2_bot
XopenDVS_pixel2x2_bot_442 openDVS_pixel2x2_bot_442/vpd[0] openDVS_pixel2x2_bot_442/vpd[1]
+ openDVS_pixel2x2_bot_442/vpd[3] openDVS_pixel2x2_bot_442/vpd[2] rowReadON[26] rowReadON[27]
+ RefrBp PrBp PrSFBp col_periphery_1x2_26/COL_LINE0 pixRst[52] pixRst[53] col_periphery_1x2_26/COL_LINE1
+ OffBn rowReadOFF[26] rowReadOFF[27] openDVS_pixel2x2_bot_447/GndD DiffBn VSUBS OnBn
+ VDD openDVS_pixel2x2_bot
XopenDVS_pixel2x2_bot_497 openDVS_pixel2x2_bot_497/vpd[0] openDVS_pixel2x2_bot_497/vpd[1]
+ openDVS_pixel2x2_bot_497/vpd[3] openDVS_pixel2x2_bot_497/vpd[2] rowReadON[30] rowReadON[31]
+ RefrBp PrBp PrSFBp col_periphery_1x2_17/COL_LINE0 pixRst[34] pixRst[35] col_periphery_1x2_17/COL_LINE1
+ OffBn rowReadOFF[30] rowReadOFF[31] openDVS_pixel2x2_bot_511/GndD DiffBn VSUBS OnBn
+ VDD openDVS_pixel2x2_bot
XopenDVS_pixel2x2_bot_464 openDVS_pixel2x2_bot_464/vpd[0] openDVS_pixel2x2_bot_464/vpd[1]
+ openDVS_pixel2x2_bot_464/vpd[3] openDVS_pixel2x2_bot_464/vpd[2] rowReadON[28] rowReadON[29]
+ RefrBp PrBp PrSFBp col_periphery_1x2_16/COL_LINE0 pixRst[32] pixRst[33] col_periphery_1x2_16/COL_LINE1
+ OffBn rowReadOFF[28] rowReadOFF[29] openDVS_pixel2x2_bot_479/GndD DiffBn VSUBS OnBn
+ VDD openDVS_pixel2x2_bot
XopenDVS_pixel2x2_bot_431 openDVS_pixel2x2_bot_431/vpd[0] openDVS_pixel2x2_bot_431/vpd[1]
+ openDVS_pixel2x2_bot_431/vpd[3] openDVS_pixel2x2_bot_431/vpd[2] rowReadON[26] rowReadON[27]
+ RefrBp PrBp PrSFBp col_periphery_1x2_15/COL_LINE0 pixRst[30] pixRst[31] col_periphery_1x2_15/COL_LINE1
+ OffBn rowReadOFF[26] rowReadOFF[27] openDVS_pixel2x2_bot_447/GndD DiffBn VSUBS OnBn
+ VDD openDVS_pixel2x2_bot
XopenDVS_pixel2x2_bot_486 openDVS_pixel2x2_bot_486/vpd[0] openDVS_pixel2x2_bot_486/vpd[1]
+ openDVS_pixel2x2_bot_486/vpd[3] openDVS_pixel2x2_bot_486/vpd[2] rowReadON[30] rowReadON[31]
+ RefrBp PrBp PrSFBp col_periphery_1x2_6/COL_LINE0 pixRst[12] pixRst[13] col_periphery_1x2_6/COL_LINE1
+ OffBn rowReadOFF[30] rowReadOFF[31] openDVS_pixel2x2_bot_511/GndD DiffBn VSUBS OnBn
+ VDD openDVS_pixel2x2_bot
XopenDVS_pixel2x2_bot_453 openDVS_pixel2x2_bot_453/vpd[0] openDVS_pixel2x2_bot_453/vpd[1]
+ openDVS_pixel2x2_bot_453/vpd[3] openDVS_pixel2x2_bot_453/vpd[2] rowReadON[28] rowReadON[29]
+ RefrBp PrBp PrSFBp col_periphery_1x2_5/COL_LINE0 pixRst[10] pixRst[11] col_periphery_1x2_5/COL_LINE1
+ OffBn rowReadOFF[28] rowReadOFF[29] openDVS_pixel2x2_bot_479/GndD DiffBn VSUBS OnBn
+ VDD openDVS_pixel2x2_bot
XopenDVS_pixel2x2_bot_420 openDVS_pixel2x2_bot_420/vpd[0] openDVS_pixel2x2_bot_420/vpd[1]
+ openDVS_pixel2x2_bot_420/vpd[3] openDVS_pixel2x2_bot_420/vpd[2] rowReadON[26] rowReadON[27]
+ RefrBp PrBp PrSFBp col_periphery_1x2_4/COL_LINE0 pixRst[8] pixRst[9] col_periphery_1x2_4/COL_LINE1
+ OffBn rowReadOFF[26] rowReadOFF[27] openDVS_pixel2x2_bot_447/GndD DiffBn VSUBS OnBn
+ VDD openDVS_pixel2x2_bot
XopenDVS_pixel2x2_bot_261 openDVS_pixel2x2_bot_261/vpd[0] openDVS_pixel2x2_bot_261/vpd[1]
+ openDVS_pixel2x2_bot_261/vpd[3] openDVS_pixel2x2_bot_261/vpd[2] rowReadON[16] rowReadON[17]
+ RefrBp PrBp PrSFBp col_periphery_1x2_5/COL_LINE0 pixRst[10] pixRst[11] col_periphery_1x2_5/COL_LINE1
+ OffBn rowReadOFF[16] rowReadOFF[17] openDVS_pixel2x2_bot_287/GndD DiffBn VSUBS OnBn
+ VDD openDVS_pixel2x2_bot
XopenDVS_pixel2x2_bot_294 openDVS_pixel2x2_bot_294/vpd[0] openDVS_pixel2x2_bot_294/vpd[1]
+ openDVS_pixel2x2_bot_294/vpd[3] openDVS_pixel2x2_bot_294/vpd[2] rowReadON[18] rowReadON[19]
+ RefrBp PrBp PrSFBp col_periphery_1x2_6/COL_LINE0 pixRst[12] pixRst[13] col_periphery_1x2_6/COL_LINE1
+ OffBn rowReadOFF[18] rowReadOFF[19] openDVS_pixel2x2_bot_319/GndD DiffBn VSUBS OnBn
+ VDD openDVS_pixel2x2_bot
XopenDVS_pixel2x2_bot_272 openDVS_pixel2x2_bot_272/vpd[0] openDVS_pixel2x2_bot_272/vpd[1]
+ openDVS_pixel2x2_bot_272/vpd[3] openDVS_pixel2x2_bot_272/vpd[2] rowReadON[16] rowReadON[17]
+ RefrBp PrBp PrSFBp col_periphery_1x2_16/COL_LINE0 pixRst[32] pixRst[33] col_periphery_1x2_16/COL_LINE1
+ OffBn rowReadOFF[16] rowReadOFF[17] openDVS_pixel2x2_bot_287/GndD DiffBn VSUBS OnBn
+ VDD openDVS_pixel2x2_bot
XopenDVS_pixel2x2_bot_250 openDVS_pixel2x2_bot_250/vpd[0] openDVS_pixel2x2_bot_250/vpd[1]
+ openDVS_pixel2x2_bot_250/vpd[3] openDVS_pixel2x2_bot_250/vpd[2] rowReadON[14] rowReadON[15]
+ RefrBp PrBp PrSFBp col_periphery_1x2_26/COL_LINE0 pixRst[52] pixRst[53] col_periphery_1x2_26/COL_LINE1
+ OffBn rowReadOFF[14] rowReadOFF[15] openDVS_pixel2x2_bot_255/GndD DiffBn VSUBS OnBn
+ VDD openDVS_pixel2x2_bot
XopenDVS_pixel2x2_bot_283 openDVS_pixel2x2_bot_283/vpd[0] openDVS_pixel2x2_bot_283/vpd[1]
+ openDVS_pixel2x2_bot_283/vpd[3] openDVS_pixel2x2_bot_283/vpd[2] rowReadON[16] rowReadON[17]
+ RefrBp PrBp PrSFBp col_periphery_1x2_27/COL_LINE0 pixRst[54] pixRst[55] col_periphery_1x2_27/COL_LINE1
+ OffBn rowReadOFF[16] rowReadOFF[17] openDVS_pixel2x2_bot_287/GndD DiffBn VSUBS OnBn
+ VDD openDVS_pixel2x2_bot
Xcol_periphery_1x2_29 pixRst[59] col_periphery_1x2_29/COL_LINE0 col_periphery_1x2_29/COL_LINE1
+ nDETECT col_periphery_1x2_9/VDD DETECT VTHRESH voutn[58] VSUBS NCHARGE voutn[59]
+ pixRst[58] col_periphery_1x2
Xcol_periphery_1x2_18 pixRst[37] col_periphery_1x2_18/COL_LINE0 col_periphery_1x2_18/COL_LINE1
+ nDETECT col_periphery_1x2_9/VDD DETECT VTHRESH voutn[36] VSUBS NCHARGE voutn[37]
+ pixRst[36] col_periphery_1x2
XopenDVS_pixel2x2_bot_7 openDVS_pixel2x2_bot_7/vpd[0] openDVS_pixel2x2_bot_7/vpd[1]
+ openDVS_pixel2x2_bot_7/vpd[3] openDVS_pixel2x2_bot_7/vpd[2] rowReadON[0] rowReadON[1]
+ RefrBp PrBp PrSFBp col_periphery_1x2_7/COL_LINE0 pixRst[14] pixRst[15] col_periphery_1x2_7/COL_LINE1
+ OffBn rowReadOFF[0] rowReadOFF[1] GND DiffBn VSUBS OnBn VDD openDVS_pixel2x2_bot
XopenDVS_pixel2x2_bot_849 openDVS_pixel2x2_bot_849/vpd[0] openDVS_pixel2x2_bot_849/vpd[1]
+ openDVS_pixel2x2_bot_849/vpd[3] openDVS_pixel2x2_bot_849/vpd[2] rowReadON[52] rowReadON[53]
+ RefrBp PrBp PrSFBp col_periphery_1x2_17/COL_LINE0 pixRst[34] pixRst[35] col_periphery_1x2_17/COL_LINE1
+ OffBn rowReadOFF[52] rowReadOFF[53] openDVS_pixel2x2_bot_863/GndD DiffBn VSUBS OnBn
+ VDD openDVS_pixel2x2_bot
XopenDVS_pixel2x2_bot_838 openDVS_pixel2x2_bot_838/vpd[0] openDVS_pixel2x2_bot_838/vpd[1]
+ openDVS_pixel2x2_bot_838/vpd[3] openDVS_pixel2x2_bot_838/vpd[2] rowReadON[52] rowReadON[53]
+ RefrBp PrBp PrSFBp col_periphery_1x2_6/COL_LINE0 pixRst[12] pixRst[13] col_periphery_1x2_6/COL_LINE1
+ OffBn rowReadOFF[52] rowReadOFF[53] openDVS_pixel2x2_bot_863/GndD DiffBn VSUBS OnBn
+ VDD openDVS_pixel2x2_bot
XopenDVS_pixel2x2_bot_827 openDVS_pixel2x2_bot_827/vpd[0] openDVS_pixel2x2_bot_827/vpd[1]
+ openDVS_pixel2x2_bot_827/vpd[3] openDVS_pixel2x2_bot_827/vpd[2] rowReadON[50] rowReadON[51]
+ RefrBp PrBp PrSFBp col_periphery_1x2_27/COL_LINE0 pixRst[54] pixRst[55] col_periphery_1x2_27/COL_LINE1
+ OffBn rowReadOFF[50] rowReadOFF[51] openDVS_pixel2x2_bot_831/GndD DiffBn VSUBS OnBn
+ VDD openDVS_pixel2x2_bot
XopenDVS_pixel2x2_bot_816 openDVS_pixel2x2_bot_816/vpd[0] openDVS_pixel2x2_bot_816/vpd[1]
+ openDVS_pixel2x2_bot_816/vpd[3] openDVS_pixel2x2_bot_816/vpd[2] rowReadON[50] rowReadON[51]
+ RefrBp PrBp PrSFBp col_periphery_1x2_16/COL_LINE0 pixRst[32] pixRst[33] col_periphery_1x2_16/COL_LINE1
+ OffBn rowReadOFF[50] rowReadOFF[51] openDVS_pixel2x2_bot_831/GndD DiffBn VSUBS OnBn
+ VDD openDVS_pixel2x2_bot
XopenDVS_pixel2x2_bot_805 openDVS_pixel2x2_bot_805/vpd[0] openDVS_pixel2x2_bot_805/vpd[1]
+ openDVS_pixel2x2_bot_805/vpd[3] openDVS_pixel2x2_bot_805/vpd[2] rowReadON[50] rowReadON[51]
+ RefrBp PrBp PrSFBp col_periphery_1x2_5/COL_LINE0 pixRst[10] pixRst[11] col_periphery_1x2_5/COL_LINE1
+ OffBn rowReadOFF[50] rowReadOFF[51] openDVS_pixel2x2_bot_831/GndD DiffBn VSUBS OnBn
+ VDD openDVS_pixel2x2_bot
XopenDVS_pixel2x2_bot_635 openDVS_pixel2x2_bot_635/vpd[0] openDVS_pixel2x2_bot_635/vpd[1]
+ openDVS_pixel2x2_bot_635/vpd[3] openDVS_pixel2x2_bot_635/vpd[2] rowReadON[38] rowReadON[39]
+ RefrBp PrBp PrSFBp col_periphery_1x2_27/COL_LINE0 pixRst[54] pixRst[55] col_periphery_1x2_27/COL_LINE1
+ OffBn rowReadOFF[38] rowReadOFF[39] openDVS_pixel2x2_bot_639/GndD DiffBn VSUBS OnBn
+ VDD openDVS_pixel2x2_bot
XopenDVS_pixel2x2_bot_602 openDVS_pixel2x2_bot_602/vpd[0] openDVS_pixel2x2_bot_602/vpd[1]
+ openDVS_pixel2x2_bot_602/vpd[3] openDVS_pixel2x2_bot_602/vpd[2] rowReadON[36] rowReadON[37]
+ RefrBp PrBp PrSFBp col_periphery_1x2_26/COL_LINE0 pixRst[52] pixRst[53] col_periphery_1x2_26/COL_LINE1
+ OffBn rowReadOFF[36] rowReadOFF[37] openDVS_pixel2x2_bot_607/GndD DiffBn VSUBS OnBn
+ VDD openDVS_pixel2x2_bot
XopenDVS_pixel2x2_bot_657 openDVS_pixel2x2_bot_657/vpd[0] openDVS_pixel2x2_bot_657/vpd[1]
+ openDVS_pixel2x2_bot_657/vpd[3] openDVS_pixel2x2_bot_657/vpd[2] rowReadON[40] rowReadON[41]
+ RefrBp PrBp PrSFBp col_periphery_1x2_17/COL_LINE0 pixRst[34] pixRst[35] col_periphery_1x2_17/COL_LINE1
+ OffBn rowReadOFF[40] rowReadOFF[41] openDVS_pixel2x2_bot_671/GndD DiffBn VSUBS OnBn
+ VDD openDVS_pixel2x2_bot
XopenDVS_pixel2x2_bot_624 openDVS_pixel2x2_bot_624/vpd[0] openDVS_pixel2x2_bot_624/vpd[1]
+ openDVS_pixel2x2_bot_624/vpd[3] openDVS_pixel2x2_bot_624/vpd[2] rowReadON[38] rowReadON[39]
+ RefrBp PrBp PrSFBp col_periphery_1x2_16/COL_LINE0 pixRst[32] pixRst[33] col_periphery_1x2_16/COL_LINE1
+ OffBn rowReadOFF[38] rowReadOFF[39] openDVS_pixel2x2_bot_639/GndD DiffBn VSUBS OnBn
+ VDD openDVS_pixel2x2_bot
XopenDVS_pixel2x2_bot_646 openDVS_pixel2x2_bot_646/vpd[0] openDVS_pixel2x2_bot_646/vpd[1]
+ openDVS_pixel2x2_bot_646/vpd[3] openDVS_pixel2x2_bot_646/vpd[2] rowReadON[40] rowReadON[41]
+ RefrBp PrBp PrSFBp col_periphery_1x2_6/COL_LINE0 pixRst[12] pixRst[13] col_periphery_1x2_6/COL_LINE1
+ OffBn rowReadOFF[40] rowReadOFF[41] openDVS_pixel2x2_bot_671/GndD DiffBn VSUBS OnBn
+ VDD openDVS_pixel2x2_bot
XopenDVS_pixel2x2_bot_613 openDVS_pixel2x2_bot_613/vpd[0] openDVS_pixel2x2_bot_613/vpd[1]
+ openDVS_pixel2x2_bot_613/vpd[3] openDVS_pixel2x2_bot_613/vpd[2] rowReadON[38] rowReadON[39]
+ RefrBp PrBp PrSFBp col_periphery_1x2_5/COL_LINE0 pixRst[10] pixRst[11] col_periphery_1x2_5/COL_LINE1
+ OffBn rowReadOFF[38] rowReadOFF[39] openDVS_pixel2x2_bot_639/GndD DiffBn VSUBS OnBn
+ VDD openDVS_pixel2x2_bot
XopenDVS_pixel2x2_bot_679 openDVS_pixel2x2_bot_679/vpd[0] openDVS_pixel2x2_bot_679/vpd[1]
+ openDVS_pixel2x2_bot_679/vpd[3] openDVS_pixel2x2_bot_679/vpd[2] rowReadON[42] rowReadON[43]
+ RefrBp PrBp PrSFBp col_periphery_1x2_7/COL_LINE0 pixRst[14] pixRst[15] col_periphery_1x2_7/COL_LINE1
+ OffBn rowReadOFF[42] rowReadOFF[43] openDVS_pixel2x2_bot_703/GndD DiffBn VSUBS OnBn
+ VDD openDVS_pixel2x2_bot
XopenDVS_pixel2x2_bot_668 openDVS_pixel2x2_bot_668/vpd[0] openDVS_pixel2x2_bot_668/vpd[1]
+ openDVS_pixel2x2_bot_668/vpd[3] openDVS_pixel2x2_bot_668/vpd[2] rowReadON[40] rowReadON[41]
+ RefrBp PrBp PrSFBp col_periphery_1x2_28/COL_LINE0 pixRst[56] pixRst[57] col_periphery_1x2_28/COL_LINE1
+ OffBn rowReadOFF[40] rowReadOFF[41] openDVS_pixel2x2_bot_671/GndD DiffBn VSUBS OnBn
+ VDD openDVS_pixel2x2_bot
XopenDVS_pixel2x2_bot_99 openDVS_pixel2x2_bot_99/vpd[0] openDVS_pixel2x2_bot_99/vpd[1]
+ openDVS_pixel2x2_bot_99/vpd[3] openDVS_pixel2x2_bot_99/vpd[2] rowReadON[6] rowReadON[7]
+ RefrBp PrBp PrSFBp col_periphery_1x2_3/COL_LINE0 pixRst[6] pixRst[7] col_periphery_1x2_3/COL_LINE1
+ OffBn rowReadOFF[6] rowReadOFF[7] openDVS_pixel2x2_bot_99/GndD DiffBn VSUBS OnBn
+ VDD openDVS_pixel2x2_bot
XopenDVS_pixel2x2_bot_66 openDVS_pixel2x2_bot_66/vpd[0] openDVS_pixel2x2_bot_66/vpd[1]
+ openDVS_pixel2x2_bot_66/vpd[3] openDVS_pixel2x2_bot_66/vpd[2] rowReadON[4] rowReadON[5]
+ RefrBp PrBp PrSFBp col_periphery_1x2_2/COL_LINE0 pixRst[4] pixRst[5] col_periphery_1x2_2/COL_LINE1
+ OffBn rowReadOFF[4] rowReadOFF[5] openDVS_pixel2x2_bot_95/GndD DiffBn VSUBS OnBn
+ VDD openDVS_pixel2x2_bot
XopenDVS_pixel2x2_bot_33 openDVS_pixel2x2_bot_33/vpd[0] openDVS_pixel2x2_bot_33/vpd[1]
+ openDVS_pixel2x2_bot_33/vpd[3] openDVS_pixel2x2_bot_33/vpd[2] rowReadON[2] rowReadON[3]
+ RefrBp PrBp PrSFBp col_periphery_1x2_1/COL_LINE0 pixRst[2] pixRst[3] col_periphery_1x2_1/COL_LINE1
+ OffBn rowReadOFF[2] rowReadOFF[3] openDVS_pixel2x2_bot_63/GndD DiffBn VSUBS OnBn
+ VDD openDVS_pixel2x2_bot
XopenDVS_pixel2x2_bot_22 openDVS_pixel2x2_bot_22/vpd[0] openDVS_pixel2x2_bot_22/vpd[1]
+ openDVS_pixel2x2_bot_22/vpd[3] openDVS_pixel2x2_bot_22/vpd[2] rowReadON[0] rowReadON[1]
+ RefrBp PrBp PrSFBp col_periphery_1x2_22/COL_LINE0 pixRst[44] pixRst[45] col_periphery_1x2_22/COL_LINE1
+ OffBn rowReadOFF[0] rowReadOFF[1] GND DiffBn VSUBS OnBn VDD openDVS_pixel2x2_bot
XopenDVS_pixel2x2_bot_11 openDVS_pixel2x2_bot_11/vpd[0] openDVS_pixel2x2_bot_11/vpd[1]
+ openDVS_pixel2x2_bot_11/vpd[3] openDVS_pixel2x2_bot_11/vpd[2] rowReadON[0] rowReadON[1]
+ RefrBp PrBp PrSFBp col_periphery_1x2_11/COL_LINE0 pixRst[22] pixRst[23] col_periphery_1x2_11/COL_LINE1
+ OffBn rowReadOFF[0] rowReadOFF[1] GND DiffBn VSUBS OnBn VDD openDVS_pixel2x2_bot
XopenDVS_pixel2x2_bot_44 openDVS_pixel2x2_bot_44/vpd[0] openDVS_pixel2x2_bot_44/vpd[1]
+ openDVS_pixel2x2_bot_44/vpd[3] openDVS_pixel2x2_bot_44/vpd[2] rowReadON[2] rowReadON[3]
+ RefrBp PrBp PrSFBp col_periphery_1x2_12/COL_LINE0 pixRst[24] pixRst[25] col_periphery_1x2_12/COL_LINE1
+ OffBn rowReadOFF[2] rowReadOFF[3] openDVS_pixel2x2_bot_63/GndD DiffBn VSUBS OnBn
+ VDD openDVS_pixel2x2_bot
XopenDVS_pixel2x2_bot_77 openDVS_pixel2x2_bot_77/vpd[0] openDVS_pixel2x2_bot_77/vpd[1]
+ openDVS_pixel2x2_bot_77/vpd[3] openDVS_pixel2x2_bot_77/vpd[2] rowReadON[4] rowReadON[5]
+ RefrBp PrBp PrSFBp col_periphery_1x2_13/COL_LINE0 pixRst[26] pixRst[27] col_periphery_1x2_13/COL_LINE1
+ OffBn rowReadOFF[4] rowReadOFF[5] openDVS_pixel2x2_bot_95/GndD DiffBn VSUBS OnBn
+ VDD openDVS_pixel2x2_bot
XopenDVS_pixel2x2_bot_55 openDVS_pixel2x2_bot_55/vpd[0] openDVS_pixel2x2_bot_55/vpd[1]
+ openDVS_pixel2x2_bot_55/vpd[3] openDVS_pixel2x2_bot_55/vpd[2] rowReadON[2] rowReadON[3]
+ RefrBp PrBp PrSFBp col_periphery_1x2_23/COL_LINE0 pixRst[46] pixRst[47] col_periphery_1x2_23/COL_LINE1
+ OffBn rowReadOFF[2] rowReadOFF[3] openDVS_pixel2x2_bot_63/GndD DiffBn VSUBS OnBn
+ VDD openDVS_pixel2x2_bot
XopenDVS_pixel2x2_bot_88 openDVS_pixel2x2_bot_88/vpd[0] openDVS_pixel2x2_bot_88/vpd[1]
+ openDVS_pixel2x2_bot_88/vpd[3] openDVS_pixel2x2_bot_88/vpd[2] rowReadON[4] rowReadON[5]
+ RefrBp PrBp PrSFBp col_periphery_1x2_24/COL_LINE0 pixRst[48] pixRst[49] col_periphery_1x2_24/COL_LINE1
+ OffBn rowReadOFF[4] rowReadOFF[5] openDVS_pixel2x2_bot_95/GndD DiffBn VSUBS OnBn
+ VDD openDVS_pixel2x2_bot
XopenDVS_pixel2x2_bot_1019 openDVS_pixel2x2_bot_1019/vpd[0] openDVS_pixel2x2_bot_1019/vpd[1]
+ openDVS_pixel2x2_bot_1019/vpd[3] openDVS_pixel2x2_bot_1019/vpd[2] rowReadON[62]
+ rowReadON[63] RefrBp PrBp PrSFBp col_periphery_1x2_27/COL_LINE0 pixRst[54] pixRst[55]
+ col_periphery_1x2_27/COL_LINE1 OffBn rowReadOFF[62] rowReadOFF[63] openDVS_pixel2x2_bot_999/GndD
+ DiffBn VSUBS OnBn VDD openDVS_pixel2x2_bot
XopenDVS_pixel2x2_bot_1008 openDVS_pixel2x2_bot_1008/vpd[0] openDVS_pixel2x2_bot_1008/vpd[1]
+ openDVS_pixel2x2_bot_1008/vpd[3] openDVS_pixel2x2_bot_1008/vpd[2] rowReadON[62]
+ rowReadON[63] RefrBp PrBp PrSFBp col_periphery_1x2_16/COL_LINE0 pixRst[32] pixRst[33]
+ col_periphery_1x2_16/COL_LINE1 OffBn rowReadOFF[62] rowReadOFF[63] openDVS_pixel2x2_bot_999/GndD
+ DiffBn VSUBS OnBn VDD openDVS_pixel2x2_bot
XopenDVS_pixel2x2_bot_476 openDVS_pixel2x2_bot_476/vpd[0] openDVS_pixel2x2_bot_476/vpd[1]
+ openDVS_pixel2x2_bot_476/vpd[3] openDVS_pixel2x2_bot_476/vpd[2] rowReadON[28] rowReadON[29]
+ RefrBp PrBp PrSFBp col_periphery_1x2_28/COL_LINE0 pixRst[56] pixRst[57] col_periphery_1x2_28/COL_LINE1
+ OffBn rowReadOFF[28] rowReadOFF[29] openDVS_pixel2x2_bot_479/GndD DiffBn VSUBS OnBn
+ VDD openDVS_pixel2x2_bot
XopenDVS_pixel2x2_bot_443 openDVS_pixel2x2_bot_443/vpd[0] openDVS_pixel2x2_bot_443/vpd[1]
+ openDVS_pixel2x2_bot_443/vpd[3] openDVS_pixel2x2_bot_443/vpd[2] rowReadON[26] rowReadON[27]
+ RefrBp PrBp PrSFBp col_periphery_1x2_27/COL_LINE0 pixRst[54] pixRst[55] col_periphery_1x2_27/COL_LINE1
+ OffBn rowReadOFF[26] rowReadOFF[27] openDVS_pixel2x2_bot_447/GndD DiffBn VSUBS OnBn
+ VDD openDVS_pixel2x2_bot
XopenDVS_pixel2x2_bot_410 openDVS_pixel2x2_bot_410/vpd[0] openDVS_pixel2x2_bot_410/vpd[1]
+ openDVS_pixel2x2_bot_410/vpd[3] openDVS_pixel2x2_bot_410/vpd[2] rowReadON[24] rowReadON[25]
+ RefrBp PrBp PrSFBp col_periphery_1x2_26/COL_LINE0 pixRst[52] pixRst[53] col_periphery_1x2_26/COL_LINE1
+ OffBn rowReadOFF[24] rowReadOFF[25] openDVS_pixel2x2_bot_415/GndD DiffBn VSUBS OnBn
+ VDD openDVS_pixel2x2_bot
XopenDVS_pixel2x2_bot_498 openDVS_pixel2x2_bot_498/vpd[0] openDVS_pixel2x2_bot_498/vpd[1]
+ openDVS_pixel2x2_bot_498/vpd[3] openDVS_pixel2x2_bot_498/vpd[2] rowReadON[30] rowReadON[31]
+ RefrBp PrBp PrSFBp col_periphery_1x2_18/COL_LINE0 pixRst[36] pixRst[37] col_periphery_1x2_18/COL_LINE1
+ OffBn rowReadOFF[30] rowReadOFF[31] openDVS_pixel2x2_bot_511/GndD DiffBn VSUBS OnBn
+ VDD openDVS_pixel2x2_bot
XopenDVS_pixel2x2_bot_465 openDVS_pixel2x2_bot_465/vpd[0] openDVS_pixel2x2_bot_465/vpd[1]
+ openDVS_pixel2x2_bot_465/vpd[3] openDVS_pixel2x2_bot_465/vpd[2] rowReadON[28] rowReadON[29]
+ RefrBp PrBp PrSFBp col_periphery_1x2_17/COL_LINE0 pixRst[34] pixRst[35] col_periphery_1x2_17/COL_LINE1
+ OffBn rowReadOFF[28] rowReadOFF[29] openDVS_pixel2x2_bot_479/GndD DiffBn VSUBS OnBn
+ VDD openDVS_pixel2x2_bot
XopenDVS_pixel2x2_bot_432 openDVS_pixel2x2_bot_432/vpd[0] openDVS_pixel2x2_bot_432/vpd[1]
+ openDVS_pixel2x2_bot_432/vpd[3] openDVS_pixel2x2_bot_432/vpd[2] rowReadON[26] rowReadON[27]
+ RefrBp PrBp PrSFBp col_periphery_1x2_16/COL_LINE0 pixRst[32] pixRst[33] col_periphery_1x2_16/COL_LINE1
+ OffBn rowReadOFF[26] rowReadOFF[27] openDVS_pixel2x2_bot_447/GndD DiffBn VSUBS OnBn
+ VDD openDVS_pixel2x2_bot
XopenDVS_pixel2x2_bot_487 openDVS_pixel2x2_bot_487/vpd[0] openDVS_pixel2x2_bot_487/vpd[1]
+ openDVS_pixel2x2_bot_487/vpd[3] openDVS_pixel2x2_bot_487/vpd[2] rowReadON[30] rowReadON[31]
+ RefrBp PrBp PrSFBp col_periphery_1x2_7/COL_LINE0 pixRst[14] pixRst[15] col_periphery_1x2_7/COL_LINE1
+ OffBn rowReadOFF[30] rowReadOFF[31] openDVS_pixel2x2_bot_511/GndD DiffBn VSUBS OnBn
+ VDD openDVS_pixel2x2_bot
XopenDVS_pixel2x2_bot_454 openDVS_pixel2x2_bot_454/vpd[0] openDVS_pixel2x2_bot_454/vpd[1]
+ openDVS_pixel2x2_bot_454/vpd[3] openDVS_pixel2x2_bot_454/vpd[2] rowReadON[28] rowReadON[29]
+ RefrBp PrBp PrSFBp col_periphery_1x2_6/COL_LINE0 pixRst[12] pixRst[13] col_periphery_1x2_6/COL_LINE1
+ OffBn rowReadOFF[28] rowReadOFF[29] openDVS_pixel2x2_bot_479/GndD DiffBn VSUBS OnBn
+ VDD openDVS_pixel2x2_bot
XopenDVS_pixel2x2_bot_421 openDVS_pixel2x2_bot_421/vpd[0] openDVS_pixel2x2_bot_421/vpd[1]
+ openDVS_pixel2x2_bot_421/vpd[3] openDVS_pixel2x2_bot_421/vpd[2] rowReadON[26] rowReadON[27]
+ RefrBp PrBp PrSFBp col_periphery_1x2_5/COL_LINE0 pixRst[10] pixRst[11] col_periphery_1x2_5/COL_LINE1
+ OffBn rowReadOFF[26] rowReadOFF[27] openDVS_pixel2x2_bot_447/GndD DiffBn VSUBS OnBn
+ VDD openDVS_pixel2x2_bot
XopenDVS_pixel2x2_bot_262 openDVS_pixel2x2_bot_262/vpd[0] openDVS_pixel2x2_bot_262/vpd[1]
+ openDVS_pixel2x2_bot_262/vpd[3] openDVS_pixel2x2_bot_262/vpd[2] rowReadON[16] rowReadON[17]
+ RefrBp PrBp PrSFBp col_periphery_1x2_6/COL_LINE0 pixRst[12] pixRst[13] col_periphery_1x2_6/COL_LINE1
+ OffBn rowReadOFF[16] rowReadOFF[17] openDVS_pixel2x2_bot_287/GndD DiffBn VSUBS OnBn
+ VDD openDVS_pixel2x2_bot
XopenDVS_pixel2x2_bot_295 openDVS_pixel2x2_bot_295/vpd[0] openDVS_pixel2x2_bot_295/vpd[1]
+ openDVS_pixel2x2_bot_295/vpd[3] openDVS_pixel2x2_bot_295/vpd[2] rowReadON[18] rowReadON[19]
+ RefrBp PrBp PrSFBp col_periphery_1x2_7/COL_LINE0 pixRst[14] pixRst[15] col_periphery_1x2_7/COL_LINE1
+ OffBn rowReadOFF[18] rowReadOFF[19] openDVS_pixel2x2_bot_319/GndD DiffBn VSUBS OnBn
+ VDD openDVS_pixel2x2_bot
XopenDVS_pixel2x2_bot_240 openDVS_pixel2x2_bot_240/vpd[0] openDVS_pixel2x2_bot_240/vpd[1]
+ openDVS_pixel2x2_bot_240/vpd[3] openDVS_pixel2x2_bot_240/vpd[2] rowReadON[14] rowReadON[15]
+ RefrBp PrBp PrSFBp col_periphery_1x2_16/COL_LINE0 pixRst[32] pixRst[33] col_periphery_1x2_16/COL_LINE1
+ OffBn rowReadOFF[14] rowReadOFF[15] openDVS_pixel2x2_bot_255/GndD DiffBn VSUBS OnBn
+ VDD openDVS_pixel2x2_bot
XopenDVS_pixel2x2_bot_273 openDVS_pixel2x2_bot_273/vpd[0] openDVS_pixel2x2_bot_273/vpd[1]
+ openDVS_pixel2x2_bot_273/vpd[3] openDVS_pixel2x2_bot_273/vpd[2] rowReadON[16] rowReadON[17]
+ RefrBp PrBp PrSFBp col_periphery_1x2_17/COL_LINE0 pixRst[34] pixRst[35] col_periphery_1x2_17/COL_LINE1
+ OffBn rowReadOFF[16] rowReadOFF[17] openDVS_pixel2x2_bot_287/GndD DiffBn VSUBS OnBn
+ VDD openDVS_pixel2x2_bot
XopenDVS_pixel2x2_bot_251 openDVS_pixel2x2_bot_251/vpd[0] openDVS_pixel2x2_bot_251/vpd[1]
+ openDVS_pixel2x2_bot_251/vpd[3] openDVS_pixel2x2_bot_251/vpd[2] rowReadON[14] rowReadON[15]
+ RefrBp PrBp PrSFBp col_periphery_1x2_27/COL_LINE0 pixRst[54] pixRst[55] col_periphery_1x2_27/COL_LINE1
+ OffBn rowReadOFF[14] rowReadOFF[15] openDVS_pixel2x2_bot_255/GndD DiffBn VSUBS OnBn
+ VDD openDVS_pixel2x2_bot
XopenDVS_pixel2x2_bot_284 openDVS_pixel2x2_bot_284/vpd[0] openDVS_pixel2x2_bot_284/vpd[1]
+ openDVS_pixel2x2_bot_284/vpd[3] openDVS_pixel2x2_bot_284/vpd[2] rowReadON[16] rowReadON[17]
+ RefrBp PrBp PrSFBp col_periphery_1x2_28/COL_LINE0 pixRst[56] pixRst[57] col_periphery_1x2_28/COL_LINE1
+ OffBn rowReadOFF[16] rowReadOFF[17] openDVS_pixel2x2_bot_287/GndD DiffBn VSUBS OnBn
+ VDD openDVS_pixel2x2_bot
Xcol_periphery_1x2_19 pixRst[39] col_periphery_1x2_19/COL_LINE0 col_periphery_1x2_19/COL_LINE1
+ nDETECT col_periphery_1x2_9/VDD DETECT VTHRESH voutn[38] VSUBS NCHARGE voutn[39]
+ pixRst[38] col_periphery_1x2
XopenDVS_pixel2x2_bot_8 openDVS_pixel2x2_bot_8/vpd[0] openDVS_pixel2x2_bot_8/vpd[1]
+ openDVS_pixel2x2_bot_8/vpd[3] openDVS_pixel2x2_bot_8/vpd[2] rowReadON[0] rowReadON[1]
+ RefrBp PrBp PrSFBp col_periphery_1x2_8/COL_LINE0 pixRst[16] pixRst[17] col_periphery_1x2_8/COL_LINE1
+ OffBn rowReadOFF[0] rowReadOFF[1] GND DiffBn VSUBS OnBn VDD openDVS_pixel2x2_bot
XopenDVS_pixel2x2_bot_839 openDVS_pixel2x2_bot_839/vpd[0] openDVS_pixel2x2_bot_839/vpd[1]
+ openDVS_pixel2x2_bot_839/vpd[3] openDVS_pixel2x2_bot_839/vpd[2] rowReadON[52] rowReadON[53]
+ RefrBp PrBp PrSFBp col_periphery_1x2_7/COL_LINE0 pixRst[14] pixRst[15] col_periphery_1x2_7/COL_LINE1
+ OffBn rowReadOFF[52] rowReadOFF[53] openDVS_pixel2x2_bot_863/GndD DiffBn VSUBS OnBn
+ VDD openDVS_pixel2x2_bot
XopenDVS_pixel2x2_bot_828 openDVS_pixel2x2_bot_828/vpd[0] openDVS_pixel2x2_bot_828/vpd[1]
+ openDVS_pixel2x2_bot_828/vpd[3] openDVS_pixel2x2_bot_828/vpd[2] rowReadON[50] rowReadON[51]
+ RefrBp PrBp PrSFBp col_periphery_1x2_28/COL_LINE0 pixRst[56] pixRst[57] col_periphery_1x2_28/COL_LINE1
+ OffBn rowReadOFF[50] rowReadOFF[51] openDVS_pixel2x2_bot_831/GndD DiffBn VSUBS OnBn
+ VDD openDVS_pixel2x2_bot
XopenDVS_pixel2x2_bot_817 openDVS_pixel2x2_bot_817/vpd[0] openDVS_pixel2x2_bot_817/vpd[1]
+ openDVS_pixel2x2_bot_817/vpd[3] openDVS_pixel2x2_bot_817/vpd[2] rowReadON[50] rowReadON[51]
+ RefrBp PrBp PrSFBp col_periphery_1x2_17/COL_LINE0 pixRst[34] pixRst[35] col_periphery_1x2_17/COL_LINE1
+ OffBn rowReadOFF[50] rowReadOFF[51] openDVS_pixel2x2_bot_831/GndD DiffBn VSUBS OnBn
+ VDD openDVS_pixel2x2_bot
XopenDVS_pixel2x2_bot_806 openDVS_pixel2x2_bot_806/vpd[0] openDVS_pixel2x2_bot_806/vpd[1]
+ openDVS_pixel2x2_bot_806/vpd[3] openDVS_pixel2x2_bot_806/vpd[2] rowReadON[50] rowReadON[51]
+ RefrBp PrBp PrSFBp col_periphery_1x2_6/COL_LINE0 pixRst[12] pixRst[13] col_periphery_1x2_6/COL_LINE1
+ OffBn rowReadOFF[50] rowReadOFF[51] openDVS_pixel2x2_bot_831/GndD DiffBn VSUBS OnBn
+ VDD openDVS_pixel2x2_bot
XopenDVS_pixel2x2_bot_669 openDVS_pixel2x2_bot_669/vpd[0] openDVS_pixel2x2_bot_669/vpd[1]
+ openDVS_pixel2x2_bot_669/vpd[3] openDVS_pixel2x2_bot_669/vpd[2] rowReadON[40] rowReadON[41]
+ RefrBp PrBp PrSFBp col_periphery_1x2_29/COL_LINE0 pixRst[58] pixRst[59] col_periphery_1x2_29/COL_LINE1
+ OffBn rowReadOFF[40] rowReadOFF[41] openDVS_pixel2x2_bot_671/GndD DiffBn VSUBS OnBn
+ VDD openDVS_pixel2x2_bot
XopenDVS_pixel2x2_bot_636 openDVS_pixel2x2_bot_636/vpd[0] openDVS_pixel2x2_bot_636/vpd[1]
+ openDVS_pixel2x2_bot_636/vpd[3] openDVS_pixel2x2_bot_636/vpd[2] rowReadON[38] rowReadON[39]
+ RefrBp PrBp PrSFBp col_periphery_1x2_28/COL_LINE0 pixRst[56] pixRst[57] col_periphery_1x2_28/COL_LINE1
+ OffBn rowReadOFF[38] rowReadOFF[39] openDVS_pixel2x2_bot_639/GndD DiffBn VSUBS OnBn
+ VDD openDVS_pixel2x2_bot
XopenDVS_pixel2x2_bot_603 openDVS_pixel2x2_bot_603/vpd[0] openDVS_pixel2x2_bot_603/vpd[1]
+ openDVS_pixel2x2_bot_603/vpd[3] openDVS_pixel2x2_bot_603/vpd[2] rowReadON[36] rowReadON[37]
+ RefrBp PrBp PrSFBp col_periphery_1x2_27/COL_LINE0 pixRst[54] pixRst[55] col_periphery_1x2_27/COL_LINE1
+ OffBn rowReadOFF[36] rowReadOFF[37] openDVS_pixel2x2_bot_607/GndD DiffBn VSUBS OnBn
+ VDD openDVS_pixel2x2_bot
XopenDVS_pixel2x2_bot_658 openDVS_pixel2x2_bot_658/vpd[0] openDVS_pixel2x2_bot_658/vpd[1]
+ openDVS_pixel2x2_bot_658/vpd[3] openDVS_pixel2x2_bot_658/vpd[2] rowReadON[40] rowReadON[41]
+ RefrBp PrBp PrSFBp col_periphery_1x2_18/COL_LINE0 pixRst[36] pixRst[37] col_periphery_1x2_18/COL_LINE1
+ OffBn rowReadOFF[40] rowReadOFF[41] openDVS_pixel2x2_bot_671/GndD DiffBn VSUBS OnBn
+ VDD openDVS_pixel2x2_bot
XopenDVS_pixel2x2_bot_625 openDVS_pixel2x2_bot_625/vpd[0] openDVS_pixel2x2_bot_625/vpd[1]
+ openDVS_pixel2x2_bot_625/vpd[3] openDVS_pixel2x2_bot_625/vpd[2] rowReadON[38] rowReadON[39]
+ RefrBp PrBp PrSFBp col_periphery_1x2_17/COL_LINE0 pixRst[34] pixRst[35] col_periphery_1x2_17/COL_LINE1
+ OffBn rowReadOFF[38] rowReadOFF[39] openDVS_pixel2x2_bot_639/GndD DiffBn VSUBS OnBn
+ VDD openDVS_pixel2x2_bot
XopenDVS_pixel2x2_bot_647 openDVS_pixel2x2_bot_647/vpd[0] openDVS_pixel2x2_bot_647/vpd[1]
+ openDVS_pixel2x2_bot_647/vpd[3] openDVS_pixel2x2_bot_647/vpd[2] rowReadON[40] rowReadON[41]
+ RefrBp PrBp PrSFBp col_periphery_1x2_7/COL_LINE0 pixRst[14] pixRst[15] col_periphery_1x2_7/COL_LINE1
+ OffBn rowReadOFF[40] rowReadOFF[41] openDVS_pixel2x2_bot_671/GndD DiffBn VSUBS OnBn
+ VDD openDVS_pixel2x2_bot
XopenDVS_pixel2x2_bot_614 openDVS_pixel2x2_bot_614/vpd[0] openDVS_pixel2x2_bot_614/vpd[1]
+ openDVS_pixel2x2_bot_614/vpd[3] openDVS_pixel2x2_bot_614/vpd[2] rowReadON[38] rowReadON[39]
+ RefrBp PrBp PrSFBp col_periphery_1x2_6/COL_LINE0 pixRst[12] pixRst[13] col_periphery_1x2_6/COL_LINE1
+ OffBn rowReadOFF[38] rowReadOFF[39] openDVS_pixel2x2_bot_639/GndD DiffBn VSUBS OnBn
+ VDD openDVS_pixel2x2_bot
XopenDVS_pixel2x2_bot_67 openDVS_pixel2x2_bot_67/vpd[0] openDVS_pixel2x2_bot_67/vpd[1]
+ openDVS_pixel2x2_bot_67/vpd[3] openDVS_pixel2x2_bot_67/vpd[2] rowReadON[4] rowReadON[5]
+ RefrBp PrBp PrSFBp col_periphery_1x2_3/COL_LINE0 pixRst[6] pixRst[7] col_periphery_1x2_3/COL_LINE1
+ OffBn rowReadOFF[4] rowReadOFF[5] openDVS_pixel2x2_bot_95/GndD DiffBn VSUBS OnBn
+ VDD openDVS_pixel2x2_bot
XopenDVS_pixel2x2_bot_34 openDVS_pixel2x2_bot_34/vpd[0] openDVS_pixel2x2_bot_34/vpd[1]
+ openDVS_pixel2x2_bot_34/vpd[3] openDVS_pixel2x2_bot_34/vpd[2] rowReadON[2] rowReadON[3]
+ RefrBp PrBp PrSFBp col_periphery_1x2_2/COL_LINE0 pixRst[4] pixRst[5] col_periphery_1x2_2/COL_LINE1
+ OffBn rowReadOFF[2] rowReadOFF[3] openDVS_pixel2x2_bot_63/GndD DiffBn VSUBS OnBn
+ VDD openDVS_pixel2x2_bot
XopenDVS_pixel2x2_bot_23 openDVS_pixel2x2_bot_23/vpd[0] openDVS_pixel2x2_bot_23/vpd[1]
+ openDVS_pixel2x2_bot_23/vpd[3] openDVS_pixel2x2_bot_23/vpd[2] rowReadON[0] rowReadON[1]
+ RefrBp PrBp PrSFBp col_periphery_1x2_23/COL_LINE0 pixRst[46] pixRst[47] col_periphery_1x2_23/COL_LINE1
+ OffBn rowReadOFF[0] rowReadOFF[1] GND DiffBn VSUBS OnBn VDD openDVS_pixel2x2_bot
XopenDVS_pixel2x2_bot_12 openDVS_pixel2x2_bot_12/vpd[0] openDVS_pixel2x2_bot_12/vpd[1]
+ openDVS_pixel2x2_bot_12/vpd[3] openDVS_pixel2x2_bot_12/vpd[2] rowReadON[0] rowReadON[1]
+ RefrBp PrBp PrSFBp col_periphery_1x2_12/COL_LINE0 pixRst[24] pixRst[25] col_periphery_1x2_12/COL_LINE1
+ OffBn rowReadOFF[0] rowReadOFF[1] GND DiffBn VSUBS OnBn VDD openDVS_pixel2x2_bot
XopenDVS_pixel2x2_bot_45 openDVS_pixel2x2_bot_45/vpd[0] openDVS_pixel2x2_bot_45/vpd[1]
+ openDVS_pixel2x2_bot_45/vpd[3] openDVS_pixel2x2_bot_45/vpd[2] rowReadON[2] rowReadON[3]
+ RefrBp PrBp PrSFBp col_periphery_1x2_13/COL_LINE0 pixRst[26] pixRst[27] col_periphery_1x2_13/COL_LINE1
+ OffBn rowReadOFF[2] rowReadOFF[3] openDVS_pixel2x2_bot_63/GndD DiffBn VSUBS OnBn
+ VDD openDVS_pixel2x2_bot
XopenDVS_pixel2x2_bot_78 openDVS_pixel2x2_bot_78/vpd[0] openDVS_pixel2x2_bot_78/vpd[1]
+ openDVS_pixel2x2_bot_78/vpd[3] openDVS_pixel2x2_bot_78/vpd[2] rowReadON[4] rowReadON[5]
+ RefrBp PrBp PrSFBp col_periphery_1x2_14/COL_LINE0 pixRst[28] pixRst[29] col_periphery_1x2_14/COL_LINE1
+ OffBn rowReadOFF[4] rowReadOFF[5] openDVS_pixel2x2_bot_95/GndD DiffBn VSUBS OnBn
+ VDD openDVS_pixel2x2_bot
XopenDVS_pixel2x2_bot_56 openDVS_pixel2x2_bot_56/vpd[0] openDVS_pixel2x2_bot_56/vpd[1]
+ openDVS_pixel2x2_bot_56/vpd[3] openDVS_pixel2x2_bot_56/vpd[2] rowReadON[2] rowReadON[3]
+ RefrBp PrBp PrSFBp col_periphery_1x2_24/COL_LINE0 pixRst[48] pixRst[49] col_periphery_1x2_24/COL_LINE1
+ OffBn rowReadOFF[2] rowReadOFF[3] openDVS_pixel2x2_bot_63/GndD DiffBn VSUBS OnBn
+ VDD openDVS_pixel2x2_bot
XopenDVS_pixel2x2_bot_89 openDVS_pixel2x2_bot_89/vpd[0] openDVS_pixel2x2_bot_89/vpd[1]
+ openDVS_pixel2x2_bot_89/vpd[3] openDVS_pixel2x2_bot_89/vpd[2] rowReadON[4] rowReadON[5]
+ RefrBp PrBp PrSFBp col_periphery_1x2_25/COL_LINE0 pixRst[50] pixRst[51] col_periphery_1x2_25/COL_LINE1
+ OffBn rowReadOFF[4] rowReadOFF[5] openDVS_pixel2x2_bot_95/GndD DiffBn VSUBS OnBn
+ VDD openDVS_pixel2x2_bot
XopenDVS_pixel2x2_bot_1009 openDVS_pixel2x2_bot_1009/vpd[0] openDVS_pixel2x2_bot_1009/vpd[1]
+ openDVS_pixel2x2_bot_1009/vpd[3] openDVS_pixel2x2_bot_1009/vpd[2] rowReadON[62]
+ rowReadON[63] RefrBp PrBp PrSFBp col_periphery_1x2_17/COL_LINE0 pixRst[34] pixRst[35]
+ col_periphery_1x2_17/COL_LINE1 OffBn rowReadOFF[62] rowReadOFF[63] openDVS_pixel2x2_bot_999/GndD
+ DiffBn VSUBS OnBn VDD openDVS_pixel2x2_bot
XopenDVS_pixel2x2_bot_477 openDVS_pixel2x2_bot_477/vpd[0] openDVS_pixel2x2_bot_477/vpd[1]
+ openDVS_pixel2x2_bot_477/vpd[3] openDVS_pixel2x2_bot_477/vpd[2] rowReadON[28] rowReadON[29]
+ RefrBp PrBp PrSFBp col_periphery_1x2_29/COL_LINE0 pixRst[58] pixRst[59] col_periphery_1x2_29/COL_LINE1
+ OffBn rowReadOFF[28] rowReadOFF[29] openDVS_pixel2x2_bot_479/GndD DiffBn VSUBS OnBn
+ VDD openDVS_pixel2x2_bot
XopenDVS_pixel2x2_bot_444 openDVS_pixel2x2_bot_444/vpd[0] openDVS_pixel2x2_bot_444/vpd[1]
+ openDVS_pixel2x2_bot_444/vpd[3] openDVS_pixel2x2_bot_444/vpd[2] rowReadON[26] rowReadON[27]
+ RefrBp PrBp PrSFBp col_periphery_1x2_28/COL_LINE0 pixRst[56] pixRst[57] col_periphery_1x2_28/COL_LINE1
+ OffBn rowReadOFF[26] rowReadOFF[27] openDVS_pixel2x2_bot_447/GndD DiffBn VSUBS OnBn
+ VDD openDVS_pixel2x2_bot
XopenDVS_pixel2x2_bot_411 openDVS_pixel2x2_bot_411/vpd[0] openDVS_pixel2x2_bot_411/vpd[1]
+ openDVS_pixel2x2_bot_411/vpd[3] openDVS_pixel2x2_bot_411/vpd[2] rowReadON[24] rowReadON[25]
+ RefrBp PrBp PrSFBp col_periphery_1x2_27/COL_LINE0 pixRst[54] pixRst[55] col_periphery_1x2_27/COL_LINE1
+ OffBn rowReadOFF[24] rowReadOFF[25] openDVS_pixel2x2_bot_415/GndD DiffBn VSUBS OnBn
+ VDD openDVS_pixel2x2_bot
XopenDVS_pixel2x2_bot_499 openDVS_pixel2x2_bot_499/vpd[0] openDVS_pixel2x2_bot_499/vpd[1]
+ openDVS_pixel2x2_bot_499/vpd[3] openDVS_pixel2x2_bot_499/vpd[2] rowReadON[30] rowReadON[31]
+ RefrBp PrBp PrSFBp col_periphery_1x2_19/COL_LINE0 pixRst[38] pixRst[39] col_periphery_1x2_19/COL_LINE1
+ OffBn rowReadOFF[30] rowReadOFF[31] openDVS_pixel2x2_bot_511/GndD DiffBn VSUBS OnBn
+ VDD openDVS_pixel2x2_bot
XopenDVS_pixel2x2_bot_466 openDVS_pixel2x2_bot_466/vpd[0] openDVS_pixel2x2_bot_466/vpd[1]
+ openDVS_pixel2x2_bot_466/vpd[3] openDVS_pixel2x2_bot_466/vpd[2] rowReadON[28] rowReadON[29]
+ RefrBp PrBp PrSFBp col_periphery_1x2_18/COL_LINE0 pixRst[36] pixRst[37] col_periphery_1x2_18/COL_LINE1
+ OffBn rowReadOFF[28] rowReadOFF[29] openDVS_pixel2x2_bot_479/GndD DiffBn VSUBS OnBn
+ VDD openDVS_pixel2x2_bot
XopenDVS_pixel2x2_bot_433 openDVS_pixel2x2_bot_433/vpd[0] openDVS_pixel2x2_bot_433/vpd[1]
+ openDVS_pixel2x2_bot_433/vpd[3] openDVS_pixel2x2_bot_433/vpd[2] rowReadON[26] rowReadON[27]
+ RefrBp PrBp PrSFBp col_periphery_1x2_17/COL_LINE0 pixRst[34] pixRst[35] col_periphery_1x2_17/COL_LINE1
+ OffBn rowReadOFF[26] rowReadOFF[27] openDVS_pixel2x2_bot_447/GndD DiffBn VSUBS OnBn
+ VDD openDVS_pixel2x2_bot
XopenDVS_pixel2x2_bot_400 openDVS_pixel2x2_bot_400/vpd[0] openDVS_pixel2x2_bot_400/vpd[1]
+ openDVS_pixel2x2_bot_400/vpd[3] openDVS_pixel2x2_bot_400/vpd[2] rowReadON[24] rowReadON[25]
+ RefrBp PrBp PrSFBp col_periphery_1x2_16/COL_LINE0 pixRst[32] pixRst[33] col_periphery_1x2_16/COL_LINE1
+ OffBn rowReadOFF[24] rowReadOFF[25] openDVS_pixel2x2_bot_415/GndD DiffBn VSUBS OnBn
+ VDD openDVS_pixel2x2_bot
XopenDVS_pixel2x2_bot_488 openDVS_pixel2x2_bot_488/vpd[0] openDVS_pixel2x2_bot_488/vpd[1]
+ openDVS_pixel2x2_bot_488/vpd[3] openDVS_pixel2x2_bot_488/vpd[2] rowReadON[30] rowReadON[31]
+ RefrBp PrBp PrSFBp col_periphery_1x2_8/COL_LINE0 pixRst[16] pixRst[17] col_periphery_1x2_8/COL_LINE1
+ OffBn rowReadOFF[30] rowReadOFF[31] openDVS_pixel2x2_bot_511/GndD DiffBn VSUBS OnBn
+ VDD openDVS_pixel2x2_bot
XopenDVS_pixel2x2_bot_455 openDVS_pixel2x2_bot_455/vpd[0] openDVS_pixel2x2_bot_455/vpd[1]
+ openDVS_pixel2x2_bot_455/vpd[3] openDVS_pixel2x2_bot_455/vpd[2] rowReadON[28] rowReadON[29]
+ RefrBp PrBp PrSFBp col_periphery_1x2_7/COL_LINE0 pixRst[14] pixRst[15] col_periphery_1x2_7/COL_LINE1
+ OffBn rowReadOFF[28] rowReadOFF[29] openDVS_pixel2x2_bot_479/GndD DiffBn VSUBS OnBn
+ VDD openDVS_pixel2x2_bot
XopenDVS_pixel2x2_bot_422 openDVS_pixel2x2_bot_422/vpd[0] openDVS_pixel2x2_bot_422/vpd[1]
+ openDVS_pixel2x2_bot_422/vpd[3] openDVS_pixel2x2_bot_422/vpd[2] rowReadON[26] rowReadON[27]
+ RefrBp PrBp PrSFBp col_periphery_1x2_6/COL_LINE0 pixRst[12] pixRst[13] col_periphery_1x2_6/COL_LINE1
+ OffBn rowReadOFF[26] rowReadOFF[27] openDVS_pixel2x2_bot_447/GndD DiffBn VSUBS OnBn
+ VDD openDVS_pixel2x2_bot
Xcol_periphery_1x2_0 pixRst[1] col_periphery_1x2_0/COL_LINE0 col_periphery_1x2_0/COL_LINE1
+ nDETECT col_periphery_1x2_9/VDD DETECT VTHRESH voutn[0] VSUBS NCHARGE voutn[1] pixRst[0]
+ col_periphery_1x2
XopenDVS_pixel2x2_bot_230 openDVS_pixel2x2_bot_230/vpd[0] openDVS_pixel2x2_bot_230/vpd[1]
+ openDVS_pixel2x2_bot_230/vpd[3] openDVS_pixel2x2_bot_230/vpd[2] rowReadON[14] rowReadON[15]
+ RefrBp PrBp PrSFBp col_periphery_1x2_6/COL_LINE0 pixRst[12] pixRst[13] col_periphery_1x2_6/COL_LINE1
+ OffBn rowReadOFF[14] rowReadOFF[15] openDVS_pixel2x2_bot_255/GndD DiffBn VSUBS OnBn
+ VDD openDVS_pixel2x2_bot
XopenDVS_pixel2x2_bot_263 openDVS_pixel2x2_bot_263/vpd[0] openDVS_pixel2x2_bot_263/vpd[1]
+ openDVS_pixel2x2_bot_263/vpd[3] openDVS_pixel2x2_bot_263/vpd[2] rowReadON[16] rowReadON[17]
+ RefrBp PrBp PrSFBp col_periphery_1x2_7/COL_LINE0 pixRst[14] pixRst[15] col_periphery_1x2_7/COL_LINE1
+ OffBn rowReadOFF[16] rowReadOFF[17] openDVS_pixel2x2_bot_287/GndD DiffBn VSUBS OnBn
+ VDD openDVS_pixel2x2_bot
XopenDVS_pixel2x2_bot_296 openDVS_pixel2x2_bot_296/vpd[0] openDVS_pixel2x2_bot_296/vpd[1]
+ openDVS_pixel2x2_bot_296/vpd[3] openDVS_pixel2x2_bot_296/vpd[2] rowReadON[18] rowReadON[19]
+ RefrBp PrBp PrSFBp col_periphery_1x2_8/COL_LINE0 pixRst[16] pixRst[17] col_periphery_1x2_8/COL_LINE1
+ OffBn rowReadOFF[18] rowReadOFF[19] openDVS_pixel2x2_bot_319/GndD DiffBn VSUBS OnBn
+ VDD openDVS_pixel2x2_bot
XopenDVS_pixel2x2_bot_241 openDVS_pixel2x2_bot_241/vpd[0] openDVS_pixel2x2_bot_241/vpd[1]
+ openDVS_pixel2x2_bot_241/vpd[3] openDVS_pixel2x2_bot_241/vpd[2] rowReadON[14] rowReadON[15]
+ RefrBp PrBp PrSFBp col_periphery_1x2_17/COL_LINE0 pixRst[34] pixRst[35] col_periphery_1x2_17/COL_LINE1
+ OffBn rowReadOFF[14] rowReadOFF[15] openDVS_pixel2x2_bot_255/GndD DiffBn VSUBS OnBn
+ VDD openDVS_pixel2x2_bot
XopenDVS_pixel2x2_bot_274 openDVS_pixel2x2_bot_274/vpd[0] openDVS_pixel2x2_bot_274/vpd[1]
+ openDVS_pixel2x2_bot_274/vpd[3] openDVS_pixel2x2_bot_274/vpd[2] rowReadON[16] rowReadON[17]
+ RefrBp PrBp PrSFBp col_periphery_1x2_18/COL_LINE0 pixRst[36] pixRst[37] col_periphery_1x2_18/COL_LINE1
+ OffBn rowReadOFF[16] rowReadOFF[17] openDVS_pixel2x2_bot_287/GndD DiffBn VSUBS OnBn
+ VDD openDVS_pixel2x2_bot
XopenDVS_pixel2x2_bot_252 openDVS_pixel2x2_bot_252/vpd[0] openDVS_pixel2x2_bot_252/vpd[1]
+ openDVS_pixel2x2_bot_252/vpd[3] openDVS_pixel2x2_bot_252/vpd[2] rowReadON[14] rowReadON[15]
+ RefrBp PrBp PrSFBp col_periphery_1x2_28/COL_LINE0 pixRst[56] pixRst[57] col_periphery_1x2_28/COL_LINE1
+ OffBn rowReadOFF[14] rowReadOFF[15] openDVS_pixel2x2_bot_255/GndD DiffBn VSUBS OnBn
+ VDD openDVS_pixel2x2_bot
XopenDVS_pixel2x2_bot_285 openDVS_pixel2x2_bot_285/vpd[0] openDVS_pixel2x2_bot_285/vpd[1]
+ openDVS_pixel2x2_bot_285/vpd[3] openDVS_pixel2x2_bot_285/vpd[2] rowReadON[16] rowReadON[17]
+ RefrBp PrBp PrSFBp col_periphery_1x2_29/COL_LINE0 pixRst[58] pixRst[59] col_periphery_1x2_29/COL_LINE1
+ OffBn rowReadOFF[16] rowReadOFF[17] openDVS_pixel2x2_bot_287/GndD DiffBn VSUBS OnBn
+ VDD openDVS_pixel2x2_bot
XopenDVS_pixel2x2_bot_9 openDVS_pixel2x2_bot_9/vpd[0] openDVS_pixel2x2_bot_9/vpd[1]
+ openDVS_pixel2x2_bot_9/vpd[3] openDVS_pixel2x2_bot_9/vpd[2] rowReadON[0] rowReadON[1]
+ RefrBp PrBp PrSFBp col_periphery_1x2_9/COL_LINE0 pixRst[18] pixRst[19] col_periphery_1x2_9/COL_LINE1
+ OffBn rowReadOFF[0] rowReadOFF[1] GND DiffBn VSUBS OnBn VDD openDVS_pixel2x2_bot
XopenDVS_pixel2x2_bot_829 openDVS_pixel2x2_bot_829/vpd[0] openDVS_pixel2x2_bot_829/vpd[1]
+ openDVS_pixel2x2_bot_829/vpd[3] openDVS_pixel2x2_bot_829/vpd[2] rowReadON[50] rowReadON[51]
+ RefrBp PrBp PrSFBp col_periphery_1x2_29/COL_LINE0 pixRst[58] pixRst[59] col_periphery_1x2_29/COL_LINE1
+ OffBn rowReadOFF[50] rowReadOFF[51] openDVS_pixel2x2_bot_831/GndD DiffBn VSUBS OnBn
+ VDD openDVS_pixel2x2_bot
XopenDVS_pixel2x2_bot_818 openDVS_pixel2x2_bot_818/vpd[0] openDVS_pixel2x2_bot_818/vpd[1]
+ openDVS_pixel2x2_bot_818/vpd[3] openDVS_pixel2x2_bot_818/vpd[2] rowReadON[50] rowReadON[51]
+ RefrBp PrBp PrSFBp col_periphery_1x2_18/COL_LINE0 pixRst[36] pixRst[37] col_periphery_1x2_18/COL_LINE1
+ OffBn rowReadOFF[50] rowReadOFF[51] openDVS_pixel2x2_bot_831/GndD DiffBn VSUBS OnBn
+ VDD openDVS_pixel2x2_bot
XopenDVS_pixel2x2_bot_807 openDVS_pixel2x2_bot_807/vpd[0] openDVS_pixel2x2_bot_807/vpd[1]
+ openDVS_pixel2x2_bot_807/vpd[3] openDVS_pixel2x2_bot_807/vpd[2] rowReadON[50] rowReadON[51]
+ RefrBp PrBp PrSFBp col_periphery_1x2_7/COL_LINE0 pixRst[14] pixRst[15] col_periphery_1x2_7/COL_LINE1
+ OffBn rowReadOFF[50] rowReadOFF[51] openDVS_pixel2x2_bot_831/GndD DiffBn VSUBS OnBn
+ VDD openDVS_pixel2x2_bot
XopenDVS_pixel2x2_bot_637 openDVS_pixel2x2_bot_637/vpd[0] openDVS_pixel2x2_bot_637/vpd[1]
+ openDVS_pixel2x2_bot_637/vpd[3] openDVS_pixel2x2_bot_637/vpd[2] rowReadON[38] rowReadON[39]
+ RefrBp PrBp PrSFBp col_periphery_1x2_29/COL_LINE0 pixRst[58] pixRst[59] col_periphery_1x2_29/COL_LINE1
+ OffBn rowReadOFF[38] rowReadOFF[39] openDVS_pixel2x2_bot_639/GndD DiffBn VSUBS OnBn
+ VDD openDVS_pixel2x2_bot
XopenDVS_pixel2x2_bot_604 openDVS_pixel2x2_bot_604/vpd[0] openDVS_pixel2x2_bot_604/vpd[1]
+ openDVS_pixel2x2_bot_604/vpd[3] openDVS_pixel2x2_bot_604/vpd[2] rowReadON[36] rowReadON[37]
+ RefrBp PrBp PrSFBp col_periphery_1x2_28/COL_LINE0 pixRst[56] pixRst[57] col_periphery_1x2_28/COL_LINE1
+ OffBn rowReadOFF[36] rowReadOFF[37] openDVS_pixel2x2_bot_607/GndD DiffBn VSUBS OnBn
+ VDD openDVS_pixel2x2_bot
XopenDVS_pixel2x2_bot_659 openDVS_pixel2x2_bot_659/vpd[0] openDVS_pixel2x2_bot_659/vpd[1]
+ openDVS_pixel2x2_bot_659/vpd[3] openDVS_pixel2x2_bot_659/vpd[2] rowReadON[40] rowReadON[41]
+ RefrBp PrBp PrSFBp col_periphery_1x2_19/COL_LINE0 pixRst[38] pixRst[39] col_periphery_1x2_19/COL_LINE1
+ OffBn rowReadOFF[40] rowReadOFF[41] openDVS_pixel2x2_bot_671/GndD DiffBn VSUBS OnBn
+ VDD openDVS_pixel2x2_bot
XopenDVS_pixel2x2_bot_626 openDVS_pixel2x2_bot_626/vpd[0] openDVS_pixel2x2_bot_626/vpd[1]
+ openDVS_pixel2x2_bot_626/vpd[3] openDVS_pixel2x2_bot_626/vpd[2] rowReadON[38] rowReadON[39]
+ RefrBp PrBp PrSFBp col_periphery_1x2_18/COL_LINE0 pixRst[36] pixRst[37] col_periphery_1x2_18/COL_LINE1
+ OffBn rowReadOFF[38] rowReadOFF[39] openDVS_pixel2x2_bot_639/GndD DiffBn VSUBS OnBn
+ VDD openDVS_pixel2x2_bot
XopenDVS_pixel2x2_bot_648 openDVS_pixel2x2_bot_648/vpd[0] openDVS_pixel2x2_bot_648/vpd[1]
+ openDVS_pixel2x2_bot_648/vpd[3] openDVS_pixel2x2_bot_648/vpd[2] rowReadON[40] rowReadON[41]
+ RefrBp PrBp PrSFBp col_periphery_1x2_8/COL_LINE0 pixRst[16] pixRst[17] col_periphery_1x2_8/COL_LINE1
+ OffBn rowReadOFF[40] rowReadOFF[41] openDVS_pixel2x2_bot_671/GndD DiffBn VSUBS OnBn
+ VDD openDVS_pixel2x2_bot
XopenDVS_pixel2x2_bot_615 openDVS_pixel2x2_bot_615/vpd[0] openDVS_pixel2x2_bot_615/vpd[1]
+ openDVS_pixel2x2_bot_615/vpd[3] openDVS_pixel2x2_bot_615/vpd[2] rowReadON[38] rowReadON[39]
+ RefrBp PrBp PrSFBp col_periphery_1x2_7/COL_LINE0 pixRst[14] pixRst[15] col_periphery_1x2_7/COL_LINE1
+ OffBn rowReadOFF[38] rowReadOFF[39] openDVS_pixel2x2_bot_639/GndD DiffBn VSUBS OnBn
+ VDD openDVS_pixel2x2_bot
XopenDVS_pixel2x2_bot_68 openDVS_pixel2x2_bot_68/vpd[0] openDVS_pixel2x2_bot_68/vpd[1]
+ openDVS_pixel2x2_bot_68/vpd[3] openDVS_pixel2x2_bot_68/vpd[2] rowReadON[4] rowReadON[5]
+ RefrBp PrBp PrSFBp col_periphery_1x2_4/COL_LINE0 pixRst[8] pixRst[9] col_periphery_1x2_4/COL_LINE1
+ OffBn rowReadOFF[4] rowReadOFF[5] openDVS_pixel2x2_bot_95/GndD DiffBn VSUBS OnBn
+ VDD openDVS_pixel2x2_bot
XopenDVS_pixel2x2_bot_35 openDVS_pixel2x2_bot_35/vpd[0] openDVS_pixel2x2_bot_35/vpd[1]
+ openDVS_pixel2x2_bot_35/vpd[3] openDVS_pixel2x2_bot_35/vpd[2] rowReadON[2] rowReadON[3]
+ RefrBp PrBp PrSFBp col_periphery_1x2_3/COL_LINE0 pixRst[6] pixRst[7] col_periphery_1x2_3/COL_LINE1
+ OffBn rowReadOFF[2] rowReadOFF[3] openDVS_pixel2x2_bot_63/GndD DiffBn VSUBS OnBn
+ VDD openDVS_pixel2x2_bot
XopenDVS_pixel2x2_bot_24 openDVS_pixel2x2_bot_24/vpd[0] openDVS_pixel2x2_bot_24/vpd[1]
+ openDVS_pixel2x2_bot_24/vpd[3] openDVS_pixel2x2_bot_24/vpd[2] rowReadON[0] rowReadON[1]
+ RefrBp PrBp PrSFBp col_periphery_1x2_24/COL_LINE0 pixRst[48] pixRst[49] col_periphery_1x2_24/COL_LINE1
+ OffBn rowReadOFF[0] rowReadOFF[1] GND DiffBn VSUBS OnBn VDD openDVS_pixel2x2_bot
XopenDVS_pixel2x2_bot_13 openDVS_pixel2x2_bot_13/vpd[0] openDVS_pixel2x2_bot_13/vpd[1]
+ openDVS_pixel2x2_bot_13/vpd[3] openDVS_pixel2x2_bot_13/vpd[2] rowReadON[0] rowReadON[1]
+ RefrBp PrBp PrSFBp col_periphery_1x2_13/COL_LINE0 pixRst[26] pixRst[27] col_periphery_1x2_13/COL_LINE1
+ OffBn rowReadOFF[0] rowReadOFF[1] GND DiffBn VSUBS OnBn VDD openDVS_pixel2x2_bot
XopenDVS_pixel2x2_bot_46 openDVS_pixel2x2_bot_46/vpd[0] openDVS_pixel2x2_bot_46/vpd[1]
+ openDVS_pixel2x2_bot_46/vpd[3] openDVS_pixel2x2_bot_46/vpd[2] rowReadON[2] rowReadON[3]
+ RefrBp PrBp PrSFBp col_periphery_1x2_14/COL_LINE0 pixRst[28] pixRst[29] col_periphery_1x2_14/COL_LINE1
+ OffBn rowReadOFF[2] rowReadOFF[3] openDVS_pixel2x2_bot_63/GndD DiffBn VSUBS OnBn
+ VDD openDVS_pixel2x2_bot
XopenDVS_pixel2x2_bot_79 openDVS_pixel2x2_bot_79/vpd[0] openDVS_pixel2x2_bot_79/vpd[1]
+ openDVS_pixel2x2_bot_79/vpd[3] openDVS_pixel2x2_bot_79/vpd[2] rowReadON[4] rowReadON[5]
+ RefrBp PrBp PrSFBp col_periphery_1x2_15/COL_LINE0 pixRst[30] pixRst[31] col_periphery_1x2_15/COL_LINE1
+ OffBn rowReadOFF[4] rowReadOFF[5] openDVS_pixel2x2_bot_95/GndD DiffBn VSUBS OnBn
+ VDD openDVS_pixel2x2_bot
XopenDVS_pixel2x2_bot_57 openDVS_pixel2x2_bot_57/vpd[0] openDVS_pixel2x2_bot_57/vpd[1]
+ openDVS_pixel2x2_bot_57/vpd[3] openDVS_pixel2x2_bot_57/vpd[2] rowReadON[2] rowReadON[3]
+ RefrBp PrBp PrSFBp col_periphery_1x2_25/COL_LINE0 pixRst[50] pixRst[51] col_periphery_1x2_25/COL_LINE1
+ OffBn rowReadOFF[2] rowReadOFF[3] openDVS_pixel2x2_bot_63/GndD DiffBn VSUBS OnBn
+ VDD openDVS_pixel2x2_bot
XopenDVS_pixel2x2_bot_412 openDVS_pixel2x2_bot_412/vpd[0] openDVS_pixel2x2_bot_412/vpd[1]
+ openDVS_pixel2x2_bot_412/vpd[3] openDVS_pixel2x2_bot_412/vpd[2] rowReadON[24] rowReadON[25]
+ RefrBp PrBp PrSFBp col_periphery_1x2_28/COL_LINE0 pixRst[56] pixRst[57] col_periphery_1x2_28/COL_LINE1
+ OffBn rowReadOFF[24] rowReadOFF[25] openDVS_pixel2x2_bot_415/GndD DiffBn VSUBS OnBn
+ VDD openDVS_pixel2x2_bot
XopenDVS_pixel2x2_bot_401 openDVS_pixel2x2_bot_401/vpd[0] openDVS_pixel2x2_bot_401/vpd[1]
+ openDVS_pixel2x2_bot_401/vpd[3] openDVS_pixel2x2_bot_401/vpd[2] rowReadON[24] rowReadON[25]
+ RefrBp PrBp PrSFBp col_periphery_1x2_17/COL_LINE0 pixRst[34] pixRst[35] col_periphery_1x2_17/COL_LINE1
+ OffBn rowReadOFF[24] rowReadOFF[25] openDVS_pixel2x2_bot_415/GndD DiffBn VSUBS OnBn
+ VDD openDVS_pixel2x2_bot
XopenDVS_pixel2x2_bot_478 openDVS_pixel2x2_bot_478/vpd[0] openDVS_pixel2x2_bot_478/vpd[1]
+ openDVS_pixel2x2_bot_478/vpd[3] openDVS_pixel2x2_bot_478/vpd[2] rowReadON[28] rowReadON[29]
+ RefrBp PrBp PrSFBp col_periphery_1x2_30/COL_LINE0 pixRst[60] pixRst[61] col_periphery_1x2_30/COL_LINE1
+ OffBn rowReadOFF[28] rowReadOFF[29] openDVS_pixel2x2_bot_479/GndD DiffBn VSUBS OnBn
+ VDD openDVS_pixel2x2_bot
XopenDVS_pixel2x2_bot_445 openDVS_pixel2x2_bot_445/vpd[0] openDVS_pixel2x2_bot_445/vpd[1]
+ openDVS_pixel2x2_bot_445/vpd[3] openDVS_pixel2x2_bot_445/vpd[2] rowReadON[26] rowReadON[27]
+ RefrBp PrBp PrSFBp col_periphery_1x2_29/COL_LINE0 pixRst[58] pixRst[59] col_periphery_1x2_29/COL_LINE1
+ OffBn rowReadOFF[26] rowReadOFF[27] openDVS_pixel2x2_bot_447/GndD DiffBn VSUBS OnBn
+ VDD openDVS_pixel2x2_bot
XopenDVS_pixel2x2_bot_467 openDVS_pixel2x2_bot_467/vpd[0] openDVS_pixel2x2_bot_467/vpd[1]
+ openDVS_pixel2x2_bot_467/vpd[3] openDVS_pixel2x2_bot_467/vpd[2] rowReadON[28] rowReadON[29]
+ RefrBp PrBp PrSFBp col_periphery_1x2_19/COL_LINE0 pixRst[38] pixRst[39] col_periphery_1x2_19/COL_LINE1
+ OffBn rowReadOFF[28] rowReadOFF[29] openDVS_pixel2x2_bot_479/GndD DiffBn VSUBS OnBn
+ VDD openDVS_pixel2x2_bot
XopenDVS_pixel2x2_bot_434 openDVS_pixel2x2_bot_434/vpd[0] openDVS_pixel2x2_bot_434/vpd[1]
+ openDVS_pixel2x2_bot_434/vpd[3] openDVS_pixel2x2_bot_434/vpd[2] rowReadON[26] rowReadON[27]
+ RefrBp PrBp PrSFBp col_periphery_1x2_18/COL_LINE0 pixRst[36] pixRst[37] col_periphery_1x2_18/COL_LINE1
+ OffBn rowReadOFF[26] rowReadOFF[27] openDVS_pixel2x2_bot_447/GndD DiffBn VSUBS OnBn
+ VDD openDVS_pixel2x2_bot
XopenDVS_pixel2x2_bot_489 openDVS_pixel2x2_bot_489/vpd[0] openDVS_pixel2x2_bot_489/vpd[1]
+ openDVS_pixel2x2_bot_489/vpd[3] openDVS_pixel2x2_bot_489/vpd[2] rowReadON[30] rowReadON[31]
+ RefrBp PrBp PrSFBp col_periphery_1x2_9/COL_LINE0 pixRst[18] pixRst[19] col_periphery_1x2_9/COL_LINE1
+ OffBn rowReadOFF[30] rowReadOFF[31] openDVS_pixel2x2_bot_511/GndD DiffBn VSUBS OnBn
+ VDD openDVS_pixel2x2_bot
XopenDVS_pixel2x2_bot_456 openDVS_pixel2x2_bot_456/vpd[0] openDVS_pixel2x2_bot_456/vpd[1]
+ openDVS_pixel2x2_bot_456/vpd[3] openDVS_pixel2x2_bot_456/vpd[2] rowReadON[28] rowReadON[29]
+ RefrBp PrBp PrSFBp col_periphery_1x2_8/COL_LINE0 pixRst[16] pixRst[17] col_periphery_1x2_8/COL_LINE1
+ OffBn rowReadOFF[28] rowReadOFF[29] openDVS_pixel2x2_bot_479/GndD DiffBn VSUBS OnBn
+ VDD openDVS_pixel2x2_bot
XopenDVS_pixel2x2_bot_423 openDVS_pixel2x2_bot_423/vpd[0] openDVS_pixel2x2_bot_423/vpd[1]
+ openDVS_pixel2x2_bot_423/vpd[3] openDVS_pixel2x2_bot_423/vpd[2] rowReadON[26] rowReadON[27]
+ RefrBp PrBp PrSFBp col_periphery_1x2_7/COL_LINE0 pixRst[14] pixRst[15] col_periphery_1x2_7/COL_LINE1
+ OffBn rowReadOFF[26] rowReadOFF[27] openDVS_pixel2x2_bot_447/GndD DiffBn VSUBS OnBn
+ VDD openDVS_pixel2x2_bot
Xcol_periphery_1x2_1 pixRst[3] col_periphery_1x2_1/COL_LINE0 col_periphery_1x2_1/COL_LINE1
+ nDETECT col_periphery_1x2_9/VDD DETECT VTHRESH voutn[2] VSUBS NCHARGE voutn[3] pixRst[2]
+ col_periphery_1x2
XopenDVS_pixel2x2_bot_990 openDVS_pixel2x2_bot_990/vpd[0] openDVS_pixel2x2_bot_990/vpd[1]
+ openDVS_pixel2x2_bot_990/vpd[3] openDVS_pixel2x2_bot_990/vpd[2] rowReadON[60] rowReadON[61]
+ RefrBp PrBp PrSFBp col_periphery_1x2_30/COL_LINE0 pixRst[60] pixRst[61] col_periphery_1x2_30/COL_LINE1
+ OffBn rowReadOFF[60] rowReadOFF[61] openDVS_pixel2x2_bot_991/GndD DiffBn VSUBS OnBn
+ VDD openDVS_pixel2x2_bot
XopenDVS_pixel2x2_bot_231 openDVS_pixel2x2_bot_231/vpd[0] openDVS_pixel2x2_bot_231/vpd[1]
+ openDVS_pixel2x2_bot_231/vpd[3] openDVS_pixel2x2_bot_231/vpd[2] rowReadON[14] rowReadON[15]
+ RefrBp PrBp PrSFBp col_periphery_1x2_7/COL_LINE0 pixRst[14] pixRst[15] col_periphery_1x2_7/COL_LINE1
+ OffBn rowReadOFF[14] rowReadOFF[15] openDVS_pixel2x2_bot_255/GndD DiffBn VSUBS OnBn
+ VDD openDVS_pixel2x2_bot
XopenDVS_pixel2x2_bot_264 openDVS_pixel2x2_bot_264/vpd[0] openDVS_pixel2x2_bot_264/vpd[1]
+ openDVS_pixel2x2_bot_264/vpd[3] openDVS_pixel2x2_bot_264/vpd[2] rowReadON[16] rowReadON[17]
+ RefrBp PrBp PrSFBp col_periphery_1x2_8/COL_LINE0 pixRst[16] pixRst[17] col_periphery_1x2_8/COL_LINE1
+ OffBn rowReadOFF[16] rowReadOFF[17] openDVS_pixel2x2_bot_287/GndD DiffBn VSUBS OnBn
+ VDD openDVS_pixel2x2_bot
XopenDVS_pixel2x2_bot_297 openDVS_pixel2x2_bot_297/vpd[0] openDVS_pixel2x2_bot_297/vpd[1]
+ openDVS_pixel2x2_bot_297/vpd[3] openDVS_pixel2x2_bot_297/vpd[2] rowReadON[18] rowReadON[19]
+ RefrBp PrBp PrSFBp col_periphery_1x2_9/COL_LINE0 pixRst[18] pixRst[19] col_periphery_1x2_9/COL_LINE1
+ OffBn rowReadOFF[18] rowReadOFF[19] openDVS_pixel2x2_bot_319/GndD DiffBn VSUBS OnBn
+ VDD openDVS_pixel2x2_bot
XopenDVS_pixel2x2_bot_242 openDVS_pixel2x2_bot_242/vpd[0] openDVS_pixel2x2_bot_242/vpd[1]
+ openDVS_pixel2x2_bot_242/vpd[3] openDVS_pixel2x2_bot_242/vpd[2] rowReadON[14] rowReadON[15]
+ RefrBp PrBp PrSFBp col_periphery_1x2_18/COL_LINE0 pixRst[36] pixRst[37] col_periphery_1x2_18/COL_LINE1
+ OffBn rowReadOFF[14] rowReadOFF[15] openDVS_pixel2x2_bot_255/GndD DiffBn VSUBS OnBn
+ VDD openDVS_pixel2x2_bot
XopenDVS_pixel2x2_bot_275 openDVS_pixel2x2_bot_275/vpd[0] openDVS_pixel2x2_bot_275/vpd[1]
+ openDVS_pixel2x2_bot_275/vpd[3] openDVS_pixel2x2_bot_275/vpd[2] rowReadON[16] rowReadON[17]
+ RefrBp PrBp PrSFBp col_periphery_1x2_19/COL_LINE0 pixRst[38] pixRst[39] col_periphery_1x2_19/COL_LINE1
+ OffBn rowReadOFF[16] rowReadOFF[17] openDVS_pixel2x2_bot_287/GndD DiffBn VSUBS OnBn
+ VDD openDVS_pixel2x2_bot
XopenDVS_pixel2x2_bot_220 openDVS_pixel2x2_bot_220/vpd[0] openDVS_pixel2x2_bot_220/vpd[1]
+ openDVS_pixel2x2_bot_220/vpd[3] openDVS_pixel2x2_bot_220/vpd[2] rowReadON[12] rowReadON[13]
+ RefrBp PrBp PrSFBp col_periphery_1x2_28/COL_LINE0 pixRst[56] pixRst[57] col_periphery_1x2_28/COL_LINE1
+ OffBn rowReadOFF[12] rowReadOFF[13] openDVS_pixel2x2_bot_223/GndD DiffBn VSUBS OnBn
+ VDD openDVS_pixel2x2_bot
XopenDVS_pixel2x2_bot_253 openDVS_pixel2x2_bot_253/vpd[0] openDVS_pixel2x2_bot_253/vpd[1]
+ openDVS_pixel2x2_bot_253/vpd[3] openDVS_pixel2x2_bot_253/vpd[2] rowReadON[14] rowReadON[15]
+ RefrBp PrBp PrSFBp col_periphery_1x2_29/COL_LINE0 pixRst[58] pixRst[59] col_periphery_1x2_29/COL_LINE1
+ OffBn rowReadOFF[14] rowReadOFF[15] openDVS_pixel2x2_bot_255/GndD DiffBn VSUBS OnBn
+ VDD openDVS_pixel2x2_bot
XopenDVS_pixel2x2_bot_286 openDVS_pixel2x2_bot_286/vpd[0] openDVS_pixel2x2_bot_286/vpd[1]
+ openDVS_pixel2x2_bot_286/vpd[3] openDVS_pixel2x2_bot_286/vpd[2] rowReadON[16] rowReadON[17]
+ RefrBp PrBp PrSFBp col_periphery_1x2_30/COL_LINE0 pixRst[60] pixRst[61] col_periphery_1x2_30/COL_LINE1
+ OffBn rowReadOFF[16] rowReadOFF[17] openDVS_pixel2x2_bot_287/GndD DiffBn VSUBS OnBn
+ VDD openDVS_pixel2x2_bot
XopenDVS_pixel2x2_bot_819 openDVS_pixel2x2_bot_819/vpd[0] openDVS_pixel2x2_bot_819/vpd[1]
+ openDVS_pixel2x2_bot_819/vpd[3] openDVS_pixel2x2_bot_819/vpd[2] rowReadON[50] rowReadON[51]
+ RefrBp PrBp PrSFBp col_periphery_1x2_19/COL_LINE0 pixRst[38] pixRst[39] col_periphery_1x2_19/COL_LINE1
+ OffBn rowReadOFF[50] rowReadOFF[51] openDVS_pixel2x2_bot_831/GndD DiffBn VSUBS OnBn
+ VDD openDVS_pixel2x2_bot
XopenDVS_pixel2x2_bot_808 openDVS_pixel2x2_bot_808/vpd[0] openDVS_pixel2x2_bot_808/vpd[1]
+ openDVS_pixel2x2_bot_808/vpd[3] openDVS_pixel2x2_bot_808/vpd[2] rowReadON[50] rowReadON[51]
+ RefrBp PrBp PrSFBp col_periphery_1x2_8/COL_LINE0 pixRst[16] pixRst[17] col_periphery_1x2_8/COL_LINE1
+ OffBn rowReadOFF[50] rowReadOFF[51] openDVS_pixel2x2_bot_831/GndD DiffBn VSUBS OnBn
+ VDD openDVS_pixel2x2_bot
XopenDVS_pixel2x2_bot_638 openDVS_pixel2x2_bot_638/vpd[0] openDVS_pixel2x2_bot_638/vpd[1]
+ openDVS_pixel2x2_bot_638/vpd[3] openDVS_pixel2x2_bot_638/vpd[2] rowReadON[38] rowReadON[39]
+ RefrBp PrBp PrSFBp col_periphery_1x2_30/COL_LINE0 pixRst[60] pixRst[61] col_periphery_1x2_30/COL_LINE1
+ OffBn rowReadOFF[38] rowReadOFF[39] openDVS_pixel2x2_bot_639/GndD DiffBn VSUBS OnBn
+ VDD openDVS_pixel2x2_bot
XopenDVS_pixel2x2_bot_605 openDVS_pixel2x2_bot_605/vpd[0] openDVS_pixel2x2_bot_605/vpd[1]
+ openDVS_pixel2x2_bot_605/vpd[3] openDVS_pixel2x2_bot_605/vpd[2] rowReadON[36] rowReadON[37]
+ RefrBp PrBp PrSFBp col_periphery_1x2_29/COL_LINE0 pixRst[58] pixRst[59] col_periphery_1x2_29/COL_LINE1
+ OffBn rowReadOFF[36] rowReadOFF[37] openDVS_pixel2x2_bot_607/GndD DiffBn VSUBS OnBn
+ VDD openDVS_pixel2x2_bot
XopenDVS_pixel2x2_bot_627 openDVS_pixel2x2_bot_627/vpd[0] openDVS_pixel2x2_bot_627/vpd[1]
+ openDVS_pixel2x2_bot_627/vpd[3] openDVS_pixel2x2_bot_627/vpd[2] rowReadON[38] rowReadON[39]
+ RefrBp PrBp PrSFBp col_periphery_1x2_19/COL_LINE0 pixRst[38] pixRst[39] col_periphery_1x2_19/COL_LINE1
+ OffBn rowReadOFF[38] rowReadOFF[39] openDVS_pixel2x2_bot_639/GndD DiffBn VSUBS OnBn
+ VDD openDVS_pixel2x2_bot
XopenDVS_pixel2x2_bot_649 openDVS_pixel2x2_bot_649/vpd[0] openDVS_pixel2x2_bot_649/vpd[1]
+ openDVS_pixel2x2_bot_649/vpd[3] openDVS_pixel2x2_bot_649/vpd[2] rowReadON[40] rowReadON[41]
+ RefrBp PrBp PrSFBp col_periphery_1x2_9/COL_LINE0 pixRst[18] pixRst[19] col_periphery_1x2_9/COL_LINE1
+ OffBn rowReadOFF[40] rowReadOFF[41] openDVS_pixel2x2_bot_671/GndD DiffBn VSUBS OnBn
+ VDD openDVS_pixel2x2_bot
XopenDVS_pixel2x2_bot_616 openDVS_pixel2x2_bot_616/vpd[0] openDVS_pixel2x2_bot_616/vpd[1]
+ openDVS_pixel2x2_bot_616/vpd[3] openDVS_pixel2x2_bot_616/vpd[2] rowReadON[38] rowReadON[39]
+ RefrBp PrBp PrSFBp col_periphery_1x2_8/COL_LINE0 pixRst[16] pixRst[17] col_periphery_1x2_8/COL_LINE1
+ OffBn rowReadOFF[38] rowReadOFF[39] openDVS_pixel2x2_bot_639/GndD DiffBn VSUBS OnBn
+ VDD openDVS_pixel2x2_bot
XopenDVS_pixel2x2_bot_69 openDVS_pixel2x2_bot_69/vpd[0] openDVS_pixel2x2_bot_69/vpd[1]
+ openDVS_pixel2x2_bot_69/vpd[3] openDVS_pixel2x2_bot_69/vpd[2] rowReadON[4] rowReadON[5]
+ RefrBp PrBp PrSFBp col_periphery_1x2_5/COL_LINE0 pixRst[10] pixRst[11] col_periphery_1x2_5/COL_LINE1
+ OffBn rowReadOFF[4] rowReadOFF[5] openDVS_pixel2x2_bot_95/GndD DiffBn VSUBS OnBn
+ VDD openDVS_pixel2x2_bot
XopenDVS_pixel2x2_bot_36 openDVS_pixel2x2_bot_36/vpd[0] openDVS_pixel2x2_bot_36/vpd[1]
+ openDVS_pixel2x2_bot_36/vpd[3] openDVS_pixel2x2_bot_36/vpd[2] rowReadON[2] rowReadON[3]
+ RefrBp PrBp PrSFBp col_periphery_1x2_4/COL_LINE0 pixRst[8] pixRst[9] col_periphery_1x2_4/COL_LINE1
+ OffBn rowReadOFF[2] rowReadOFF[3] openDVS_pixel2x2_bot_63/GndD DiffBn VSUBS OnBn
+ VDD openDVS_pixel2x2_bot
XopenDVS_pixel2x2_bot_25 openDVS_pixel2x2_bot_25/vpd[0] openDVS_pixel2x2_bot_25/vpd[1]
+ openDVS_pixel2x2_bot_25/vpd[3] openDVS_pixel2x2_bot_25/vpd[2] rowReadON[0] rowReadON[1]
+ RefrBp PrBp PrSFBp col_periphery_1x2_25/COL_LINE0 pixRst[50] pixRst[51] col_periphery_1x2_25/COL_LINE1
+ OffBn rowReadOFF[0] rowReadOFF[1] GND DiffBn VSUBS OnBn VDD openDVS_pixel2x2_bot
XopenDVS_pixel2x2_bot_14 openDVS_pixel2x2_bot_14/vpd[0] openDVS_pixel2x2_bot_14/vpd[1]
+ openDVS_pixel2x2_bot_14/vpd[3] openDVS_pixel2x2_bot_14/vpd[2] rowReadON[0] rowReadON[1]
+ RefrBp PrBp PrSFBp col_periphery_1x2_14/COL_LINE0 pixRst[28] pixRst[29] col_periphery_1x2_14/COL_LINE1
+ OffBn rowReadOFF[0] rowReadOFF[1] GND DiffBn VSUBS OnBn VDD openDVS_pixel2x2_bot
XopenDVS_pixel2x2_bot_47 openDVS_pixel2x2_bot_47/vpd[0] openDVS_pixel2x2_bot_47/vpd[1]
+ openDVS_pixel2x2_bot_47/vpd[3] openDVS_pixel2x2_bot_47/vpd[2] rowReadON[2] rowReadON[3]
+ RefrBp PrBp PrSFBp col_periphery_1x2_15/COL_LINE0 pixRst[30] pixRst[31] col_periphery_1x2_15/COL_LINE1
+ OffBn rowReadOFF[2] rowReadOFF[3] openDVS_pixel2x2_bot_63/GndD DiffBn VSUBS OnBn
+ VDD openDVS_pixel2x2_bot
XopenDVS_pixel2x2_bot_58 openDVS_pixel2x2_bot_58/vpd[0] openDVS_pixel2x2_bot_58/vpd[1]
+ openDVS_pixel2x2_bot_58/vpd[3] openDVS_pixel2x2_bot_58/vpd[2] rowReadON[2] rowReadON[3]
+ RefrBp PrBp PrSFBp col_periphery_1x2_26/COL_LINE0 pixRst[52] pixRst[53] col_periphery_1x2_26/COL_LINE1
+ OffBn rowReadOFF[2] rowReadOFF[3] openDVS_pixel2x2_bot_63/GndD DiffBn VSUBS OnBn
+ VDD openDVS_pixel2x2_bot
XopenDVS_pixel2x2_bot_479 openDVS_pixel2x2_bot_479/vpd[0] openDVS_pixel2x2_bot_479/vpd[1]
+ openDVS_pixel2x2_bot_479/vpd[3] openDVS_pixel2x2_bot_479/vpd[2] rowReadON[28] rowReadON[29]
+ RefrBp PrBp PrSFBp col_periphery_1x2_31/COL_LINE0 pixRst[62] pixRst[63] col_periphery_1x2_31/COL_LINE1
+ OffBn rowReadOFF[28] rowReadOFF[29] openDVS_pixel2x2_bot_479/GndD DiffBn VSUBS OnBn
+ VDD openDVS_pixel2x2_bot
XopenDVS_pixel2x2_bot_446 openDVS_pixel2x2_bot_446/vpd[0] openDVS_pixel2x2_bot_446/vpd[1]
+ openDVS_pixel2x2_bot_446/vpd[3] openDVS_pixel2x2_bot_446/vpd[2] rowReadON[26] rowReadON[27]
+ RefrBp PrBp PrSFBp col_periphery_1x2_30/COL_LINE0 pixRst[60] pixRst[61] col_periphery_1x2_30/COL_LINE1
+ OffBn rowReadOFF[26] rowReadOFF[27] openDVS_pixel2x2_bot_447/GndD DiffBn VSUBS OnBn
+ VDD openDVS_pixel2x2_bot
XopenDVS_pixel2x2_bot_413 openDVS_pixel2x2_bot_413/vpd[0] openDVS_pixel2x2_bot_413/vpd[1]
+ openDVS_pixel2x2_bot_413/vpd[3] openDVS_pixel2x2_bot_413/vpd[2] rowReadON[24] rowReadON[25]
+ RefrBp PrBp PrSFBp col_periphery_1x2_29/COL_LINE0 pixRst[58] pixRst[59] col_periphery_1x2_29/COL_LINE1
+ OffBn rowReadOFF[24] rowReadOFF[25] openDVS_pixel2x2_bot_415/GndD DiffBn VSUBS OnBn
+ VDD openDVS_pixel2x2_bot
XopenDVS_pixel2x2_bot_468 openDVS_pixel2x2_bot_468/vpd[0] openDVS_pixel2x2_bot_468/vpd[1]
+ openDVS_pixel2x2_bot_468/vpd[3] openDVS_pixel2x2_bot_468/vpd[2] rowReadON[28] rowReadON[29]
+ RefrBp PrBp PrSFBp col_periphery_1x2_20/COL_LINE0 pixRst[40] pixRst[41] col_periphery_1x2_20/COL_LINE1
+ OffBn rowReadOFF[28] rowReadOFF[29] openDVS_pixel2x2_bot_479/GndD DiffBn VSUBS OnBn
+ VDD openDVS_pixel2x2_bot
XopenDVS_pixel2x2_bot_435 openDVS_pixel2x2_bot_435/vpd[0] openDVS_pixel2x2_bot_435/vpd[1]
+ openDVS_pixel2x2_bot_435/vpd[3] openDVS_pixel2x2_bot_435/vpd[2] rowReadON[26] rowReadON[27]
+ RefrBp PrBp PrSFBp col_periphery_1x2_19/COL_LINE0 pixRst[38] pixRst[39] col_periphery_1x2_19/COL_LINE1
+ OffBn rowReadOFF[26] rowReadOFF[27] openDVS_pixel2x2_bot_447/GndD DiffBn VSUBS OnBn
+ VDD openDVS_pixel2x2_bot
XopenDVS_pixel2x2_bot_402 openDVS_pixel2x2_bot_402/vpd[0] openDVS_pixel2x2_bot_402/vpd[1]
+ openDVS_pixel2x2_bot_402/vpd[3] openDVS_pixel2x2_bot_402/vpd[2] rowReadON[24] rowReadON[25]
+ RefrBp PrBp PrSFBp col_periphery_1x2_18/COL_LINE0 pixRst[36] pixRst[37] col_periphery_1x2_18/COL_LINE1
+ OffBn rowReadOFF[24] rowReadOFF[25] openDVS_pixel2x2_bot_415/GndD DiffBn VSUBS OnBn
+ VDD openDVS_pixel2x2_bot
XopenDVS_pixel2x2_bot_457 openDVS_pixel2x2_bot_457/vpd[0] openDVS_pixel2x2_bot_457/vpd[1]
+ openDVS_pixel2x2_bot_457/vpd[3] openDVS_pixel2x2_bot_457/vpd[2] rowReadON[28] rowReadON[29]
+ RefrBp PrBp PrSFBp col_periphery_1x2_9/COL_LINE0 pixRst[18] pixRst[19] col_periphery_1x2_9/COL_LINE1
+ OffBn rowReadOFF[28] rowReadOFF[29] openDVS_pixel2x2_bot_479/GndD DiffBn VSUBS OnBn
+ VDD openDVS_pixel2x2_bot
XopenDVS_pixel2x2_bot_424 openDVS_pixel2x2_bot_424/vpd[0] openDVS_pixel2x2_bot_424/vpd[1]
+ openDVS_pixel2x2_bot_424/vpd[3] openDVS_pixel2x2_bot_424/vpd[2] rowReadON[26] rowReadON[27]
+ RefrBp PrBp PrSFBp col_periphery_1x2_8/COL_LINE0 pixRst[16] pixRst[17] col_periphery_1x2_8/COL_LINE1
+ OffBn rowReadOFF[26] rowReadOFF[27] openDVS_pixel2x2_bot_447/GndD DiffBn VSUBS OnBn
+ VDD openDVS_pixel2x2_bot
Xcol_periphery_1x2_2 pixRst[5] col_periphery_1x2_2/COL_LINE0 col_periphery_1x2_2/COL_LINE1
+ nDETECT col_periphery_1x2_9/VDD DETECT VTHRESH voutn[4] VSUBS NCHARGE voutn[5] pixRst[4]
+ col_periphery_1x2
XopenDVS_pixel2x2_bot_991 openDVS_pixel2x2_bot_991/vpd[0] openDVS_pixel2x2_bot_991/vpd[1]
+ openDVS_pixel2x2_bot_991/vpd[3] openDVS_pixel2x2_bot_991/vpd[2] rowReadON[60] rowReadON[61]
+ RefrBp PrBp PrSFBp col_periphery_1x2_31/COL_LINE0 pixRst[62] pixRst[63] col_periphery_1x2_31/COL_LINE1
+ OffBn rowReadOFF[60] rowReadOFF[61] openDVS_pixel2x2_bot_991/GndD DiffBn VSUBS OnBn
+ VDD openDVS_pixel2x2_bot
XopenDVS_pixel2x2_bot_980 openDVS_pixel2x2_bot_980/vpd[0] openDVS_pixel2x2_bot_980/vpd[1]
+ openDVS_pixel2x2_bot_980/vpd[3] openDVS_pixel2x2_bot_980/vpd[2] rowReadON[60] rowReadON[61]
+ RefrBp PrBp PrSFBp col_periphery_1x2_20/COL_LINE0 pixRst[40] pixRst[41] col_periphery_1x2_20/COL_LINE1
+ OffBn rowReadOFF[60] rowReadOFF[61] openDVS_pixel2x2_bot_991/GndD DiffBn VSUBS OnBn
+ VDD openDVS_pixel2x2_bot
XopenDVS_pixel2x2_bot_232 openDVS_pixel2x2_bot_232/vpd[0] openDVS_pixel2x2_bot_232/vpd[1]
+ openDVS_pixel2x2_bot_232/vpd[3] openDVS_pixel2x2_bot_232/vpd[2] rowReadON[14] rowReadON[15]
+ RefrBp PrBp PrSFBp col_periphery_1x2_8/COL_LINE0 pixRst[16] pixRst[17] col_periphery_1x2_8/COL_LINE1
+ OffBn rowReadOFF[14] rowReadOFF[15] openDVS_pixel2x2_bot_255/GndD DiffBn VSUBS OnBn
+ VDD openDVS_pixel2x2_bot
XopenDVS_pixel2x2_bot_265 openDVS_pixel2x2_bot_265/vpd[0] openDVS_pixel2x2_bot_265/vpd[1]
+ openDVS_pixel2x2_bot_265/vpd[3] openDVS_pixel2x2_bot_265/vpd[2] rowReadON[16] rowReadON[17]
+ RefrBp PrBp PrSFBp col_periphery_1x2_9/COL_LINE0 pixRst[18] pixRst[19] col_periphery_1x2_9/COL_LINE1
+ OffBn rowReadOFF[16] rowReadOFF[17] openDVS_pixel2x2_bot_287/GndD DiffBn VSUBS OnBn
+ VDD openDVS_pixel2x2_bot
XopenDVS_pixel2x2_bot_298 openDVS_pixel2x2_bot_298/vpd[0] openDVS_pixel2x2_bot_298/vpd[1]
+ openDVS_pixel2x2_bot_298/vpd[3] openDVS_pixel2x2_bot_298/vpd[2] rowReadON[18] rowReadON[19]
+ RefrBp PrBp PrSFBp col_periphery_1x2_10/COL_LINE0 pixRst[20] pixRst[21] col_periphery_1x2_10/COL_LINE1
+ OffBn rowReadOFF[18] rowReadOFF[19] openDVS_pixel2x2_bot_319/GndD DiffBn VSUBS OnBn
+ VDD openDVS_pixel2x2_bot
XopenDVS_pixel2x2_bot_210 openDVS_pixel2x2_bot_210/vpd[0] openDVS_pixel2x2_bot_210/vpd[1]
+ openDVS_pixel2x2_bot_210/vpd[3] openDVS_pixel2x2_bot_210/vpd[2] rowReadON[12] rowReadON[13]
+ RefrBp PrBp PrSFBp col_periphery_1x2_18/COL_LINE0 pixRst[36] pixRst[37] col_periphery_1x2_18/COL_LINE1
+ OffBn rowReadOFF[12] rowReadOFF[13] openDVS_pixel2x2_bot_223/GndD DiffBn VSUBS OnBn
+ VDD openDVS_pixel2x2_bot
XopenDVS_pixel2x2_bot_243 openDVS_pixel2x2_bot_243/vpd[0] openDVS_pixel2x2_bot_243/vpd[1]
+ openDVS_pixel2x2_bot_243/vpd[3] openDVS_pixel2x2_bot_243/vpd[2] rowReadON[14] rowReadON[15]
+ RefrBp PrBp PrSFBp col_periphery_1x2_19/COL_LINE0 pixRst[38] pixRst[39] col_periphery_1x2_19/COL_LINE1
+ OffBn rowReadOFF[14] rowReadOFF[15] openDVS_pixel2x2_bot_255/GndD DiffBn VSUBS OnBn
+ VDD openDVS_pixel2x2_bot
XopenDVS_pixel2x2_bot_276 openDVS_pixel2x2_bot_276/vpd[0] openDVS_pixel2x2_bot_276/vpd[1]
+ openDVS_pixel2x2_bot_276/vpd[3] openDVS_pixel2x2_bot_276/vpd[2] rowReadON[16] rowReadON[17]
+ RefrBp PrBp PrSFBp col_periphery_1x2_20/COL_LINE0 pixRst[40] pixRst[41] col_periphery_1x2_20/COL_LINE1
+ OffBn rowReadOFF[16] rowReadOFF[17] openDVS_pixel2x2_bot_287/GndD DiffBn VSUBS OnBn
+ VDD openDVS_pixel2x2_bot
XopenDVS_pixel2x2_bot_221 openDVS_pixel2x2_bot_221/vpd[0] openDVS_pixel2x2_bot_221/vpd[1]
+ openDVS_pixel2x2_bot_221/vpd[3] openDVS_pixel2x2_bot_221/vpd[2] rowReadON[12] rowReadON[13]
+ RefrBp PrBp PrSFBp col_periphery_1x2_29/COL_LINE0 pixRst[58] pixRst[59] col_periphery_1x2_29/COL_LINE1
+ OffBn rowReadOFF[12] rowReadOFF[13] openDVS_pixel2x2_bot_223/GndD DiffBn VSUBS OnBn
+ VDD openDVS_pixel2x2_bot
XopenDVS_pixel2x2_bot_254 openDVS_pixel2x2_bot_254/vpd[0] openDVS_pixel2x2_bot_254/vpd[1]
+ openDVS_pixel2x2_bot_254/vpd[3] openDVS_pixel2x2_bot_254/vpd[2] rowReadON[14] rowReadON[15]
+ RefrBp PrBp PrSFBp col_periphery_1x2_30/COL_LINE0 pixRst[60] pixRst[61] col_periphery_1x2_30/COL_LINE1
+ OffBn rowReadOFF[14] rowReadOFF[15] openDVS_pixel2x2_bot_255/GndD DiffBn VSUBS OnBn
+ VDD openDVS_pixel2x2_bot
XopenDVS_pixel2x2_bot_287 openDVS_pixel2x2_bot_287/vpd[0] openDVS_pixel2x2_bot_287/vpd[1]
+ openDVS_pixel2x2_bot_287/vpd[3] openDVS_pixel2x2_bot_287/vpd[2] rowReadON[16] rowReadON[17]
+ RefrBp PrBp PrSFBp col_periphery_1x2_31/COL_LINE0 pixRst[62] pixRst[63] col_periphery_1x2_31/COL_LINE1
+ OffBn rowReadOFF[16] rowReadOFF[17] openDVS_pixel2x2_bot_287/GndD DiffBn VSUBS OnBn
+ VDD openDVS_pixel2x2_bot
XopenDVS_pixel2x2_bot_809 openDVS_pixel2x2_bot_809/vpd[0] openDVS_pixel2x2_bot_809/vpd[1]
+ openDVS_pixel2x2_bot_809/vpd[3] openDVS_pixel2x2_bot_809/vpd[2] rowReadON[50] rowReadON[51]
+ RefrBp PrBp PrSFBp col_periphery_1x2_9/COL_LINE0 pixRst[18] pixRst[19] col_periphery_1x2_9/COL_LINE1
+ OffBn rowReadOFF[50] rowReadOFF[51] openDVS_pixel2x2_bot_831/GndD DiffBn VSUBS OnBn
+ VDD openDVS_pixel2x2_bot
XopenDVS_pixel2x2_bot_639 openDVS_pixel2x2_bot_639/vpd[0] openDVS_pixel2x2_bot_639/vpd[1]
+ openDVS_pixel2x2_bot_639/vpd[3] openDVS_pixel2x2_bot_639/vpd[2] rowReadON[38] rowReadON[39]
+ RefrBp PrBp PrSFBp col_periphery_1x2_31/COL_LINE0 pixRst[62] pixRst[63] col_periphery_1x2_31/COL_LINE1
+ OffBn rowReadOFF[38] rowReadOFF[39] openDVS_pixel2x2_bot_639/GndD DiffBn VSUBS OnBn
+ VDD openDVS_pixel2x2_bot
XopenDVS_pixel2x2_bot_606 openDVS_pixel2x2_bot_606/vpd[0] openDVS_pixel2x2_bot_606/vpd[1]
+ openDVS_pixel2x2_bot_606/vpd[3] openDVS_pixel2x2_bot_606/vpd[2] rowReadON[36] rowReadON[37]
+ RefrBp PrBp PrSFBp col_periphery_1x2_30/COL_LINE0 pixRst[60] pixRst[61] col_periphery_1x2_30/COL_LINE1
+ OffBn rowReadOFF[36] rowReadOFF[37] openDVS_pixel2x2_bot_607/GndD DiffBn VSUBS OnBn
+ VDD openDVS_pixel2x2_bot
XopenDVS_pixel2x2_bot_628 openDVS_pixel2x2_bot_628/vpd[0] openDVS_pixel2x2_bot_628/vpd[1]
+ openDVS_pixel2x2_bot_628/vpd[3] openDVS_pixel2x2_bot_628/vpd[2] rowReadON[38] rowReadON[39]
+ RefrBp PrBp PrSFBp col_periphery_1x2_20/COL_LINE0 pixRst[40] pixRst[41] col_periphery_1x2_20/COL_LINE1
+ OffBn rowReadOFF[38] rowReadOFF[39] openDVS_pixel2x2_bot_639/GndD DiffBn VSUBS OnBn
+ VDD openDVS_pixel2x2_bot
XopenDVS_pixel2x2_bot_617 openDVS_pixel2x2_bot_617/vpd[0] openDVS_pixel2x2_bot_617/vpd[1]
+ openDVS_pixel2x2_bot_617/vpd[3] openDVS_pixel2x2_bot_617/vpd[2] rowReadON[38] rowReadON[39]
+ RefrBp PrBp PrSFBp col_periphery_1x2_9/COL_LINE0 pixRst[18] pixRst[19] col_periphery_1x2_9/COL_LINE1
+ OffBn rowReadOFF[38] rowReadOFF[39] openDVS_pixel2x2_bot_639/GndD DiffBn VSUBS OnBn
+ VDD openDVS_pixel2x2_bot
XopenDVS_pixel2x2_bot_37 openDVS_pixel2x2_bot_37/vpd[0] openDVS_pixel2x2_bot_37/vpd[1]
+ openDVS_pixel2x2_bot_37/vpd[3] openDVS_pixel2x2_bot_37/vpd[2] rowReadON[2] rowReadON[3]
+ RefrBp PrBp PrSFBp col_periphery_1x2_5/COL_LINE0 pixRst[10] pixRst[11] col_periphery_1x2_5/COL_LINE1
+ OffBn rowReadOFF[2] rowReadOFF[3] openDVS_pixel2x2_bot_63/GndD DiffBn VSUBS OnBn
+ VDD openDVS_pixel2x2_bot
XopenDVS_pixel2x2_bot_26 openDVS_pixel2x2_bot_26/vpd[0] openDVS_pixel2x2_bot_26/vpd[1]
+ openDVS_pixel2x2_bot_26/vpd[3] openDVS_pixel2x2_bot_26/vpd[2] rowReadON[0] rowReadON[1]
+ RefrBp PrBp PrSFBp col_periphery_1x2_26/COL_LINE0 pixRst[52] pixRst[53] col_periphery_1x2_26/COL_LINE1
+ OffBn rowReadOFF[0] rowReadOFF[1] GND DiffBn VSUBS OnBn VDD openDVS_pixel2x2_bot
XopenDVS_pixel2x2_bot_15 openDVS_pixel2x2_bot_15/vpd[0] openDVS_pixel2x2_bot_15/vpd[1]
+ openDVS_pixel2x2_bot_15/vpd[3] openDVS_pixel2x2_bot_15/vpd[2] rowReadON[0] rowReadON[1]
+ RefrBp PrBp PrSFBp col_periphery_1x2_15/COL_LINE0 pixRst[30] pixRst[31] col_periphery_1x2_15/COL_LINE1
+ OffBn rowReadOFF[0] rowReadOFF[1] GND DiffBn VSUBS OnBn VDD openDVS_pixel2x2_bot
XopenDVS_pixel2x2_bot_48 openDVS_pixel2x2_bot_48/vpd[0] openDVS_pixel2x2_bot_48/vpd[1]
+ openDVS_pixel2x2_bot_48/vpd[3] openDVS_pixel2x2_bot_48/vpd[2] rowReadON[2] rowReadON[3]
+ RefrBp PrBp PrSFBp col_periphery_1x2_16/COL_LINE0 pixRst[32] pixRst[33] col_periphery_1x2_16/COL_LINE1
+ OffBn rowReadOFF[2] rowReadOFF[3] openDVS_pixel2x2_bot_63/GndD DiffBn VSUBS OnBn
+ VDD openDVS_pixel2x2_bot
XopenDVS_pixel2x2_bot_59 openDVS_pixel2x2_bot_59/vpd[0] openDVS_pixel2x2_bot_59/vpd[1]
+ openDVS_pixel2x2_bot_59/vpd[3] openDVS_pixel2x2_bot_59/vpd[2] rowReadON[2] rowReadON[3]
+ RefrBp PrBp PrSFBp col_periphery_1x2_27/COL_LINE0 pixRst[54] pixRst[55] col_periphery_1x2_27/COL_LINE1
+ OffBn rowReadOFF[2] rowReadOFF[3] openDVS_pixel2x2_bot_63/GndD DiffBn VSUBS OnBn
+ VDD openDVS_pixel2x2_bot
XopenDVS_pixel2x2_bot_447 openDVS_pixel2x2_bot_447/vpd[0] openDVS_pixel2x2_bot_447/vpd[1]
+ openDVS_pixel2x2_bot_447/vpd[3] openDVS_pixel2x2_bot_447/vpd[2] rowReadON[26] rowReadON[27]
+ RefrBp PrBp PrSFBp col_periphery_1x2_31/COL_LINE0 pixRst[62] pixRst[63] col_periphery_1x2_31/COL_LINE1
+ OffBn rowReadOFF[26] rowReadOFF[27] openDVS_pixel2x2_bot_447/GndD DiffBn VSUBS OnBn
+ VDD openDVS_pixel2x2_bot
XopenDVS_pixel2x2_bot_414 openDVS_pixel2x2_bot_414/vpd[0] openDVS_pixel2x2_bot_414/vpd[1]
+ openDVS_pixel2x2_bot_414/vpd[3] openDVS_pixel2x2_bot_414/vpd[2] rowReadON[24] rowReadON[25]
+ RefrBp PrBp PrSFBp col_periphery_1x2_30/COL_LINE0 pixRst[60] pixRst[61] col_periphery_1x2_30/COL_LINE1
+ OffBn rowReadOFF[24] rowReadOFF[25] openDVS_pixel2x2_bot_415/GndD DiffBn VSUBS OnBn
+ VDD openDVS_pixel2x2_bot
XopenDVS_pixel2x2_bot_469 openDVS_pixel2x2_bot_469/vpd[0] openDVS_pixel2x2_bot_469/vpd[1]
+ openDVS_pixel2x2_bot_469/vpd[3] openDVS_pixel2x2_bot_469/vpd[2] rowReadON[28] rowReadON[29]
+ RefrBp PrBp PrSFBp col_periphery_1x2_21/COL_LINE0 pixRst[42] pixRst[43] col_periphery_1x2_21/COL_LINE1
+ OffBn rowReadOFF[28] rowReadOFF[29] openDVS_pixel2x2_bot_479/GndD DiffBn VSUBS OnBn
+ VDD openDVS_pixel2x2_bot
XopenDVS_pixel2x2_bot_436 openDVS_pixel2x2_bot_436/vpd[0] openDVS_pixel2x2_bot_436/vpd[1]
+ openDVS_pixel2x2_bot_436/vpd[3] openDVS_pixel2x2_bot_436/vpd[2] rowReadON[26] rowReadON[27]
+ RefrBp PrBp PrSFBp col_periphery_1x2_20/COL_LINE0 pixRst[40] pixRst[41] col_periphery_1x2_20/COL_LINE1
+ OffBn rowReadOFF[26] rowReadOFF[27] openDVS_pixel2x2_bot_447/GndD DiffBn VSUBS OnBn
+ VDD openDVS_pixel2x2_bot
XopenDVS_pixel2x2_bot_403 openDVS_pixel2x2_bot_403/vpd[0] openDVS_pixel2x2_bot_403/vpd[1]
+ openDVS_pixel2x2_bot_403/vpd[3] openDVS_pixel2x2_bot_403/vpd[2] rowReadON[24] rowReadON[25]
+ RefrBp PrBp PrSFBp col_periphery_1x2_19/COL_LINE0 pixRst[38] pixRst[39] col_periphery_1x2_19/COL_LINE1
+ OffBn rowReadOFF[24] rowReadOFF[25] openDVS_pixel2x2_bot_415/GndD DiffBn VSUBS OnBn
+ VDD openDVS_pixel2x2_bot
XopenDVS_pixel2x2_bot_458 openDVS_pixel2x2_bot_458/vpd[0] openDVS_pixel2x2_bot_458/vpd[1]
+ openDVS_pixel2x2_bot_458/vpd[3] openDVS_pixel2x2_bot_458/vpd[2] rowReadON[28] rowReadON[29]
+ RefrBp PrBp PrSFBp col_periphery_1x2_10/COL_LINE0 pixRst[20] pixRst[21] col_periphery_1x2_10/COL_LINE1
+ OffBn rowReadOFF[28] rowReadOFF[29] openDVS_pixel2x2_bot_479/GndD DiffBn VSUBS OnBn
+ VDD openDVS_pixel2x2_bot
XopenDVS_pixel2x2_bot_425 openDVS_pixel2x2_bot_425/vpd[0] openDVS_pixel2x2_bot_425/vpd[1]
+ openDVS_pixel2x2_bot_425/vpd[3] openDVS_pixel2x2_bot_425/vpd[2] rowReadON[26] rowReadON[27]
+ RefrBp PrBp PrSFBp col_periphery_1x2_9/COL_LINE0 pixRst[18] pixRst[19] col_periphery_1x2_9/COL_LINE1
+ OffBn rowReadOFF[26] rowReadOFF[27] openDVS_pixel2x2_bot_447/GndD DiffBn VSUBS OnBn
+ VDD openDVS_pixel2x2_bot
Xcol_periphery_1x2_3 pixRst[7] col_periphery_1x2_3/COL_LINE0 col_periphery_1x2_3/COL_LINE1
+ nDETECT col_periphery_1x2_9/VDD DETECT VTHRESH voutn[6] VSUBS NCHARGE voutn[7] pixRst[6]
+ col_periphery_1x2
XopenDVS_pixel2x2_bot_992 openDVS_pixel2x2_bot_992/vpd[0] openDVS_pixel2x2_bot_992/vpd[1]
+ openDVS_pixel2x2_bot_992/vpd[3] openDVS_pixel2x2_bot_992/vpd[2] rowReadON[62] rowReadON[63]
+ RefrBp PrBp PrSFBp col_periphery_1x2_0/COL_LINE0 pixRst[0] pixRst[1] col_periphery_1x2_0/COL_LINE1
+ OffBn rowReadOFF[62] rowReadOFF[63] openDVS_pixel2x2_bot_999/GndD DiffBn VSUBS OnBn
+ VDD openDVS_pixel2x2_bot
XopenDVS_pixel2x2_bot_981 openDVS_pixel2x2_bot_981/vpd[0] openDVS_pixel2x2_bot_981/vpd[1]
+ openDVS_pixel2x2_bot_981/vpd[3] openDVS_pixel2x2_bot_981/vpd[2] rowReadON[60] rowReadON[61]
+ RefrBp PrBp PrSFBp col_periphery_1x2_21/COL_LINE0 pixRst[42] pixRst[43] col_periphery_1x2_21/COL_LINE1
+ OffBn rowReadOFF[60] rowReadOFF[61] openDVS_pixel2x2_bot_991/GndD DiffBn VSUBS OnBn
+ VDD openDVS_pixel2x2_bot
XopenDVS_pixel2x2_bot_970 openDVS_pixel2x2_bot_970/vpd[0] openDVS_pixel2x2_bot_970/vpd[1]
+ openDVS_pixel2x2_bot_970/vpd[3] openDVS_pixel2x2_bot_970/vpd[2] rowReadON[60] rowReadON[61]
+ RefrBp PrBp PrSFBp col_periphery_1x2_10/COL_LINE0 pixRst[20] pixRst[21] col_periphery_1x2_10/COL_LINE1
+ OffBn rowReadOFF[60] rowReadOFF[61] openDVS_pixel2x2_bot_991/GndD DiffBn VSUBS OnBn
+ VDD openDVS_pixel2x2_bot
XopenDVS_pixel2x2_bot_288 openDVS_pixel2x2_bot_288/vpd[0] openDVS_pixel2x2_bot_288/vpd[1]
+ openDVS_pixel2x2_bot_288/vpd[3] openDVS_pixel2x2_bot_288/vpd[2] rowReadON[18] rowReadON[19]
+ RefrBp PrBp PrSFBp col_periphery_1x2_0/COL_LINE0 pixRst[0] pixRst[1] col_periphery_1x2_0/COL_LINE1
+ OffBn rowReadOFF[18] rowReadOFF[19] openDVS_pixel2x2_bot_319/GndD DiffBn VSUBS OnBn
+ VDD openDVS_pixel2x2_bot
XopenDVS_pixel2x2_bot_200 openDVS_pixel2x2_bot_200/vpd[0] openDVS_pixel2x2_bot_200/vpd[1]
+ openDVS_pixel2x2_bot_200/vpd[3] openDVS_pixel2x2_bot_200/vpd[2] rowReadON[12] rowReadON[13]
+ RefrBp PrBp PrSFBp col_periphery_1x2_8/COL_LINE0 pixRst[16] pixRst[17] col_periphery_1x2_8/COL_LINE1
+ OffBn rowReadOFF[12] rowReadOFF[13] openDVS_pixel2x2_bot_223/GndD DiffBn VSUBS OnBn
+ VDD openDVS_pixel2x2_bot
XopenDVS_pixel2x2_bot_233 openDVS_pixel2x2_bot_233/vpd[0] openDVS_pixel2x2_bot_233/vpd[1]
+ openDVS_pixel2x2_bot_233/vpd[3] openDVS_pixel2x2_bot_233/vpd[2] rowReadON[14] rowReadON[15]
+ RefrBp PrBp PrSFBp col_periphery_1x2_9/COL_LINE0 pixRst[18] pixRst[19] col_periphery_1x2_9/COL_LINE1
+ OffBn rowReadOFF[14] rowReadOFF[15] openDVS_pixel2x2_bot_255/GndD DiffBn VSUBS OnBn
+ VDD openDVS_pixel2x2_bot
XopenDVS_pixel2x2_bot_266 openDVS_pixel2x2_bot_266/vpd[0] openDVS_pixel2x2_bot_266/vpd[1]
+ openDVS_pixel2x2_bot_266/vpd[3] openDVS_pixel2x2_bot_266/vpd[2] rowReadON[16] rowReadON[17]
+ RefrBp PrBp PrSFBp col_periphery_1x2_10/COL_LINE0 pixRst[20] pixRst[21] col_periphery_1x2_10/COL_LINE1
+ OffBn rowReadOFF[16] rowReadOFF[17] openDVS_pixel2x2_bot_287/GndD DiffBn VSUBS OnBn
+ VDD openDVS_pixel2x2_bot
XopenDVS_pixel2x2_bot_299 openDVS_pixel2x2_bot_299/vpd[0] openDVS_pixel2x2_bot_299/vpd[1]
+ openDVS_pixel2x2_bot_299/vpd[3] openDVS_pixel2x2_bot_299/vpd[2] rowReadON[18] rowReadON[19]
+ RefrBp PrBp PrSFBp col_periphery_1x2_11/COL_LINE0 pixRst[22] pixRst[23] col_periphery_1x2_11/COL_LINE1
+ OffBn rowReadOFF[18] rowReadOFF[19] openDVS_pixel2x2_bot_319/GndD DiffBn VSUBS OnBn
+ VDD openDVS_pixel2x2_bot
XopenDVS_pixel2x2_bot_211 openDVS_pixel2x2_bot_211/vpd[0] openDVS_pixel2x2_bot_211/vpd[1]
+ openDVS_pixel2x2_bot_211/vpd[3] openDVS_pixel2x2_bot_211/vpd[2] rowReadON[12] rowReadON[13]
+ RefrBp PrBp PrSFBp col_periphery_1x2_19/COL_LINE0 pixRst[38] pixRst[39] col_periphery_1x2_19/COL_LINE1
+ OffBn rowReadOFF[12] rowReadOFF[13] openDVS_pixel2x2_bot_223/GndD DiffBn VSUBS OnBn
+ VDD openDVS_pixel2x2_bot
XopenDVS_pixel2x2_bot_244 openDVS_pixel2x2_bot_244/vpd[0] openDVS_pixel2x2_bot_244/vpd[1]
+ openDVS_pixel2x2_bot_244/vpd[3] openDVS_pixel2x2_bot_244/vpd[2] rowReadON[14] rowReadON[15]
+ RefrBp PrBp PrSFBp col_periphery_1x2_20/COL_LINE0 pixRst[40] pixRst[41] col_periphery_1x2_20/COL_LINE1
+ OffBn rowReadOFF[14] rowReadOFF[15] openDVS_pixel2x2_bot_255/GndD DiffBn VSUBS OnBn
+ VDD openDVS_pixel2x2_bot
XopenDVS_pixel2x2_bot_277 openDVS_pixel2x2_bot_277/vpd[0] openDVS_pixel2x2_bot_277/vpd[1]
+ openDVS_pixel2x2_bot_277/vpd[3] openDVS_pixel2x2_bot_277/vpd[2] rowReadON[16] rowReadON[17]
+ RefrBp PrBp PrSFBp col_periphery_1x2_21/COL_LINE0 pixRst[42] pixRst[43] col_periphery_1x2_21/COL_LINE1
+ OffBn rowReadOFF[16] rowReadOFF[17] openDVS_pixel2x2_bot_287/GndD DiffBn VSUBS OnBn
+ VDD openDVS_pixel2x2_bot
XopenDVS_pixel2x2_bot_222 openDVS_pixel2x2_bot_222/vpd[0] openDVS_pixel2x2_bot_222/vpd[1]
+ openDVS_pixel2x2_bot_222/vpd[3] openDVS_pixel2x2_bot_222/vpd[2] rowReadON[12] rowReadON[13]
+ RefrBp PrBp PrSFBp col_periphery_1x2_30/COL_LINE0 pixRst[60] pixRst[61] col_periphery_1x2_30/COL_LINE1
+ OffBn rowReadOFF[12] rowReadOFF[13] openDVS_pixel2x2_bot_223/GndD DiffBn VSUBS OnBn
+ VDD openDVS_pixel2x2_bot
XopenDVS_pixel2x2_bot_255 openDVS_pixel2x2_bot_255/vpd[0] openDVS_pixel2x2_bot_255/vpd[1]
+ openDVS_pixel2x2_bot_255/vpd[3] openDVS_pixel2x2_bot_255/vpd[2] rowReadON[14] rowReadON[15]
+ RefrBp PrBp PrSFBp col_periphery_1x2_31/COL_LINE0 pixRst[62] pixRst[63] col_periphery_1x2_31/COL_LINE1
+ OffBn rowReadOFF[14] rowReadOFF[15] openDVS_pixel2x2_bot_255/GndD DiffBn VSUBS OnBn
+ VDD openDVS_pixel2x2_bot
XopenDVS_pixel2x2_bot_607 openDVS_pixel2x2_bot_607/vpd[0] openDVS_pixel2x2_bot_607/vpd[1]
+ openDVS_pixel2x2_bot_607/vpd[3] openDVS_pixel2x2_bot_607/vpd[2] rowReadON[36] rowReadON[37]
+ RefrBp PrBp PrSFBp col_periphery_1x2_31/COL_LINE0 pixRst[62] pixRst[63] col_periphery_1x2_31/COL_LINE1
+ OffBn rowReadOFF[36] rowReadOFF[37] openDVS_pixel2x2_bot_607/GndD DiffBn VSUBS OnBn
+ VDD openDVS_pixel2x2_bot
XopenDVS_pixel2x2_bot_629 openDVS_pixel2x2_bot_629/vpd[0] openDVS_pixel2x2_bot_629/vpd[1]
+ openDVS_pixel2x2_bot_629/vpd[3] openDVS_pixel2x2_bot_629/vpd[2] rowReadON[38] rowReadON[39]
+ RefrBp PrBp PrSFBp col_periphery_1x2_21/COL_LINE0 pixRst[42] pixRst[43] col_periphery_1x2_21/COL_LINE1
+ OffBn rowReadOFF[38] rowReadOFF[39] openDVS_pixel2x2_bot_639/GndD DiffBn VSUBS OnBn
+ VDD openDVS_pixel2x2_bot
XopenDVS_pixel2x2_bot_618 openDVS_pixel2x2_bot_618/vpd[0] openDVS_pixel2x2_bot_618/vpd[1]
+ openDVS_pixel2x2_bot_618/vpd[3] openDVS_pixel2x2_bot_618/vpd[2] rowReadON[38] rowReadON[39]
+ RefrBp PrBp PrSFBp col_periphery_1x2_10/COL_LINE0 pixRst[20] pixRst[21] col_periphery_1x2_10/COL_LINE1
+ OffBn rowReadOFF[38] rowReadOFF[39] openDVS_pixel2x2_bot_639/GndD DiffBn VSUBS OnBn
+ VDD openDVS_pixel2x2_bot
XopenDVS_pixel2x2_bot_38 openDVS_pixel2x2_bot_38/vpd[0] openDVS_pixel2x2_bot_38/vpd[1]
+ openDVS_pixel2x2_bot_38/vpd[3] openDVS_pixel2x2_bot_38/vpd[2] rowReadON[2] rowReadON[3]
+ RefrBp PrBp PrSFBp col_periphery_1x2_6/COL_LINE0 pixRst[12] pixRst[13] col_periphery_1x2_6/COL_LINE1
+ OffBn rowReadOFF[2] rowReadOFF[3] openDVS_pixel2x2_bot_63/GndD DiffBn VSUBS OnBn
+ VDD openDVS_pixel2x2_bot
XopenDVS_pixel2x2_bot_27 openDVS_pixel2x2_bot_27/vpd[0] openDVS_pixel2x2_bot_27/vpd[1]
+ openDVS_pixel2x2_bot_27/vpd[3] openDVS_pixel2x2_bot_27/vpd[2] rowReadON[0] rowReadON[1]
+ RefrBp PrBp PrSFBp col_periphery_1x2_27/COL_LINE0 pixRst[54] pixRst[55] col_periphery_1x2_27/COL_LINE1
+ OffBn rowReadOFF[0] rowReadOFF[1] GND DiffBn VSUBS OnBn VDD openDVS_pixel2x2_bot
XopenDVS_pixel2x2_bot_16 openDVS_pixel2x2_bot_16/vpd[0] openDVS_pixel2x2_bot_16/vpd[1]
+ openDVS_pixel2x2_bot_16/vpd[3] openDVS_pixel2x2_bot_16/vpd[2] rowReadON[0] rowReadON[1]
+ RefrBp PrBp PrSFBp col_periphery_1x2_16/COL_LINE0 pixRst[32] pixRst[33] col_periphery_1x2_16/COL_LINE1
+ OffBn rowReadOFF[0] rowReadOFF[1] GND DiffBn VSUBS OnBn VDD openDVS_pixel2x2_bot
XopenDVS_pixel2x2_bot_49 openDVS_pixel2x2_bot_49/vpd[0] openDVS_pixel2x2_bot_49/vpd[1]
+ openDVS_pixel2x2_bot_49/vpd[3] openDVS_pixel2x2_bot_49/vpd[2] rowReadON[2] rowReadON[3]
+ RefrBp PrBp PrSFBp col_periphery_1x2_17/COL_LINE0 pixRst[34] pixRst[35] col_periphery_1x2_17/COL_LINE1
+ OffBn rowReadOFF[2] rowReadOFF[3] openDVS_pixel2x2_bot_63/GndD DiffBn VSUBS OnBn
+ VDD openDVS_pixel2x2_bot
XopenDVS_pixel2x2_bot_415 openDVS_pixel2x2_bot_415/vpd[0] openDVS_pixel2x2_bot_415/vpd[1]
+ openDVS_pixel2x2_bot_415/vpd[3] openDVS_pixel2x2_bot_415/vpd[2] rowReadON[24] rowReadON[25]
+ RefrBp PrBp PrSFBp col_periphery_1x2_31/COL_LINE0 pixRst[62] pixRst[63] col_periphery_1x2_31/COL_LINE1
+ OffBn rowReadOFF[24] rowReadOFF[25] openDVS_pixel2x2_bot_415/GndD DiffBn VSUBS OnBn
+ VDD openDVS_pixel2x2_bot
XopenDVS_pixel2x2_bot_437 openDVS_pixel2x2_bot_437/vpd[0] openDVS_pixel2x2_bot_437/vpd[1]
+ openDVS_pixel2x2_bot_437/vpd[3] openDVS_pixel2x2_bot_437/vpd[2] rowReadON[26] rowReadON[27]
+ RefrBp PrBp PrSFBp col_periphery_1x2_21/COL_LINE0 pixRst[42] pixRst[43] col_periphery_1x2_21/COL_LINE1
+ OffBn rowReadOFF[26] rowReadOFF[27] openDVS_pixel2x2_bot_447/GndD DiffBn VSUBS OnBn
+ VDD openDVS_pixel2x2_bot
XopenDVS_pixel2x2_bot_404 openDVS_pixel2x2_bot_404/vpd[0] openDVS_pixel2x2_bot_404/vpd[1]
+ openDVS_pixel2x2_bot_404/vpd[3] openDVS_pixel2x2_bot_404/vpd[2] rowReadON[24] rowReadON[25]
+ RefrBp PrBp PrSFBp col_periphery_1x2_20/COL_LINE0 pixRst[40] pixRst[41] col_periphery_1x2_20/COL_LINE1
+ OffBn rowReadOFF[24] rowReadOFF[25] openDVS_pixel2x2_bot_415/GndD DiffBn VSUBS OnBn
+ VDD openDVS_pixel2x2_bot
XopenDVS_pixel2x2_bot_459 openDVS_pixel2x2_bot_459/vpd[0] openDVS_pixel2x2_bot_459/vpd[1]
+ openDVS_pixel2x2_bot_459/vpd[3] openDVS_pixel2x2_bot_459/vpd[2] rowReadON[28] rowReadON[29]
+ RefrBp PrBp PrSFBp col_periphery_1x2_11/COL_LINE0 pixRst[22] pixRst[23] col_periphery_1x2_11/COL_LINE1
+ OffBn rowReadOFF[28] rowReadOFF[29] openDVS_pixel2x2_bot_479/GndD DiffBn VSUBS OnBn
+ VDD openDVS_pixel2x2_bot
XopenDVS_pixel2x2_bot_426 openDVS_pixel2x2_bot_426/vpd[0] openDVS_pixel2x2_bot_426/vpd[1]
+ openDVS_pixel2x2_bot_426/vpd[3] openDVS_pixel2x2_bot_426/vpd[2] rowReadON[26] rowReadON[27]
+ RefrBp PrBp PrSFBp col_periphery_1x2_10/COL_LINE0 pixRst[20] pixRst[21] col_periphery_1x2_10/COL_LINE1
+ OffBn rowReadOFF[26] rowReadOFF[27] openDVS_pixel2x2_bot_447/GndD DiffBn VSUBS OnBn
+ VDD openDVS_pixel2x2_bot
XopenDVS_pixel2x2_bot_448 openDVS_pixel2x2_bot_448/vpd[0] openDVS_pixel2x2_bot_448/vpd[1]
+ openDVS_pixel2x2_bot_448/vpd[3] openDVS_pixel2x2_bot_448/vpd[2] rowReadON[28] rowReadON[29]
+ RefrBp PrBp PrSFBp col_periphery_1x2_0/COL_LINE0 pixRst[0] pixRst[1] col_periphery_1x2_0/COL_LINE1
+ OffBn rowReadOFF[28] rowReadOFF[29] openDVS_pixel2x2_bot_479/GndD DiffBn VSUBS OnBn
+ VDD openDVS_pixel2x2_bot
Xcol_periphery_1x2_4 pixRst[9] col_periphery_1x2_4/COL_LINE0 col_periphery_1x2_4/COL_LINE1
+ nDETECT col_periphery_1x2_9/VDD DETECT VTHRESH voutn[8] VSUBS NCHARGE voutn[9] pixRst[8]
+ col_periphery_1x2
XopenDVS_pixel2x2_bot_993 openDVS_pixel2x2_bot_993/vpd[0] openDVS_pixel2x2_bot_993/vpd[1]
+ openDVS_pixel2x2_bot_993/vpd[3] openDVS_pixel2x2_bot_993/vpd[2] rowReadON[62] rowReadON[63]
+ RefrBp PrBp PrSFBp col_periphery_1x2_1/COL_LINE0 pixRst[2] pixRst[3] col_periphery_1x2_1/COL_LINE1
+ OffBn rowReadOFF[62] rowReadOFF[63] openDVS_pixel2x2_bot_999/GndD DiffBn VSUBS OnBn
+ VDD openDVS_pixel2x2_bot
XopenDVS_pixel2x2_bot_982 openDVS_pixel2x2_bot_982/vpd[0] openDVS_pixel2x2_bot_982/vpd[1]
+ openDVS_pixel2x2_bot_982/vpd[3] openDVS_pixel2x2_bot_982/vpd[2] rowReadON[60] rowReadON[61]
+ RefrBp PrBp PrSFBp col_periphery_1x2_22/COL_LINE0 pixRst[44] pixRst[45] col_periphery_1x2_22/COL_LINE1
+ OffBn rowReadOFF[60] rowReadOFF[61] openDVS_pixel2x2_bot_991/GndD DiffBn VSUBS OnBn
+ VDD openDVS_pixel2x2_bot
XopenDVS_pixel2x2_bot_971 openDVS_pixel2x2_bot_971/vpd[0] openDVS_pixel2x2_bot_971/vpd[1]
+ openDVS_pixel2x2_bot_971/vpd[3] openDVS_pixel2x2_bot_971/vpd[2] rowReadON[60] rowReadON[61]
+ RefrBp PrBp PrSFBp col_periphery_1x2_11/COL_LINE0 pixRst[22] pixRst[23] col_periphery_1x2_11/COL_LINE1
+ OffBn rowReadOFF[60] rowReadOFF[61] openDVS_pixel2x2_bot_991/GndD DiffBn VSUBS OnBn
+ VDD openDVS_pixel2x2_bot
XopenDVS_pixel2x2_bot_960 openDVS_pixel2x2_bot_960/vpd[0] openDVS_pixel2x2_bot_960/vpd[1]
+ openDVS_pixel2x2_bot_960/vpd[3] openDVS_pixel2x2_bot_960/vpd[2] rowReadON[60] rowReadON[61]
+ RefrBp PrBp PrSFBp col_periphery_1x2_0/COL_LINE0 pixRst[0] pixRst[1] col_periphery_1x2_0/COL_LINE1
+ OffBn rowReadOFF[60] rowReadOFF[61] openDVS_pixel2x2_bot_991/GndD DiffBn VSUBS OnBn
+ VDD openDVS_pixel2x2_bot
XopenDVS_pixel2x2_bot_256 openDVS_pixel2x2_bot_256/vpd[0] openDVS_pixel2x2_bot_256/vpd[1]
+ openDVS_pixel2x2_bot_256/vpd[3] openDVS_pixel2x2_bot_256/vpd[2] rowReadON[16] rowReadON[17]
+ RefrBp PrBp PrSFBp col_periphery_1x2_0/COL_LINE0 pixRst[0] pixRst[1] col_periphery_1x2_0/COL_LINE1
+ OffBn rowReadOFF[16] rowReadOFF[17] openDVS_pixel2x2_bot_287/GndD DiffBn VSUBS OnBn
+ VDD openDVS_pixel2x2_bot
XopenDVS_pixel2x2_bot_289 openDVS_pixel2x2_bot_289/vpd[0] openDVS_pixel2x2_bot_289/vpd[1]
+ openDVS_pixel2x2_bot_289/vpd[3] openDVS_pixel2x2_bot_289/vpd[2] rowReadON[18] rowReadON[19]
+ RefrBp PrBp PrSFBp col_periphery_1x2_1/COL_LINE0 pixRst[2] pixRst[3] col_periphery_1x2_1/COL_LINE1
+ OffBn rowReadOFF[18] rowReadOFF[19] openDVS_pixel2x2_bot_319/GndD DiffBn VSUBS OnBn
+ VDD openDVS_pixel2x2_bot
XopenDVS_pixel2x2_bot_201 openDVS_pixel2x2_bot_201/vpd[0] openDVS_pixel2x2_bot_201/vpd[1]
+ openDVS_pixel2x2_bot_201/vpd[3] openDVS_pixel2x2_bot_201/vpd[2] rowReadON[12] rowReadON[13]
+ RefrBp PrBp PrSFBp col_periphery_1x2_9/COL_LINE0 pixRst[18] pixRst[19] col_periphery_1x2_9/COL_LINE1
+ OffBn rowReadOFF[12] rowReadOFF[13] openDVS_pixel2x2_bot_223/GndD DiffBn VSUBS OnBn
+ VDD openDVS_pixel2x2_bot
XopenDVS_pixel2x2_bot_234 openDVS_pixel2x2_bot_234/vpd[0] openDVS_pixel2x2_bot_234/vpd[1]
+ openDVS_pixel2x2_bot_234/vpd[3] openDVS_pixel2x2_bot_234/vpd[2] rowReadON[14] rowReadON[15]
+ RefrBp PrBp PrSFBp col_periphery_1x2_10/COL_LINE0 pixRst[20] pixRst[21] col_periphery_1x2_10/COL_LINE1
+ OffBn rowReadOFF[14] rowReadOFF[15] openDVS_pixel2x2_bot_255/GndD DiffBn VSUBS OnBn
+ VDD openDVS_pixel2x2_bot
XopenDVS_pixel2x2_bot_267 openDVS_pixel2x2_bot_267/vpd[0] openDVS_pixel2x2_bot_267/vpd[1]
+ openDVS_pixel2x2_bot_267/vpd[3] openDVS_pixel2x2_bot_267/vpd[2] rowReadON[16] rowReadON[17]
+ RefrBp PrBp PrSFBp col_periphery_1x2_11/COL_LINE0 pixRst[22] pixRst[23] col_periphery_1x2_11/COL_LINE1
+ OffBn rowReadOFF[16] rowReadOFF[17] openDVS_pixel2x2_bot_287/GndD DiffBn VSUBS OnBn
+ VDD openDVS_pixel2x2_bot
XopenDVS_pixel2x2_bot_212 openDVS_pixel2x2_bot_212/vpd[0] openDVS_pixel2x2_bot_212/vpd[1]
+ openDVS_pixel2x2_bot_212/vpd[3] openDVS_pixel2x2_bot_212/vpd[2] rowReadON[12] rowReadON[13]
+ RefrBp PrBp PrSFBp col_periphery_1x2_20/COL_LINE0 pixRst[40] pixRst[41] col_periphery_1x2_20/COL_LINE1
+ OffBn rowReadOFF[12] rowReadOFF[13] openDVS_pixel2x2_bot_223/GndD DiffBn VSUBS OnBn
+ VDD openDVS_pixel2x2_bot
XopenDVS_pixel2x2_bot_245 openDVS_pixel2x2_bot_245/vpd[0] openDVS_pixel2x2_bot_245/vpd[1]
+ openDVS_pixel2x2_bot_245/vpd[3] openDVS_pixel2x2_bot_245/vpd[2] rowReadON[14] rowReadON[15]
+ RefrBp PrBp PrSFBp col_periphery_1x2_21/COL_LINE0 pixRst[42] pixRst[43] col_periphery_1x2_21/COL_LINE1
+ OffBn rowReadOFF[14] rowReadOFF[15] openDVS_pixel2x2_bot_255/GndD DiffBn VSUBS OnBn
+ VDD openDVS_pixel2x2_bot
XopenDVS_pixel2x2_bot_278 openDVS_pixel2x2_bot_278/vpd[0] openDVS_pixel2x2_bot_278/vpd[1]
+ openDVS_pixel2x2_bot_278/vpd[3] openDVS_pixel2x2_bot_278/vpd[2] rowReadON[16] rowReadON[17]
+ RefrBp PrBp PrSFBp col_periphery_1x2_22/COL_LINE0 pixRst[44] pixRst[45] col_periphery_1x2_22/COL_LINE1
+ OffBn rowReadOFF[16] rowReadOFF[17] openDVS_pixel2x2_bot_287/GndD DiffBn VSUBS OnBn
+ VDD openDVS_pixel2x2_bot
XopenDVS_pixel2x2_bot_223 openDVS_pixel2x2_bot_223/vpd[0] openDVS_pixel2x2_bot_223/vpd[1]
+ openDVS_pixel2x2_bot_223/vpd[3] openDVS_pixel2x2_bot_223/vpd[2] rowReadON[12] rowReadON[13]
+ RefrBp PrBp PrSFBp col_periphery_1x2_31/COL_LINE0 pixRst[62] pixRst[63] col_periphery_1x2_31/COL_LINE1
+ OffBn rowReadOFF[12] rowReadOFF[13] openDVS_pixel2x2_bot_223/GndD DiffBn VSUBS OnBn
+ VDD openDVS_pixel2x2_bot
XopenDVS_pixel2x2_bot_790 openDVS_pixel2x2_bot_790/vpd[0] openDVS_pixel2x2_bot_790/vpd[1]
+ openDVS_pixel2x2_bot_790/vpd[3] openDVS_pixel2x2_bot_790/vpd[2] rowReadON[48] rowReadON[49]
+ RefrBp PrBp PrSFBp col_periphery_1x2_22/COL_LINE0 pixRst[44] pixRst[45] col_periphery_1x2_22/COL_LINE1
+ OffBn rowReadOFF[48] rowReadOFF[49] openDVS_pixel2x2_bot_799/GndD DiffBn VSUBS OnBn
+ VDD openDVS_pixel2x2_bot
XopenDVS_pixel2x2_bot_619 openDVS_pixel2x2_bot_619/vpd[0] openDVS_pixel2x2_bot_619/vpd[1]
+ openDVS_pixel2x2_bot_619/vpd[3] openDVS_pixel2x2_bot_619/vpd[2] rowReadON[38] rowReadON[39]
+ RefrBp PrBp PrSFBp col_periphery_1x2_11/COL_LINE0 pixRst[22] pixRst[23] col_periphery_1x2_11/COL_LINE1
+ OffBn rowReadOFF[38] rowReadOFF[39] openDVS_pixel2x2_bot_639/GndD DiffBn VSUBS OnBn
+ VDD openDVS_pixel2x2_bot
XopenDVS_pixel2x2_bot_608 openDVS_pixel2x2_bot_608/vpd[0] openDVS_pixel2x2_bot_608/vpd[1]
+ openDVS_pixel2x2_bot_608/vpd[3] openDVS_pixel2x2_bot_608/vpd[2] rowReadON[38] rowReadON[39]
+ RefrBp PrBp PrSFBp col_periphery_1x2_0/COL_LINE0 pixRst[0] pixRst[1] col_periphery_1x2_0/COL_LINE1
+ OffBn rowReadOFF[38] rowReadOFF[39] openDVS_pixel2x2_bot_639/GndD DiffBn VSUBS OnBn
+ VDD openDVS_pixel2x2_bot
XopenDVS_pixel2x2_bot_28 openDVS_pixel2x2_bot_28/vpd[0] openDVS_pixel2x2_bot_28/vpd[1]
+ openDVS_pixel2x2_bot_28/vpd[3] openDVS_pixel2x2_bot_28/vpd[2] rowReadON[0] rowReadON[1]
+ RefrBp PrBp PrSFBp col_periphery_1x2_28/COL_LINE0 pixRst[56] pixRst[57] col_periphery_1x2_28/COL_LINE1
+ OffBn rowReadOFF[0] rowReadOFF[1] GND DiffBn VSUBS OnBn VDD openDVS_pixel2x2_bot
XopenDVS_pixel2x2_bot_17 openDVS_pixel2x2_bot_17/vpd[0] openDVS_pixel2x2_bot_17/vpd[1]
+ openDVS_pixel2x2_bot_17/vpd[3] openDVS_pixel2x2_bot_17/vpd[2] rowReadON[0] rowReadON[1]
+ RefrBp PrBp PrSFBp col_periphery_1x2_17/COL_LINE0 pixRst[34] pixRst[35] col_periphery_1x2_17/COL_LINE1
+ OffBn rowReadOFF[0] rowReadOFF[1] GND DiffBn VSUBS OnBn VDD openDVS_pixel2x2_bot
XopenDVS_pixel2x2_bot_39 openDVS_pixel2x2_bot_39/vpd[0] openDVS_pixel2x2_bot_39/vpd[1]
+ openDVS_pixel2x2_bot_39/vpd[3] openDVS_pixel2x2_bot_39/vpd[2] rowReadON[2] rowReadON[3]
+ RefrBp PrBp PrSFBp col_periphery_1x2_7/COL_LINE0 pixRst[14] pixRst[15] col_periphery_1x2_7/COL_LINE1
+ OffBn rowReadOFF[2] rowReadOFF[3] openDVS_pixel2x2_bot_63/GndD DiffBn VSUBS OnBn
+ VDD openDVS_pixel2x2_bot
XopenDVS_pixel2x2_bot_438 openDVS_pixel2x2_bot_438/vpd[0] openDVS_pixel2x2_bot_438/vpd[1]
+ openDVS_pixel2x2_bot_438/vpd[3] openDVS_pixel2x2_bot_438/vpd[2] rowReadON[26] rowReadON[27]
+ RefrBp PrBp PrSFBp col_periphery_1x2_22/COL_LINE0 pixRst[44] pixRst[45] col_periphery_1x2_22/COL_LINE1
+ OffBn rowReadOFF[26] rowReadOFF[27] openDVS_pixel2x2_bot_447/GndD DiffBn VSUBS OnBn
+ VDD openDVS_pixel2x2_bot
XopenDVS_pixel2x2_bot_405 openDVS_pixel2x2_bot_405/vpd[0] openDVS_pixel2x2_bot_405/vpd[1]
+ openDVS_pixel2x2_bot_405/vpd[3] openDVS_pixel2x2_bot_405/vpd[2] rowReadON[24] rowReadON[25]
+ RefrBp PrBp PrSFBp col_periphery_1x2_21/COL_LINE0 pixRst[42] pixRst[43] col_periphery_1x2_21/COL_LINE1
+ OffBn rowReadOFF[24] rowReadOFF[25] openDVS_pixel2x2_bot_415/GndD DiffBn VSUBS OnBn
+ VDD openDVS_pixel2x2_bot
XopenDVS_pixel2x2_bot_427 openDVS_pixel2x2_bot_427/vpd[0] openDVS_pixel2x2_bot_427/vpd[1]
+ openDVS_pixel2x2_bot_427/vpd[3] openDVS_pixel2x2_bot_427/vpd[2] rowReadON[26] rowReadON[27]
+ RefrBp PrBp PrSFBp col_periphery_1x2_11/COL_LINE0 pixRst[22] pixRst[23] col_periphery_1x2_11/COL_LINE1
+ OffBn rowReadOFF[26] rowReadOFF[27] openDVS_pixel2x2_bot_447/GndD DiffBn VSUBS OnBn
+ VDD openDVS_pixel2x2_bot
XopenDVS_pixel2x2_bot_449 openDVS_pixel2x2_bot_449/vpd[0] openDVS_pixel2x2_bot_449/vpd[1]
+ openDVS_pixel2x2_bot_449/vpd[3] openDVS_pixel2x2_bot_449/vpd[2] rowReadON[28] rowReadON[29]
+ RefrBp PrBp PrSFBp col_periphery_1x2_1/COL_LINE0 pixRst[2] pixRst[3] col_periphery_1x2_1/COL_LINE1
+ OffBn rowReadOFF[28] rowReadOFF[29] openDVS_pixel2x2_bot_479/GndD DiffBn VSUBS OnBn
+ VDD openDVS_pixel2x2_bot
XopenDVS_pixel2x2_bot_416 openDVS_pixel2x2_bot_416/vpd[0] openDVS_pixel2x2_bot_416/vpd[1]
+ openDVS_pixel2x2_bot_416/vpd[3] openDVS_pixel2x2_bot_416/vpd[2] rowReadON[26] rowReadON[27]
+ RefrBp PrBp PrSFBp col_periphery_1x2_0/COL_LINE0 pixRst[0] pixRst[1] col_periphery_1x2_0/COL_LINE1
+ OffBn rowReadOFF[26] rowReadOFF[27] openDVS_pixel2x2_bot_447/GndD DiffBn VSUBS OnBn
+ VDD openDVS_pixel2x2_bot
XopenDVS_pixel2x2_bot_994 openDVS_pixel2x2_bot_994/vpd[0] openDVS_pixel2x2_bot_994/vpd[1]
+ openDVS_pixel2x2_bot_994/vpd[3] openDVS_pixel2x2_bot_994/vpd[2] rowReadON[62] rowReadON[63]
+ RefrBp PrBp PrSFBp col_periphery_1x2_2/COL_LINE0 pixRst[4] pixRst[5] col_periphery_1x2_2/COL_LINE1
+ OffBn rowReadOFF[62] rowReadOFF[63] openDVS_pixel2x2_bot_999/GndD DiffBn VSUBS OnBn
+ VDD openDVS_pixel2x2_bot
XopenDVS_pixel2x2_bot_983 openDVS_pixel2x2_bot_983/vpd[0] openDVS_pixel2x2_bot_983/vpd[1]
+ openDVS_pixel2x2_bot_983/vpd[3] openDVS_pixel2x2_bot_983/vpd[2] rowReadON[60] rowReadON[61]
+ RefrBp PrBp PrSFBp col_periphery_1x2_23/COL_LINE0 pixRst[46] pixRst[47] col_periphery_1x2_23/COL_LINE1
+ OffBn rowReadOFF[60] rowReadOFF[61] openDVS_pixel2x2_bot_991/GndD DiffBn VSUBS OnBn
+ VDD openDVS_pixel2x2_bot
XopenDVS_pixel2x2_bot_950 openDVS_pixel2x2_bot_950/vpd[0] openDVS_pixel2x2_bot_950/vpd[1]
+ openDVS_pixel2x2_bot_950/vpd[3] openDVS_pixel2x2_bot_950/vpd[2] rowReadON[58] rowReadON[59]
+ RefrBp PrBp PrSFBp col_periphery_1x2_22/COL_LINE0 pixRst[44] pixRst[45] col_periphery_1x2_22/COL_LINE1
+ OffBn rowReadOFF[58] rowReadOFF[59] openDVS_pixel2x2_bot_959/GndD DiffBn VSUBS OnBn
+ VDD openDVS_pixel2x2_bot
XopenDVS_pixel2x2_bot_972 openDVS_pixel2x2_bot_972/vpd[0] openDVS_pixel2x2_bot_972/vpd[1]
+ openDVS_pixel2x2_bot_972/vpd[3] openDVS_pixel2x2_bot_972/vpd[2] rowReadON[60] rowReadON[61]
+ RefrBp PrBp PrSFBp col_periphery_1x2_12/COL_LINE0 pixRst[24] pixRst[25] col_periphery_1x2_12/COL_LINE1
+ OffBn rowReadOFF[60] rowReadOFF[61] openDVS_pixel2x2_bot_991/GndD DiffBn VSUBS OnBn
+ VDD openDVS_pixel2x2_bot
XopenDVS_pixel2x2_bot_961 openDVS_pixel2x2_bot_961/vpd[0] openDVS_pixel2x2_bot_961/vpd[1]
+ openDVS_pixel2x2_bot_961/vpd[3] openDVS_pixel2x2_bot_961/vpd[2] rowReadON[60] rowReadON[61]
+ RefrBp PrBp PrSFBp col_periphery_1x2_1/COL_LINE0 pixRst[2] pixRst[3] col_periphery_1x2_1/COL_LINE1
+ OffBn rowReadOFF[60] rowReadOFF[61] openDVS_pixel2x2_bot_991/GndD DiffBn VSUBS OnBn
+ VDD openDVS_pixel2x2_bot
Xcol_periphery_1x2_5 pixRst[11] col_periphery_1x2_5/COL_LINE0 col_periphery_1x2_5/COL_LINE1
+ nDETECT col_periphery_1x2_9/VDD DETECT VTHRESH voutn[10] VSUBS NCHARGE voutn[11]
+ pixRst[10] col_periphery_1x2
XopenDVS_pixel2x2_bot_224 openDVS_pixel2x2_bot_224/vpd[0] openDVS_pixel2x2_bot_224/vpd[1]
+ openDVS_pixel2x2_bot_224/vpd[3] openDVS_pixel2x2_bot_224/vpd[2] rowReadON[14] rowReadON[15]
+ RefrBp PrBp PrSFBp col_periphery_1x2_0/COL_LINE0 pixRst[0] pixRst[1] col_periphery_1x2_0/COL_LINE1
+ OffBn rowReadOFF[14] rowReadOFF[15] openDVS_pixel2x2_bot_255/GndD DiffBn VSUBS OnBn
+ VDD openDVS_pixel2x2_bot
XopenDVS_pixel2x2_bot_257 openDVS_pixel2x2_bot_257/vpd[0] openDVS_pixel2x2_bot_257/vpd[1]
+ openDVS_pixel2x2_bot_257/vpd[3] openDVS_pixel2x2_bot_257/vpd[2] rowReadON[16] rowReadON[17]
+ RefrBp PrBp PrSFBp col_periphery_1x2_1/COL_LINE0 pixRst[2] pixRst[3] col_periphery_1x2_1/COL_LINE1
+ OffBn rowReadOFF[16] rowReadOFF[17] openDVS_pixel2x2_bot_287/GndD DiffBn VSUBS OnBn
+ VDD openDVS_pixel2x2_bot
XopenDVS_pixel2x2_bot_202 openDVS_pixel2x2_bot_202/vpd[0] openDVS_pixel2x2_bot_202/vpd[1]
+ openDVS_pixel2x2_bot_202/vpd[3] openDVS_pixel2x2_bot_202/vpd[2] rowReadON[12] rowReadON[13]
+ RefrBp PrBp PrSFBp col_periphery_1x2_10/COL_LINE0 pixRst[20] pixRst[21] col_periphery_1x2_10/COL_LINE1
+ OffBn rowReadOFF[12] rowReadOFF[13] openDVS_pixel2x2_bot_223/GndD DiffBn VSUBS OnBn
+ VDD openDVS_pixel2x2_bot
XopenDVS_pixel2x2_bot_235 openDVS_pixel2x2_bot_235/vpd[0] openDVS_pixel2x2_bot_235/vpd[1]
+ openDVS_pixel2x2_bot_235/vpd[3] openDVS_pixel2x2_bot_235/vpd[2] rowReadON[14] rowReadON[15]
+ RefrBp PrBp PrSFBp col_periphery_1x2_11/COL_LINE0 pixRst[22] pixRst[23] col_periphery_1x2_11/COL_LINE1
+ OffBn rowReadOFF[14] rowReadOFF[15] openDVS_pixel2x2_bot_255/GndD DiffBn VSUBS OnBn
+ VDD openDVS_pixel2x2_bot
XopenDVS_pixel2x2_bot_268 openDVS_pixel2x2_bot_268/vpd[0] openDVS_pixel2x2_bot_268/vpd[1]
+ openDVS_pixel2x2_bot_268/vpd[3] openDVS_pixel2x2_bot_268/vpd[2] rowReadON[16] rowReadON[17]
+ RefrBp PrBp PrSFBp col_periphery_1x2_12/COL_LINE0 pixRst[24] pixRst[25] col_periphery_1x2_12/COL_LINE1
+ OffBn rowReadOFF[16] rowReadOFF[17] openDVS_pixel2x2_bot_287/GndD DiffBn VSUBS OnBn
+ VDD openDVS_pixel2x2_bot
XopenDVS_pixel2x2_bot_213 openDVS_pixel2x2_bot_213/vpd[0] openDVS_pixel2x2_bot_213/vpd[1]
+ openDVS_pixel2x2_bot_213/vpd[3] openDVS_pixel2x2_bot_213/vpd[2] rowReadON[12] rowReadON[13]
+ RefrBp PrBp PrSFBp col_periphery_1x2_21/COL_LINE0 pixRst[42] pixRst[43] col_periphery_1x2_21/COL_LINE1
+ OffBn rowReadOFF[12] rowReadOFF[13] openDVS_pixel2x2_bot_223/GndD DiffBn VSUBS OnBn
+ VDD openDVS_pixel2x2_bot
XopenDVS_pixel2x2_bot_246 openDVS_pixel2x2_bot_246/vpd[0] openDVS_pixel2x2_bot_246/vpd[1]
+ openDVS_pixel2x2_bot_246/vpd[3] openDVS_pixel2x2_bot_246/vpd[2] rowReadON[14] rowReadON[15]
+ RefrBp PrBp PrSFBp col_periphery_1x2_22/COL_LINE0 pixRst[44] pixRst[45] col_periphery_1x2_22/COL_LINE1
+ OffBn rowReadOFF[14] rowReadOFF[15] openDVS_pixel2x2_bot_255/GndD DiffBn VSUBS OnBn
+ VDD openDVS_pixel2x2_bot
XopenDVS_pixel2x2_bot_279 openDVS_pixel2x2_bot_279/vpd[0] openDVS_pixel2x2_bot_279/vpd[1]
+ openDVS_pixel2x2_bot_279/vpd[3] openDVS_pixel2x2_bot_279/vpd[2] rowReadON[16] rowReadON[17]
+ RefrBp PrBp PrSFBp col_periphery_1x2_23/COL_LINE0 pixRst[46] pixRst[47] col_periphery_1x2_23/COL_LINE1
+ OffBn rowReadOFF[16] rowReadOFF[17] openDVS_pixel2x2_bot_287/GndD DiffBn VSUBS OnBn
+ VDD openDVS_pixel2x2_bot
XopenDVS_pixel2x2_bot_791 openDVS_pixel2x2_bot_791/vpd[0] openDVS_pixel2x2_bot_791/vpd[1]
+ openDVS_pixel2x2_bot_791/vpd[3] openDVS_pixel2x2_bot_791/vpd[2] rowReadON[48] rowReadON[49]
+ RefrBp PrBp PrSFBp col_periphery_1x2_23/COL_LINE0 pixRst[46] pixRst[47] col_periphery_1x2_23/COL_LINE1
+ OffBn rowReadOFF[48] rowReadOFF[49] openDVS_pixel2x2_bot_799/GndD DiffBn VSUBS OnBn
+ VDD openDVS_pixel2x2_bot
XopenDVS_pixel2x2_bot_780 openDVS_pixel2x2_bot_780/vpd[0] openDVS_pixel2x2_bot_780/vpd[1]
+ openDVS_pixel2x2_bot_780/vpd[3] openDVS_pixel2x2_bot_780/vpd[2] rowReadON[48] rowReadON[49]
+ RefrBp PrBp PrSFBp col_periphery_1x2_12/COL_LINE0 pixRst[24] pixRst[25] col_periphery_1x2_12/COL_LINE1
+ OffBn rowReadOFF[48] rowReadOFF[49] openDVS_pixel2x2_bot_799/GndD DiffBn VSUBS OnBn
+ VDD openDVS_pixel2x2_bot
XopenDVS_pixel2x2_bot_609 openDVS_pixel2x2_bot_609/vpd[0] openDVS_pixel2x2_bot_609/vpd[1]
+ openDVS_pixel2x2_bot_609/vpd[3] openDVS_pixel2x2_bot_609/vpd[2] rowReadON[38] rowReadON[39]
+ RefrBp PrBp PrSFBp col_periphery_1x2_1/COL_LINE0 pixRst[2] pixRst[3] col_periphery_1x2_1/COL_LINE1
+ OffBn rowReadOFF[38] rowReadOFF[39] openDVS_pixel2x2_bot_639/GndD DiffBn VSUBS OnBn
+ VDD openDVS_pixel2x2_bot
XopenDVS_pixel2x2_bot_29 openDVS_pixel2x2_bot_29/vpd[0] openDVS_pixel2x2_bot_29/vpd[1]
+ openDVS_pixel2x2_bot_29/vpd[3] openDVS_pixel2x2_bot_29/vpd[2] rowReadON[0] rowReadON[1]
+ RefrBp PrBp PrSFBp col_periphery_1x2_29/COL_LINE0 pixRst[58] pixRst[59] col_periphery_1x2_29/COL_LINE1
+ OffBn rowReadOFF[0] rowReadOFF[1] GND DiffBn VSUBS OnBn VDD openDVS_pixel2x2_bot
XopenDVS_pixel2x2_bot_18 openDVS_pixel2x2_bot_18/vpd[0] openDVS_pixel2x2_bot_18/vpd[1]
+ openDVS_pixel2x2_bot_18/vpd[3] openDVS_pixel2x2_bot_18/vpd[2] rowReadON[0] rowReadON[1]
+ RefrBp PrBp PrSFBp col_periphery_1x2_18/COL_LINE0 pixRst[36] pixRst[37] col_periphery_1x2_18/COL_LINE1
+ OffBn rowReadOFF[0] rowReadOFF[1] GND DiffBn VSUBS OnBn VDD openDVS_pixel2x2_bot
XopenDVS_pixel2x2_bot_406 openDVS_pixel2x2_bot_406/vpd[0] openDVS_pixel2x2_bot_406/vpd[1]
+ openDVS_pixel2x2_bot_406/vpd[3] openDVS_pixel2x2_bot_406/vpd[2] rowReadON[24] rowReadON[25]
+ RefrBp PrBp PrSFBp col_periphery_1x2_22/COL_LINE0 pixRst[44] pixRst[45] col_periphery_1x2_22/COL_LINE1
+ OffBn rowReadOFF[24] rowReadOFF[25] openDVS_pixel2x2_bot_415/GndD DiffBn VSUBS OnBn
+ VDD openDVS_pixel2x2_bot
XopenDVS_pixel2x2_bot_428 openDVS_pixel2x2_bot_428/vpd[0] openDVS_pixel2x2_bot_428/vpd[1]
+ openDVS_pixel2x2_bot_428/vpd[3] openDVS_pixel2x2_bot_428/vpd[2] rowReadON[26] rowReadON[27]
+ RefrBp PrBp PrSFBp col_periphery_1x2_12/COL_LINE0 pixRst[24] pixRst[25] col_periphery_1x2_12/COL_LINE1
+ OffBn rowReadOFF[26] rowReadOFF[27] openDVS_pixel2x2_bot_447/GndD DiffBn VSUBS OnBn
+ VDD openDVS_pixel2x2_bot
XopenDVS_pixel2x2_bot_417 openDVS_pixel2x2_bot_417/vpd[0] openDVS_pixel2x2_bot_417/vpd[1]
+ openDVS_pixel2x2_bot_417/vpd[3] openDVS_pixel2x2_bot_417/vpd[2] rowReadON[26] rowReadON[27]
+ RefrBp PrBp PrSFBp col_periphery_1x2_1/COL_LINE0 pixRst[2] pixRst[3] col_periphery_1x2_1/COL_LINE1
+ OffBn rowReadOFF[26] rowReadOFF[27] openDVS_pixel2x2_bot_447/GndD DiffBn VSUBS OnBn
+ VDD openDVS_pixel2x2_bot
XopenDVS_pixel2x2_bot_984 openDVS_pixel2x2_bot_984/vpd[0] openDVS_pixel2x2_bot_984/vpd[1]
+ openDVS_pixel2x2_bot_984/vpd[3] openDVS_pixel2x2_bot_984/vpd[2] rowReadON[60] rowReadON[61]
+ RefrBp PrBp PrSFBp col_periphery_1x2_24/COL_LINE0 pixRst[48] pixRst[49] col_periphery_1x2_24/COL_LINE1
+ OffBn rowReadOFF[60] rowReadOFF[61] openDVS_pixel2x2_bot_991/GndD DiffBn VSUBS OnBn
+ VDD openDVS_pixel2x2_bot
XopenDVS_pixel2x2_bot_951 openDVS_pixel2x2_bot_951/vpd[0] openDVS_pixel2x2_bot_951/vpd[1]
+ openDVS_pixel2x2_bot_951/vpd[3] openDVS_pixel2x2_bot_951/vpd[2] rowReadON[58] rowReadON[59]
+ RefrBp PrBp PrSFBp col_periphery_1x2_23/COL_LINE0 pixRst[46] pixRst[47] col_periphery_1x2_23/COL_LINE1
+ OffBn rowReadOFF[58] rowReadOFF[59] openDVS_pixel2x2_bot_959/GndD DiffBn VSUBS OnBn
+ VDD openDVS_pixel2x2_bot
XopenDVS_pixel2x2_bot_973 openDVS_pixel2x2_bot_973/vpd[0] openDVS_pixel2x2_bot_973/vpd[1]
+ openDVS_pixel2x2_bot_973/vpd[3] openDVS_pixel2x2_bot_973/vpd[2] rowReadON[60] rowReadON[61]
+ RefrBp PrBp PrSFBp col_periphery_1x2_13/COL_LINE0 pixRst[26] pixRst[27] col_periphery_1x2_13/COL_LINE1
+ OffBn rowReadOFF[60] rowReadOFF[61] openDVS_pixel2x2_bot_991/GndD DiffBn VSUBS OnBn
+ VDD openDVS_pixel2x2_bot
XopenDVS_pixel2x2_bot_940 openDVS_pixel2x2_bot_940/vpd[0] openDVS_pixel2x2_bot_940/vpd[1]
+ openDVS_pixel2x2_bot_940/vpd[3] openDVS_pixel2x2_bot_940/vpd[2] rowReadON[58] rowReadON[59]
+ RefrBp PrBp PrSFBp col_periphery_1x2_12/COL_LINE0 pixRst[24] pixRst[25] col_periphery_1x2_12/COL_LINE1
+ OffBn rowReadOFF[58] rowReadOFF[59] openDVS_pixel2x2_bot_959/GndD DiffBn VSUBS OnBn
+ VDD openDVS_pixel2x2_bot
XopenDVS_pixel2x2_bot_962 openDVS_pixel2x2_bot_962/vpd[0] openDVS_pixel2x2_bot_962/vpd[1]
+ openDVS_pixel2x2_bot_962/vpd[3] openDVS_pixel2x2_bot_962/vpd[2] rowReadON[60] rowReadON[61]
+ RefrBp PrBp PrSFBp col_periphery_1x2_2/COL_LINE0 pixRst[4] pixRst[5] col_periphery_1x2_2/COL_LINE1
+ OffBn rowReadOFF[60] rowReadOFF[61] openDVS_pixel2x2_bot_991/GndD DiffBn VSUBS OnBn
+ VDD openDVS_pixel2x2_bot
XopenDVS_pixel2x2_bot_439 openDVS_pixel2x2_bot_439/vpd[0] openDVS_pixel2x2_bot_439/vpd[1]
+ openDVS_pixel2x2_bot_439/vpd[3] openDVS_pixel2x2_bot_439/vpd[2] rowReadON[26] rowReadON[27]
+ RefrBp PrBp PrSFBp col_periphery_1x2_23/COL_LINE0 pixRst[46] pixRst[47] col_periphery_1x2_23/COL_LINE1
+ OffBn rowReadOFF[26] rowReadOFF[27] openDVS_pixel2x2_bot_447/GndD DiffBn VSUBS OnBn
+ VDD openDVS_pixel2x2_bot
Xcol_periphery_1x2_6 pixRst[13] col_periphery_1x2_6/COL_LINE0 col_periphery_1x2_6/COL_LINE1
+ nDETECT col_periphery_1x2_9/VDD DETECT VTHRESH voutn[12] VSUBS NCHARGE voutn[13]
+ pixRst[12] col_periphery_1x2
XopenDVS_pixel2x2_bot_995 openDVS_pixel2x2_bot_995/vpd[0] openDVS_pixel2x2_bot_995/vpd[1]
+ openDVS_pixel2x2_bot_995/vpd[3] openDVS_pixel2x2_bot_995/vpd[2] rowReadON[62] rowReadON[63]
+ RefrBp PrBp PrSFBp col_periphery_1x2_3/COL_LINE0 pixRst[6] pixRst[7] col_periphery_1x2_3/COL_LINE1
+ OffBn rowReadOFF[62] rowReadOFF[63] openDVS_pixel2x2_bot_999/GndD DiffBn VSUBS OnBn
+ VDD openDVS_pixel2x2_bot
XopenDVS_pixel2x2_bot_225 openDVS_pixel2x2_bot_225/vpd[0] openDVS_pixel2x2_bot_225/vpd[1]
+ openDVS_pixel2x2_bot_225/vpd[3] openDVS_pixel2x2_bot_225/vpd[2] rowReadON[14] rowReadON[15]
+ RefrBp PrBp PrSFBp col_periphery_1x2_1/COL_LINE0 pixRst[2] pixRst[3] col_periphery_1x2_1/COL_LINE1
+ OffBn rowReadOFF[14] rowReadOFF[15] openDVS_pixel2x2_bot_255/GndD DiffBn VSUBS OnBn
+ VDD openDVS_pixel2x2_bot
XopenDVS_pixel2x2_bot_258 openDVS_pixel2x2_bot_258/vpd[0] openDVS_pixel2x2_bot_258/vpd[1]
+ openDVS_pixel2x2_bot_258/vpd[3] openDVS_pixel2x2_bot_258/vpd[2] rowReadON[16] rowReadON[17]
+ RefrBp PrBp PrSFBp col_periphery_1x2_2/COL_LINE0 pixRst[4] pixRst[5] col_periphery_1x2_2/COL_LINE1
+ OffBn rowReadOFF[16] rowReadOFF[17] openDVS_pixel2x2_bot_287/GndD DiffBn VSUBS OnBn
+ VDD openDVS_pixel2x2_bot
XopenDVS_pixel2x2_bot_203 openDVS_pixel2x2_bot_203/vpd[0] openDVS_pixel2x2_bot_203/vpd[1]
+ openDVS_pixel2x2_bot_203/vpd[3] openDVS_pixel2x2_bot_203/vpd[2] rowReadON[12] rowReadON[13]
+ RefrBp PrBp PrSFBp col_periphery_1x2_11/COL_LINE0 pixRst[22] pixRst[23] col_periphery_1x2_11/COL_LINE1
+ OffBn rowReadOFF[12] rowReadOFF[13] openDVS_pixel2x2_bot_223/GndD DiffBn VSUBS OnBn
+ VDD openDVS_pixel2x2_bot
XopenDVS_pixel2x2_bot_236 openDVS_pixel2x2_bot_236/vpd[0] openDVS_pixel2x2_bot_236/vpd[1]
+ openDVS_pixel2x2_bot_236/vpd[3] openDVS_pixel2x2_bot_236/vpd[2] rowReadON[14] rowReadON[15]
+ RefrBp PrBp PrSFBp col_periphery_1x2_12/COL_LINE0 pixRst[24] pixRst[25] col_periphery_1x2_12/COL_LINE1
+ OffBn rowReadOFF[14] rowReadOFF[15] openDVS_pixel2x2_bot_255/GndD DiffBn VSUBS OnBn
+ VDD openDVS_pixel2x2_bot
XopenDVS_pixel2x2_bot_269 openDVS_pixel2x2_bot_269/vpd[0] openDVS_pixel2x2_bot_269/vpd[1]
+ openDVS_pixel2x2_bot_269/vpd[3] openDVS_pixel2x2_bot_269/vpd[2] rowReadON[16] rowReadON[17]
+ RefrBp PrBp PrSFBp col_periphery_1x2_13/COL_LINE0 pixRst[26] pixRst[27] col_periphery_1x2_13/COL_LINE1
+ OffBn rowReadOFF[16] rowReadOFF[17] openDVS_pixel2x2_bot_287/GndD DiffBn VSUBS OnBn
+ VDD openDVS_pixel2x2_bot
XopenDVS_pixel2x2_bot_214 openDVS_pixel2x2_bot_214/vpd[0] openDVS_pixel2x2_bot_214/vpd[1]
+ openDVS_pixel2x2_bot_214/vpd[3] openDVS_pixel2x2_bot_214/vpd[2] rowReadON[12] rowReadON[13]
+ RefrBp PrBp PrSFBp col_periphery_1x2_22/COL_LINE0 pixRst[44] pixRst[45] col_periphery_1x2_22/COL_LINE1
+ OffBn rowReadOFF[12] rowReadOFF[13] openDVS_pixel2x2_bot_223/GndD DiffBn VSUBS OnBn
+ VDD openDVS_pixel2x2_bot
XopenDVS_pixel2x2_bot_247 openDVS_pixel2x2_bot_247/vpd[0] openDVS_pixel2x2_bot_247/vpd[1]
+ openDVS_pixel2x2_bot_247/vpd[3] openDVS_pixel2x2_bot_247/vpd[2] rowReadON[14] rowReadON[15]
+ RefrBp PrBp PrSFBp col_periphery_1x2_23/COL_LINE0 pixRst[46] pixRst[47] col_periphery_1x2_23/COL_LINE1
+ OffBn rowReadOFF[14] rowReadOFF[15] openDVS_pixel2x2_bot_255/GndD DiffBn VSUBS OnBn
+ VDD openDVS_pixel2x2_bot
XopenDVS_pixel2x2_bot_792 openDVS_pixel2x2_bot_792/vpd[0] openDVS_pixel2x2_bot_792/vpd[1]
+ openDVS_pixel2x2_bot_792/vpd[3] openDVS_pixel2x2_bot_792/vpd[2] rowReadON[48] rowReadON[49]
+ RefrBp PrBp PrSFBp col_periphery_1x2_24/COL_LINE0 pixRst[48] pixRst[49] col_periphery_1x2_24/COL_LINE1
+ OffBn rowReadOFF[48] rowReadOFF[49] openDVS_pixel2x2_bot_799/GndD DiffBn VSUBS OnBn
+ VDD openDVS_pixel2x2_bot
XopenDVS_pixel2x2_bot_781 openDVS_pixel2x2_bot_781/vpd[0] openDVS_pixel2x2_bot_781/vpd[1]
+ openDVS_pixel2x2_bot_781/vpd[3] openDVS_pixel2x2_bot_781/vpd[2] rowReadON[48] rowReadON[49]
+ RefrBp PrBp PrSFBp col_periphery_1x2_13/COL_LINE0 pixRst[26] pixRst[27] col_periphery_1x2_13/COL_LINE1
+ OffBn rowReadOFF[48] rowReadOFF[49] openDVS_pixel2x2_bot_799/GndD DiffBn VSUBS OnBn
+ VDD openDVS_pixel2x2_bot
XopenDVS_pixel2x2_bot_770 openDVS_pixel2x2_bot_770/vpd[0] openDVS_pixel2x2_bot_770/vpd[1]
+ openDVS_pixel2x2_bot_770/vpd[3] openDVS_pixel2x2_bot_770/vpd[2] rowReadON[48] rowReadON[49]
+ RefrBp PrBp PrSFBp col_periphery_1x2_2/COL_LINE0 pixRst[4] pixRst[5] col_periphery_1x2_2/COL_LINE1
+ OffBn rowReadOFF[48] rowReadOFF[49] openDVS_pixel2x2_bot_799/GndD DiffBn VSUBS OnBn
+ VDD openDVS_pixel2x2_bot
XopenDVS_pixel2x2_bot_19 openDVS_pixel2x2_bot_19/vpd[0] openDVS_pixel2x2_bot_19/vpd[1]
+ openDVS_pixel2x2_bot_19/vpd[3] openDVS_pixel2x2_bot_19/vpd[2] rowReadON[0] rowReadON[1]
+ RefrBp PrBp PrSFBp col_periphery_1x2_19/COL_LINE0 pixRst[38] pixRst[39] col_periphery_1x2_19/COL_LINE1
+ OffBn rowReadOFF[0] rowReadOFF[1] GND DiffBn VSUBS OnBn VDD openDVS_pixel2x2_bot
XopenDVS_pixel2x2_bot_407 openDVS_pixel2x2_bot_407/vpd[0] openDVS_pixel2x2_bot_407/vpd[1]
+ openDVS_pixel2x2_bot_407/vpd[3] openDVS_pixel2x2_bot_407/vpd[2] rowReadON[24] rowReadON[25]
+ RefrBp PrBp PrSFBp col_periphery_1x2_23/COL_LINE0 pixRst[46] pixRst[47] col_periphery_1x2_23/COL_LINE1
+ OffBn rowReadOFF[24] rowReadOFF[25] openDVS_pixel2x2_bot_415/GndD DiffBn VSUBS OnBn
+ VDD openDVS_pixel2x2_bot
XopenDVS_pixel2x2_bot_429 openDVS_pixel2x2_bot_429/vpd[0] openDVS_pixel2x2_bot_429/vpd[1]
+ openDVS_pixel2x2_bot_429/vpd[3] openDVS_pixel2x2_bot_429/vpd[2] rowReadON[26] rowReadON[27]
+ RefrBp PrBp PrSFBp col_periphery_1x2_13/COL_LINE0 pixRst[26] pixRst[27] col_periphery_1x2_13/COL_LINE1
+ OffBn rowReadOFF[26] rowReadOFF[27] openDVS_pixel2x2_bot_447/GndD DiffBn VSUBS OnBn
+ VDD openDVS_pixel2x2_bot
XopenDVS_pixel2x2_bot_418 openDVS_pixel2x2_bot_418/vpd[0] openDVS_pixel2x2_bot_418/vpd[1]
+ openDVS_pixel2x2_bot_418/vpd[3] openDVS_pixel2x2_bot_418/vpd[2] rowReadON[26] rowReadON[27]
+ RefrBp PrBp PrSFBp col_periphery_1x2_2/COL_LINE0 pixRst[4] pixRst[5] col_periphery_1x2_2/COL_LINE1
+ OffBn rowReadOFF[26] rowReadOFF[27] openDVS_pixel2x2_bot_447/GndD DiffBn VSUBS OnBn
+ VDD openDVS_pixel2x2_bot
Xcol_periphery_1x2_7 pixRst[15] col_periphery_1x2_7/COL_LINE0 col_periphery_1x2_7/COL_LINE1
+ nDETECT col_periphery_1x2_9/VDD DETECT VTHRESH voutn[14] VSUBS NCHARGE voutn[15]
+ pixRst[14] col_periphery_1x2
XopenDVS_pixel2x2_bot_996 openDVS_pixel2x2_bot_996/vpd[0] openDVS_pixel2x2_bot_996/vpd[1]
+ openDVS_pixel2x2_bot_996/vpd[3] openDVS_pixel2x2_bot_996/vpd[2] rowReadON[62] rowReadON[63]
+ RefrBp PrBp PrSFBp col_periphery_1x2_4/COL_LINE0 pixRst[8] pixRst[9] col_periphery_1x2_4/COL_LINE1
+ OffBn rowReadOFF[62] rowReadOFF[63] openDVS_pixel2x2_bot_999/GndD DiffBn VSUBS OnBn
+ VDD openDVS_pixel2x2_bot
XopenDVS_pixel2x2_bot_985 openDVS_pixel2x2_bot_985/vpd[0] openDVS_pixel2x2_bot_985/vpd[1]
+ openDVS_pixel2x2_bot_985/vpd[3] openDVS_pixel2x2_bot_985/vpd[2] rowReadON[60] rowReadON[61]
+ RefrBp PrBp PrSFBp col_periphery_1x2_25/COL_LINE0 pixRst[50] pixRst[51] col_periphery_1x2_25/COL_LINE1
+ OffBn rowReadOFF[60] rowReadOFF[61] openDVS_pixel2x2_bot_991/GndD DiffBn VSUBS OnBn
+ VDD openDVS_pixel2x2_bot
XopenDVS_pixel2x2_bot_952 openDVS_pixel2x2_bot_952/vpd[0] openDVS_pixel2x2_bot_952/vpd[1]
+ openDVS_pixel2x2_bot_952/vpd[3] openDVS_pixel2x2_bot_952/vpd[2] rowReadON[58] rowReadON[59]
+ RefrBp PrBp PrSFBp col_periphery_1x2_24/COL_LINE0 pixRst[48] pixRst[49] col_periphery_1x2_24/COL_LINE1
+ OffBn rowReadOFF[58] rowReadOFF[59] openDVS_pixel2x2_bot_959/GndD DiffBn VSUBS OnBn
+ VDD openDVS_pixel2x2_bot
XopenDVS_pixel2x2_bot_974 openDVS_pixel2x2_bot_974/vpd[0] openDVS_pixel2x2_bot_974/vpd[1]
+ openDVS_pixel2x2_bot_974/vpd[3] openDVS_pixel2x2_bot_974/vpd[2] rowReadON[60] rowReadON[61]
+ RefrBp PrBp PrSFBp col_periphery_1x2_14/COL_LINE0 pixRst[28] pixRst[29] col_periphery_1x2_14/COL_LINE1
+ OffBn rowReadOFF[60] rowReadOFF[61] openDVS_pixel2x2_bot_991/GndD DiffBn VSUBS OnBn
+ VDD openDVS_pixel2x2_bot
XopenDVS_pixel2x2_bot_941 openDVS_pixel2x2_bot_941/vpd[0] openDVS_pixel2x2_bot_941/vpd[1]
+ openDVS_pixel2x2_bot_941/vpd[3] openDVS_pixel2x2_bot_941/vpd[2] rowReadON[58] rowReadON[59]
+ RefrBp PrBp PrSFBp col_periphery_1x2_13/COL_LINE0 pixRst[26] pixRst[27] col_periphery_1x2_13/COL_LINE1
+ OffBn rowReadOFF[58] rowReadOFF[59] openDVS_pixel2x2_bot_959/GndD DiffBn VSUBS OnBn
+ VDD openDVS_pixel2x2_bot
XopenDVS_pixel2x2_bot_963 openDVS_pixel2x2_bot_963/vpd[0] openDVS_pixel2x2_bot_963/vpd[1]
+ openDVS_pixel2x2_bot_963/vpd[3] openDVS_pixel2x2_bot_963/vpd[2] rowReadON[60] rowReadON[61]
+ RefrBp PrBp PrSFBp col_periphery_1x2_3/COL_LINE0 pixRst[6] pixRst[7] col_periphery_1x2_3/COL_LINE1
+ OffBn rowReadOFF[60] rowReadOFF[61] openDVS_pixel2x2_bot_991/GndD DiffBn VSUBS OnBn
+ VDD openDVS_pixel2x2_bot
XopenDVS_pixel2x2_bot_930 openDVS_pixel2x2_bot_930/vpd[0] openDVS_pixel2x2_bot_930/vpd[1]
+ openDVS_pixel2x2_bot_930/vpd[3] openDVS_pixel2x2_bot_930/vpd[2] rowReadON[58] rowReadON[59]
+ RefrBp PrBp PrSFBp col_periphery_1x2_2/COL_LINE0 pixRst[4] pixRst[5] col_periphery_1x2_2/COL_LINE1
+ OffBn rowReadOFF[58] rowReadOFF[59] openDVS_pixel2x2_bot_959/GndD DiffBn VSUBS OnBn
+ VDD openDVS_pixel2x2_bot
XopenDVS_pixel2x2_bot_226 openDVS_pixel2x2_bot_226/vpd[0] openDVS_pixel2x2_bot_226/vpd[1]
+ openDVS_pixel2x2_bot_226/vpd[3] openDVS_pixel2x2_bot_226/vpd[2] rowReadON[14] rowReadON[15]
+ RefrBp PrBp PrSFBp col_periphery_1x2_2/COL_LINE0 pixRst[4] pixRst[5] col_periphery_1x2_2/COL_LINE1
+ OffBn rowReadOFF[14] rowReadOFF[15] openDVS_pixel2x2_bot_255/GndD DiffBn VSUBS OnBn
+ VDD openDVS_pixel2x2_bot
XopenDVS_pixel2x2_bot_259 openDVS_pixel2x2_bot_259/vpd[0] openDVS_pixel2x2_bot_259/vpd[1]
+ openDVS_pixel2x2_bot_259/vpd[3] openDVS_pixel2x2_bot_259/vpd[2] rowReadON[16] rowReadON[17]
+ RefrBp PrBp PrSFBp col_periphery_1x2_3/COL_LINE0 pixRst[6] pixRst[7] col_periphery_1x2_3/COL_LINE1
+ OffBn rowReadOFF[16] rowReadOFF[17] openDVS_pixel2x2_bot_287/GndD DiffBn VSUBS OnBn
+ VDD openDVS_pixel2x2_bot
XopenDVS_pixel2x2_bot_204 openDVS_pixel2x2_bot_204/vpd[0] openDVS_pixel2x2_bot_204/vpd[1]
+ openDVS_pixel2x2_bot_204/vpd[3] openDVS_pixel2x2_bot_204/vpd[2] rowReadON[12] rowReadON[13]
+ RefrBp PrBp PrSFBp col_periphery_1x2_12/COL_LINE0 pixRst[24] pixRst[25] col_periphery_1x2_12/COL_LINE1
+ OffBn rowReadOFF[12] rowReadOFF[13] openDVS_pixel2x2_bot_223/GndD DiffBn VSUBS OnBn
+ VDD openDVS_pixel2x2_bot
XopenDVS_pixel2x2_bot_237 openDVS_pixel2x2_bot_237/vpd[0] openDVS_pixel2x2_bot_237/vpd[1]
+ openDVS_pixel2x2_bot_237/vpd[3] openDVS_pixel2x2_bot_237/vpd[2] rowReadON[14] rowReadON[15]
+ RefrBp PrBp PrSFBp col_periphery_1x2_13/COL_LINE0 pixRst[26] pixRst[27] col_periphery_1x2_13/COL_LINE1
+ OffBn rowReadOFF[14] rowReadOFF[15] openDVS_pixel2x2_bot_255/GndD DiffBn VSUBS OnBn
+ VDD openDVS_pixel2x2_bot
XopenDVS_pixel2x2_bot_215 openDVS_pixel2x2_bot_215/vpd[0] openDVS_pixel2x2_bot_215/vpd[1]
+ openDVS_pixel2x2_bot_215/vpd[3] openDVS_pixel2x2_bot_215/vpd[2] rowReadON[12] rowReadON[13]
+ RefrBp PrBp PrSFBp col_periphery_1x2_23/COL_LINE0 pixRst[46] pixRst[47] col_periphery_1x2_23/COL_LINE1
+ OffBn rowReadOFF[12] rowReadOFF[13] openDVS_pixel2x2_bot_223/GndD DiffBn VSUBS OnBn
+ VDD openDVS_pixel2x2_bot
XopenDVS_pixel2x2_bot_248 openDVS_pixel2x2_bot_248/vpd[0] openDVS_pixel2x2_bot_248/vpd[1]
+ openDVS_pixel2x2_bot_248/vpd[3] openDVS_pixel2x2_bot_248/vpd[2] rowReadON[14] rowReadON[15]
+ RefrBp PrBp PrSFBp col_periphery_1x2_24/COL_LINE0 pixRst[48] pixRst[49] col_periphery_1x2_24/COL_LINE1
+ OffBn rowReadOFF[14] rowReadOFF[15] openDVS_pixel2x2_bot_255/GndD DiffBn VSUBS OnBn
+ VDD openDVS_pixel2x2_bot
XopenDVS_pixel2x2_bot_793 openDVS_pixel2x2_bot_793/vpd[0] openDVS_pixel2x2_bot_793/vpd[1]
+ openDVS_pixel2x2_bot_793/vpd[3] openDVS_pixel2x2_bot_793/vpd[2] rowReadON[48] rowReadON[49]
+ RefrBp PrBp PrSFBp col_periphery_1x2_25/COL_LINE0 pixRst[50] pixRst[51] col_periphery_1x2_25/COL_LINE1
+ OffBn rowReadOFF[48] rowReadOFF[49] openDVS_pixel2x2_bot_799/GndD DiffBn VSUBS OnBn
+ VDD openDVS_pixel2x2_bot
XopenDVS_pixel2x2_bot_760 openDVS_pixel2x2_bot_760/vpd[0] openDVS_pixel2x2_bot_760/vpd[1]
+ openDVS_pixel2x2_bot_760/vpd[3] openDVS_pixel2x2_bot_760/vpd[2] rowReadON[46] rowReadON[47]
+ RefrBp PrBp PrSFBp col_periphery_1x2_24/COL_LINE0 pixRst[48] pixRst[49] col_periphery_1x2_24/COL_LINE1
+ OffBn rowReadOFF[46] rowReadOFF[47] openDVS_pixel2x2_bot_767/GndD DiffBn VSUBS OnBn
+ VDD openDVS_pixel2x2_bot
XopenDVS_pixel2x2_bot_782 openDVS_pixel2x2_bot_782/vpd[0] openDVS_pixel2x2_bot_782/vpd[1]
+ openDVS_pixel2x2_bot_782/vpd[3] openDVS_pixel2x2_bot_782/vpd[2] rowReadON[48] rowReadON[49]
+ RefrBp PrBp PrSFBp col_periphery_1x2_14/COL_LINE0 pixRst[28] pixRst[29] col_periphery_1x2_14/COL_LINE1
+ OffBn rowReadOFF[48] rowReadOFF[49] openDVS_pixel2x2_bot_799/GndD DiffBn VSUBS OnBn
+ VDD openDVS_pixel2x2_bot
XopenDVS_pixel2x2_bot_771 openDVS_pixel2x2_bot_771/vpd[0] openDVS_pixel2x2_bot_771/vpd[1]
+ openDVS_pixel2x2_bot_771/vpd[3] openDVS_pixel2x2_bot_771/vpd[2] rowReadON[48] rowReadON[49]
+ RefrBp PrBp PrSFBp col_periphery_1x2_3/COL_LINE0 pixRst[6] pixRst[7] col_periphery_1x2_3/COL_LINE1
+ OffBn rowReadOFF[48] rowReadOFF[49] openDVS_pixel2x2_bot_799/GndD DiffBn VSUBS OnBn
+ VDD openDVS_pixel2x2_bot
XopenDVS_pixel2x2_bot_590 openDVS_pixel2x2_bot_590/vpd[0] openDVS_pixel2x2_bot_590/vpd[1]
+ openDVS_pixel2x2_bot_590/vpd[3] openDVS_pixel2x2_bot_590/vpd[2] rowReadON[36] rowReadON[37]
+ RefrBp PrBp PrSFBp col_periphery_1x2_14/COL_LINE0 pixRst[28] pixRst[29] col_periphery_1x2_14/COL_LINE1
+ OffBn rowReadOFF[36] rowReadOFF[37] openDVS_pixel2x2_bot_607/GndD DiffBn VSUBS OnBn
+ VDD openDVS_pixel2x2_bot
XopenDVS_pixel2x2_bot_408 openDVS_pixel2x2_bot_408/vpd[0] openDVS_pixel2x2_bot_408/vpd[1]
+ openDVS_pixel2x2_bot_408/vpd[3] openDVS_pixel2x2_bot_408/vpd[2] rowReadON[24] rowReadON[25]
+ RefrBp PrBp PrSFBp col_periphery_1x2_24/COL_LINE0 pixRst[48] pixRst[49] col_periphery_1x2_24/COL_LINE1
+ OffBn rowReadOFF[24] rowReadOFF[25] openDVS_pixel2x2_bot_415/GndD DiffBn VSUBS OnBn
+ VDD openDVS_pixel2x2_bot
XopenDVS_pixel2x2_bot_419 openDVS_pixel2x2_bot_419/vpd[0] openDVS_pixel2x2_bot_419/vpd[1]
+ openDVS_pixel2x2_bot_419/vpd[3] openDVS_pixel2x2_bot_419/vpd[2] rowReadON[26] rowReadON[27]
+ RefrBp PrBp PrSFBp col_periphery_1x2_3/COL_LINE0 pixRst[6] pixRst[7] col_periphery_1x2_3/COL_LINE1
+ OffBn rowReadOFF[26] rowReadOFF[27] openDVS_pixel2x2_bot_447/GndD DiffBn VSUBS OnBn
+ VDD openDVS_pixel2x2_bot
Xcol_periphery_1x2_8 pixRst[17] col_periphery_1x2_8/COL_LINE0 col_periphery_1x2_8/COL_LINE1
+ nDETECT col_periphery_1x2_9/VDD DETECT VTHRESH voutn[16] VSUBS NCHARGE voutn[17]
+ pixRst[16] col_periphery_1x2
XopenDVS_pixel2x2_bot_997 openDVS_pixel2x2_bot_997/vpd[0] openDVS_pixel2x2_bot_997/vpd[1]
+ openDVS_pixel2x2_bot_997/vpd[3] openDVS_pixel2x2_bot_997/vpd[2] rowReadON[62] rowReadON[63]
+ RefrBp PrBp PrSFBp col_periphery_1x2_5/COL_LINE0 pixRst[10] pixRst[11] col_periphery_1x2_5/COL_LINE1
+ OffBn rowReadOFF[62] rowReadOFF[63] openDVS_pixel2x2_bot_999/GndD DiffBn VSUBS OnBn
+ VDD openDVS_pixel2x2_bot
XopenDVS_pixel2x2_bot_986 openDVS_pixel2x2_bot_986/vpd[0] openDVS_pixel2x2_bot_986/vpd[1]
+ openDVS_pixel2x2_bot_986/vpd[3] openDVS_pixel2x2_bot_986/vpd[2] rowReadON[60] rowReadON[61]
+ RefrBp PrBp PrSFBp col_periphery_1x2_26/COL_LINE0 pixRst[52] pixRst[53] col_periphery_1x2_26/COL_LINE1
+ OffBn rowReadOFF[60] rowReadOFF[61] openDVS_pixel2x2_bot_991/GndD DiffBn VSUBS OnBn
+ VDD openDVS_pixel2x2_bot
XopenDVS_pixel2x2_bot_953 openDVS_pixel2x2_bot_953/vpd[0] openDVS_pixel2x2_bot_953/vpd[1]
+ openDVS_pixel2x2_bot_953/vpd[3] openDVS_pixel2x2_bot_953/vpd[2] rowReadON[58] rowReadON[59]
+ RefrBp PrBp PrSFBp col_periphery_1x2_25/COL_LINE0 pixRst[50] pixRst[51] col_periphery_1x2_25/COL_LINE1
+ OffBn rowReadOFF[58] rowReadOFF[59] openDVS_pixel2x2_bot_959/GndD DiffBn VSUBS OnBn
+ VDD openDVS_pixel2x2_bot
XopenDVS_pixel2x2_bot_920 openDVS_pixel2x2_bot_920/vpd[0] openDVS_pixel2x2_bot_920/vpd[1]
+ openDVS_pixel2x2_bot_920/vpd[3] openDVS_pixel2x2_bot_920/vpd[2] rowReadON[56] rowReadON[57]
+ RefrBp PrBp PrSFBp col_periphery_1x2_24/COL_LINE0 pixRst[48] pixRst[49] col_periphery_1x2_24/COL_LINE1
+ OffBn rowReadOFF[56] rowReadOFF[57] openDVS_pixel2x2_bot_927/GndD DiffBn VSUBS OnBn
+ VDD openDVS_pixel2x2_bot
XopenDVS_pixel2x2_bot_975 openDVS_pixel2x2_bot_975/vpd[0] openDVS_pixel2x2_bot_975/vpd[1]
+ openDVS_pixel2x2_bot_975/vpd[3] openDVS_pixel2x2_bot_975/vpd[2] rowReadON[60] rowReadON[61]
+ RefrBp PrBp PrSFBp col_periphery_1x2_15/COL_LINE0 pixRst[30] pixRst[31] col_periphery_1x2_15/COL_LINE1
+ OffBn rowReadOFF[60] rowReadOFF[61] openDVS_pixel2x2_bot_991/GndD DiffBn VSUBS OnBn
+ VDD openDVS_pixel2x2_bot
XopenDVS_pixel2x2_bot_942 openDVS_pixel2x2_bot_942/vpd[0] openDVS_pixel2x2_bot_942/vpd[1]
+ openDVS_pixel2x2_bot_942/vpd[3] openDVS_pixel2x2_bot_942/vpd[2] rowReadON[58] rowReadON[59]
+ RefrBp PrBp PrSFBp col_periphery_1x2_14/COL_LINE0 pixRst[28] pixRst[29] col_periphery_1x2_14/COL_LINE1
+ OffBn rowReadOFF[58] rowReadOFF[59] openDVS_pixel2x2_bot_959/GndD DiffBn VSUBS OnBn
+ VDD openDVS_pixel2x2_bot
XopenDVS_pixel2x2_bot_964 openDVS_pixel2x2_bot_964/vpd[0] openDVS_pixel2x2_bot_964/vpd[1]
+ openDVS_pixel2x2_bot_964/vpd[3] openDVS_pixel2x2_bot_964/vpd[2] rowReadON[60] rowReadON[61]
+ RefrBp PrBp PrSFBp col_periphery_1x2_4/COL_LINE0 pixRst[8] pixRst[9] col_periphery_1x2_4/COL_LINE1
+ OffBn rowReadOFF[60] rowReadOFF[61] openDVS_pixel2x2_bot_991/GndD DiffBn VSUBS OnBn
+ VDD openDVS_pixel2x2_bot
XopenDVS_pixel2x2_bot_931 openDVS_pixel2x2_bot_931/vpd[0] openDVS_pixel2x2_bot_931/vpd[1]
+ openDVS_pixel2x2_bot_931/vpd[3] openDVS_pixel2x2_bot_931/vpd[2] rowReadON[58] rowReadON[59]
+ RefrBp PrBp PrSFBp col_periphery_1x2_3/COL_LINE0 pixRst[6] pixRst[7] col_periphery_1x2_3/COL_LINE1
+ OffBn rowReadOFF[58] rowReadOFF[59] openDVS_pixel2x2_bot_959/GndD DiffBn VSUBS OnBn
+ VDD openDVS_pixel2x2_bot
XopenDVS_pixel2x2_bot_750 openDVS_pixel2x2_bot_750/vpd[0] openDVS_pixel2x2_bot_750/vpd[1]
+ openDVS_pixel2x2_bot_750/vpd[3] openDVS_pixel2x2_bot_750/vpd[2] rowReadON[46] rowReadON[47]
+ RefrBp PrBp PrSFBp col_periphery_1x2_14/COL_LINE0 pixRst[28] pixRst[29] col_periphery_1x2_14/COL_LINE1
+ OffBn rowReadOFF[46] rowReadOFF[47] openDVS_pixel2x2_bot_767/GndD DiffBn VSUBS OnBn
+ VDD openDVS_pixel2x2_bot
XopenDVS_pixel2x2_bot_227 openDVS_pixel2x2_bot_227/vpd[0] openDVS_pixel2x2_bot_227/vpd[1]
+ openDVS_pixel2x2_bot_227/vpd[3] openDVS_pixel2x2_bot_227/vpd[2] rowReadON[14] rowReadON[15]
+ RefrBp PrBp PrSFBp col_periphery_1x2_3/COL_LINE0 pixRst[6] pixRst[7] col_periphery_1x2_3/COL_LINE1
+ OffBn rowReadOFF[14] rowReadOFF[15] openDVS_pixel2x2_bot_255/GndD DiffBn VSUBS OnBn
+ VDD openDVS_pixel2x2_bot
XopenDVS_pixel2x2_bot_205 openDVS_pixel2x2_bot_205/vpd[0] openDVS_pixel2x2_bot_205/vpd[1]
+ openDVS_pixel2x2_bot_205/vpd[3] openDVS_pixel2x2_bot_205/vpd[2] rowReadON[12] rowReadON[13]
+ RefrBp PrBp PrSFBp col_periphery_1x2_13/COL_LINE0 pixRst[26] pixRst[27] col_periphery_1x2_13/COL_LINE1
+ OffBn rowReadOFF[12] rowReadOFF[13] openDVS_pixel2x2_bot_223/GndD DiffBn VSUBS OnBn
+ VDD openDVS_pixel2x2_bot
XopenDVS_pixel2x2_bot_238 openDVS_pixel2x2_bot_238/vpd[0] openDVS_pixel2x2_bot_238/vpd[1]
+ openDVS_pixel2x2_bot_238/vpd[3] openDVS_pixel2x2_bot_238/vpd[2] rowReadON[14] rowReadON[15]
+ RefrBp PrBp PrSFBp col_periphery_1x2_14/COL_LINE0 pixRst[28] pixRst[29] col_periphery_1x2_14/COL_LINE1
+ OffBn rowReadOFF[14] rowReadOFF[15] openDVS_pixel2x2_bot_255/GndD DiffBn VSUBS OnBn
+ VDD openDVS_pixel2x2_bot
XopenDVS_pixel2x2_bot_216 openDVS_pixel2x2_bot_216/vpd[0] openDVS_pixel2x2_bot_216/vpd[1]
+ openDVS_pixel2x2_bot_216/vpd[3] openDVS_pixel2x2_bot_216/vpd[2] rowReadON[12] rowReadON[13]
+ RefrBp PrBp PrSFBp col_periphery_1x2_24/COL_LINE0 pixRst[48] pixRst[49] col_periphery_1x2_24/COL_LINE1
+ OffBn rowReadOFF[12] rowReadOFF[13] openDVS_pixel2x2_bot_223/GndD DiffBn VSUBS OnBn
+ VDD openDVS_pixel2x2_bot
XopenDVS_pixel2x2_bot_249 openDVS_pixel2x2_bot_249/vpd[0] openDVS_pixel2x2_bot_249/vpd[1]
+ openDVS_pixel2x2_bot_249/vpd[3] openDVS_pixel2x2_bot_249/vpd[2] rowReadON[14] rowReadON[15]
+ RefrBp PrBp PrSFBp col_periphery_1x2_25/COL_LINE0 pixRst[50] pixRst[51] col_periphery_1x2_25/COL_LINE1
+ OffBn rowReadOFF[14] rowReadOFF[15] openDVS_pixel2x2_bot_255/GndD DiffBn VSUBS OnBn
+ VDD openDVS_pixel2x2_bot
XopenDVS_pixel2x2_bot_794 openDVS_pixel2x2_bot_794/vpd[0] openDVS_pixel2x2_bot_794/vpd[1]
+ openDVS_pixel2x2_bot_794/vpd[3] openDVS_pixel2x2_bot_794/vpd[2] rowReadON[48] rowReadON[49]
+ RefrBp PrBp PrSFBp col_periphery_1x2_26/COL_LINE0 pixRst[52] pixRst[53] col_periphery_1x2_26/COL_LINE1
+ OffBn rowReadOFF[48] rowReadOFF[49] openDVS_pixel2x2_bot_799/GndD DiffBn VSUBS OnBn
+ VDD openDVS_pixel2x2_bot
XopenDVS_pixel2x2_bot_761 openDVS_pixel2x2_bot_761/vpd[0] openDVS_pixel2x2_bot_761/vpd[1]
+ openDVS_pixel2x2_bot_761/vpd[3] openDVS_pixel2x2_bot_761/vpd[2] rowReadON[46] rowReadON[47]
+ RefrBp PrBp PrSFBp col_periphery_1x2_25/COL_LINE0 pixRst[50] pixRst[51] col_periphery_1x2_25/COL_LINE1
+ OffBn rowReadOFF[46] rowReadOFF[47] openDVS_pixel2x2_bot_767/GndD DiffBn VSUBS OnBn
+ VDD openDVS_pixel2x2_bot
XopenDVS_pixel2x2_bot_783 openDVS_pixel2x2_bot_783/vpd[0] openDVS_pixel2x2_bot_783/vpd[1]
+ openDVS_pixel2x2_bot_783/vpd[3] openDVS_pixel2x2_bot_783/vpd[2] rowReadON[48] rowReadON[49]
+ RefrBp PrBp PrSFBp col_periphery_1x2_15/COL_LINE0 pixRst[30] pixRst[31] col_periphery_1x2_15/COL_LINE1
+ OffBn rowReadOFF[48] rowReadOFF[49] openDVS_pixel2x2_bot_799/GndD DiffBn VSUBS OnBn
+ VDD openDVS_pixel2x2_bot
XopenDVS_pixel2x2_bot_772 openDVS_pixel2x2_bot_772/vpd[0] openDVS_pixel2x2_bot_772/vpd[1]
+ openDVS_pixel2x2_bot_772/vpd[3] openDVS_pixel2x2_bot_772/vpd[2] rowReadON[48] rowReadON[49]
+ RefrBp PrBp PrSFBp col_periphery_1x2_4/COL_LINE0 pixRst[8] pixRst[9] col_periphery_1x2_4/COL_LINE1
+ OffBn rowReadOFF[48] rowReadOFF[49] openDVS_pixel2x2_bot_799/GndD DiffBn VSUBS OnBn
+ VDD openDVS_pixel2x2_bot
XopenDVS_pixel2x2_bot_591 openDVS_pixel2x2_bot_591/vpd[0] openDVS_pixel2x2_bot_591/vpd[1]
+ openDVS_pixel2x2_bot_591/vpd[3] openDVS_pixel2x2_bot_591/vpd[2] rowReadON[36] rowReadON[37]
+ RefrBp PrBp PrSFBp col_periphery_1x2_15/COL_LINE0 pixRst[30] pixRst[31] col_periphery_1x2_15/COL_LINE1
+ OffBn rowReadOFF[36] rowReadOFF[37] openDVS_pixel2x2_bot_607/GndD DiffBn VSUBS OnBn
+ VDD openDVS_pixel2x2_bot
XopenDVS_pixel2x2_bot_580 openDVS_pixel2x2_bot_580/vpd[0] openDVS_pixel2x2_bot_580/vpd[1]
+ openDVS_pixel2x2_bot_580/vpd[3] openDVS_pixel2x2_bot_580/vpd[2] rowReadON[36] rowReadON[37]
+ RefrBp PrBp PrSFBp col_periphery_1x2_4/COL_LINE0 pixRst[8] pixRst[9] col_periphery_1x2_4/COL_LINE1
+ OffBn rowReadOFF[36] rowReadOFF[37] openDVS_pixel2x2_bot_607/GndD DiffBn VSUBS OnBn
+ VDD openDVS_pixel2x2_bot
XopenDVS_pixel2x2_bot_409 openDVS_pixel2x2_bot_409/vpd[0] openDVS_pixel2x2_bot_409/vpd[1]
+ openDVS_pixel2x2_bot_409/vpd[3] openDVS_pixel2x2_bot_409/vpd[2] rowReadON[24] rowReadON[25]
+ RefrBp PrBp PrSFBp col_periphery_1x2_25/COL_LINE0 pixRst[50] pixRst[51] col_periphery_1x2_25/COL_LINE1
+ OffBn rowReadOFF[24] rowReadOFF[25] openDVS_pixel2x2_bot_415/GndD DiffBn VSUBS OnBn
+ VDD openDVS_pixel2x2_bot
Xcol_periphery_1x2_9 pixRst[19] col_periphery_1x2_9/COL_LINE0 col_periphery_1x2_9/COL_LINE1
+ nDETECT col_periphery_1x2_9/VDD DETECT VTHRESH voutn[18] VSUBS NCHARGE voutn[19]
+ pixRst[18] col_periphery_1x2
XopenDVS_pixel2x2_bot_998 openDVS_pixel2x2_bot_998/vpd[0] openDVS_pixel2x2_bot_998/vpd[1]
+ openDVS_pixel2x2_bot_998/vpd[3] openDVS_pixel2x2_bot_998/vpd[2] rowReadON[62] rowReadON[63]
+ RefrBp PrBp PrSFBp col_periphery_1x2_6/COL_LINE0 pixRst[12] pixRst[13] col_periphery_1x2_6/COL_LINE1
+ OffBn rowReadOFF[62] rowReadOFF[63] openDVS_pixel2x2_bot_999/GndD DiffBn VSUBS OnBn
+ VDD openDVS_pixel2x2_bot
XopenDVS_pixel2x2_bot_987 openDVS_pixel2x2_bot_987/vpd[0] openDVS_pixel2x2_bot_987/vpd[1]
+ openDVS_pixel2x2_bot_987/vpd[3] openDVS_pixel2x2_bot_987/vpd[2] rowReadON[60] rowReadON[61]
+ RefrBp PrBp PrSFBp col_periphery_1x2_27/COL_LINE0 pixRst[54] pixRst[55] col_periphery_1x2_27/COL_LINE1
+ OffBn rowReadOFF[60] rowReadOFF[61] openDVS_pixel2x2_bot_991/GndD DiffBn VSUBS OnBn
+ VDD openDVS_pixel2x2_bot
XopenDVS_pixel2x2_bot_954 openDVS_pixel2x2_bot_954/vpd[0] openDVS_pixel2x2_bot_954/vpd[1]
+ openDVS_pixel2x2_bot_954/vpd[3] openDVS_pixel2x2_bot_954/vpd[2] rowReadON[58] rowReadON[59]
+ RefrBp PrBp PrSFBp col_periphery_1x2_26/COL_LINE0 pixRst[52] pixRst[53] col_periphery_1x2_26/COL_LINE1
+ OffBn rowReadOFF[58] rowReadOFF[59] openDVS_pixel2x2_bot_959/GndD DiffBn VSUBS OnBn
+ VDD openDVS_pixel2x2_bot
XopenDVS_pixel2x2_bot_921 openDVS_pixel2x2_bot_921/vpd[0] openDVS_pixel2x2_bot_921/vpd[1]
+ openDVS_pixel2x2_bot_921/vpd[3] openDVS_pixel2x2_bot_921/vpd[2] rowReadON[56] rowReadON[57]
+ RefrBp PrBp PrSFBp col_periphery_1x2_25/COL_LINE0 pixRst[50] pixRst[51] col_periphery_1x2_25/COL_LINE1
+ OffBn rowReadOFF[56] rowReadOFF[57] openDVS_pixel2x2_bot_927/GndD DiffBn VSUBS OnBn
+ VDD openDVS_pixel2x2_bot
XopenDVS_pixel2x2_bot_976 openDVS_pixel2x2_bot_976/vpd[0] openDVS_pixel2x2_bot_976/vpd[1]
+ openDVS_pixel2x2_bot_976/vpd[3] openDVS_pixel2x2_bot_976/vpd[2] rowReadON[60] rowReadON[61]
+ RefrBp PrBp PrSFBp col_periphery_1x2_16/COL_LINE0 pixRst[32] pixRst[33] col_periphery_1x2_16/COL_LINE1
+ OffBn rowReadOFF[60] rowReadOFF[61] openDVS_pixel2x2_bot_991/GndD DiffBn VSUBS OnBn
+ VDD openDVS_pixel2x2_bot
XopenDVS_pixel2x2_bot_943 openDVS_pixel2x2_bot_943/vpd[0] openDVS_pixel2x2_bot_943/vpd[1]
+ openDVS_pixel2x2_bot_943/vpd[3] openDVS_pixel2x2_bot_943/vpd[2] rowReadON[58] rowReadON[59]
+ RefrBp PrBp PrSFBp col_periphery_1x2_15/COL_LINE0 pixRst[30] pixRst[31] col_periphery_1x2_15/COL_LINE1
+ OffBn rowReadOFF[58] rowReadOFF[59] openDVS_pixel2x2_bot_959/GndD DiffBn VSUBS OnBn
+ VDD openDVS_pixel2x2_bot
XopenDVS_pixel2x2_bot_910 openDVS_pixel2x2_bot_910/vpd[0] openDVS_pixel2x2_bot_910/vpd[1]
+ openDVS_pixel2x2_bot_910/vpd[3] openDVS_pixel2x2_bot_910/vpd[2] rowReadON[56] rowReadON[57]
+ RefrBp PrBp PrSFBp col_periphery_1x2_14/COL_LINE0 pixRst[28] pixRst[29] col_periphery_1x2_14/COL_LINE1
+ OffBn rowReadOFF[56] rowReadOFF[57] openDVS_pixel2x2_bot_927/GndD DiffBn VSUBS OnBn
+ VDD openDVS_pixel2x2_bot
XopenDVS_pixel2x2_bot_965 openDVS_pixel2x2_bot_965/vpd[0] openDVS_pixel2x2_bot_965/vpd[1]
+ openDVS_pixel2x2_bot_965/vpd[3] openDVS_pixel2x2_bot_965/vpd[2] rowReadON[60] rowReadON[61]
+ RefrBp PrBp PrSFBp col_periphery_1x2_5/COL_LINE0 pixRst[10] pixRst[11] col_periphery_1x2_5/COL_LINE1
+ OffBn rowReadOFF[60] rowReadOFF[61] openDVS_pixel2x2_bot_991/GndD DiffBn VSUBS OnBn
+ VDD openDVS_pixel2x2_bot
XopenDVS_pixel2x2_bot_932 openDVS_pixel2x2_bot_932/vpd[0] openDVS_pixel2x2_bot_932/vpd[1]
+ openDVS_pixel2x2_bot_932/vpd[3] openDVS_pixel2x2_bot_932/vpd[2] rowReadON[58] rowReadON[59]
+ RefrBp PrBp PrSFBp col_periphery_1x2_4/COL_LINE0 pixRst[8] pixRst[9] col_periphery_1x2_4/COL_LINE1
+ OffBn rowReadOFF[58] rowReadOFF[59] openDVS_pixel2x2_bot_959/GndD DiffBn VSUBS OnBn
+ VDD openDVS_pixel2x2_bot
XopenDVS_pixel2x2_bot_228 openDVS_pixel2x2_bot_228/vpd[0] openDVS_pixel2x2_bot_228/vpd[1]
+ openDVS_pixel2x2_bot_228/vpd[3] openDVS_pixel2x2_bot_228/vpd[2] rowReadON[14] rowReadON[15]
+ RefrBp PrBp PrSFBp col_periphery_1x2_4/COL_LINE0 pixRst[8] pixRst[9] col_periphery_1x2_4/COL_LINE1
+ OffBn rowReadOFF[14] rowReadOFF[15] openDVS_pixel2x2_bot_255/GndD DiffBn VSUBS OnBn
+ VDD openDVS_pixel2x2_bot
XopenDVS_pixel2x2_bot_206 openDVS_pixel2x2_bot_206/vpd[0] openDVS_pixel2x2_bot_206/vpd[1]
+ openDVS_pixel2x2_bot_206/vpd[3] openDVS_pixel2x2_bot_206/vpd[2] rowReadON[12] rowReadON[13]
+ RefrBp PrBp PrSFBp col_periphery_1x2_14/COL_LINE0 pixRst[28] pixRst[29] col_periphery_1x2_14/COL_LINE1
+ OffBn rowReadOFF[12] rowReadOFF[13] openDVS_pixel2x2_bot_223/GndD DiffBn VSUBS OnBn
+ VDD openDVS_pixel2x2_bot
XopenDVS_pixel2x2_bot_239 openDVS_pixel2x2_bot_239/vpd[0] openDVS_pixel2x2_bot_239/vpd[1]
+ openDVS_pixel2x2_bot_239/vpd[3] openDVS_pixel2x2_bot_239/vpd[2] rowReadON[14] rowReadON[15]
+ RefrBp PrBp PrSFBp col_periphery_1x2_15/COL_LINE0 pixRst[30] pixRst[31] col_periphery_1x2_15/COL_LINE1
+ OffBn rowReadOFF[14] rowReadOFF[15] openDVS_pixel2x2_bot_255/GndD DiffBn VSUBS OnBn
+ VDD openDVS_pixel2x2_bot
XopenDVS_pixel2x2_bot_217 openDVS_pixel2x2_bot_217/vpd[0] openDVS_pixel2x2_bot_217/vpd[1]
+ openDVS_pixel2x2_bot_217/vpd[3] openDVS_pixel2x2_bot_217/vpd[2] rowReadON[12] rowReadON[13]
+ RefrBp PrBp PrSFBp col_periphery_1x2_25/COL_LINE0 pixRst[50] pixRst[51] col_periphery_1x2_25/COL_LINE1
+ OffBn rowReadOFF[12] rowReadOFF[13] openDVS_pixel2x2_bot_223/GndD DiffBn VSUBS OnBn
+ VDD openDVS_pixel2x2_bot
XopenDVS_pixel2x2_bot_795 openDVS_pixel2x2_bot_795/vpd[0] openDVS_pixel2x2_bot_795/vpd[1]
+ openDVS_pixel2x2_bot_795/vpd[3] openDVS_pixel2x2_bot_795/vpd[2] rowReadON[48] rowReadON[49]
+ RefrBp PrBp PrSFBp col_periphery_1x2_27/COL_LINE0 pixRst[54] pixRst[55] col_periphery_1x2_27/COL_LINE1
+ OffBn rowReadOFF[48] rowReadOFF[49] openDVS_pixel2x2_bot_799/GndD DiffBn VSUBS OnBn
+ VDD openDVS_pixel2x2_bot
XopenDVS_pixel2x2_bot_762 openDVS_pixel2x2_bot_762/vpd[0] openDVS_pixel2x2_bot_762/vpd[1]
+ openDVS_pixel2x2_bot_762/vpd[3] openDVS_pixel2x2_bot_762/vpd[2] rowReadON[46] rowReadON[47]
+ RefrBp PrBp PrSFBp col_periphery_1x2_26/COL_LINE0 pixRst[52] pixRst[53] col_periphery_1x2_26/COL_LINE1
+ OffBn rowReadOFF[46] rowReadOFF[47] openDVS_pixel2x2_bot_767/GndD DiffBn VSUBS OnBn
+ VDD openDVS_pixel2x2_bot
XopenDVS_pixel2x2_bot_784 openDVS_pixel2x2_bot_784/vpd[0] openDVS_pixel2x2_bot_784/vpd[1]
+ openDVS_pixel2x2_bot_784/vpd[3] openDVS_pixel2x2_bot_784/vpd[2] rowReadON[48] rowReadON[49]
+ RefrBp PrBp PrSFBp col_periphery_1x2_16/COL_LINE0 pixRst[32] pixRst[33] col_periphery_1x2_16/COL_LINE1
+ OffBn rowReadOFF[48] rowReadOFF[49] openDVS_pixel2x2_bot_799/GndD DiffBn VSUBS OnBn
+ VDD openDVS_pixel2x2_bot
XopenDVS_pixel2x2_bot_751 openDVS_pixel2x2_bot_751/vpd[0] openDVS_pixel2x2_bot_751/vpd[1]
+ openDVS_pixel2x2_bot_751/vpd[3] openDVS_pixel2x2_bot_751/vpd[2] rowReadON[46] rowReadON[47]
+ RefrBp PrBp PrSFBp col_periphery_1x2_15/COL_LINE0 pixRst[30] pixRst[31] col_periphery_1x2_15/COL_LINE1
+ OffBn rowReadOFF[46] rowReadOFF[47] openDVS_pixel2x2_bot_767/GndD DiffBn VSUBS OnBn
+ VDD openDVS_pixel2x2_bot
XopenDVS_pixel2x2_bot_773 openDVS_pixel2x2_bot_773/vpd[0] openDVS_pixel2x2_bot_773/vpd[1]
+ openDVS_pixel2x2_bot_773/vpd[3] openDVS_pixel2x2_bot_773/vpd[2] rowReadON[48] rowReadON[49]
+ RefrBp PrBp PrSFBp col_periphery_1x2_5/COL_LINE0 pixRst[10] pixRst[11] col_periphery_1x2_5/COL_LINE1
+ OffBn rowReadOFF[48] rowReadOFF[49] openDVS_pixel2x2_bot_799/GndD DiffBn VSUBS OnBn
+ VDD openDVS_pixel2x2_bot
XopenDVS_pixel2x2_bot_740 openDVS_pixel2x2_bot_740/vpd[0] openDVS_pixel2x2_bot_740/vpd[1]
+ openDVS_pixel2x2_bot_740/vpd[3] openDVS_pixel2x2_bot_740/vpd[2] rowReadON[46] rowReadON[47]
+ RefrBp PrBp PrSFBp col_periphery_1x2_4/COL_LINE0 pixRst[8] pixRst[9] col_periphery_1x2_4/COL_LINE1
+ OffBn rowReadOFF[46] rowReadOFF[47] openDVS_pixel2x2_bot_767/GndD DiffBn VSUBS OnBn
+ VDD openDVS_pixel2x2_bot
XopenDVS_pixel2x2_bot_570 openDVS_pixel2x2_bot_570/vpd[0] openDVS_pixel2x2_bot_570/vpd[1]
+ openDVS_pixel2x2_bot_570/vpd[3] openDVS_pixel2x2_bot_570/vpd[2] rowReadON[34] rowReadON[35]
+ RefrBp PrBp PrSFBp col_periphery_1x2_26/COL_LINE0 pixRst[52] pixRst[53] col_periphery_1x2_26/COL_LINE1
+ OffBn rowReadOFF[34] rowReadOFF[35] openDVS_pixel2x2_bot_575/GndD DiffBn VSUBS OnBn
+ VDD openDVS_pixel2x2_bot
XopenDVS_pixel2x2_bot_592 openDVS_pixel2x2_bot_592/vpd[0] openDVS_pixel2x2_bot_592/vpd[1]
+ openDVS_pixel2x2_bot_592/vpd[3] openDVS_pixel2x2_bot_592/vpd[2] rowReadON[36] rowReadON[37]
+ RefrBp PrBp PrSFBp col_periphery_1x2_16/COL_LINE0 pixRst[32] pixRst[33] col_periphery_1x2_16/COL_LINE1
+ OffBn rowReadOFF[36] rowReadOFF[37] openDVS_pixel2x2_bot_607/GndD DiffBn VSUBS OnBn
+ VDD openDVS_pixel2x2_bot
XopenDVS_pixel2x2_bot_581 openDVS_pixel2x2_bot_581/vpd[0] openDVS_pixel2x2_bot_581/vpd[1]
+ openDVS_pixel2x2_bot_581/vpd[3] openDVS_pixel2x2_bot_581/vpd[2] rowReadON[36] rowReadON[37]
+ RefrBp PrBp PrSFBp col_periphery_1x2_5/COL_LINE0 pixRst[10] pixRst[11] col_periphery_1x2_5/COL_LINE1
+ OffBn rowReadOFF[36] rowReadOFF[37] openDVS_pixel2x2_bot_607/GndD DiffBn VSUBS OnBn
+ VDD openDVS_pixel2x2_bot
XopenDVS_pixel2x2_bot_999 openDVS_pixel2x2_bot_999/vpd[0] openDVS_pixel2x2_bot_999/vpd[1]
+ openDVS_pixel2x2_bot_999/vpd[3] openDVS_pixel2x2_bot_999/vpd[2] rowReadON[62] rowReadON[63]
+ RefrBp PrBp PrSFBp col_periphery_1x2_7/COL_LINE0 pixRst[14] pixRst[15] col_periphery_1x2_7/COL_LINE1
+ OffBn rowReadOFF[62] rowReadOFF[63] openDVS_pixel2x2_bot_999/GndD DiffBn VSUBS OnBn
+ VDD openDVS_pixel2x2_bot
XopenDVS_pixel2x2_bot_988 openDVS_pixel2x2_bot_988/vpd[0] openDVS_pixel2x2_bot_988/vpd[1]
+ openDVS_pixel2x2_bot_988/vpd[3] openDVS_pixel2x2_bot_988/vpd[2] rowReadON[60] rowReadON[61]
+ RefrBp PrBp PrSFBp col_periphery_1x2_28/COL_LINE0 pixRst[56] pixRst[57] col_periphery_1x2_28/COL_LINE1
+ OffBn rowReadOFF[60] rowReadOFF[61] openDVS_pixel2x2_bot_991/GndD DiffBn VSUBS OnBn
+ VDD openDVS_pixel2x2_bot
XopenDVS_pixel2x2_bot_955 openDVS_pixel2x2_bot_955/vpd[0] openDVS_pixel2x2_bot_955/vpd[1]
+ openDVS_pixel2x2_bot_955/vpd[3] openDVS_pixel2x2_bot_955/vpd[2] rowReadON[58] rowReadON[59]
+ RefrBp PrBp PrSFBp col_periphery_1x2_27/COL_LINE0 pixRst[54] pixRst[55] col_periphery_1x2_27/COL_LINE1
+ OffBn rowReadOFF[58] rowReadOFF[59] openDVS_pixel2x2_bot_959/GndD DiffBn VSUBS OnBn
+ VDD openDVS_pixel2x2_bot
XopenDVS_pixel2x2_bot_922 openDVS_pixel2x2_bot_922/vpd[0] openDVS_pixel2x2_bot_922/vpd[1]
+ openDVS_pixel2x2_bot_922/vpd[3] openDVS_pixel2x2_bot_922/vpd[2] rowReadON[56] rowReadON[57]
+ RefrBp PrBp PrSFBp col_periphery_1x2_26/COL_LINE0 pixRst[52] pixRst[53] col_periphery_1x2_26/COL_LINE1
+ OffBn rowReadOFF[56] rowReadOFF[57] openDVS_pixel2x2_bot_927/GndD DiffBn VSUBS OnBn
+ VDD openDVS_pixel2x2_bot
XopenDVS_pixel2x2_bot_977 openDVS_pixel2x2_bot_977/vpd[0] openDVS_pixel2x2_bot_977/vpd[1]
+ openDVS_pixel2x2_bot_977/vpd[3] openDVS_pixel2x2_bot_977/vpd[2] rowReadON[60] rowReadON[61]
+ RefrBp PrBp PrSFBp col_periphery_1x2_17/COL_LINE0 pixRst[34] pixRst[35] col_periphery_1x2_17/COL_LINE1
+ OffBn rowReadOFF[60] rowReadOFF[61] openDVS_pixel2x2_bot_991/GndD DiffBn VSUBS OnBn
+ VDD openDVS_pixel2x2_bot
XopenDVS_pixel2x2_bot_944 openDVS_pixel2x2_bot_944/vpd[0] openDVS_pixel2x2_bot_944/vpd[1]
+ openDVS_pixel2x2_bot_944/vpd[3] openDVS_pixel2x2_bot_944/vpd[2] rowReadON[58] rowReadON[59]
+ RefrBp PrBp PrSFBp col_periphery_1x2_16/COL_LINE0 pixRst[32] pixRst[33] col_periphery_1x2_16/COL_LINE1
+ OffBn rowReadOFF[58] rowReadOFF[59] openDVS_pixel2x2_bot_959/GndD DiffBn VSUBS OnBn
+ VDD openDVS_pixel2x2_bot
XopenDVS_pixel2x2_bot_911 openDVS_pixel2x2_bot_911/vpd[0] openDVS_pixel2x2_bot_911/vpd[1]
+ openDVS_pixel2x2_bot_911/vpd[3] openDVS_pixel2x2_bot_911/vpd[2] rowReadON[56] rowReadON[57]
+ RefrBp PrBp PrSFBp col_periphery_1x2_15/COL_LINE0 pixRst[30] pixRst[31] col_periphery_1x2_15/COL_LINE1
+ OffBn rowReadOFF[56] rowReadOFF[57] openDVS_pixel2x2_bot_927/GndD DiffBn VSUBS OnBn
+ VDD openDVS_pixel2x2_bot
XopenDVS_pixel2x2_bot_966 openDVS_pixel2x2_bot_966/vpd[0] openDVS_pixel2x2_bot_966/vpd[1]
+ openDVS_pixel2x2_bot_966/vpd[3] openDVS_pixel2x2_bot_966/vpd[2] rowReadON[60] rowReadON[61]
+ RefrBp PrBp PrSFBp col_periphery_1x2_6/COL_LINE0 pixRst[12] pixRst[13] col_periphery_1x2_6/COL_LINE1
+ OffBn rowReadOFF[60] rowReadOFF[61] openDVS_pixel2x2_bot_991/GndD DiffBn VSUBS OnBn
+ VDD openDVS_pixel2x2_bot
XopenDVS_pixel2x2_bot_933 openDVS_pixel2x2_bot_933/vpd[0] openDVS_pixel2x2_bot_933/vpd[1]
+ openDVS_pixel2x2_bot_933/vpd[3] openDVS_pixel2x2_bot_933/vpd[2] rowReadON[58] rowReadON[59]
+ RefrBp PrBp PrSFBp col_periphery_1x2_5/COL_LINE0 pixRst[10] pixRst[11] col_periphery_1x2_5/COL_LINE1
+ OffBn rowReadOFF[58] rowReadOFF[59] openDVS_pixel2x2_bot_959/GndD DiffBn VSUBS OnBn
+ VDD openDVS_pixel2x2_bot
XopenDVS_pixel2x2_bot_900 openDVS_pixel2x2_bot_900/vpd[0] openDVS_pixel2x2_bot_900/vpd[1]
+ openDVS_pixel2x2_bot_900/vpd[3] openDVS_pixel2x2_bot_900/vpd[2] rowReadON[56] rowReadON[57]
+ RefrBp PrBp PrSFBp col_periphery_1x2_4/COL_LINE0 pixRst[8] pixRst[9] col_periphery_1x2_4/COL_LINE1
+ OffBn rowReadOFF[56] rowReadOFF[57] openDVS_pixel2x2_bot_927/GndD DiffBn VSUBS OnBn
+ VDD openDVS_pixel2x2_bot
XopenDVS_pixel2x2_bot_229 openDVS_pixel2x2_bot_229/vpd[0] openDVS_pixel2x2_bot_229/vpd[1]
+ openDVS_pixel2x2_bot_229/vpd[3] openDVS_pixel2x2_bot_229/vpd[2] rowReadON[14] rowReadON[15]
+ RefrBp PrBp PrSFBp col_periphery_1x2_5/COL_LINE0 pixRst[10] pixRst[11] col_periphery_1x2_5/COL_LINE1
+ OffBn rowReadOFF[14] rowReadOFF[15] openDVS_pixel2x2_bot_255/GndD DiffBn VSUBS OnBn
+ VDD openDVS_pixel2x2_bot
XopenDVS_pixel2x2_bot_207 openDVS_pixel2x2_bot_207/vpd[0] openDVS_pixel2x2_bot_207/vpd[1]
+ openDVS_pixel2x2_bot_207/vpd[3] openDVS_pixel2x2_bot_207/vpd[2] rowReadON[12] rowReadON[13]
+ RefrBp PrBp PrSFBp col_periphery_1x2_15/COL_LINE0 pixRst[30] pixRst[31] col_periphery_1x2_15/COL_LINE1
+ OffBn rowReadOFF[12] rowReadOFF[13] openDVS_pixel2x2_bot_223/GndD DiffBn VSUBS OnBn
+ VDD openDVS_pixel2x2_bot
XopenDVS_pixel2x2_bot_218 openDVS_pixel2x2_bot_218/vpd[0] openDVS_pixel2x2_bot_218/vpd[1]
+ openDVS_pixel2x2_bot_218/vpd[3] openDVS_pixel2x2_bot_218/vpd[2] rowReadON[12] rowReadON[13]
+ RefrBp PrBp PrSFBp col_periphery_1x2_26/COL_LINE0 pixRst[52] pixRst[53] col_periphery_1x2_26/COL_LINE1
+ OffBn rowReadOFF[12] rowReadOFF[13] openDVS_pixel2x2_bot_223/GndD DiffBn VSUBS OnBn
+ VDD openDVS_pixel2x2_bot
XopenDVS_pixel2x2_bot_796 openDVS_pixel2x2_bot_796/vpd[0] openDVS_pixel2x2_bot_796/vpd[1]
+ openDVS_pixel2x2_bot_796/vpd[3] openDVS_pixel2x2_bot_796/vpd[2] rowReadON[48] rowReadON[49]
+ RefrBp PrBp PrSFBp col_periphery_1x2_28/COL_LINE0 pixRst[56] pixRst[57] col_periphery_1x2_28/COL_LINE1
+ OffBn rowReadOFF[48] rowReadOFF[49] openDVS_pixel2x2_bot_799/GndD DiffBn VSUBS OnBn
+ VDD openDVS_pixel2x2_bot
XopenDVS_pixel2x2_bot_763 openDVS_pixel2x2_bot_763/vpd[0] openDVS_pixel2x2_bot_763/vpd[1]
+ openDVS_pixel2x2_bot_763/vpd[3] openDVS_pixel2x2_bot_763/vpd[2] rowReadON[46] rowReadON[47]
+ RefrBp PrBp PrSFBp col_periphery_1x2_27/COL_LINE0 pixRst[54] pixRst[55] col_periphery_1x2_27/COL_LINE1
+ OffBn rowReadOFF[46] rowReadOFF[47] openDVS_pixel2x2_bot_767/GndD DiffBn VSUBS OnBn
+ VDD openDVS_pixel2x2_bot
XopenDVS_pixel2x2_bot_730 openDVS_pixel2x2_bot_730/vpd[0] openDVS_pixel2x2_bot_730/vpd[1]
+ openDVS_pixel2x2_bot_730/vpd[3] openDVS_pixel2x2_bot_730/vpd[2] rowReadON[44] rowReadON[45]
+ RefrBp PrBp PrSFBp col_periphery_1x2_26/COL_LINE0 pixRst[52] pixRst[53] col_periphery_1x2_26/COL_LINE1
+ OffBn rowReadOFF[44] rowReadOFF[45] openDVS_pixel2x2_bot_735/GndD DiffBn VSUBS OnBn
+ VDD openDVS_pixel2x2_bot
XopenDVS_pixel2x2_bot_785 openDVS_pixel2x2_bot_785/vpd[0] openDVS_pixel2x2_bot_785/vpd[1]
+ openDVS_pixel2x2_bot_785/vpd[3] openDVS_pixel2x2_bot_785/vpd[2] rowReadON[48] rowReadON[49]
+ RefrBp PrBp PrSFBp col_periphery_1x2_17/COL_LINE0 pixRst[34] pixRst[35] col_periphery_1x2_17/COL_LINE1
+ OffBn rowReadOFF[48] rowReadOFF[49] openDVS_pixel2x2_bot_799/GndD DiffBn VSUBS OnBn
+ VDD openDVS_pixel2x2_bot
XopenDVS_pixel2x2_bot_752 openDVS_pixel2x2_bot_752/vpd[0] openDVS_pixel2x2_bot_752/vpd[1]
+ openDVS_pixel2x2_bot_752/vpd[3] openDVS_pixel2x2_bot_752/vpd[2] rowReadON[46] rowReadON[47]
+ RefrBp PrBp PrSFBp col_periphery_1x2_16/COL_LINE0 pixRst[32] pixRst[33] col_periphery_1x2_16/COL_LINE1
+ OffBn rowReadOFF[46] rowReadOFF[47] openDVS_pixel2x2_bot_767/GndD DiffBn VSUBS OnBn
+ VDD openDVS_pixel2x2_bot
XopenDVS_pixel2x2_bot_774 openDVS_pixel2x2_bot_774/vpd[0] openDVS_pixel2x2_bot_774/vpd[1]
+ openDVS_pixel2x2_bot_774/vpd[3] openDVS_pixel2x2_bot_774/vpd[2] rowReadON[48] rowReadON[49]
+ RefrBp PrBp PrSFBp col_periphery_1x2_6/COL_LINE0 pixRst[12] pixRst[13] col_periphery_1x2_6/COL_LINE1
+ OffBn rowReadOFF[48] rowReadOFF[49] openDVS_pixel2x2_bot_799/GndD DiffBn VSUBS OnBn
+ VDD openDVS_pixel2x2_bot
XopenDVS_pixel2x2_bot_741 openDVS_pixel2x2_bot_741/vpd[0] openDVS_pixel2x2_bot_741/vpd[1]
+ openDVS_pixel2x2_bot_741/vpd[3] openDVS_pixel2x2_bot_741/vpd[2] rowReadON[46] rowReadON[47]
+ RefrBp PrBp PrSFBp col_periphery_1x2_5/COL_LINE0 pixRst[10] pixRst[11] col_periphery_1x2_5/COL_LINE1
+ OffBn rowReadOFF[46] rowReadOFF[47] openDVS_pixel2x2_bot_767/GndD DiffBn VSUBS OnBn
+ VDD openDVS_pixel2x2_bot
XopenDVS_pixel2x2_bot_571 openDVS_pixel2x2_bot_571/vpd[0] openDVS_pixel2x2_bot_571/vpd[1]
+ openDVS_pixel2x2_bot_571/vpd[3] openDVS_pixel2x2_bot_571/vpd[2] rowReadON[34] rowReadON[35]
+ RefrBp PrBp PrSFBp col_periphery_1x2_27/COL_LINE0 pixRst[54] pixRst[55] col_periphery_1x2_27/COL_LINE1
+ OffBn rowReadOFF[34] rowReadOFF[35] openDVS_pixel2x2_bot_575/GndD DiffBn VSUBS OnBn
+ VDD openDVS_pixel2x2_bot
XopenDVS_pixel2x2_bot_593 openDVS_pixel2x2_bot_593/vpd[0] openDVS_pixel2x2_bot_593/vpd[1]
+ openDVS_pixel2x2_bot_593/vpd[3] openDVS_pixel2x2_bot_593/vpd[2] rowReadON[36] rowReadON[37]
+ RefrBp PrBp PrSFBp col_periphery_1x2_17/COL_LINE0 pixRst[34] pixRst[35] col_periphery_1x2_17/COL_LINE1
+ OffBn rowReadOFF[36] rowReadOFF[37] openDVS_pixel2x2_bot_607/GndD DiffBn VSUBS OnBn
+ VDD openDVS_pixel2x2_bot
XopenDVS_pixel2x2_bot_560 openDVS_pixel2x2_bot_560/vpd[0] openDVS_pixel2x2_bot_560/vpd[1]
+ openDVS_pixel2x2_bot_560/vpd[3] openDVS_pixel2x2_bot_560/vpd[2] rowReadON[34] rowReadON[35]
+ RefrBp PrBp PrSFBp col_periphery_1x2_16/COL_LINE0 pixRst[32] pixRst[33] col_periphery_1x2_16/COL_LINE1
+ OffBn rowReadOFF[34] rowReadOFF[35] openDVS_pixel2x2_bot_575/GndD DiffBn VSUBS OnBn
+ VDD openDVS_pixel2x2_bot
XopenDVS_pixel2x2_bot_582 openDVS_pixel2x2_bot_582/vpd[0] openDVS_pixel2x2_bot_582/vpd[1]
+ openDVS_pixel2x2_bot_582/vpd[3] openDVS_pixel2x2_bot_582/vpd[2] rowReadON[36] rowReadON[37]
+ RefrBp PrBp PrSFBp col_periphery_1x2_6/COL_LINE0 pixRst[12] pixRst[13] col_periphery_1x2_6/COL_LINE1
+ OffBn rowReadOFF[36] rowReadOFF[37] openDVS_pixel2x2_bot_607/GndD DiffBn VSUBS OnBn
+ VDD openDVS_pixel2x2_bot
XopenDVS_pixel2x2_bot_390 openDVS_pixel2x2_bot_390/vpd[0] openDVS_pixel2x2_bot_390/vpd[1]
+ openDVS_pixel2x2_bot_390/vpd[3] openDVS_pixel2x2_bot_390/vpd[2] rowReadON[24] rowReadON[25]
+ RefrBp PrBp PrSFBp col_periphery_1x2_6/COL_LINE0 pixRst[12] pixRst[13] col_periphery_1x2_6/COL_LINE1
+ OffBn rowReadOFF[24] rowReadOFF[25] openDVS_pixel2x2_bot_415/GndD DiffBn VSUBS OnBn
+ VDD openDVS_pixel2x2_bot
XopenDVS_pixel2x2_bot_989 openDVS_pixel2x2_bot_989/vpd[0] openDVS_pixel2x2_bot_989/vpd[1]
+ openDVS_pixel2x2_bot_989/vpd[3] openDVS_pixel2x2_bot_989/vpd[2] rowReadON[60] rowReadON[61]
+ RefrBp PrBp PrSFBp col_periphery_1x2_29/COL_LINE0 pixRst[58] pixRst[59] col_periphery_1x2_29/COL_LINE1
+ OffBn rowReadOFF[60] rowReadOFF[61] openDVS_pixel2x2_bot_991/GndD DiffBn VSUBS OnBn
+ VDD openDVS_pixel2x2_bot
XopenDVS_pixel2x2_bot_956 openDVS_pixel2x2_bot_956/vpd[0] openDVS_pixel2x2_bot_956/vpd[1]
+ openDVS_pixel2x2_bot_956/vpd[3] openDVS_pixel2x2_bot_956/vpd[2] rowReadON[58] rowReadON[59]
+ RefrBp PrBp PrSFBp col_periphery_1x2_28/COL_LINE0 pixRst[56] pixRst[57] col_periphery_1x2_28/COL_LINE1
+ OffBn rowReadOFF[58] rowReadOFF[59] openDVS_pixel2x2_bot_959/GndD DiffBn VSUBS OnBn
+ VDD openDVS_pixel2x2_bot
XopenDVS_pixel2x2_bot_923 openDVS_pixel2x2_bot_923/vpd[0] openDVS_pixel2x2_bot_923/vpd[1]
+ openDVS_pixel2x2_bot_923/vpd[3] openDVS_pixel2x2_bot_923/vpd[2] rowReadON[56] rowReadON[57]
+ RefrBp PrBp PrSFBp col_periphery_1x2_27/COL_LINE0 pixRst[54] pixRst[55] col_periphery_1x2_27/COL_LINE1
+ OffBn rowReadOFF[56] rowReadOFF[57] openDVS_pixel2x2_bot_927/GndD DiffBn VSUBS OnBn
+ VDD openDVS_pixel2x2_bot
XopenDVS_pixel2x2_bot_978 openDVS_pixel2x2_bot_978/vpd[0] openDVS_pixel2x2_bot_978/vpd[1]
+ openDVS_pixel2x2_bot_978/vpd[3] openDVS_pixel2x2_bot_978/vpd[2] rowReadON[60] rowReadON[61]
+ RefrBp PrBp PrSFBp col_periphery_1x2_18/COL_LINE0 pixRst[36] pixRst[37] col_periphery_1x2_18/COL_LINE1
+ OffBn rowReadOFF[60] rowReadOFF[61] openDVS_pixel2x2_bot_991/GndD DiffBn VSUBS OnBn
+ VDD openDVS_pixel2x2_bot
XopenDVS_pixel2x2_bot_945 openDVS_pixel2x2_bot_945/vpd[0] openDVS_pixel2x2_bot_945/vpd[1]
+ openDVS_pixel2x2_bot_945/vpd[3] openDVS_pixel2x2_bot_945/vpd[2] rowReadON[58] rowReadON[59]
+ RefrBp PrBp PrSFBp col_periphery_1x2_17/COL_LINE0 pixRst[34] pixRst[35] col_periphery_1x2_17/COL_LINE1
+ OffBn rowReadOFF[58] rowReadOFF[59] openDVS_pixel2x2_bot_959/GndD DiffBn VSUBS OnBn
+ VDD openDVS_pixel2x2_bot
XopenDVS_pixel2x2_bot_912 openDVS_pixel2x2_bot_912/vpd[0] openDVS_pixel2x2_bot_912/vpd[1]
+ openDVS_pixel2x2_bot_912/vpd[3] openDVS_pixel2x2_bot_912/vpd[2] rowReadON[56] rowReadON[57]
+ RefrBp PrBp PrSFBp col_periphery_1x2_16/COL_LINE0 pixRst[32] pixRst[33] col_periphery_1x2_16/COL_LINE1
+ OffBn rowReadOFF[56] rowReadOFF[57] openDVS_pixel2x2_bot_927/GndD DiffBn VSUBS OnBn
+ VDD openDVS_pixel2x2_bot
XopenDVS_pixel2x2_bot_967 openDVS_pixel2x2_bot_967/vpd[0] openDVS_pixel2x2_bot_967/vpd[1]
+ openDVS_pixel2x2_bot_967/vpd[3] openDVS_pixel2x2_bot_967/vpd[2] rowReadON[60] rowReadON[61]
+ RefrBp PrBp PrSFBp col_periphery_1x2_7/COL_LINE0 pixRst[14] pixRst[15] col_periphery_1x2_7/COL_LINE1
+ OffBn rowReadOFF[60] rowReadOFF[61] openDVS_pixel2x2_bot_991/GndD DiffBn VSUBS OnBn
+ VDD openDVS_pixel2x2_bot
XopenDVS_pixel2x2_bot_934 openDVS_pixel2x2_bot_934/vpd[0] openDVS_pixel2x2_bot_934/vpd[1]
+ openDVS_pixel2x2_bot_934/vpd[3] openDVS_pixel2x2_bot_934/vpd[2] rowReadON[58] rowReadON[59]
+ RefrBp PrBp PrSFBp col_periphery_1x2_6/COL_LINE0 pixRst[12] pixRst[13] col_periphery_1x2_6/COL_LINE1
+ OffBn rowReadOFF[58] rowReadOFF[59] openDVS_pixel2x2_bot_959/GndD DiffBn VSUBS OnBn
+ VDD openDVS_pixel2x2_bot
XopenDVS_pixel2x2_bot_901 openDVS_pixel2x2_bot_901/vpd[0] openDVS_pixel2x2_bot_901/vpd[1]
+ openDVS_pixel2x2_bot_901/vpd[3] openDVS_pixel2x2_bot_901/vpd[2] rowReadON[56] rowReadON[57]
+ RefrBp PrBp PrSFBp col_periphery_1x2_5/COL_LINE0 pixRst[10] pixRst[11] col_periphery_1x2_5/COL_LINE1
+ OffBn rowReadOFF[56] rowReadOFF[57] openDVS_pixel2x2_bot_927/GndD DiffBn VSUBS OnBn
+ VDD openDVS_pixel2x2_bot
XopenDVS_pixel2x2_bot_208 openDVS_pixel2x2_bot_208/vpd[0] openDVS_pixel2x2_bot_208/vpd[1]
+ openDVS_pixel2x2_bot_208/vpd[3] openDVS_pixel2x2_bot_208/vpd[2] rowReadON[12] rowReadON[13]
+ RefrBp PrBp PrSFBp col_periphery_1x2_16/COL_LINE0 pixRst[32] pixRst[33] col_periphery_1x2_16/COL_LINE1
+ OffBn rowReadOFF[12] rowReadOFF[13] openDVS_pixel2x2_bot_223/GndD DiffBn VSUBS OnBn
+ VDD openDVS_pixel2x2_bot
XopenDVS_pixel2x2_bot_219 openDVS_pixel2x2_bot_219/vpd[0] openDVS_pixel2x2_bot_219/vpd[1]
+ openDVS_pixel2x2_bot_219/vpd[3] openDVS_pixel2x2_bot_219/vpd[2] rowReadON[12] rowReadON[13]
+ RefrBp PrBp PrSFBp col_periphery_1x2_27/COL_LINE0 pixRst[54] pixRst[55] col_periphery_1x2_27/COL_LINE1
+ OffBn rowReadOFF[12] rowReadOFF[13] openDVS_pixel2x2_bot_223/GndD DiffBn VSUBS OnBn
+ VDD openDVS_pixel2x2_bot
XopenDVS_pixel2x2_bot_797 openDVS_pixel2x2_bot_797/vpd[0] openDVS_pixel2x2_bot_797/vpd[1]
+ openDVS_pixel2x2_bot_797/vpd[3] openDVS_pixel2x2_bot_797/vpd[2] rowReadON[48] rowReadON[49]
+ RefrBp PrBp PrSFBp col_periphery_1x2_29/COL_LINE0 pixRst[58] pixRst[59] col_periphery_1x2_29/COL_LINE1
+ OffBn rowReadOFF[48] rowReadOFF[49] openDVS_pixel2x2_bot_799/GndD DiffBn VSUBS OnBn
+ VDD openDVS_pixel2x2_bot
XopenDVS_pixel2x2_bot_764 openDVS_pixel2x2_bot_764/vpd[0] openDVS_pixel2x2_bot_764/vpd[1]
+ openDVS_pixel2x2_bot_764/vpd[3] openDVS_pixel2x2_bot_764/vpd[2] rowReadON[46] rowReadON[47]
+ RefrBp PrBp PrSFBp col_periphery_1x2_28/COL_LINE0 pixRst[56] pixRst[57] col_periphery_1x2_28/COL_LINE1
+ OffBn rowReadOFF[46] rowReadOFF[47] openDVS_pixel2x2_bot_767/GndD DiffBn VSUBS OnBn
+ VDD openDVS_pixel2x2_bot
XopenDVS_pixel2x2_bot_731 openDVS_pixel2x2_bot_731/vpd[0] openDVS_pixel2x2_bot_731/vpd[1]
+ openDVS_pixel2x2_bot_731/vpd[3] openDVS_pixel2x2_bot_731/vpd[2] rowReadON[44] rowReadON[45]
+ RefrBp PrBp PrSFBp col_periphery_1x2_27/COL_LINE0 pixRst[54] pixRst[55] col_periphery_1x2_27/COL_LINE1
+ OffBn rowReadOFF[44] rowReadOFF[45] openDVS_pixel2x2_bot_735/GndD DiffBn VSUBS OnBn
+ VDD openDVS_pixel2x2_bot
XopenDVS_pixel2x2_bot_786 openDVS_pixel2x2_bot_786/vpd[0] openDVS_pixel2x2_bot_786/vpd[1]
+ openDVS_pixel2x2_bot_786/vpd[3] openDVS_pixel2x2_bot_786/vpd[2] rowReadON[48] rowReadON[49]
+ RefrBp PrBp PrSFBp col_periphery_1x2_18/COL_LINE0 pixRst[36] pixRst[37] col_periphery_1x2_18/COL_LINE1
+ OffBn rowReadOFF[48] rowReadOFF[49] openDVS_pixel2x2_bot_799/GndD DiffBn VSUBS OnBn
+ VDD openDVS_pixel2x2_bot
XopenDVS_pixel2x2_bot_753 openDVS_pixel2x2_bot_753/vpd[0] openDVS_pixel2x2_bot_753/vpd[1]
+ openDVS_pixel2x2_bot_753/vpd[3] openDVS_pixel2x2_bot_753/vpd[2] rowReadON[46] rowReadON[47]
+ RefrBp PrBp PrSFBp col_periphery_1x2_17/COL_LINE0 pixRst[34] pixRst[35] col_periphery_1x2_17/COL_LINE1
+ OffBn rowReadOFF[46] rowReadOFF[47] openDVS_pixel2x2_bot_767/GndD DiffBn VSUBS OnBn
+ VDD openDVS_pixel2x2_bot
XopenDVS_pixel2x2_bot_720 openDVS_pixel2x2_bot_720/vpd[0] openDVS_pixel2x2_bot_720/vpd[1]
+ openDVS_pixel2x2_bot_720/vpd[3] openDVS_pixel2x2_bot_720/vpd[2] rowReadON[44] rowReadON[45]
+ RefrBp PrBp PrSFBp col_periphery_1x2_16/COL_LINE0 pixRst[32] pixRst[33] col_periphery_1x2_16/COL_LINE1
+ OffBn rowReadOFF[44] rowReadOFF[45] openDVS_pixel2x2_bot_735/GndD DiffBn VSUBS OnBn
+ VDD openDVS_pixel2x2_bot
XopenDVS_pixel2x2_bot_775 openDVS_pixel2x2_bot_775/vpd[0] openDVS_pixel2x2_bot_775/vpd[1]
+ openDVS_pixel2x2_bot_775/vpd[3] openDVS_pixel2x2_bot_775/vpd[2] rowReadON[48] rowReadON[49]
+ RefrBp PrBp PrSFBp col_periphery_1x2_7/COL_LINE0 pixRst[14] pixRst[15] col_periphery_1x2_7/COL_LINE1
+ OffBn rowReadOFF[48] rowReadOFF[49] openDVS_pixel2x2_bot_799/GndD DiffBn VSUBS OnBn
+ VDD openDVS_pixel2x2_bot
XopenDVS_pixel2x2_bot_742 openDVS_pixel2x2_bot_742/vpd[0] openDVS_pixel2x2_bot_742/vpd[1]
+ openDVS_pixel2x2_bot_742/vpd[3] openDVS_pixel2x2_bot_742/vpd[2] rowReadON[46] rowReadON[47]
+ RefrBp PrBp PrSFBp col_periphery_1x2_6/COL_LINE0 pixRst[12] pixRst[13] col_periphery_1x2_6/COL_LINE1
+ OffBn rowReadOFF[46] rowReadOFF[47] openDVS_pixel2x2_bot_767/GndD DiffBn VSUBS OnBn
+ VDD openDVS_pixel2x2_bot
XopenDVS_pixel2x2_bot_572 openDVS_pixel2x2_bot_572/vpd[0] openDVS_pixel2x2_bot_572/vpd[1]
+ openDVS_pixel2x2_bot_572/vpd[3] openDVS_pixel2x2_bot_572/vpd[2] rowReadON[34] rowReadON[35]
+ RefrBp PrBp PrSFBp col_periphery_1x2_28/COL_LINE0 pixRst[56] pixRst[57] col_periphery_1x2_28/COL_LINE1
+ OffBn rowReadOFF[34] rowReadOFF[35] openDVS_pixel2x2_bot_575/GndD DiffBn VSUBS OnBn
+ VDD openDVS_pixel2x2_bot
XopenDVS_pixel2x2_bot_594 openDVS_pixel2x2_bot_594/vpd[0] openDVS_pixel2x2_bot_594/vpd[1]
+ openDVS_pixel2x2_bot_594/vpd[3] openDVS_pixel2x2_bot_594/vpd[2] rowReadON[36] rowReadON[37]
+ RefrBp PrBp PrSFBp col_periphery_1x2_18/COL_LINE0 pixRst[36] pixRst[37] col_periphery_1x2_18/COL_LINE1
+ OffBn rowReadOFF[36] rowReadOFF[37] openDVS_pixel2x2_bot_607/GndD DiffBn VSUBS OnBn
+ VDD openDVS_pixel2x2_bot
XopenDVS_pixel2x2_bot_561 openDVS_pixel2x2_bot_561/vpd[0] openDVS_pixel2x2_bot_561/vpd[1]
+ openDVS_pixel2x2_bot_561/vpd[3] openDVS_pixel2x2_bot_561/vpd[2] rowReadON[34] rowReadON[35]
+ RefrBp PrBp PrSFBp col_periphery_1x2_17/COL_LINE0 pixRst[34] pixRst[35] col_periphery_1x2_17/COL_LINE1
+ OffBn rowReadOFF[34] rowReadOFF[35] openDVS_pixel2x2_bot_575/GndD DiffBn VSUBS OnBn
+ VDD openDVS_pixel2x2_bot
XopenDVS_pixel2x2_bot_583 openDVS_pixel2x2_bot_583/vpd[0] openDVS_pixel2x2_bot_583/vpd[1]
+ openDVS_pixel2x2_bot_583/vpd[3] openDVS_pixel2x2_bot_583/vpd[2] rowReadON[36] rowReadON[37]
+ RefrBp PrBp PrSFBp col_periphery_1x2_7/COL_LINE0 pixRst[14] pixRst[15] col_periphery_1x2_7/COL_LINE1
+ OffBn rowReadOFF[36] rowReadOFF[37] openDVS_pixel2x2_bot_607/GndD DiffBn VSUBS OnBn
+ VDD openDVS_pixel2x2_bot
XopenDVS_pixel2x2_bot_550 openDVS_pixel2x2_bot_550/vpd[0] openDVS_pixel2x2_bot_550/vpd[1]
+ openDVS_pixel2x2_bot_550/vpd[3] openDVS_pixel2x2_bot_550/vpd[2] rowReadON[34] rowReadON[35]
+ RefrBp PrBp PrSFBp col_periphery_1x2_6/COL_LINE0 pixRst[12] pixRst[13] col_periphery_1x2_6/COL_LINE1
+ OffBn rowReadOFF[34] rowReadOFF[35] openDVS_pixel2x2_bot_575/GndD DiffBn VSUBS OnBn
+ VDD openDVS_pixel2x2_bot
XopenDVS_pixel2x2_bot_380 openDVS_pixel2x2_bot_380/vpd[0] openDVS_pixel2x2_bot_380/vpd[1]
+ openDVS_pixel2x2_bot_380/vpd[3] openDVS_pixel2x2_bot_380/vpd[2] rowReadON[22] rowReadON[23]
+ RefrBp PrBp PrSFBp col_periphery_1x2_28/COL_LINE0 pixRst[56] pixRst[57] col_periphery_1x2_28/COL_LINE1
+ OffBn rowReadOFF[22] rowReadOFF[23] openDVS_pixel2x2_bot_383/GndD DiffBn VSUBS OnBn
+ VDD openDVS_pixel2x2_bot
XopenDVS_pixel2x2_bot_391 openDVS_pixel2x2_bot_391/vpd[0] openDVS_pixel2x2_bot_391/vpd[1]
+ openDVS_pixel2x2_bot_391/vpd[3] openDVS_pixel2x2_bot_391/vpd[2] rowReadON[24] rowReadON[25]
+ RefrBp PrBp PrSFBp col_periphery_1x2_7/COL_LINE0 pixRst[14] pixRst[15] col_periphery_1x2_7/COL_LINE1
+ OffBn rowReadOFF[24] rowReadOFF[25] openDVS_pixel2x2_bot_415/GndD DiffBn VSUBS OnBn
+ VDD openDVS_pixel2x2_bot
XopenDVS_pixel2x2_bot_957 openDVS_pixel2x2_bot_957/vpd[0] openDVS_pixel2x2_bot_957/vpd[1]
+ openDVS_pixel2x2_bot_957/vpd[3] openDVS_pixel2x2_bot_957/vpd[2] rowReadON[58] rowReadON[59]
+ RefrBp PrBp PrSFBp col_periphery_1x2_29/COL_LINE0 pixRst[58] pixRst[59] col_periphery_1x2_29/COL_LINE1
+ OffBn rowReadOFF[58] rowReadOFF[59] openDVS_pixel2x2_bot_959/GndD DiffBn VSUBS OnBn
+ VDD openDVS_pixel2x2_bot
XopenDVS_pixel2x2_bot_924 openDVS_pixel2x2_bot_924/vpd[0] openDVS_pixel2x2_bot_924/vpd[1]
+ openDVS_pixel2x2_bot_924/vpd[3] openDVS_pixel2x2_bot_924/vpd[2] rowReadON[56] rowReadON[57]
+ RefrBp PrBp PrSFBp col_periphery_1x2_28/COL_LINE0 pixRst[56] pixRst[57] col_periphery_1x2_28/COL_LINE1
+ OffBn rowReadOFF[56] rowReadOFF[57] openDVS_pixel2x2_bot_927/GndD DiffBn VSUBS OnBn
+ VDD openDVS_pixel2x2_bot
XopenDVS_pixel2x2_bot_979 openDVS_pixel2x2_bot_979/vpd[0] openDVS_pixel2x2_bot_979/vpd[1]
+ openDVS_pixel2x2_bot_979/vpd[3] openDVS_pixel2x2_bot_979/vpd[2] rowReadON[60] rowReadON[61]
+ RefrBp PrBp PrSFBp col_periphery_1x2_19/COL_LINE0 pixRst[38] pixRst[39] col_periphery_1x2_19/COL_LINE1
+ OffBn rowReadOFF[60] rowReadOFF[61] openDVS_pixel2x2_bot_991/GndD DiffBn VSUBS OnBn
+ VDD openDVS_pixel2x2_bot
XopenDVS_pixel2x2_bot_946 openDVS_pixel2x2_bot_946/vpd[0] openDVS_pixel2x2_bot_946/vpd[1]
+ openDVS_pixel2x2_bot_946/vpd[3] openDVS_pixel2x2_bot_946/vpd[2] rowReadON[58] rowReadON[59]
+ RefrBp PrBp PrSFBp col_periphery_1x2_18/COL_LINE0 pixRst[36] pixRst[37] col_periphery_1x2_18/COL_LINE1
+ OffBn rowReadOFF[58] rowReadOFF[59] openDVS_pixel2x2_bot_959/GndD DiffBn VSUBS OnBn
+ VDD openDVS_pixel2x2_bot
XopenDVS_pixel2x2_bot_913 openDVS_pixel2x2_bot_913/vpd[0] openDVS_pixel2x2_bot_913/vpd[1]
+ openDVS_pixel2x2_bot_913/vpd[3] openDVS_pixel2x2_bot_913/vpd[2] rowReadON[56] rowReadON[57]
+ RefrBp PrBp PrSFBp col_periphery_1x2_17/COL_LINE0 pixRst[34] pixRst[35] col_periphery_1x2_17/COL_LINE1
+ OffBn rowReadOFF[56] rowReadOFF[57] openDVS_pixel2x2_bot_927/GndD DiffBn VSUBS OnBn
+ VDD openDVS_pixel2x2_bot
XopenDVS_pixel2x2_bot_968 openDVS_pixel2x2_bot_968/vpd[0] openDVS_pixel2x2_bot_968/vpd[1]
+ openDVS_pixel2x2_bot_968/vpd[3] openDVS_pixel2x2_bot_968/vpd[2] rowReadON[60] rowReadON[61]
+ RefrBp PrBp PrSFBp col_periphery_1x2_8/COL_LINE0 pixRst[16] pixRst[17] col_periphery_1x2_8/COL_LINE1
+ OffBn rowReadOFF[60] rowReadOFF[61] openDVS_pixel2x2_bot_991/GndD DiffBn VSUBS OnBn
+ VDD openDVS_pixel2x2_bot
XopenDVS_pixel2x2_bot_935 openDVS_pixel2x2_bot_935/vpd[0] openDVS_pixel2x2_bot_935/vpd[1]
+ openDVS_pixel2x2_bot_935/vpd[3] openDVS_pixel2x2_bot_935/vpd[2] rowReadON[58] rowReadON[59]
+ RefrBp PrBp PrSFBp col_periphery_1x2_7/COL_LINE0 pixRst[14] pixRst[15] col_periphery_1x2_7/COL_LINE1
+ OffBn rowReadOFF[58] rowReadOFF[59] openDVS_pixel2x2_bot_959/GndD DiffBn VSUBS OnBn
+ VDD openDVS_pixel2x2_bot
XopenDVS_pixel2x2_bot_902 openDVS_pixel2x2_bot_902/vpd[0] openDVS_pixel2x2_bot_902/vpd[1]
+ openDVS_pixel2x2_bot_902/vpd[3] openDVS_pixel2x2_bot_902/vpd[2] rowReadON[56] rowReadON[57]
+ RefrBp PrBp PrSFBp col_periphery_1x2_6/COL_LINE0 pixRst[12] pixRst[13] col_periphery_1x2_6/COL_LINE1
+ OffBn rowReadOFF[56] rowReadOFF[57] openDVS_pixel2x2_bot_927/GndD DiffBn VSUBS OnBn
+ VDD openDVS_pixel2x2_bot
XopenDVS_pixel2x2_bot_209 openDVS_pixel2x2_bot_209/vpd[0] openDVS_pixel2x2_bot_209/vpd[1]
+ openDVS_pixel2x2_bot_209/vpd[3] openDVS_pixel2x2_bot_209/vpd[2] rowReadON[12] rowReadON[13]
+ RefrBp PrBp PrSFBp col_periphery_1x2_17/COL_LINE0 pixRst[34] pixRst[35] col_periphery_1x2_17/COL_LINE1
+ OffBn rowReadOFF[12] rowReadOFF[13] openDVS_pixel2x2_bot_223/GndD DiffBn VSUBS OnBn
+ VDD openDVS_pixel2x2_bot
XopenDVS_pixel2x2_bot_798 openDVS_pixel2x2_bot_798/vpd[0] openDVS_pixel2x2_bot_798/vpd[1]
+ openDVS_pixel2x2_bot_798/vpd[3] openDVS_pixel2x2_bot_798/vpd[2] rowReadON[48] rowReadON[49]
+ RefrBp PrBp PrSFBp col_periphery_1x2_30/COL_LINE0 pixRst[60] pixRst[61] col_periphery_1x2_30/COL_LINE1
+ OffBn rowReadOFF[48] rowReadOFF[49] openDVS_pixel2x2_bot_799/GndD DiffBn VSUBS OnBn
+ VDD openDVS_pixel2x2_bot
XopenDVS_pixel2x2_bot_765 openDVS_pixel2x2_bot_765/vpd[0] openDVS_pixel2x2_bot_765/vpd[1]
+ openDVS_pixel2x2_bot_765/vpd[3] openDVS_pixel2x2_bot_765/vpd[2] rowReadON[46] rowReadON[47]
+ RefrBp PrBp PrSFBp col_periphery_1x2_29/COL_LINE0 pixRst[58] pixRst[59] col_periphery_1x2_29/COL_LINE1
+ OffBn rowReadOFF[46] rowReadOFF[47] openDVS_pixel2x2_bot_767/GndD DiffBn VSUBS OnBn
+ VDD openDVS_pixel2x2_bot
XopenDVS_pixel2x2_bot_732 openDVS_pixel2x2_bot_732/vpd[0] openDVS_pixel2x2_bot_732/vpd[1]
+ openDVS_pixel2x2_bot_732/vpd[3] openDVS_pixel2x2_bot_732/vpd[2] rowReadON[44] rowReadON[45]
+ RefrBp PrBp PrSFBp col_periphery_1x2_28/COL_LINE0 pixRst[56] pixRst[57] col_periphery_1x2_28/COL_LINE1
+ OffBn rowReadOFF[44] rowReadOFF[45] openDVS_pixel2x2_bot_735/GndD DiffBn VSUBS OnBn
+ VDD openDVS_pixel2x2_bot
XopenDVS_pixel2x2_bot_787 openDVS_pixel2x2_bot_787/vpd[0] openDVS_pixel2x2_bot_787/vpd[1]
+ openDVS_pixel2x2_bot_787/vpd[3] openDVS_pixel2x2_bot_787/vpd[2] rowReadON[48] rowReadON[49]
+ RefrBp PrBp PrSFBp col_periphery_1x2_19/COL_LINE0 pixRst[38] pixRst[39] col_periphery_1x2_19/COL_LINE1
+ OffBn rowReadOFF[48] rowReadOFF[49] openDVS_pixel2x2_bot_799/GndD DiffBn VSUBS OnBn
+ VDD openDVS_pixel2x2_bot
XopenDVS_pixel2x2_bot_754 openDVS_pixel2x2_bot_754/vpd[0] openDVS_pixel2x2_bot_754/vpd[1]
+ openDVS_pixel2x2_bot_754/vpd[3] openDVS_pixel2x2_bot_754/vpd[2] rowReadON[46] rowReadON[47]
+ RefrBp PrBp PrSFBp col_periphery_1x2_18/COL_LINE0 pixRst[36] pixRst[37] col_periphery_1x2_18/COL_LINE1
+ OffBn rowReadOFF[46] rowReadOFF[47] openDVS_pixel2x2_bot_767/GndD DiffBn VSUBS OnBn
+ VDD openDVS_pixel2x2_bot
XopenDVS_pixel2x2_bot_721 openDVS_pixel2x2_bot_721/vpd[0] openDVS_pixel2x2_bot_721/vpd[1]
+ openDVS_pixel2x2_bot_721/vpd[3] openDVS_pixel2x2_bot_721/vpd[2] rowReadON[44] rowReadON[45]
+ RefrBp PrBp PrSFBp col_periphery_1x2_17/COL_LINE0 pixRst[34] pixRst[35] col_periphery_1x2_17/COL_LINE1
+ OffBn rowReadOFF[44] rowReadOFF[45] openDVS_pixel2x2_bot_735/GndD DiffBn VSUBS OnBn
+ VDD openDVS_pixel2x2_bot
XopenDVS_pixel2x2_bot_776 openDVS_pixel2x2_bot_776/vpd[0] openDVS_pixel2x2_bot_776/vpd[1]
+ openDVS_pixel2x2_bot_776/vpd[3] openDVS_pixel2x2_bot_776/vpd[2] rowReadON[48] rowReadON[49]
+ RefrBp PrBp PrSFBp col_periphery_1x2_8/COL_LINE0 pixRst[16] pixRst[17] col_periphery_1x2_8/COL_LINE1
+ OffBn rowReadOFF[48] rowReadOFF[49] openDVS_pixel2x2_bot_799/GndD DiffBn VSUBS OnBn
+ VDD openDVS_pixel2x2_bot
XopenDVS_pixel2x2_bot_743 openDVS_pixel2x2_bot_743/vpd[0] openDVS_pixel2x2_bot_743/vpd[1]
+ openDVS_pixel2x2_bot_743/vpd[3] openDVS_pixel2x2_bot_743/vpd[2] rowReadON[46] rowReadON[47]
+ RefrBp PrBp PrSFBp col_periphery_1x2_7/COL_LINE0 pixRst[14] pixRst[15] col_periphery_1x2_7/COL_LINE1
+ OffBn rowReadOFF[46] rowReadOFF[47] openDVS_pixel2x2_bot_767/GndD DiffBn VSUBS OnBn
+ VDD openDVS_pixel2x2_bot
XopenDVS_pixel2x2_bot_710 openDVS_pixel2x2_bot_710/vpd[0] openDVS_pixel2x2_bot_710/vpd[1]
+ openDVS_pixel2x2_bot_710/vpd[3] openDVS_pixel2x2_bot_710/vpd[2] rowReadON[44] rowReadON[45]
+ RefrBp PrBp PrSFBp col_periphery_1x2_6/COL_LINE0 pixRst[12] pixRst[13] col_periphery_1x2_6/COL_LINE1
+ OffBn rowReadOFF[44] rowReadOFF[45] openDVS_pixel2x2_bot_735/GndD DiffBn VSUBS OnBn
+ VDD openDVS_pixel2x2_bot
XopenDVS_pixel2x2_bot_573 openDVS_pixel2x2_bot_573/vpd[0] openDVS_pixel2x2_bot_573/vpd[1]
+ openDVS_pixel2x2_bot_573/vpd[3] openDVS_pixel2x2_bot_573/vpd[2] rowReadON[34] rowReadON[35]
+ RefrBp PrBp PrSFBp col_periphery_1x2_29/COL_LINE0 pixRst[58] pixRst[59] col_periphery_1x2_29/COL_LINE1
+ OffBn rowReadOFF[34] rowReadOFF[35] openDVS_pixel2x2_bot_575/GndD DiffBn VSUBS OnBn
+ VDD openDVS_pixel2x2_bot
XopenDVS_pixel2x2_bot_540 openDVS_pixel2x2_bot_540/vpd[0] openDVS_pixel2x2_bot_540/vpd[1]
+ openDVS_pixel2x2_bot_540/vpd[3] openDVS_pixel2x2_bot_540/vpd[2] rowReadON[32] rowReadON[33]
+ RefrBp PrBp PrSFBp col_periphery_1x2_28/COL_LINE0 pixRst[56] pixRst[57] col_periphery_1x2_28/COL_LINE1
+ OffBn rowReadOFF[32] rowReadOFF[33] openDVS_pixel2x2_bot_543/GndD DiffBn VSUBS OnBn
+ VDD openDVS_pixel2x2_bot
XopenDVS_pixel2x2_bot_595 openDVS_pixel2x2_bot_595/vpd[0] openDVS_pixel2x2_bot_595/vpd[1]
+ openDVS_pixel2x2_bot_595/vpd[3] openDVS_pixel2x2_bot_595/vpd[2] rowReadON[36] rowReadON[37]
+ RefrBp PrBp PrSFBp col_periphery_1x2_19/COL_LINE0 pixRst[38] pixRst[39] col_periphery_1x2_19/COL_LINE1
+ OffBn rowReadOFF[36] rowReadOFF[37] openDVS_pixel2x2_bot_607/GndD DiffBn VSUBS OnBn
+ VDD openDVS_pixel2x2_bot
XopenDVS_pixel2x2_bot_562 openDVS_pixel2x2_bot_562/vpd[0] openDVS_pixel2x2_bot_562/vpd[1]
+ openDVS_pixel2x2_bot_562/vpd[3] openDVS_pixel2x2_bot_562/vpd[2] rowReadON[34] rowReadON[35]
+ RefrBp PrBp PrSFBp col_periphery_1x2_18/COL_LINE0 pixRst[36] pixRst[37] col_periphery_1x2_18/COL_LINE1
+ OffBn rowReadOFF[34] rowReadOFF[35] openDVS_pixel2x2_bot_575/GndD DiffBn VSUBS OnBn
+ VDD openDVS_pixel2x2_bot
XopenDVS_pixel2x2_bot_584 openDVS_pixel2x2_bot_584/vpd[0] openDVS_pixel2x2_bot_584/vpd[1]
+ openDVS_pixel2x2_bot_584/vpd[3] openDVS_pixel2x2_bot_584/vpd[2] rowReadON[36] rowReadON[37]
+ RefrBp PrBp PrSFBp col_periphery_1x2_8/COL_LINE0 pixRst[16] pixRst[17] col_periphery_1x2_8/COL_LINE1
+ OffBn rowReadOFF[36] rowReadOFF[37] openDVS_pixel2x2_bot_607/GndD DiffBn VSUBS OnBn
+ VDD openDVS_pixel2x2_bot
XopenDVS_pixel2x2_bot_551 openDVS_pixel2x2_bot_551/vpd[0] openDVS_pixel2x2_bot_551/vpd[1]
+ openDVS_pixel2x2_bot_551/vpd[3] openDVS_pixel2x2_bot_551/vpd[2] rowReadON[34] rowReadON[35]
+ RefrBp PrBp PrSFBp col_periphery_1x2_7/COL_LINE0 pixRst[14] pixRst[15] col_periphery_1x2_7/COL_LINE1
+ OffBn rowReadOFF[34] rowReadOFF[35] openDVS_pixel2x2_bot_575/GndD DiffBn VSUBS OnBn
+ VDD openDVS_pixel2x2_bot
XopenDVS_pixel2x2_bot_381 openDVS_pixel2x2_bot_381/vpd[0] openDVS_pixel2x2_bot_381/vpd[1]
+ openDVS_pixel2x2_bot_381/vpd[3] openDVS_pixel2x2_bot_381/vpd[2] rowReadON[22] rowReadON[23]
+ RefrBp PrBp PrSFBp col_periphery_1x2_29/COL_LINE0 pixRst[58] pixRst[59] col_periphery_1x2_29/COL_LINE1
+ OffBn rowReadOFF[22] rowReadOFF[23] openDVS_pixel2x2_bot_383/GndD DiffBn VSUBS OnBn
+ VDD openDVS_pixel2x2_bot
XopenDVS_pixel2x2_bot_370 openDVS_pixel2x2_bot_370/vpd[0] openDVS_pixel2x2_bot_370/vpd[1]
+ openDVS_pixel2x2_bot_370/vpd[3] openDVS_pixel2x2_bot_370/vpd[2] rowReadON[22] rowReadON[23]
+ RefrBp PrBp PrSFBp col_periphery_1x2_18/COL_LINE0 pixRst[36] pixRst[37] col_periphery_1x2_18/COL_LINE1
+ OffBn rowReadOFF[22] rowReadOFF[23] openDVS_pixel2x2_bot_383/GndD DiffBn VSUBS OnBn
+ VDD openDVS_pixel2x2_bot
XopenDVS_pixel2x2_bot_392 openDVS_pixel2x2_bot_392/vpd[0] openDVS_pixel2x2_bot_392/vpd[1]
+ openDVS_pixel2x2_bot_392/vpd[3] openDVS_pixel2x2_bot_392/vpd[2] rowReadON[24] rowReadON[25]
+ RefrBp PrBp PrSFBp col_periphery_1x2_8/COL_LINE0 pixRst[16] pixRst[17] col_periphery_1x2_8/COL_LINE1
+ OffBn rowReadOFF[24] rowReadOFF[25] openDVS_pixel2x2_bot_415/GndD DiffBn VSUBS OnBn
+ VDD openDVS_pixel2x2_bot
XopenDVS_pixel2x2_bot_958 openDVS_pixel2x2_bot_958/vpd[0] openDVS_pixel2x2_bot_958/vpd[1]
+ openDVS_pixel2x2_bot_958/vpd[3] openDVS_pixel2x2_bot_958/vpd[2] rowReadON[58] rowReadON[59]
+ RefrBp PrBp PrSFBp col_periphery_1x2_30/COL_LINE0 pixRst[60] pixRst[61] col_periphery_1x2_30/COL_LINE1
+ OffBn rowReadOFF[58] rowReadOFF[59] openDVS_pixel2x2_bot_959/GndD DiffBn VSUBS OnBn
+ VDD openDVS_pixel2x2_bot
XopenDVS_pixel2x2_bot_925 openDVS_pixel2x2_bot_925/vpd[0] openDVS_pixel2x2_bot_925/vpd[1]
+ openDVS_pixel2x2_bot_925/vpd[3] openDVS_pixel2x2_bot_925/vpd[2] rowReadON[56] rowReadON[57]
+ RefrBp PrBp PrSFBp col_periphery_1x2_29/COL_LINE0 pixRst[58] pixRst[59] col_periphery_1x2_29/COL_LINE1
+ OffBn rowReadOFF[56] rowReadOFF[57] openDVS_pixel2x2_bot_927/GndD DiffBn VSUBS OnBn
+ VDD openDVS_pixel2x2_bot
XopenDVS_pixel2x2_bot_947 openDVS_pixel2x2_bot_947/vpd[0] openDVS_pixel2x2_bot_947/vpd[1]
+ openDVS_pixel2x2_bot_947/vpd[3] openDVS_pixel2x2_bot_947/vpd[2] rowReadON[58] rowReadON[59]
+ RefrBp PrBp PrSFBp col_periphery_1x2_19/COL_LINE0 pixRst[38] pixRst[39] col_periphery_1x2_19/COL_LINE1
+ OffBn rowReadOFF[58] rowReadOFF[59] openDVS_pixel2x2_bot_959/GndD DiffBn VSUBS OnBn
+ VDD openDVS_pixel2x2_bot
XopenDVS_pixel2x2_bot_914 openDVS_pixel2x2_bot_914/vpd[0] openDVS_pixel2x2_bot_914/vpd[1]
+ openDVS_pixel2x2_bot_914/vpd[3] openDVS_pixel2x2_bot_914/vpd[2] rowReadON[56] rowReadON[57]
+ RefrBp PrBp PrSFBp col_periphery_1x2_18/COL_LINE0 pixRst[36] pixRst[37] col_periphery_1x2_18/COL_LINE1
+ OffBn rowReadOFF[56] rowReadOFF[57] openDVS_pixel2x2_bot_927/GndD DiffBn VSUBS OnBn
+ VDD openDVS_pixel2x2_bot
XopenDVS_pixel2x2_bot_969 openDVS_pixel2x2_bot_969/vpd[0] openDVS_pixel2x2_bot_969/vpd[1]
+ openDVS_pixel2x2_bot_969/vpd[3] openDVS_pixel2x2_bot_969/vpd[2] rowReadON[60] rowReadON[61]
+ RefrBp PrBp PrSFBp col_periphery_1x2_9/COL_LINE0 pixRst[18] pixRst[19] col_periphery_1x2_9/COL_LINE1
+ OffBn rowReadOFF[60] rowReadOFF[61] openDVS_pixel2x2_bot_991/GndD DiffBn VSUBS OnBn
+ VDD openDVS_pixel2x2_bot
XopenDVS_pixel2x2_bot_936 openDVS_pixel2x2_bot_936/vpd[0] openDVS_pixel2x2_bot_936/vpd[1]
+ openDVS_pixel2x2_bot_936/vpd[3] openDVS_pixel2x2_bot_936/vpd[2] rowReadON[58] rowReadON[59]
+ RefrBp PrBp PrSFBp col_periphery_1x2_8/COL_LINE0 pixRst[16] pixRst[17] col_periphery_1x2_8/COL_LINE1
+ OffBn rowReadOFF[58] rowReadOFF[59] openDVS_pixel2x2_bot_959/GndD DiffBn VSUBS OnBn
+ VDD openDVS_pixel2x2_bot
XopenDVS_pixel2x2_bot_903 openDVS_pixel2x2_bot_903/vpd[0] openDVS_pixel2x2_bot_903/vpd[1]
+ openDVS_pixel2x2_bot_903/vpd[3] openDVS_pixel2x2_bot_903/vpd[2] rowReadON[56] rowReadON[57]
+ RefrBp PrBp PrSFBp col_periphery_1x2_7/COL_LINE0 pixRst[14] pixRst[15] col_periphery_1x2_7/COL_LINE1
+ OffBn rowReadOFF[56] rowReadOFF[57] openDVS_pixel2x2_bot_927/GndD DiffBn VSUBS OnBn
+ VDD openDVS_pixel2x2_bot
XopenDVS_pixel2x2_bot_766 openDVS_pixel2x2_bot_766/vpd[0] openDVS_pixel2x2_bot_766/vpd[1]
+ openDVS_pixel2x2_bot_766/vpd[3] openDVS_pixel2x2_bot_766/vpd[2] rowReadON[46] rowReadON[47]
+ RefrBp PrBp PrSFBp col_periphery_1x2_30/COL_LINE0 pixRst[60] pixRst[61] col_periphery_1x2_30/COL_LINE1
+ OffBn rowReadOFF[46] rowReadOFF[47] openDVS_pixel2x2_bot_767/GndD DiffBn VSUBS OnBn
+ VDD openDVS_pixel2x2_bot
XopenDVS_pixel2x2_bot_733 openDVS_pixel2x2_bot_733/vpd[0] openDVS_pixel2x2_bot_733/vpd[1]
+ openDVS_pixel2x2_bot_733/vpd[3] openDVS_pixel2x2_bot_733/vpd[2] rowReadON[44] rowReadON[45]
+ RefrBp PrBp PrSFBp col_periphery_1x2_29/COL_LINE0 pixRst[58] pixRst[59] col_periphery_1x2_29/COL_LINE1
+ OffBn rowReadOFF[44] rowReadOFF[45] openDVS_pixel2x2_bot_735/GndD DiffBn VSUBS OnBn
+ VDD openDVS_pixel2x2_bot
XopenDVS_pixel2x2_bot_700 openDVS_pixel2x2_bot_700/vpd[0] openDVS_pixel2x2_bot_700/vpd[1]
+ openDVS_pixel2x2_bot_700/vpd[3] openDVS_pixel2x2_bot_700/vpd[2] rowReadON[42] rowReadON[43]
+ RefrBp PrBp PrSFBp col_periphery_1x2_28/COL_LINE0 pixRst[56] pixRst[57] col_periphery_1x2_28/COL_LINE1
+ OffBn rowReadOFF[42] rowReadOFF[43] openDVS_pixel2x2_bot_703/GndD DiffBn VSUBS OnBn
+ VDD openDVS_pixel2x2_bot
XopenDVS_pixel2x2_bot_755 openDVS_pixel2x2_bot_755/vpd[0] openDVS_pixel2x2_bot_755/vpd[1]
+ openDVS_pixel2x2_bot_755/vpd[3] openDVS_pixel2x2_bot_755/vpd[2] rowReadON[46] rowReadON[47]
+ RefrBp PrBp PrSFBp col_periphery_1x2_19/COL_LINE0 pixRst[38] pixRst[39] col_periphery_1x2_19/COL_LINE1
+ OffBn rowReadOFF[46] rowReadOFF[47] openDVS_pixel2x2_bot_767/GndD DiffBn VSUBS OnBn
+ VDD openDVS_pixel2x2_bot
XopenDVS_pixel2x2_bot_722 openDVS_pixel2x2_bot_722/vpd[0] openDVS_pixel2x2_bot_722/vpd[1]
+ openDVS_pixel2x2_bot_722/vpd[3] openDVS_pixel2x2_bot_722/vpd[2] rowReadON[44] rowReadON[45]
+ RefrBp PrBp PrSFBp col_periphery_1x2_18/COL_LINE0 pixRst[36] pixRst[37] col_periphery_1x2_18/COL_LINE1
+ OffBn rowReadOFF[44] rowReadOFF[45] openDVS_pixel2x2_bot_735/GndD DiffBn VSUBS OnBn
+ VDD openDVS_pixel2x2_bot
XopenDVS_pixel2x2_bot_744 openDVS_pixel2x2_bot_744/vpd[0] openDVS_pixel2x2_bot_744/vpd[1]
+ openDVS_pixel2x2_bot_744/vpd[3] openDVS_pixel2x2_bot_744/vpd[2] rowReadON[46] rowReadON[47]
+ RefrBp PrBp PrSFBp col_periphery_1x2_8/COL_LINE0 pixRst[16] pixRst[17] col_periphery_1x2_8/COL_LINE1
+ OffBn rowReadOFF[46] rowReadOFF[47] openDVS_pixel2x2_bot_767/GndD DiffBn VSUBS OnBn
+ VDD openDVS_pixel2x2_bot
XopenDVS_pixel2x2_bot_711 openDVS_pixel2x2_bot_711/vpd[0] openDVS_pixel2x2_bot_711/vpd[1]
+ openDVS_pixel2x2_bot_711/vpd[3] openDVS_pixel2x2_bot_711/vpd[2] rowReadON[44] rowReadON[45]
+ RefrBp PrBp PrSFBp col_periphery_1x2_7/COL_LINE0 pixRst[14] pixRst[15] col_periphery_1x2_7/COL_LINE1
+ OffBn rowReadOFF[44] rowReadOFF[45] openDVS_pixel2x2_bot_735/GndD DiffBn VSUBS OnBn
+ VDD openDVS_pixel2x2_bot
XopenDVS_pixel2x2_bot_799 openDVS_pixel2x2_bot_799/vpd[0] openDVS_pixel2x2_bot_799/vpd[1]
+ openDVS_pixel2x2_bot_799/vpd[3] openDVS_pixel2x2_bot_799/vpd[2] rowReadON[48] rowReadON[49]
+ RefrBp PrBp PrSFBp col_periphery_1x2_31/COL_LINE0 pixRst[62] pixRst[63] col_periphery_1x2_31/COL_LINE1
+ OffBn rowReadOFF[48] rowReadOFF[49] openDVS_pixel2x2_bot_799/GndD DiffBn VSUBS OnBn
+ VDD openDVS_pixel2x2_bot
XopenDVS_pixel2x2_bot_788 openDVS_pixel2x2_bot_788/vpd[0] openDVS_pixel2x2_bot_788/vpd[1]
+ openDVS_pixel2x2_bot_788/vpd[3] openDVS_pixel2x2_bot_788/vpd[2] rowReadON[48] rowReadON[49]
+ RefrBp PrBp PrSFBp col_periphery_1x2_20/COL_LINE0 pixRst[40] pixRst[41] col_periphery_1x2_20/COL_LINE1
+ OffBn rowReadOFF[48] rowReadOFF[49] openDVS_pixel2x2_bot_799/GndD DiffBn VSUBS OnBn
+ VDD openDVS_pixel2x2_bot
XopenDVS_pixel2x2_bot_777 openDVS_pixel2x2_bot_777/vpd[0] openDVS_pixel2x2_bot_777/vpd[1]
+ openDVS_pixel2x2_bot_777/vpd[3] openDVS_pixel2x2_bot_777/vpd[2] rowReadON[48] rowReadON[49]
+ RefrBp PrBp PrSFBp col_periphery_1x2_9/COL_LINE0 pixRst[18] pixRst[19] col_periphery_1x2_9/COL_LINE1
+ OffBn rowReadOFF[48] rowReadOFF[49] openDVS_pixel2x2_bot_799/GndD DiffBn VSUBS OnBn
+ VDD openDVS_pixel2x2_bot
.ends

.subckt openDVS_pixel2x2_top vpd[0] vpd[1] vpd[3] vpd[2] rowReadOFF[1] rowReadON[1]
+ rowReadON[0] RefrBp PrBp PrSFBp readLine[0] pixRst[0] OffBn rowReadOFF[0] pixRst[1]
+ GndD DiffBn readLine[1] GndA VddA18 OnBn
XopenDVS_pixel_1 DiffBn rowReadOFF[1] OnBn RefrBp OffBn PrSFBp GndA GndA rowReadON[1]
+ VddA18 RefrBp PrSFBp readLine[1] VddA18 GndA vpd[3] OnBn pixRst[1] PrBp DiffBn GndD
+ PrBp GndA OnBn DiffBn OffBn OffBn openDVS_pixel
XopenDVS_pixel_3 DiffBn rowReadOFF[0] OnBn RefrBp OffBn PrSFBp GndA VddA18 rowReadON[0]
+ GndA RefrBp PrSFBp readLine[1] VddA18 GndA vpd[2] OnBn pixRst[1] PrBp DiffBn GndD
+ PrBp GndA OnBn DiffBn OffBn OffBn openDVS_pixel
XopenDVS_pixel_2 DiffBn rowReadOFF[1] OnBn OffBn OffBn PrSFBp GndA GndA rowReadON[1]
+ VddA18 RefrBp PrBp readLine[0] VddA18 GndA vpd[1] DiffBn pixRst[0] PrBp OnBn GndD
+ PrSFBp GndA OnBn DiffBn OffBn RefrBp openDVS_pixel
XopenDVS_pixel_0 DiffBn rowReadOFF[0] OnBn OffBn OffBn PrSFBp GndA VddA18 rowReadON[0]
+ GndA RefrBp PrBp readLine[0] VddA18 GndA vpd[0] DiffBn pixRst[0] PrBp OnBn GndD
+ PrSFBp GndA OnBn DiffBn OffBn RefrBp openDVS_pixel
.ends

.subckt pixel_layout_tile rowReadOFF[0] rowReadOFF[1] rowReadOFF[4] rowReadOFF[5]
+ rowReadOFF[6] rowReadOFF[7] rowReadOFF[10] rowReadOFF[11] rowReadOFF[12] rowReadOFF[13]
+ rowReadOFF[14] rowReadOFF[15] rowReadOFF[16] rowReadOFF[17] rowReadOFF[18] rowReadOFF[19]
+ rowReadOFF[22] rowReadOFF[23] rowReadOFF[26] rowReadOFF[27] rowReadOFF[31] rowReadOFF[32]
+ rowReadOFF[33] rowReadOFF[34] rowReadOFF[35] rowReadOFF[36] rowReadOFF[37] rowReadOFF[38]
+ rowReadOFF[39] rowReadOFF[42] rowReadOFF[43] rowReadOFF[46] rowReadOFF[47] rowReadOFF[50]
+ rowReadOFF[51] rowReadOFF[52] rowReadOFF[53] rowReadOFF[54] rowReadOFF[55] rowReadOFF[56]
+ rowReadOFF[63] rowReadON[0] rowReadON[1] rowReadON[6] rowReadON[7] rowReadON[21]
+ rowReadON[26] rowReadON[27] rowReadON[28] rowReadON[29] rowReadON[30] rowReadON[31]
+ rowReadON[40] rowReadON[41] rowReadON[44] rowReadON[45] rowReadON[46] rowReadON[47]
+ rowReadON[56] rowReadON[57] rowReadON[60] rowReadON[61] nDETECT voutn[3] voutn[6]
+ voutn[7] pixRst[9] pixRst[8] pixRst[7] pixRst[6] pixRst[5] pixRst[0] voutn[57] voutn[56]
+ voutn[55] voutn[54] voutn[53] voutn[52] voutn[51] voutn[39] voutn[38] voutn[37]
+ voutn[36] voutn[33] voutn[32] voutn[31] voutn[19] voutn[13] voutn[12] voutn[11]
+ pixRst[29] pixRst[30] pixRst[31] pixRst[36] pixRst[37] pixRst[38] pixRst[39] pixRst[52]
+ pixRst[55] pixRst[56] pixRst[57] pixRst[58] pixRst[59] pixRst[63] pixRst[19] pixRst[18]
+ pixRst[15] pixRst[10] openDVS_pixel2x2_top_607/GndD pixRst[21] rowReadON[12] rowReadON[13]
+ rowReadON[52] pixRst[20] rowReadON[53] pixRst[62] openDVS_pixel2x2_top_319/GndD
+ rowReadOFF[59] rowReadON[38] voutn[45] pixRst[28] openDVS_pixel2x2_top_671/GndD
+ rowReadON[34] rowReadON[39] pixRst[22] pixRst[41] rowReadON[35] rowReadOFF[60] pixRst[49]
+ pixRst[40] voutn[40] voutn[23] rowReadOFF[61] openDVS_pixel2x2_top_511/GndD rowReadOFF[40]
+ voutn[28] rowReadON[4] openDVS_pixel2x2_top_447/GndD rowReadOFF[41] rowReadOFF[20]
+ pixRst[48] rowReadON[5] pixRst[47] rowReadON[50] rowReadOFF[21] rowReadON[51] rowReadON[16]
+ voutn[44] openDVS_pixel2x2_top_63/GndD openDVS_pixel2x2_top_287/GndD openDVS_pixel2x2_top_383/GndD
+ voutn[43] voutn[2] rowReadON[17] voutn[1] openDVS_pixel2x2_top_767/GndD openDVS_pixel2x2_top_863/GndD
+ pixRst[25] voutn[27] rowReadON[22] openDVS_pixel2x2_top_927/GndD voutn[22] voutn[26]
+ rowReadOFF[2] voutn[21] openDVS_pixel2x2_top_223/GndD openDVS_pixel2x2_top_543/GndD
+ rowReadON[36] rowReadON[23] rowReadOFF[58] pixRst[32] openDVS_pixel2x2_top_159/GndD
+ VTHRESH pixRst[14] rowReadOFF[3] rowReadON[32] rowReadON[37] pixRst[13] pixRst[51]
+ openDVS_pixel2x2_top_703/GndD pixRst[42] openDVS_pixel2x2_top_999/GndD rowReadOFF[44]
+ pixRst[17] voutn[60] voutn[63] openDVS_pixel2x2_top_95/GndD pixRst[61] openDVS_pixel2x2_top_639/GndD
+ rowReadON[33] pixRst[50] pixRst[46] rowReadOFF[45] pixRst[16] rowReadOFF[30] voutn[48]
+ pixRst[4] voutn[16] rowReadOFF[24] pixRst[60] rowReadON[42] voutn[10] NCHARGE openDVS_pixel2x2_top_799/GndD
+ voutn[9] pixRst[33] rowReadOFF[25] rowReadOFF[48] rowReadON[43] rowReadON[8] voutn[5]
+ voutn[42] rowReadON[2] voutn[41] voutn[0] rowReadOFF[49] openDVS_pixel2x2_top_479/GndD
+ openDVS_pixel2x2_top_575/GndD rowReadON[9] pixRst[24] voutn[25] voutn[4] rowReadOFF[28]
+ pixRst[23] voutn[30] rowReadON[3] voutn[29] rowReadOFF[57] rowReadON[18] voutn[24]
+ openDVS_pixel2x2_top_959/GndD rowReadOFF[29] voutn[58] rowReadON[48] openDVS_pixel2x2_top_255/GndD
+ rowReadOFF[8] rowReadON[14] rowReadON[19] DETECT rowReadON[62] voutn[20] rowReadON[49]
+ openDVS_pixel2x2_top_351/GndD rowReadOFF[9] pixRst[27] rowReadON[10] pixRst[54]
+ rowReadON[15] voutn[47] openDVS_pixel2x2_top_415/GndD openDVS_pixel2x2_top_735/GndD
+ voutn[15] openDVS_pixel2x2_top_831/GndD rowReadON[63] pixRst[12] voutn[59] rowReadON[58]
+ voutn[18] col_periphery_1x2_9/VDD pixRst[35] rowReadON[24] voutn[17] pixRst[26]
+ rowReadON[11] voutn[46] pixRst[3] voutn[62] voutn[35] voutn[14] voutn[61] RefrBp
+ openDVS_pixel2x2_top_895/GndD openDVS_pixel2x2_top_991/GndD pixRst[45] rowReadON[54]
+ rowReadON[59] PrBp openDVS_pixel2x2_top_9/GndD pixRst[34] rowReadON[20] pixRst[11]
+ openDVS_pixel2x2_top_191/GndD rowReadON[25] pixRst[43] voutn[50] voutn[34] PrSFBp
+ pixRst[2] rowReadOFF[62] voutn[49] pixRst[53] OffBn DiffBn pixRst[44] OnBn openDVS_pixel2x2_top_99/GndD
+ pixRst[1] voutn[8] rowReadON[55] VddA18 GndD
XopenDVS_pixel2x2_top_309 openDVS_pixel2x2_top_309/vpd[0] openDVS_pixel2x2_top_309/vpd[1]
+ openDVS_pixel2x2_top_309/vpd[3] openDVS_pixel2x2_top_309/vpd[2] rowReadOFF[19] rowReadON[19]
+ rowReadON[18] RefrBp PrBp PrSFBp col_periphery_1x2_21/COL_LINE0 pixRst[42] OffBn
+ rowReadOFF[18] pixRst[43] openDVS_pixel2x2_top_319/GndD DiffBn col_periphery_1x2_21/COL_LINE1
+ GndD VddA18 OnBn openDVS_pixel2x2_top
XopenDVS_pixel2x2_top_876 openDVS_pixel2x2_top_876/vpd[0] openDVS_pixel2x2_top_876/vpd[1]
+ openDVS_pixel2x2_top_876/vpd[3] openDVS_pixel2x2_top_876/vpd[2] rowReadOFF[55] rowReadON[55]
+ rowReadON[54] RefrBp PrBp PrSFBp col_periphery_1x2_12/COL_LINE0 pixRst[24] OffBn
+ rowReadOFF[54] pixRst[25] openDVS_pixel2x2_top_895/GndD DiffBn col_periphery_1x2_12/COL_LINE1
+ GndD VddA18 OnBn openDVS_pixel2x2_top
XopenDVS_pixel2x2_top_843 openDVS_pixel2x2_top_843/vpd[0] openDVS_pixel2x2_top_843/vpd[1]
+ openDVS_pixel2x2_top_843/vpd[3] openDVS_pixel2x2_top_843/vpd[2] rowReadOFF[53] rowReadON[53]
+ rowReadON[52] RefrBp PrBp PrSFBp col_periphery_1x2_11/COL_LINE0 pixRst[22] OffBn
+ rowReadOFF[52] pixRst[23] openDVS_pixel2x2_top_863/GndD DiffBn col_periphery_1x2_11/COL_LINE1
+ GndD VddA18 OnBn openDVS_pixel2x2_top
XopenDVS_pixel2x2_top_898 openDVS_pixel2x2_top_898/vpd[0] openDVS_pixel2x2_top_898/vpd[1]
+ openDVS_pixel2x2_top_898/vpd[3] openDVS_pixel2x2_top_898/vpd[2] rowReadOFF[57] rowReadON[57]
+ rowReadON[56] RefrBp PrBp PrSFBp col_periphery_1x2_2/COL_LINE0 pixRst[4] OffBn rowReadOFF[56]
+ pixRst[5] openDVS_pixel2x2_top_927/GndD DiffBn col_periphery_1x2_2/COL_LINE1 GndD
+ VddA18 OnBn openDVS_pixel2x2_top
XopenDVS_pixel2x2_top_832 openDVS_pixel2x2_top_832/vpd[0] openDVS_pixel2x2_top_832/vpd[1]
+ openDVS_pixel2x2_top_832/vpd[3] openDVS_pixel2x2_top_832/vpd[2] rowReadOFF[53] rowReadON[53]
+ rowReadON[52] RefrBp PrBp PrSFBp col_periphery_1x2_0/COL_LINE0 pixRst[0] OffBn rowReadOFF[52]
+ pixRst[1] openDVS_pixel2x2_top_863/GndD DiffBn col_periphery_1x2_0/COL_LINE1 GndD
+ VddA18 OnBn openDVS_pixel2x2_top
XopenDVS_pixel2x2_top_865 openDVS_pixel2x2_top_865/vpd[0] openDVS_pixel2x2_top_865/vpd[1]
+ openDVS_pixel2x2_top_865/vpd[3] openDVS_pixel2x2_top_865/vpd[2] rowReadOFF[55] rowReadON[55]
+ rowReadON[54] RefrBp PrBp PrSFBp col_periphery_1x2_1/COL_LINE0 pixRst[2] OffBn rowReadOFF[54]
+ pixRst[3] openDVS_pixel2x2_top_895/GndD DiffBn col_periphery_1x2_1/COL_LINE1 GndD
+ VddA18 OnBn openDVS_pixel2x2_top
XopenDVS_pixel2x2_top_854 openDVS_pixel2x2_top_854/vpd[0] openDVS_pixel2x2_top_854/vpd[1]
+ openDVS_pixel2x2_top_854/vpd[3] openDVS_pixel2x2_top_854/vpd[2] rowReadOFF[53] rowReadON[53]
+ rowReadON[52] RefrBp PrBp PrSFBp col_periphery_1x2_22/COL_LINE0 pixRst[44] OffBn
+ rowReadOFF[52] pixRst[45] openDVS_pixel2x2_top_863/GndD DiffBn col_periphery_1x2_22/COL_LINE1
+ GndD VddA18 OnBn openDVS_pixel2x2_top
XopenDVS_pixel2x2_top_887 openDVS_pixel2x2_top_887/vpd[0] openDVS_pixel2x2_top_887/vpd[1]
+ openDVS_pixel2x2_top_887/vpd[3] openDVS_pixel2x2_top_887/vpd[2] rowReadOFF[55] rowReadON[55]
+ rowReadON[54] RefrBp PrBp PrSFBp col_periphery_1x2_23/COL_LINE0 pixRst[46] OffBn
+ rowReadOFF[54] pixRst[47] openDVS_pixel2x2_top_895/GndD DiffBn col_periphery_1x2_23/COL_LINE1
+ GndD VddA18 OnBn openDVS_pixel2x2_top
XopenDVS_pixel2x2_top_810 openDVS_pixel2x2_top_810/vpd[0] openDVS_pixel2x2_top_810/vpd[1]
+ openDVS_pixel2x2_top_810/vpd[3] openDVS_pixel2x2_top_810/vpd[2] rowReadOFF[51] rowReadON[51]
+ rowReadON[50] RefrBp PrBp PrSFBp col_periphery_1x2_10/COL_LINE0 pixRst[20] OffBn
+ rowReadOFF[50] pixRst[21] openDVS_pixel2x2_top_831/GndD DiffBn col_periphery_1x2_10/COL_LINE1
+ GndD VddA18 OnBn openDVS_pixel2x2_top
XopenDVS_pixel2x2_top_821 openDVS_pixel2x2_top_821/vpd[0] openDVS_pixel2x2_top_821/vpd[1]
+ openDVS_pixel2x2_top_821/vpd[3] openDVS_pixel2x2_top_821/vpd[2] rowReadOFF[51] rowReadON[51]
+ rowReadON[50] RefrBp PrBp PrSFBp col_periphery_1x2_21/COL_LINE0 pixRst[42] OffBn
+ rowReadOFF[50] pixRst[43] openDVS_pixel2x2_top_831/GndD DiffBn col_periphery_1x2_21/COL_LINE1
+ GndD VddA18 OnBn openDVS_pixel2x2_top
XopenDVS_pixel2x2_top_117 openDVS_pixel2x2_top_117/vpd[0] openDVS_pixel2x2_top_117/vpd[1]
+ openDVS_pixel2x2_top_117/vpd[3] openDVS_pixel2x2_top_117/vpd[2] rowReadOFF[7] rowReadON[7]
+ rowReadON[6] RefrBp PrBp PrSFBp col_periphery_1x2_21/COL_LINE0 pixRst[42] OffBn
+ rowReadOFF[6] pixRst[43] openDVS_pixel2x2_top_99/GndD DiffBn col_periphery_1x2_21/COL_LINE1
+ GndD VddA18 OnBn openDVS_pixel2x2_top
XopenDVS_pixel2x2_top_106 openDVS_pixel2x2_top_106/vpd[0] openDVS_pixel2x2_top_106/vpd[1]
+ openDVS_pixel2x2_top_106/vpd[3] openDVS_pixel2x2_top_106/vpd[2] rowReadOFF[7] rowReadON[7]
+ rowReadON[6] RefrBp PrBp PrSFBp col_periphery_1x2_10/COL_LINE0 pixRst[20] OffBn
+ rowReadOFF[6] pixRst[21] openDVS_pixel2x2_top_99/GndD DiffBn col_periphery_1x2_10/COL_LINE1
+ GndD VddA18 OnBn openDVS_pixel2x2_top
XopenDVS_pixel2x2_top_139 openDVS_pixel2x2_top_139/vpd[0] openDVS_pixel2x2_top_139/vpd[1]
+ openDVS_pixel2x2_top_139/vpd[3] openDVS_pixel2x2_top_139/vpd[2] rowReadOFF[9] rowReadON[9]
+ rowReadON[8] RefrBp PrBp PrSFBp col_periphery_1x2_11/COL_LINE0 pixRst[22] OffBn
+ rowReadOFF[8] pixRst[23] openDVS_pixel2x2_top_159/GndD DiffBn col_periphery_1x2_11/COL_LINE1
+ GndD VddA18 OnBn openDVS_pixel2x2_top
XopenDVS_pixel2x2_top_128 openDVS_pixel2x2_top_128/vpd[0] openDVS_pixel2x2_top_128/vpd[1]
+ openDVS_pixel2x2_top_128/vpd[3] openDVS_pixel2x2_top_128/vpd[2] rowReadOFF[9] rowReadON[9]
+ rowReadON[8] RefrBp PrBp PrSFBp col_periphery_1x2_0/COL_LINE0 pixRst[0] OffBn rowReadOFF[8]
+ pixRst[1] openDVS_pixel2x2_top_159/GndD DiffBn col_periphery_1x2_0/COL_LINE1 GndD
+ VddA18 OnBn openDVS_pixel2x2_top
XopenDVS_pixel2x2_top_662 openDVS_pixel2x2_top_662/vpd[0] openDVS_pixel2x2_top_662/vpd[1]
+ openDVS_pixel2x2_top_662/vpd[3] openDVS_pixel2x2_top_662/vpd[2] rowReadOFF[41] rowReadON[41]
+ rowReadON[40] RefrBp PrBp PrSFBp col_periphery_1x2_22/COL_LINE0 pixRst[44] OffBn
+ rowReadOFF[40] pixRst[45] openDVS_pixel2x2_top_671/GndD DiffBn col_periphery_1x2_22/COL_LINE1
+ GndD VddA18 OnBn openDVS_pixel2x2_top
XopenDVS_pixel2x2_top_651 openDVS_pixel2x2_top_651/vpd[0] openDVS_pixel2x2_top_651/vpd[1]
+ openDVS_pixel2x2_top_651/vpd[3] openDVS_pixel2x2_top_651/vpd[2] rowReadOFF[41] rowReadON[41]
+ rowReadON[40] RefrBp PrBp PrSFBp col_periphery_1x2_11/COL_LINE0 pixRst[22] OffBn
+ rowReadOFF[40] pixRst[23] openDVS_pixel2x2_top_671/GndD DiffBn col_periphery_1x2_11/COL_LINE1
+ GndD VddA18 OnBn openDVS_pixel2x2_top
XopenDVS_pixel2x2_top_1007 openDVS_pixel2x2_top_1007/vpd[0] openDVS_pixel2x2_top_1007/vpd[1]
+ openDVS_pixel2x2_top_1007/vpd[3] openDVS_pixel2x2_top_1007/vpd[2] rowReadOFF[63]
+ rowReadON[63] rowReadON[62] RefrBp PrBp PrSFBp col_periphery_1x2_15/COL_LINE0 pixRst[30]
+ OffBn rowReadOFF[62] pixRst[31] openDVS_pixel2x2_top_999/GndD DiffBn col_periphery_1x2_15/COL_LINE1
+ GndD VddA18 OnBn openDVS_pixel2x2_top
XopenDVS_pixel2x2_top_1018 openDVS_pixel2x2_top_1018/vpd[0] openDVS_pixel2x2_top_1018/vpd[1]
+ openDVS_pixel2x2_top_1018/vpd[3] openDVS_pixel2x2_top_1018/vpd[2] rowReadOFF[63]
+ rowReadON[63] rowReadON[62] RefrBp PrBp PrSFBp col_periphery_1x2_26/COL_LINE0 pixRst[52]
+ OffBn rowReadOFF[62] pixRst[53] openDVS_pixel2x2_top_999/GndD DiffBn col_periphery_1x2_26/COL_LINE1
+ GndD VddA18 OnBn openDVS_pixel2x2_top
XopenDVS_pixel2x2_top_673 openDVS_pixel2x2_top_673/vpd[0] openDVS_pixel2x2_top_673/vpd[1]
+ openDVS_pixel2x2_top_673/vpd[3] openDVS_pixel2x2_top_673/vpd[2] rowReadOFF[43] rowReadON[43]
+ rowReadON[42] RefrBp PrBp PrSFBp col_periphery_1x2_1/COL_LINE0 pixRst[2] OffBn rowReadOFF[42]
+ pixRst[3] openDVS_pixel2x2_top_703/GndD DiffBn col_periphery_1x2_1/COL_LINE1 GndD
+ VddA18 OnBn openDVS_pixel2x2_top
XopenDVS_pixel2x2_top_684 openDVS_pixel2x2_top_684/vpd[0] openDVS_pixel2x2_top_684/vpd[1]
+ openDVS_pixel2x2_top_684/vpd[3] openDVS_pixel2x2_top_684/vpd[2] rowReadOFF[43] rowReadON[43]
+ rowReadON[42] RefrBp PrBp PrSFBp col_periphery_1x2_12/COL_LINE0 pixRst[24] OffBn
+ rowReadOFF[42] pixRst[25] openDVS_pixel2x2_top_703/GndD DiffBn col_periphery_1x2_12/COL_LINE1
+ GndD VddA18 OnBn openDVS_pixel2x2_top
XopenDVS_pixel2x2_top_695 openDVS_pixel2x2_top_695/vpd[0] openDVS_pixel2x2_top_695/vpd[1]
+ openDVS_pixel2x2_top_695/vpd[3] openDVS_pixel2x2_top_695/vpd[2] rowReadOFF[43] rowReadON[43]
+ rowReadON[42] RefrBp PrBp PrSFBp col_periphery_1x2_23/COL_LINE0 pixRst[46] OffBn
+ rowReadOFF[42] pixRst[47] openDVS_pixel2x2_top_703/GndD DiffBn col_periphery_1x2_23/COL_LINE1
+ GndD VddA18 OnBn openDVS_pixel2x2_top
XopenDVS_pixel2x2_top_640 openDVS_pixel2x2_top_640/vpd[0] openDVS_pixel2x2_top_640/vpd[1]
+ openDVS_pixel2x2_top_640/vpd[3] openDVS_pixel2x2_top_640/vpd[2] rowReadOFF[41] rowReadON[41]
+ rowReadON[40] RefrBp PrBp PrSFBp col_periphery_1x2_0/COL_LINE0 pixRst[0] OffBn rowReadOFF[40]
+ pixRst[1] openDVS_pixel2x2_top_671/GndD DiffBn col_periphery_1x2_0/COL_LINE1 GndD
+ VddA18 OnBn openDVS_pixel2x2_top
XopenDVS_pixel2x2_top_470 openDVS_pixel2x2_top_470/vpd[0] openDVS_pixel2x2_top_470/vpd[1]
+ openDVS_pixel2x2_top_470/vpd[3] openDVS_pixel2x2_top_470/vpd[2] rowReadOFF[29] rowReadON[29]
+ rowReadON[28] RefrBp PrBp PrSFBp col_periphery_1x2_22/COL_LINE0 pixRst[44] OffBn
+ rowReadOFF[28] pixRst[45] openDVS_pixel2x2_top_479/GndD DiffBn col_periphery_1x2_22/COL_LINE1
+ GndD VddA18 OnBn openDVS_pixel2x2_top
XopenDVS_pixel2x2_top_492 openDVS_pixel2x2_top_492/vpd[0] openDVS_pixel2x2_top_492/vpd[1]
+ openDVS_pixel2x2_top_492/vpd[3] openDVS_pixel2x2_top_492/vpd[2] rowReadOFF[31] rowReadON[31]
+ rowReadON[30] RefrBp PrBp PrSFBp col_periphery_1x2_12/COL_LINE0 pixRst[24] OffBn
+ rowReadOFF[30] pixRst[25] openDVS_pixel2x2_top_511/GndD DiffBn col_periphery_1x2_12/COL_LINE1
+ GndD VddA18 OnBn openDVS_pixel2x2_top
XopenDVS_pixel2x2_top_481 openDVS_pixel2x2_top_481/vpd[0] openDVS_pixel2x2_top_481/vpd[1]
+ openDVS_pixel2x2_top_481/vpd[3] openDVS_pixel2x2_top_481/vpd[2] rowReadOFF[31] rowReadON[31]
+ rowReadON[30] RefrBp PrBp PrSFBp col_periphery_1x2_1/COL_LINE0 pixRst[2] OffBn rowReadOFF[30]
+ pixRst[3] openDVS_pixel2x2_top_511/GndD DiffBn col_periphery_1x2_1/COL_LINE1 GndD
+ VddA18 OnBn openDVS_pixel2x2_top
XopenDVS_pixel2x2_top_877 openDVS_pixel2x2_top_877/vpd[0] openDVS_pixel2x2_top_877/vpd[1]
+ openDVS_pixel2x2_top_877/vpd[3] openDVS_pixel2x2_top_877/vpd[2] rowReadOFF[55] rowReadON[55]
+ rowReadON[54] RefrBp PrBp PrSFBp col_periphery_1x2_13/COL_LINE0 pixRst[26] OffBn
+ rowReadOFF[54] pixRst[27] openDVS_pixel2x2_top_895/GndD DiffBn col_periphery_1x2_13/COL_LINE1
+ GndD VddA18 OnBn openDVS_pixel2x2_top
XopenDVS_pixel2x2_top_844 openDVS_pixel2x2_top_844/vpd[0] openDVS_pixel2x2_top_844/vpd[1]
+ openDVS_pixel2x2_top_844/vpd[3] openDVS_pixel2x2_top_844/vpd[2] rowReadOFF[53] rowReadON[53]
+ rowReadON[52] RefrBp PrBp PrSFBp col_periphery_1x2_12/COL_LINE0 pixRst[24] OffBn
+ rowReadOFF[52] pixRst[25] openDVS_pixel2x2_top_863/GndD DiffBn col_periphery_1x2_12/COL_LINE1
+ GndD VddA18 OnBn openDVS_pixel2x2_top
XopenDVS_pixel2x2_top_899 openDVS_pixel2x2_top_899/vpd[0] openDVS_pixel2x2_top_899/vpd[1]
+ openDVS_pixel2x2_top_899/vpd[3] openDVS_pixel2x2_top_899/vpd[2] rowReadOFF[57] rowReadON[57]
+ rowReadON[56] RefrBp PrBp PrSFBp col_periphery_1x2_3/COL_LINE0 pixRst[6] OffBn rowReadOFF[56]
+ pixRst[7] openDVS_pixel2x2_top_927/GndD DiffBn col_periphery_1x2_3/COL_LINE1 GndD
+ VddA18 OnBn openDVS_pixel2x2_top
XopenDVS_pixel2x2_top_866 openDVS_pixel2x2_top_866/vpd[0] openDVS_pixel2x2_top_866/vpd[1]
+ openDVS_pixel2x2_top_866/vpd[3] openDVS_pixel2x2_top_866/vpd[2] rowReadOFF[55] rowReadON[55]
+ rowReadON[54] RefrBp PrBp PrSFBp col_periphery_1x2_2/COL_LINE0 pixRst[4] OffBn rowReadOFF[54]
+ pixRst[5] openDVS_pixel2x2_top_895/GndD DiffBn col_periphery_1x2_2/COL_LINE1 GndD
+ VddA18 OnBn openDVS_pixel2x2_top
XopenDVS_pixel2x2_top_833 openDVS_pixel2x2_top_833/vpd[0] openDVS_pixel2x2_top_833/vpd[1]
+ openDVS_pixel2x2_top_833/vpd[3] openDVS_pixel2x2_top_833/vpd[2] rowReadOFF[53] rowReadON[53]
+ rowReadON[52] RefrBp PrBp PrSFBp col_periphery_1x2_1/COL_LINE0 pixRst[2] OffBn rowReadOFF[52]
+ pixRst[3] openDVS_pixel2x2_top_863/GndD DiffBn col_periphery_1x2_1/COL_LINE1 GndD
+ VddA18 OnBn openDVS_pixel2x2_top
XopenDVS_pixel2x2_top_855 openDVS_pixel2x2_top_855/vpd[0] openDVS_pixel2x2_top_855/vpd[1]
+ openDVS_pixel2x2_top_855/vpd[3] openDVS_pixel2x2_top_855/vpd[2] rowReadOFF[53] rowReadON[53]
+ rowReadON[52] RefrBp PrBp PrSFBp col_periphery_1x2_23/COL_LINE0 pixRst[46] OffBn
+ rowReadOFF[52] pixRst[47] openDVS_pixel2x2_top_863/GndD DiffBn col_periphery_1x2_23/COL_LINE1
+ GndD VddA18 OnBn openDVS_pixel2x2_top
XopenDVS_pixel2x2_top_888 openDVS_pixel2x2_top_888/vpd[0] openDVS_pixel2x2_top_888/vpd[1]
+ openDVS_pixel2x2_top_888/vpd[3] openDVS_pixel2x2_top_888/vpd[2] rowReadOFF[55] rowReadON[55]
+ rowReadON[54] RefrBp PrBp PrSFBp col_periphery_1x2_24/COL_LINE0 pixRst[48] OffBn
+ rowReadOFF[54] pixRst[49] openDVS_pixel2x2_top_895/GndD DiffBn col_periphery_1x2_24/COL_LINE1
+ GndD VddA18 OnBn openDVS_pixel2x2_top
XopenDVS_pixel2x2_top_800 openDVS_pixel2x2_top_800/vpd[0] openDVS_pixel2x2_top_800/vpd[1]
+ openDVS_pixel2x2_top_800/vpd[3] openDVS_pixel2x2_top_800/vpd[2] rowReadOFF[51] rowReadON[51]
+ rowReadON[50] RefrBp PrBp PrSFBp col_periphery_1x2_0/COL_LINE0 pixRst[0] OffBn rowReadOFF[50]
+ pixRst[1] openDVS_pixel2x2_top_831/GndD DiffBn col_periphery_1x2_0/COL_LINE1 GndD
+ VddA18 OnBn openDVS_pixel2x2_top
XopenDVS_pixel2x2_top_811 openDVS_pixel2x2_top_811/vpd[0] openDVS_pixel2x2_top_811/vpd[1]
+ openDVS_pixel2x2_top_811/vpd[3] openDVS_pixel2x2_top_811/vpd[2] rowReadOFF[51] rowReadON[51]
+ rowReadON[50] RefrBp PrBp PrSFBp col_periphery_1x2_11/COL_LINE0 pixRst[22] OffBn
+ rowReadOFF[50] pixRst[23] openDVS_pixel2x2_top_831/GndD DiffBn col_periphery_1x2_11/COL_LINE1
+ GndD VddA18 OnBn openDVS_pixel2x2_top
XopenDVS_pixel2x2_top_822 openDVS_pixel2x2_top_822/vpd[0] openDVS_pixel2x2_top_822/vpd[1]
+ openDVS_pixel2x2_top_822/vpd[3] openDVS_pixel2x2_top_822/vpd[2] rowReadOFF[51] rowReadON[51]
+ rowReadON[50] RefrBp PrBp PrSFBp col_periphery_1x2_22/COL_LINE0 pixRst[44] OffBn
+ rowReadOFF[50] pixRst[45] openDVS_pixel2x2_top_831/GndD DiffBn col_periphery_1x2_22/COL_LINE1
+ GndD VddA18 OnBn openDVS_pixel2x2_top
XopenDVS_pixel2x2_top_118 openDVS_pixel2x2_top_118/vpd[0] openDVS_pixel2x2_top_118/vpd[1]
+ openDVS_pixel2x2_top_118/vpd[3] openDVS_pixel2x2_top_118/vpd[2] rowReadOFF[7] rowReadON[7]
+ rowReadON[6] RefrBp PrBp PrSFBp col_periphery_1x2_22/COL_LINE0 pixRst[44] OffBn
+ rowReadOFF[6] pixRst[45] openDVS_pixel2x2_top_99/GndD DiffBn col_periphery_1x2_22/COL_LINE1
+ GndD VddA18 OnBn openDVS_pixel2x2_top
XopenDVS_pixel2x2_top_107 openDVS_pixel2x2_top_107/vpd[0] openDVS_pixel2x2_top_107/vpd[1]
+ openDVS_pixel2x2_top_107/vpd[3] openDVS_pixel2x2_top_107/vpd[2] rowReadOFF[7] rowReadON[7]
+ rowReadON[6] RefrBp PrBp PrSFBp col_periphery_1x2_11/COL_LINE0 pixRst[22] OffBn
+ rowReadOFF[6] pixRst[23] openDVS_pixel2x2_top_99/GndD DiffBn col_periphery_1x2_11/COL_LINE1
+ GndD VddA18 OnBn openDVS_pixel2x2_top
XopenDVS_pixel2x2_top_129 openDVS_pixel2x2_top_129/vpd[0] openDVS_pixel2x2_top_129/vpd[1]
+ openDVS_pixel2x2_top_129/vpd[3] openDVS_pixel2x2_top_129/vpd[2] rowReadOFF[9] rowReadON[9]
+ rowReadON[8] RefrBp PrBp PrSFBp col_periphery_1x2_1/COL_LINE0 pixRst[2] OffBn rowReadOFF[8]
+ pixRst[3] openDVS_pixel2x2_top_159/GndD DiffBn col_periphery_1x2_1/COL_LINE1 GndD
+ VddA18 OnBn openDVS_pixel2x2_top
XopenDVS_pixel2x2_top_663 openDVS_pixel2x2_top_663/vpd[0] openDVS_pixel2x2_top_663/vpd[1]
+ openDVS_pixel2x2_top_663/vpd[3] openDVS_pixel2x2_top_663/vpd[2] rowReadOFF[41] rowReadON[41]
+ rowReadON[40] RefrBp PrBp PrSFBp col_periphery_1x2_23/COL_LINE0 pixRst[46] OffBn
+ rowReadOFF[40] pixRst[47] openDVS_pixel2x2_top_671/GndD DiffBn col_periphery_1x2_23/COL_LINE1
+ GndD VddA18 OnBn openDVS_pixel2x2_top
XopenDVS_pixel2x2_top_630 openDVS_pixel2x2_top_630/vpd[0] openDVS_pixel2x2_top_630/vpd[1]
+ openDVS_pixel2x2_top_630/vpd[3] openDVS_pixel2x2_top_630/vpd[2] rowReadOFF[39] rowReadON[39]
+ rowReadON[38] RefrBp PrBp PrSFBp col_periphery_1x2_22/COL_LINE0 pixRst[44] OffBn
+ rowReadOFF[38] pixRst[45] openDVS_pixel2x2_top_639/GndD DiffBn col_periphery_1x2_22/COL_LINE1
+ GndD VddA18 OnBn openDVS_pixel2x2_top
XopenDVS_pixel2x2_top_652 openDVS_pixel2x2_top_652/vpd[0] openDVS_pixel2x2_top_652/vpd[1]
+ openDVS_pixel2x2_top_652/vpd[3] openDVS_pixel2x2_top_652/vpd[2] rowReadOFF[41] rowReadON[41]
+ rowReadON[40] RefrBp PrBp PrSFBp col_periphery_1x2_12/COL_LINE0 pixRst[24] OffBn
+ rowReadOFF[40] pixRst[25] openDVS_pixel2x2_top_671/GndD DiffBn col_periphery_1x2_12/COL_LINE1
+ GndD VddA18 OnBn openDVS_pixel2x2_top
XopenDVS_pixel2x2_top_1008 openDVS_pixel2x2_top_1008/vpd[0] openDVS_pixel2x2_top_1008/vpd[1]
+ openDVS_pixel2x2_top_1008/vpd[3] openDVS_pixel2x2_top_1008/vpd[2] rowReadOFF[63]
+ rowReadON[63] rowReadON[62] RefrBp PrBp PrSFBp col_periphery_1x2_16/COL_LINE0 pixRst[32]
+ OffBn rowReadOFF[62] pixRst[33] openDVS_pixel2x2_top_999/GndD DiffBn col_periphery_1x2_16/COL_LINE1
+ GndD VddA18 OnBn openDVS_pixel2x2_top
XopenDVS_pixel2x2_top_1019 openDVS_pixel2x2_top_1019/vpd[0] openDVS_pixel2x2_top_1019/vpd[1]
+ openDVS_pixel2x2_top_1019/vpd[3] openDVS_pixel2x2_top_1019/vpd[2] rowReadOFF[63]
+ rowReadON[63] rowReadON[62] RefrBp PrBp PrSFBp col_periphery_1x2_27/COL_LINE0 pixRst[54]
+ OffBn rowReadOFF[62] pixRst[55] openDVS_pixel2x2_top_999/GndD DiffBn col_periphery_1x2_27/COL_LINE1
+ GndD VddA18 OnBn openDVS_pixel2x2_top
XopenDVS_pixel2x2_top_674 openDVS_pixel2x2_top_674/vpd[0] openDVS_pixel2x2_top_674/vpd[1]
+ openDVS_pixel2x2_top_674/vpd[3] openDVS_pixel2x2_top_674/vpd[2] rowReadOFF[43] rowReadON[43]
+ rowReadON[42] RefrBp PrBp PrSFBp col_periphery_1x2_2/COL_LINE0 pixRst[4] OffBn rowReadOFF[42]
+ pixRst[5] openDVS_pixel2x2_top_703/GndD DiffBn col_periphery_1x2_2/COL_LINE1 GndD
+ VddA18 OnBn openDVS_pixel2x2_top
XopenDVS_pixel2x2_top_685 openDVS_pixel2x2_top_685/vpd[0] openDVS_pixel2x2_top_685/vpd[1]
+ openDVS_pixel2x2_top_685/vpd[3] openDVS_pixel2x2_top_685/vpd[2] rowReadOFF[43] rowReadON[43]
+ rowReadON[42] RefrBp PrBp PrSFBp col_periphery_1x2_13/COL_LINE0 pixRst[26] OffBn
+ rowReadOFF[42] pixRst[27] openDVS_pixel2x2_top_703/GndD DiffBn col_periphery_1x2_13/COL_LINE1
+ GndD VddA18 OnBn openDVS_pixel2x2_top
XopenDVS_pixel2x2_top_696 openDVS_pixel2x2_top_696/vpd[0] openDVS_pixel2x2_top_696/vpd[1]
+ openDVS_pixel2x2_top_696/vpd[3] openDVS_pixel2x2_top_696/vpd[2] rowReadOFF[43] rowReadON[43]
+ rowReadON[42] RefrBp PrBp PrSFBp col_periphery_1x2_24/COL_LINE0 pixRst[48] OffBn
+ rowReadOFF[42] pixRst[49] openDVS_pixel2x2_top_703/GndD DiffBn col_periphery_1x2_24/COL_LINE1
+ GndD VddA18 OnBn openDVS_pixel2x2_top
XopenDVS_pixel2x2_top_641 openDVS_pixel2x2_top_641/vpd[0] openDVS_pixel2x2_top_641/vpd[1]
+ openDVS_pixel2x2_top_641/vpd[3] openDVS_pixel2x2_top_641/vpd[2] rowReadOFF[41] rowReadON[41]
+ rowReadON[40] RefrBp PrBp PrSFBp col_periphery_1x2_1/COL_LINE0 pixRst[2] OffBn rowReadOFF[40]
+ pixRst[3] openDVS_pixel2x2_top_671/GndD DiffBn col_periphery_1x2_1/COL_LINE1 GndD
+ VddA18 OnBn openDVS_pixel2x2_top
XopenDVS_pixel2x2_top_0 openDVS_pixel2x2_top_0/vpd[0] openDVS_pixel2x2_top_0/vpd[1]
+ openDVS_pixel2x2_top_0/vpd[3] openDVS_pixel2x2_top_0/vpd[2] rowReadOFF[1] rowReadON[1]
+ rowReadON[0] RefrBp PrBp PrSFBp col_periphery_1x2_0/COL_LINE0 pixRst[0] OffBn rowReadOFF[0]
+ pixRst[1] openDVS_pixel2x2_top_9/GndD DiffBn col_periphery_1x2_0/COL_LINE1 GndD
+ VddA18 OnBn openDVS_pixel2x2_top
XopenDVS_pixel2x2_top_471 openDVS_pixel2x2_top_471/vpd[0] openDVS_pixel2x2_top_471/vpd[1]
+ openDVS_pixel2x2_top_471/vpd[3] openDVS_pixel2x2_top_471/vpd[2] rowReadOFF[29] rowReadON[29]
+ rowReadON[28] RefrBp PrBp PrSFBp col_periphery_1x2_23/COL_LINE0 pixRst[46] OffBn
+ rowReadOFF[28] pixRst[47] openDVS_pixel2x2_top_479/GndD DiffBn col_periphery_1x2_23/COL_LINE1
+ GndD VddA18 OnBn openDVS_pixel2x2_top
XopenDVS_pixel2x2_top_493 openDVS_pixel2x2_top_493/vpd[0] openDVS_pixel2x2_top_493/vpd[1]
+ openDVS_pixel2x2_top_493/vpd[3] openDVS_pixel2x2_top_493/vpd[2] rowReadOFF[31] rowReadON[31]
+ rowReadON[30] RefrBp PrBp PrSFBp col_periphery_1x2_13/COL_LINE0 pixRst[26] OffBn
+ rowReadOFF[30] pixRst[27] openDVS_pixel2x2_top_511/GndD DiffBn col_periphery_1x2_13/COL_LINE1
+ GndD VddA18 OnBn openDVS_pixel2x2_top
XopenDVS_pixel2x2_top_460 openDVS_pixel2x2_top_460/vpd[0] openDVS_pixel2x2_top_460/vpd[1]
+ openDVS_pixel2x2_top_460/vpd[3] openDVS_pixel2x2_top_460/vpd[2] rowReadOFF[29] rowReadON[29]
+ rowReadON[28] RefrBp PrBp PrSFBp col_periphery_1x2_12/COL_LINE0 pixRst[24] OffBn
+ rowReadOFF[28] pixRst[25] openDVS_pixel2x2_top_479/GndD DiffBn col_periphery_1x2_12/COL_LINE1
+ GndD VddA18 OnBn openDVS_pixel2x2_top
XopenDVS_pixel2x2_top_482 openDVS_pixel2x2_top_482/vpd[0] openDVS_pixel2x2_top_482/vpd[1]
+ openDVS_pixel2x2_top_482/vpd[3] openDVS_pixel2x2_top_482/vpd[2] rowReadOFF[31] rowReadON[31]
+ rowReadON[30] RefrBp PrBp PrSFBp col_periphery_1x2_2/COL_LINE0 pixRst[4] OffBn rowReadOFF[30]
+ pixRst[5] openDVS_pixel2x2_top_511/GndD DiffBn col_periphery_1x2_2/COL_LINE1 GndD
+ VddA18 OnBn openDVS_pixel2x2_top
XopenDVS_pixel2x2_top_290 openDVS_pixel2x2_top_290/vpd[0] openDVS_pixel2x2_top_290/vpd[1]
+ openDVS_pixel2x2_top_290/vpd[3] openDVS_pixel2x2_top_290/vpd[2] rowReadOFF[19] rowReadON[19]
+ rowReadON[18] RefrBp PrBp PrSFBp col_periphery_1x2_2/COL_LINE0 pixRst[4] OffBn rowReadOFF[18]
+ pixRst[5] openDVS_pixel2x2_top_319/GndD DiffBn col_periphery_1x2_2/COL_LINE1 GndD
+ VddA18 OnBn openDVS_pixel2x2_top
XopenDVS_pixel2x2_top_878 openDVS_pixel2x2_top_878/vpd[0] openDVS_pixel2x2_top_878/vpd[1]
+ openDVS_pixel2x2_top_878/vpd[3] openDVS_pixel2x2_top_878/vpd[2] rowReadOFF[55] rowReadON[55]
+ rowReadON[54] RefrBp PrBp PrSFBp col_periphery_1x2_14/COL_LINE0 pixRst[28] OffBn
+ rowReadOFF[54] pixRst[29] openDVS_pixel2x2_top_895/GndD DiffBn col_periphery_1x2_14/COL_LINE1
+ GndD VddA18 OnBn openDVS_pixel2x2_top
XopenDVS_pixel2x2_top_845 openDVS_pixel2x2_top_845/vpd[0] openDVS_pixel2x2_top_845/vpd[1]
+ openDVS_pixel2x2_top_845/vpd[3] openDVS_pixel2x2_top_845/vpd[2] rowReadOFF[53] rowReadON[53]
+ rowReadON[52] RefrBp PrBp PrSFBp col_periphery_1x2_13/COL_LINE0 pixRst[26] OffBn
+ rowReadOFF[52] pixRst[27] openDVS_pixel2x2_top_863/GndD DiffBn col_periphery_1x2_13/COL_LINE1
+ GndD VddA18 OnBn openDVS_pixel2x2_top
XopenDVS_pixel2x2_top_867 openDVS_pixel2x2_top_867/vpd[0] openDVS_pixel2x2_top_867/vpd[1]
+ openDVS_pixel2x2_top_867/vpd[3] openDVS_pixel2x2_top_867/vpd[2] rowReadOFF[55] rowReadON[55]
+ rowReadON[54] RefrBp PrBp PrSFBp col_periphery_1x2_3/COL_LINE0 pixRst[6] OffBn rowReadOFF[54]
+ pixRst[7] openDVS_pixel2x2_top_895/GndD DiffBn col_periphery_1x2_3/COL_LINE1 GndD
+ VddA18 OnBn openDVS_pixel2x2_top
XopenDVS_pixel2x2_top_834 openDVS_pixel2x2_top_834/vpd[0] openDVS_pixel2x2_top_834/vpd[1]
+ openDVS_pixel2x2_top_834/vpd[3] openDVS_pixel2x2_top_834/vpd[2] rowReadOFF[53] rowReadON[53]
+ rowReadON[52] RefrBp PrBp PrSFBp col_periphery_1x2_2/COL_LINE0 pixRst[4] OffBn rowReadOFF[52]
+ pixRst[5] openDVS_pixel2x2_top_863/GndD DiffBn col_periphery_1x2_2/COL_LINE1 GndD
+ VddA18 OnBn openDVS_pixel2x2_top
XopenDVS_pixel2x2_top_856 openDVS_pixel2x2_top_856/vpd[0] openDVS_pixel2x2_top_856/vpd[1]
+ openDVS_pixel2x2_top_856/vpd[3] openDVS_pixel2x2_top_856/vpd[2] rowReadOFF[53] rowReadON[53]
+ rowReadON[52] RefrBp PrBp PrSFBp col_periphery_1x2_24/COL_LINE0 pixRst[48] OffBn
+ rowReadOFF[52] pixRst[49] openDVS_pixel2x2_top_863/GndD DiffBn col_periphery_1x2_24/COL_LINE1
+ GndD VddA18 OnBn openDVS_pixel2x2_top
XopenDVS_pixel2x2_top_889 openDVS_pixel2x2_top_889/vpd[0] openDVS_pixel2x2_top_889/vpd[1]
+ openDVS_pixel2x2_top_889/vpd[3] openDVS_pixel2x2_top_889/vpd[2] rowReadOFF[55] rowReadON[55]
+ rowReadON[54] RefrBp PrBp PrSFBp col_periphery_1x2_25/COL_LINE0 pixRst[50] OffBn
+ rowReadOFF[54] pixRst[51] openDVS_pixel2x2_top_895/GndD DiffBn col_periphery_1x2_25/COL_LINE1
+ GndD VddA18 OnBn openDVS_pixel2x2_top
XopenDVS_pixel2x2_top_801 openDVS_pixel2x2_top_801/vpd[0] openDVS_pixel2x2_top_801/vpd[1]
+ openDVS_pixel2x2_top_801/vpd[3] openDVS_pixel2x2_top_801/vpd[2] rowReadOFF[51] rowReadON[51]
+ rowReadON[50] RefrBp PrBp PrSFBp col_periphery_1x2_1/COL_LINE0 pixRst[2] OffBn rowReadOFF[50]
+ pixRst[3] openDVS_pixel2x2_top_831/GndD DiffBn col_periphery_1x2_1/COL_LINE1 GndD
+ VddA18 OnBn openDVS_pixel2x2_top
XopenDVS_pixel2x2_top_812 openDVS_pixel2x2_top_812/vpd[0] openDVS_pixel2x2_top_812/vpd[1]
+ openDVS_pixel2x2_top_812/vpd[3] openDVS_pixel2x2_top_812/vpd[2] rowReadOFF[51] rowReadON[51]
+ rowReadON[50] RefrBp PrBp PrSFBp col_periphery_1x2_12/COL_LINE0 pixRst[24] OffBn
+ rowReadOFF[50] pixRst[25] openDVS_pixel2x2_top_831/GndD DiffBn col_periphery_1x2_12/COL_LINE1
+ GndD VddA18 OnBn openDVS_pixel2x2_top
XopenDVS_pixel2x2_top_823 openDVS_pixel2x2_top_823/vpd[0] openDVS_pixel2x2_top_823/vpd[1]
+ openDVS_pixel2x2_top_823/vpd[3] openDVS_pixel2x2_top_823/vpd[2] rowReadOFF[51] rowReadON[51]
+ rowReadON[50] RefrBp PrBp PrSFBp col_periphery_1x2_23/COL_LINE0 pixRst[46] OffBn
+ rowReadOFF[50] pixRst[47] openDVS_pixel2x2_top_831/GndD DiffBn col_periphery_1x2_23/COL_LINE1
+ GndD VddA18 OnBn openDVS_pixel2x2_top
XopenDVS_pixel2x2_top_119 openDVS_pixel2x2_top_119/vpd[0] openDVS_pixel2x2_top_119/vpd[1]
+ openDVS_pixel2x2_top_119/vpd[3] openDVS_pixel2x2_top_119/vpd[2] rowReadOFF[7] rowReadON[7]
+ rowReadON[6] RefrBp PrBp PrSFBp col_periphery_1x2_23/COL_LINE0 pixRst[46] OffBn
+ rowReadOFF[6] pixRst[47] openDVS_pixel2x2_top_99/GndD DiffBn col_periphery_1x2_23/COL_LINE1
+ GndD VddA18 OnBn openDVS_pixel2x2_top
XopenDVS_pixel2x2_top_108 openDVS_pixel2x2_top_108/vpd[0] openDVS_pixel2x2_top_108/vpd[1]
+ openDVS_pixel2x2_top_108/vpd[3] openDVS_pixel2x2_top_108/vpd[2] rowReadOFF[7] rowReadON[7]
+ rowReadON[6] RefrBp PrBp PrSFBp col_periphery_1x2_12/COL_LINE0 pixRst[24] OffBn
+ rowReadOFF[6] pixRst[25] openDVS_pixel2x2_top_99/GndD DiffBn col_periphery_1x2_12/COL_LINE1
+ GndD VddA18 OnBn openDVS_pixel2x2_top
XopenDVS_pixel2x2_top_664 openDVS_pixel2x2_top_664/vpd[0] openDVS_pixel2x2_top_664/vpd[1]
+ openDVS_pixel2x2_top_664/vpd[3] openDVS_pixel2x2_top_664/vpd[2] rowReadOFF[41] rowReadON[41]
+ rowReadON[40] RefrBp PrBp PrSFBp col_periphery_1x2_24/COL_LINE0 pixRst[48] OffBn
+ rowReadOFF[40] pixRst[49] openDVS_pixel2x2_top_671/GndD DiffBn col_periphery_1x2_24/COL_LINE1
+ GndD VddA18 OnBn openDVS_pixel2x2_top
XopenDVS_pixel2x2_top_631 openDVS_pixel2x2_top_631/vpd[0] openDVS_pixel2x2_top_631/vpd[1]
+ openDVS_pixel2x2_top_631/vpd[3] openDVS_pixel2x2_top_631/vpd[2] rowReadOFF[39] rowReadON[39]
+ rowReadON[38] RefrBp PrBp PrSFBp col_periphery_1x2_23/COL_LINE0 pixRst[46] OffBn
+ rowReadOFF[38] pixRst[47] openDVS_pixel2x2_top_639/GndD DiffBn col_periphery_1x2_23/COL_LINE1
+ GndD VddA18 OnBn openDVS_pixel2x2_top
XopenDVS_pixel2x2_top_653 openDVS_pixel2x2_top_653/vpd[0] openDVS_pixel2x2_top_653/vpd[1]
+ openDVS_pixel2x2_top_653/vpd[3] openDVS_pixel2x2_top_653/vpd[2] rowReadOFF[41] rowReadON[41]
+ rowReadON[40] RefrBp PrBp PrSFBp col_periphery_1x2_13/COL_LINE0 pixRst[26] OffBn
+ rowReadOFF[40] pixRst[27] openDVS_pixel2x2_top_671/GndD DiffBn col_periphery_1x2_13/COL_LINE1
+ GndD VddA18 OnBn openDVS_pixel2x2_top
XopenDVS_pixel2x2_top_620 openDVS_pixel2x2_top_620/vpd[0] openDVS_pixel2x2_top_620/vpd[1]
+ openDVS_pixel2x2_top_620/vpd[3] openDVS_pixel2x2_top_620/vpd[2] rowReadOFF[39] rowReadON[39]
+ rowReadON[38] RefrBp PrBp PrSFBp col_periphery_1x2_12/COL_LINE0 pixRst[24] OffBn
+ rowReadOFF[38] pixRst[25] openDVS_pixel2x2_top_639/GndD DiffBn col_periphery_1x2_12/COL_LINE1
+ GndD VddA18 OnBn openDVS_pixel2x2_top
XopenDVS_pixel2x2_top_675 openDVS_pixel2x2_top_675/vpd[0] openDVS_pixel2x2_top_675/vpd[1]
+ openDVS_pixel2x2_top_675/vpd[3] openDVS_pixel2x2_top_675/vpd[2] rowReadOFF[43] rowReadON[43]
+ rowReadON[42] RefrBp PrBp PrSFBp col_periphery_1x2_3/COL_LINE0 pixRst[6] OffBn rowReadOFF[42]
+ pixRst[7] openDVS_pixel2x2_top_703/GndD DiffBn col_periphery_1x2_3/COL_LINE1 GndD
+ VddA18 OnBn openDVS_pixel2x2_top
XopenDVS_pixel2x2_top_686 openDVS_pixel2x2_top_686/vpd[0] openDVS_pixel2x2_top_686/vpd[1]
+ openDVS_pixel2x2_top_686/vpd[3] openDVS_pixel2x2_top_686/vpd[2] rowReadOFF[43] rowReadON[43]
+ rowReadON[42] RefrBp PrBp PrSFBp col_periphery_1x2_14/COL_LINE0 pixRst[28] OffBn
+ rowReadOFF[42] pixRst[29] openDVS_pixel2x2_top_703/GndD DiffBn col_periphery_1x2_14/COL_LINE1
+ GndD VddA18 OnBn openDVS_pixel2x2_top
XopenDVS_pixel2x2_top_697 openDVS_pixel2x2_top_697/vpd[0] openDVS_pixel2x2_top_697/vpd[1]
+ openDVS_pixel2x2_top_697/vpd[3] openDVS_pixel2x2_top_697/vpd[2] rowReadOFF[43] rowReadON[43]
+ rowReadON[42] RefrBp PrBp PrSFBp col_periphery_1x2_25/COL_LINE0 pixRst[50] OffBn
+ rowReadOFF[42] pixRst[51] openDVS_pixel2x2_top_703/GndD DiffBn col_periphery_1x2_25/COL_LINE1
+ GndD VddA18 OnBn openDVS_pixel2x2_top
XopenDVS_pixel2x2_top_642 openDVS_pixel2x2_top_642/vpd[0] openDVS_pixel2x2_top_642/vpd[1]
+ openDVS_pixel2x2_top_642/vpd[3] openDVS_pixel2x2_top_642/vpd[2] rowReadOFF[41] rowReadON[41]
+ rowReadON[40] RefrBp PrBp PrSFBp col_periphery_1x2_2/COL_LINE0 pixRst[4] OffBn rowReadOFF[40]
+ pixRst[5] openDVS_pixel2x2_top_671/GndD DiffBn col_periphery_1x2_2/COL_LINE1 GndD
+ VddA18 OnBn openDVS_pixel2x2_top
XopenDVS_pixel2x2_top_1009 openDVS_pixel2x2_top_1009/vpd[0] openDVS_pixel2x2_top_1009/vpd[1]
+ openDVS_pixel2x2_top_1009/vpd[3] openDVS_pixel2x2_top_1009/vpd[2] rowReadOFF[63]
+ rowReadON[63] rowReadON[62] RefrBp PrBp PrSFBp col_periphery_1x2_17/COL_LINE0 pixRst[34]
+ OffBn rowReadOFF[62] pixRst[35] openDVS_pixel2x2_top_999/GndD DiffBn col_periphery_1x2_17/COL_LINE1
+ GndD VddA18 OnBn openDVS_pixel2x2_top
XopenDVS_pixel2x2_top_1 openDVS_pixel2x2_top_1/vpd[0] openDVS_pixel2x2_top_1/vpd[1]
+ openDVS_pixel2x2_top_1/vpd[3] openDVS_pixel2x2_top_1/vpd[2] rowReadOFF[1] rowReadON[1]
+ rowReadON[0] RefrBp PrBp PrSFBp col_periphery_1x2_1/COL_LINE0 pixRst[2] OffBn rowReadOFF[0]
+ pixRst[3] openDVS_pixel2x2_top_9/GndD DiffBn col_periphery_1x2_1/COL_LINE1 GndD
+ VddA18 OnBn openDVS_pixel2x2_top
XopenDVS_pixel2x2_top_472 openDVS_pixel2x2_top_472/vpd[0] openDVS_pixel2x2_top_472/vpd[1]
+ openDVS_pixel2x2_top_472/vpd[3] openDVS_pixel2x2_top_472/vpd[2] rowReadOFF[29] rowReadON[29]
+ rowReadON[28] RefrBp PrBp PrSFBp col_periphery_1x2_24/COL_LINE0 pixRst[48] OffBn
+ rowReadOFF[28] pixRst[49] openDVS_pixel2x2_top_479/GndD DiffBn col_periphery_1x2_24/COL_LINE1
+ GndD VddA18 OnBn openDVS_pixel2x2_top
XopenDVS_pixel2x2_top_494 openDVS_pixel2x2_top_494/vpd[0] openDVS_pixel2x2_top_494/vpd[1]
+ openDVS_pixel2x2_top_494/vpd[3] openDVS_pixel2x2_top_494/vpd[2] rowReadOFF[31] rowReadON[31]
+ rowReadON[30] RefrBp PrBp PrSFBp col_periphery_1x2_14/COL_LINE0 pixRst[28] OffBn
+ rowReadOFF[30] pixRst[29] openDVS_pixel2x2_top_511/GndD DiffBn col_periphery_1x2_14/COL_LINE1
+ GndD VddA18 OnBn openDVS_pixel2x2_top
XopenDVS_pixel2x2_top_461 openDVS_pixel2x2_top_461/vpd[0] openDVS_pixel2x2_top_461/vpd[1]
+ openDVS_pixel2x2_top_461/vpd[3] openDVS_pixel2x2_top_461/vpd[2] rowReadOFF[29] rowReadON[29]
+ rowReadON[28] RefrBp PrBp PrSFBp col_periphery_1x2_13/COL_LINE0 pixRst[26] OffBn
+ rowReadOFF[28] pixRst[27] openDVS_pixel2x2_top_479/GndD DiffBn col_periphery_1x2_13/COL_LINE1
+ GndD VddA18 OnBn openDVS_pixel2x2_top
XopenDVS_pixel2x2_top_483 openDVS_pixel2x2_top_483/vpd[0] openDVS_pixel2x2_top_483/vpd[1]
+ openDVS_pixel2x2_top_483/vpd[3] openDVS_pixel2x2_top_483/vpd[2] rowReadOFF[31] rowReadON[31]
+ rowReadON[30] RefrBp PrBp PrSFBp col_periphery_1x2_3/COL_LINE0 pixRst[6] OffBn rowReadOFF[30]
+ pixRst[7] openDVS_pixel2x2_top_511/GndD DiffBn col_periphery_1x2_3/COL_LINE1 GndD
+ VddA18 OnBn openDVS_pixel2x2_top
XopenDVS_pixel2x2_top_450 openDVS_pixel2x2_top_450/vpd[0] openDVS_pixel2x2_top_450/vpd[1]
+ openDVS_pixel2x2_top_450/vpd[3] openDVS_pixel2x2_top_450/vpd[2] rowReadOFF[29] rowReadON[29]
+ rowReadON[28] RefrBp PrBp PrSFBp col_periphery_1x2_2/COL_LINE0 pixRst[4] OffBn rowReadOFF[28]
+ pixRst[5] openDVS_pixel2x2_top_479/GndD DiffBn col_periphery_1x2_2/COL_LINE1 GndD
+ VddA18 OnBn openDVS_pixel2x2_top
XopenDVS_pixel2x2_top_280 openDVS_pixel2x2_top_280/vpd[0] openDVS_pixel2x2_top_280/vpd[1]
+ openDVS_pixel2x2_top_280/vpd[3] openDVS_pixel2x2_top_280/vpd[2] rowReadOFF[17] rowReadON[17]
+ rowReadON[16] RefrBp PrBp PrSFBp col_periphery_1x2_24/COL_LINE0 pixRst[48] OffBn
+ rowReadOFF[16] pixRst[49] openDVS_pixel2x2_top_287/GndD DiffBn col_periphery_1x2_24/COL_LINE1
+ GndD VddA18 OnBn openDVS_pixel2x2_top
XopenDVS_pixel2x2_top_291 openDVS_pixel2x2_top_291/vpd[0] openDVS_pixel2x2_top_291/vpd[1]
+ openDVS_pixel2x2_top_291/vpd[3] openDVS_pixel2x2_top_291/vpd[2] rowReadOFF[19] rowReadON[19]
+ rowReadON[18] RefrBp PrBp PrSFBp col_periphery_1x2_3/COL_LINE0 pixRst[6] OffBn rowReadOFF[18]
+ pixRst[7] openDVS_pixel2x2_top_319/GndD DiffBn col_periphery_1x2_3/COL_LINE1 GndD
+ VddA18 OnBn openDVS_pixel2x2_top
XopenDVS_pixel2x2_top_879 openDVS_pixel2x2_top_879/vpd[0] openDVS_pixel2x2_top_879/vpd[1]
+ openDVS_pixel2x2_top_879/vpd[3] openDVS_pixel2x2_top_879/vpd[2] rowReadOFF[55] rowReadON[55]
+ rowReadON[54] RefrBp PrBp PrSFBp col_periphery_1x2_15/COL_LINE0 pixRst[30] OffBn
+ rowReadOFF[54] pixRst[31] openDVS_pixel2x2_top_895/GndD DiffBn col_periphery_1x2_15/COL_LINE1
+ GndD VddA18 OnBn openDVS_pixel2x2_top
XopenDVS_pixel2x2_top_846 openDVS_pixel2x2_top_846/vpd[0] openDVS_pixel2x2_top_846/vpd[1]
+ openDVS_pixel2x2_top_846/vpd[3] openDVS_pixel2x2_top_846/vpd[2] rowReadOFF[53] rowReadON[53]
+ rowReadON[52] RefrBp PrBp PrSFBp col_periphery_1x2_14/COL_LINE0 pixRst[28] OffBn
+ rowReadOFF[52] pixRst[29] openDVS_pixel2x2_top_863/GndD DiffBn col_periphery_1x2_14/COL_LINE1
+ GndD VddA18 OnBn openDVS_pixel2x2_top
XopenDVS_pixel2x2_top_868 openDVS_pixel2x2_top_868/vpd[0] openDVS_pixel2x2_top_868/vpd[1]
+ openDVS_pixel2x2_top_868/vpd[3] openDVS_pixel2x2_top_868/vpd[2] rowReadOFF[55] rowReadON[55]
+ rowReadON[54] RefrBp PrBp PrSFBp col_periphery_1x2_4/COL_LINE0 pixRst[8] OffBn rowReadOFF[54]
+ pixRst[9] openDVS_pixel2x2_top_895/GndD DiffBn col_periphery_1x2_4/COL_LINE1 GndD
+ VddA18 OnBn openDVS_pixel2x2_top
XopenDVS_pixel2x2_top_835 openDVS_pixel2x2_top_835/vpd[0] openDVS_pixel2x2_top_835/vpd[1]
+ openDVS_pixel2x2_top_835/vpd[3] openDVS_pixel2x2_top_835/vpd[2] rowReadOFF[53] rowReadON[53]
+ rowReadON[52] RefrBp PrBp PrSFBp col_periphery_1x2_3/COL_LINE0 pixRst[6] OffBn rowReadOFF[52]
+ pixRst[7] openDVS_pixel2x2_top_863/GndD DiffBn col_periphery_1x2_3/COL_LINE1 GndD
+ VddA18 OnBn openDVS_pixel2x2_top
XopenDVS_pixel2x2_top_857 openDVS_pixel2x2_top_857/vpd[0] openDVS_pixel2x2_top_857/vpd[1]
+ openDVS_pixel2x2_top_857/vpd[3] openDVS_pixel2x2_top_857/vpd[2] rowReadOFF[53] rowReadON[53]
+ rowReadON[52] RefrBp PrBp PrSFBp col_periphery_1x2_25/COL_LINE0 pixRst[50] OffBn
+ rowReadOFF[52] pixRst[51] openDVS_pixel2x2_top_863/GndD DiffBn col_periphery_1x2_25/COL_LINE1
+ GndD VddA18 OnBn openDVS_pixel2x2_top
XopenDVS_pixel2x2_top_802 openDVS_pixel2x2_top_802/vpd[0] openDVS_pixel2x2_top_802/vpd[1]
+ openDVS_pixel2x2_top_802/vpd[3] openDVS_pixel2x2_top_802/vpd[2] rowReadOFF[51] rowReadON[51]
+ rowReadON[50] RefrBp PrBp PrSFBp col_periphery_1x2_2/COL_LINE0 pixRst[4] OffBn rowReadOFF[50]
+ pixRst[5] openDVS_pixel2x2_top_831/GndD DiffBn col_periphery_1x2_2/COL_LINE1 GndD
+ VddA18 OnBn openDVS_pixel2x2_top
XopenDVS_pixel2x2_top_813 openDVS_pixel2x2_top_813/vpd[0] openDVS_pixel2x2_top_813/vpd[1]
+ openDVS_pixel2x2_top_813/vpd[3] openDVS_pixel2x2_top_813/vpd[2] rowReadOFF[51] rowReadON[51]
+ rowReadON[50] RefrBp PrBp PrSFBp col_periphery_1x2_13/COL_LINE0 pixRst[26] OffBn
+ rowReadOFF[50] pixRst[27] openDVS_pixel2x2_top_831/GndD DiffBn col_periphery_1x2_13/COL_LINE1
+ GndD VddA18 OnBn openDVS_pixel2x2_top
XopenDVS_pixel2x2_top_824 openDVS_pixel2x2_top_824/vpd[0] openDVS_pixel2x2_top_824/vpd[1]
+ openDVS_pixel2x2_top_824/vpd[3] openDVS_pixel2x2_top_824/vpd[2] rowReadOFF[51] rowReadON[51]
+ rowReadON[50] RefrBp PrBp PrSFBp col_periphery_1x2_24/COL_LINE0 pixRst[48] OffBn
+ rowReadOFF[50] pixRst[49] openDVS_pixel2x2_top_831/GndD DiffBn col_periphery_1x2_24/COL_LINE1
+ GndD VddA18 OnBn openDVS_pixel2x2_top
XopenDVS_pixel2x2_top_109 openDVS_pixel2x2_top_109/vpd[0] openDVS_pixel2x2_top_109/vpd[1]
+ openDVS_pixel2x2_top_109/vpd[3] openDVS_pixel2x2_top_109/vpd[2] rowReadOFF[7] rowReadON[7]
+ rowReadON[6] RefrBp PrBp PrSFBp col_periphery_1x2_13/COL_LINE0 pixRst[26] OffBn
+ rowReadOFF[6] pixRst[27] openDVS_pixel2x2_top_99/GndD DiffBn col_periphery_1x2_13/COL_LINE1
+ GndD VddA18 OnBn openDVS_pixel2x2_top
XopenDVS_pixel2x2_top_665 openDVS_pixel2x2_top_665/vpd[0] openDVS_pixel2x2_top_665/vpd[1]
+ openDVS_pixel2x2_top_665/vpd[3] openDVS_pixel2x2_top_665/vpd[2] rowReadOFF[41] rowReadON[41]
+ rowReadON[40] RefrBp PrBp PrSFBp col_periphery_1x2_25/COL_LINE0 pixRst[50] OffBn
+ rowReadOFF[40] pixRst[51] openDVS_pixel2x2_top_671/GndD DiffBn col_periphery_1x2_25/COL_LINE1
+ GndD VddA18 OnBn openDVS_pixel2x2_top
XopenDVS_pixel2x2_top_632 openDVS_pixel2x2_top_632/vpd[0] openDVS_pixel2x2_top_632/vpd[1]
+ openDVS_pixel2x2_top_632/vpd[3] openDVS_pixel2x2_top_632/vpd[2] rowReadOFF[39] rowReadON[39]
+ rowReadON[38] RefrBp PrBp PrSFBp col_periphery_1x2_24/COL_LINE0 pixRst[48] OffBn
+ rowReadOFF[38] pixRst[49] openDVS_pixel2x2_top_639/GndD DiffBn col_periphery_1x2_24/COL_LINE1
+ GndD VddA18 OnBn openDVS_pixel2x2_top
XopenDVS_pixel2x2_top_654 openDVS_pixel2x2_top_654/vpd[0] openDVS_pixel2x2_top_654/vpd[1]
+ openDVS_pixel2x2_top_654/vpd[3] openDVS_pixel2x2_top_654/vpd[2] rowReadOFF[41] rowReadON[41]
+ rowReadON[40] RefrBp PrBp PrSFBp col_periphery_1x2_14/COL_LINE0 pixRst[28] OffBn
+ rowReadOFF[40] pixRst[29] openDVS_pixel2x2_top_671/GndD DiffBn col_periphery_1x2_14/COL_LINE1
+ GndD VddA18 OnBn openDVS_pixel2x2_top
XopenDVS_pixel2x2_top_621 openDVS_pixel2x2_top_621/vpd[0] openDVS_pixel2x2_top_621/vpd[1]
+ openDVS_pixel2x2_top_621/vpd[3] openDVS_pixel2x2_top_621/vpd[2] rowReadOFF[39] rowReadON[39]
+ rowReadON[38] RefrBp PrBp PrSFBp col_periphery_1x2_13/COL_LINE0 pixRst[26] OffBn
+ rowReadOFF[38] pixRst[27] openDVS_pixel2x2_top_639/GndD DiffBn col_periphery_1x2_13/COL_LINE1
+ GndD VddA18 OnBn openDVS_pixel2x2_top
XopenDVS_pixel2x2_top_676 openDVS_pixel2x2_top_676/vpd[0] openDVS_pixel2x2_top_676/vpd[1]
+ openDVS_pixel2x2_top_676/vpd[3] openDVS_pixel2x2_top_676/vpd[2] rowReadOFF[43] rowReadON[43]
+ rowReadON[42] RefrBp PrBp PrSFBp col_periphery_1x2_4/COL_LINE0 pixRst[8] OffBn rowReadOFF[42]
+ pixRst[9] openDVS_pixel2x2_top_703/GndD DiffBn col_periphery_1x2_4/COL_LINE1 GndD
+ VddA18 OnBn openDVS_pixel2x2_top
XopenDVS_pixel2x2_top_687 openDVS_pixel2x2_top_687/vpd[0] openDVS_pixel2x2_top_687/vpd[1]
+ openDVS_pixel2x2_top_687/vpd[3] openDVS_pixel2x2_top_687/vpd[2] rowReadOFF[43] rowReadON[43]
+ rowReadON[42] RefrBp PrBp PrSFBp col_periphery_1x2_15/COL_LINE0 pixRst[30] OffBn
+ rowReadOFF[42] pixRst[31] openDVS_pixel2x2_top_703/GndD DiffBn col_periphery_1x2_15/COL_LINE1
+ GndD VddA18 OnBn openDVS_pixel2x2_top
XopenDVS_pixel2x2_top_698 openDVS_pixel2x2_top_698/vpd[0] openDVS_pixel2x2_top_698/vpd[1]
+ openDVS_pixel2x2_top_698/vpd[3] openDVS_pixel2x2_top_698/vpd[2] rowReadOFF[43] rowReadON[43]
+ rowReadON[42] RefrBp PrBp PrSFBp col_periphery_1x2_26/COL_LINE0 pixRst[52] OffBn
+ rowReadOFF[42] pixRst[53] openDVS_pixel2x2_top_703/GndD DiffBn col_periphery_1x2_26/COL_LINE1
+ GndD VddA18 OnBn openDVS_pixel2x2_top
XopenDVS_pixel2x2_top_610 openDVS_pixel2x2_top_610/vpd[0] openDVS_pixel2x2_top_610/vpd[1]
+ openDVS_pixel2x2_top_610/vpd[3] openDVS_pixel2x2_top_610/vpd[2] rowReadOFF[39] rowReadON[39]
+ rowReadON[38] RefrBp PrBp PrSFBp col_periphery_1x2_2/COL_LINE0 pixRst[4] OffBn rowReadOFF[38]
+ pixRst[5] openDVS_pixel2x2_top_639/GndD DiffBn col_periphery_1x2_2/COL_LINE1 GndD
+ VddA18 OnBn openDVS_pixel2x2_top
XopenDVS_pixel2x2_top_643 openDVS_pixel2x2_top_643/vpd[0] openDVS_pixel2x2_top_643/vpd[1]
+ openDVS_pixel2x2_top_643/vpd[3] openDVS_pixel2x2_top_643/vpd[2] rowReadOFF[41] rowReadON[41]
+ rowReadON[40] RefrBp PrBp PrSFBp col_periphery_1x2_3/COL_LINE0 pixRst[6] OffBn rowReadOFF[40]
+ pixRst[7] openDVS_pixel2x2_top_671/GndD DiffBn col_periphery_1x2_3/COL_LINE1 GndD
+ VddA18 OnBn openDVS_pixel2x2_top
XopenDVS_pixel2x2_top_2 openDVS_pixel2x2_top_2/vpd[0] openDVS_pixel2x2_top_2/vpd[1]
+ openDVS_pixel2x2_top_2/vpd[3] openDVS_pixel2x2_top_2/vpd[2] rowReadOFF[1] rowReadON[1]
+ rowReadON[0] RefrBp PrBp PrSFBp col_periphery_1x2_2/COL_LINE0 pixRst[4] OffBn rowReadOFF[0]
+ pixRst[5] openDVS_pixel2x2_top_9/GndD DiffBn col_periphery_1x2_2/COL_LINE1 GndD
+ VddA18 OnBn openDVS_pixel2x2_top
XopenDVS_pixel2x2_top_473 openDVS_pixel2x2_top_473/vpd[0] openDVS_pixel2x2_top_473/vpd[1]
+ openDVS_pixel2x2_top_473/vpd[3] openDVS_pixel2x2_top_473/vpd[2] rowReadOFF[29] rowReadON[29]
+ rowReadON[28] RefrBp PrBp PrSFBp col_periphery_1x2_25/COL_LINE0 pixRst[50] OffBn
+ rowReadOFF[28] pixRst[51] openDVS_pixel2x2_top_479/GndD DiffBn col_periphery_1x2_25/COL_LINE1
+ GndD VddA18 OnBn openDVS_pixel2x2_top
XopenDVS_pixel2x2_top_440 openDVS_pixel2x2_top_440/vpd[0] openDVS_pixel2x2_top_440/vpd[1]
+ openDVS_pixel2x2_top_440/vpd[3] openDVS_pixel2x2_top_440/vpd[2] rowReadOFF[27] rowReadON[27]
+ rowReadON[26] RefrBp PrBp PrSFBp col_periphery_1x2_24/COL_LINE0 pixRst[48] OffBn
+ rowReadOFF[26] pixRst[49] openDVS_pixel2x2_top_447/GndD DiffBn col_periphery_1x2_24/COL_LINE1
+ GndD VddA18 OnBn openDVS_pixel2x2_top
XopenDVS_pixel2x2_top_495 openDVS_pixel2x2_top_495/vpd[0] openDVS_pixel2x2_top_495/vpd[1]
+ openDVS_pixel2x2_top_495/vpd[3] openDVS_pixel2x2_top_495/vpd[2] rowReadOFF[31] rowReadON[31]
+ rowReadON[30] RefrBp PrBp PrSFBp col_periphery_1x2_15/COL_LINE0 pixRst[30] OffBn
+ rowReadOFF[30] pixRst[31] openDVS_pixel2x2_top_511/GndD DiffBn col_periphery_1x2_15/COL_LINE1
+ GndD VddA18 OnBn openDVS_pixel2x2_top
XopenDVS_pixel2x2_top_462 openDVS_pixel2x2_top_462/vpd[0] openDVS_pixel2x2_top_462/vpd[1]
+ openDVS_pixel2x2_top_462/vpd[3] openDVS_pixel2x2_top_462/vpd[2] rowReadOFF[29] rowReadON[29]
+ rowReadON[28] RefrBp PrBp PrSFBp col_periphery_1x2_14/COL_LINE0 pixRst[28] OffBn
+ rowReadOFF[28] pixRst[29] openDVS_pixel2x2_top_479/GndD DiffBn col_periphery_1x2_14/COL_LINE1
+ GndD VddA18 OnBn openDVS_pixel2x2_top
XopenDVS_pixel2x2_top_484 openDVS_pixel2x2_top_484/vpd[0] openDVS_pixel2x2_top_484/vpd[1]
+ openDVS_pixel2x2_top_484/vpd[3] openDVS_pixel2x2_top_484/vpd[2] rowReadOFF[31] rowReadON[31]
+ rowReadON[30] RefrBp PrBp PrSFBp col_periphery_1x2_4/COL_LINE0 pixRst[8] OffBn rowReadOFF[30]
+ pixRst[9] openDVS_pixel2x2_top_511/GndD DiffBn col_periphery_1x2_4/COL_LINE1 GndD
+ VddA18 OnBn openDVS_pixel2x2_top
XopenDVS_pixel2x2_top_451 openDVS_pixel2x2_top_451/vpd[0] openDVS_pixel2x2_top_451/vpd[1]
+ openDVS_pixel2x2_top_451/vpd[3] openDVS_pixel2x2_top_451/vpd[2] rowReadOFF[29] rowReadON[29]
+ rowReadON[28] RefrBp PrBp PrSFBp col_periphery_1x2_3/COL_LINE0 pixRst[6] OffBn rowReadOFF[28]
+ pixRst[7] openDVS_pixel2x2_top_479/GndD DiffBn col_periphery_1x2_3/COL_LINE1 GndD
+ VddA18 OnBn openDVS_pixel2x2_top
XopenDVS_pixel2x2_top_281 openDVS_pixel2x2_top_281/vpd[0] openDVS_pixel2x2_top_281/vpd[1]
+ openDVS_pixel2x2_top_281/vpd[3] openDVS_pixel2x2_top_281/vpd[2] rowReadOFF[17] rowReadON[17]
+ rowReadON[16] RefrBp PrBp PrSFBp col_periphery_1x2_25/COL_LINE0 pixRst[50] OffBn
+ rowReadOFF[16] pixRst[51] openDVS_pixel2x2_top_287/GndD DiffBn col_periphery_1x2_25/COL_LINE1
+ GndD VddA18 OnBn openDVS_pixel2x2_top
XopenDVS_pixel2x2_top_270 openDVS_pixel2x2_top_270/vpd[0] openDVS_pixel2x2_top_270/vpd[1]
+ openDVS_pixel2x2_top_270/vpd[3] openDVS_pixel2x2_top_270/vpd[2] rowReadOFF[17] rowReadON[17]
+ rowReadON[16] RefrBp PrBp PrSFBp col_periphery_1x2_14/COL_LINE0 pixRst[28] OffBn
+ rowReadOFF[16] pixRst[29] openDVS_pixel2x2_top_287/GndD DiffBn col_periphery_1x2_14/COL_LINE1
+ GndD VddA18 OnBn openDVS_pixel2x2_top
XopenDVS_pixel2x2_top_292 openDVS_pixel2x2_top_292/vpd[0] openDVS_pixel2x2_top_292/vpd[1]
+ openDVS_pixel2x2_top_292/vpd[3] openDVS_pixel2x2_top_292/vpd[2] rowReadOFF[19] rowReadON[19]
+ rowReadON[18] RefrBp PrBp PrSFBp col_periphery_1x2_4/COL_LINE0 pixRst[8] OffBn rowReadOFF[18]
+ pixRst[9] openDVS_pixel2x2_top_319/GndD DiffBn col_periphery_1x2_4/COL_LINE1 GndD
+ VddA18 OnBn openDVS_pixel2x2_top
XopenDVS_pixel2x2_top_847 openDVS_pixel2x2_top_847/vpd[0] openDVS_pixel2x2_top_847/vpd[1]
+ openDVS_pixel2x2_top_847/vpd[3] openDVS_pixel2x2_top_847/vpd[2] rowReadOFF[53] rowReadON[53]
+ rowReadON[52] RefrBp PrBp PrSFBp col_periphery_1x2_15/COL_LINE0 pixRst[30] OffBn
+ rowReadOFF[52] pixRst[31] openDVS_pixel2x2_top_863/GndD DiffBn col_periphery_1x2_15/COL_LINE1
+ GndD VddA18 OnBn openDVS_pixel2x2_top
XopenDVS_pixel2x2_top_869 openDVS_pixel2x2_top_869/vpd[0] openDVS_pixel2x2_top_869/vpd[1]
+ openDVS_pixel2x2_top_869/vpd[3] openDVS_pixel2x2_top_869/vpd[2] rowReadOFF[55] rowReadON[55]
+ rowReadON[54] RefrBp PrBp PrSFBp col_periphery_1x2_5/COL_LINE0 pixRst[10] OffBn
+ rowReadOFF[54] pixRst[11] openDVS_pixel2x2_top_895/GndD DiffBn col_periphery_1x2_5/COL_LINE1
+ GndD VddA18 OnBn openDVS_pixel2x2_top
XopenDVS_pixel2x2_top_836 openDVS_pixel2x2_top_836/vpd[0] openDVS_pixel2x2_top_836/vpd[1]
+ openDVS_pixel2x2_top_836/vpd[3] openDVS_pixel2x2_top_836/vpd[2] rowReadOFF[53] rowReadON[53]
+ rowReadON[52] RefrBp PrBp PrSFBp col_periphery_1x2_4/COL_LINE0 pixRst[8] OffBn rowReadOFF[52]
+ pixRst[9] openDVS_pixel2x2_top_863/GndD DiffBn col_periphery_1x2_4/COL_LINE1 GndD
+ VddA18 OnBn openDVS_pixel2x2_top
XopenDVS_pixel2x2_top_858 openDVS_pixel2x2_top_858/vpd[0] openDVS_pixel2x2_top_858/vpd[1]
+ openDVS_pixel2x2_top_858/vpd[3] openDVS_pixel2x2_top_858/vpd[2] rowReadOFF[53] rowReadON[53]
+ rowReadON[52] RefrBp PrBp PrSFBp col_periphery_1x2_26/COL_LINE0 pixRst[52] OffBn
+ rowReadOFF[52] pixRst[53] openDVS_pixel2x2_top_863/GndD DiffBn col_periphery_1x2_26/COL_LINE1
+ GndD VddA18 OnBn openDVS_pixel2x2_top
XopenDVS_pixel2x2_top_803 openDVS_pixel2x2_top_803/vpd[0] openDVS_pixel2x2_top_803/vpd[1]
+ openDVS_pixel2x2_top_803/vpd[3] openDVS_pixel2x2_top_803/vpd[2] rowReadOFF[51] rowReadON[51]
+ rowReadON[50] RefrBp PrBp PrSFBp col_periphery_1x2_3/COL_LINE0 pixRst[6] OffBn rowReadOFF[50]
+ pixRst[7] openDVS_pixel2x2_top_831/GndD DiffBn col_periphery_1x2_3/COL_LINE1 GndD
+ VddA18 OnBn openDVS_pixel2x2_top
XopenDVS_pixel2x2_top_814 openDVS_pixel2x2_top_814/vpd[0] openDVS_pixel2x2_top_814/vpd[1]
+ openDVS_pixel2x2_top_814/vpd[3] openDVS_pixel2x2_top_814/vpd[2] rowReadOFF[51] rowReadON[51]
+ rowReadON[50] RefrBp PrBp PrSFBp col_periphery_1x2_14/COL_LINE0 pixRst[28] OffBn
+ rowReadOFF[50] pixRst[29] openDVS_pixel2x2_top_831/GndD DiffBn col_periphery_1x2_14/COL_LINE1
+ GndD VddA18 OnBn openDVS_pixel2x2_top
XopenDVS_pixel2x2_top_825 openDVS_pixel2x2_top_825/vpd[0] openDVS_pixel2x2_top_825/vpd[1]
+ openDVS_pixel2x2_top_825/vpd[3] openDVS_pixel2x2_top_825/vpd[2] rowReadOFF[51] rowReadON[51]
+ rowReadON[50] RefrBp PrBp PrSFBp col_periphery_1x2_25/COL_LINE0 pixRst[50] OffBn
+ rowReadOFF[50] pixRst[51] openDVS_pixel2x2_top_831/GndD DiffBn col_periphery_1x2_25/COL_LINE1
+ GndD VddA18 OnBn openDVS_pixel2x2_top
XopenDVS_pixel2x2_top_633 openDVS_pixel2x2_top_633/vpd[0] openDVS_pixel2x2_top_633/vpd[1]
+ openDVS_pixel2x2_top_633/vpd[3] openDVS_pixel2x2_top_633/vpd[2] rowReadOFF[39] rowReadON[39]
+ rowReadON[38] RefrBp PrBp PrSFBp col_periphery_1x2_25/COL_LINE0 pixRst[50] OffBn
+ rowReadOFF[38] pixRst[51] openDVS_pixel2x2_top_639/GndD DiffBn col_periphery_1x2_25/COL_LINE1
+ GndD VddA18 OnBn openDVS_pixel2x2_top
XopenDVS_pixel2x2_top_600 openDVS_pixel2x2_top_600/vpd[0] openDVS_pixel2x2_top_600/vpd[1]
+ openDVS_pixel2x2_top_600/vpd[3] openDVS_pixel2x2_top_600/vpd[2] rowReadOFF[37] rowReadON[37]
+ rowReadON[36] RefrBp PrBp PrSFBp col_periphery_1x2_24/COL_LINE0 pixRst[48] OffBn
+ rowReadOFF[36] pixRst[49] openDVS_pixel2x2_top_607/GndD DiffBn col_periphery_1x2_24/COL_LINE1
+ GndD VddA18 OnBn openDVS_pixel2x2_top
XopenDVS_pixel2x2_top_655 openDVS_pixel2x2_top_655/vpd[0] openDVS_pixel2x2_top_655/vpd[1]
+ openDVS_pixel2x2_top_655/vpd[3] openDVS_pixel2x2_top_655/vpd[2] rowReadOFF[41] rowReadON[41]
+ rowReadON[40] RefrBp PrBp PrSFBp col_periphery_1x2_15/COL_LINE0 pixRst[30] OffBn
+ rowReadOFF[40] pixRst[31] openDVS_pixel2x2_top_671/GndD DiffBn col_periphery_1x2_15/COL_LINE1
+ GndD VddA18 OnBn openDVS_pixel2x2_top
XopenDVS_pixel2x2_top_622 openDVS_pixel2x2_top_622/vpd[0] openDVS_pixel2x2_top_622/vpd[1]
+ openDVS_pixel2x2_top_622/vpd[3] openDVS_pixel2x2_top_622/vpd[2] rowReadOFF[39] rowReadON[39]
+ rowReadON[38] RefrBp PrBp PrSFBp col_periphery_1x2_14/COL_LINE0 pixRst[28] OffBn
+ rowReadOFF[38] pixRst[29] openDVS_pixel2x2_top_639/GndD DiffBn col_periphery_1x2_14/COL_LINE1
+ GndD VddA18 OnBn openDVS_pixel2x2_top
XopenDVS_pixel2x2_top_611 openDVS_pixel2x2_top_611/vpd[0] openDVS_pixel2x2_top_611/vpd[1]
+ openDVS_pixel2x2_top_611/vpd[3] openDVS_pixel2x2_top_611/vpd[2] rowReadOFF[39] rowReadON[39]
+ rowReadON[38] RefrBp PrBp PrSFBp col_periphery_1x2_3/COL_LINE0 pixRst[6] OffBn rowReadOFF[38]
+ pixRst[7] openDVS_pixel2x2_top_639/GndD DiffBn col_periphery_1x2_3/COL_LINE1 GndD
+ VddA18 OnBn openDVS_pixel2x2_top
XopenDVS_pixel2x2_top_644 openDVS_pixel2x2_top_644/vpd[0] openDVS_pixel2x2_top_644/vpd[1]
+ openDVS_pixel2x2_top_644/vpd[3] openDVS_pixel2x2_top_644/vpd[2] rowReadOFF[41] rowReadON[41]
+ rowReadON[40] RefrBp PrBp PrSFBp col_periphery_1x2_4/COL_LINE0 pixRst[8] OffBn rowReadOFF[40]
+ pixRst[9] openDVS_pixel2x2_top_671/GndD DiffBn col_periphery_1x2_4/COL_LINE1 GndD
+ VddA18 OnBn openDVS_pixel2x2_top
XopenDVS_pixel2x2_top_666 openDVS_pixel2x2_top_666/vpd[0] openDVS_pixel2x2_top_666/vpd[1]
+ openDVS_pixel2x2_top_666/vpd[3] openDVS_pixel2x2_top_666/vpd[2] rowReadOFF[41] rowReadON[41]
+ rowReadON[40] RefrBp PrBp PrSFBp col_periphery_1x2_26/COL_LINE0 pixRst[52] OffBn
+ rowReadOFF[40] pixRst[53] openDVS_pixel2x2_top_671/GndD DiffBn col_periphery_1x2_26/COL_LINE1
+ GndD VddA18 OnBn openDVS_pixel2x2_top
XopenDVS_pixel2x2_top_677 openDVS_pixel2x2_top_677/vpd[0] openDVS_pixel2x2_top_677/vpd[1]
+ openDVS_pixel2x2_top_677/vpd[3] openDVS_pixel2x2_top_677/vpd[2] rowReadOFF[43] rowReadON[43]
+ rowReadON[42] RefrBp PrBp PrSFBp col_periphery_1x2_5/COL_LINE0 pixRst[10] OffBn
+ rowReadOFF[42] pixRst[11] openDVS_pixel2x2_top_703/GndD DiffBn col_periphery_1x2_5/COL_LINE1
+ GndD VddA18 OnBn openDVS_pixel2x2_top
XopenDVS_pixel2x2_top_688 openDVS_pixel2x2_top_688/vpd[0] openDVS_pixel2x2_top_688/vpd[1]
+ openDVS_pixel2x2_top_688/vpd[3] openDVS_pixel2x2_top_688/vpd[2] rowReadOFF[43] rowReadON[43]
+ rowReadON[42] RefrBp PrBp PrSFBp col_periphery_1x2_16/COL_LINE0 pixRst[32] OffBn
+ rowReadOFF[42] pixRst[33] openDVS_pixel2x2_top_703/GndD DiffBn col_periphery_1x2_16/COL_LINE1
+ GndD VddA18 OnBn openDVS_pixel2x2_top
XopenDVS_pixel2x2_top_699 openDVS_pixel2x2_top_699/vpd[0] openDVS_pixel2x2_top_699/vpd[1]
+ openDVS_pixel2x2_top_699/vpd[3] openDVS_pixel2x2_top_699/vpd[2] rowReadOFF[43] rowReadON[43]
+ rowReadON[42] RefrBp PrBp PrSFBp col_periphery_1x2_27/COL_LINE0 pixRst[54] OffBn
+ rowReadOFF[42] pixRst[55] openDVS_pixel2x2_top_703/GndD DiffBn col_periphery_1x2_27/COL_LINE1
+ GndD VddA18 OnBn openDVS_pixel2x2_top
XopenDVS_pixel2x2_top_3 openDVS_pixel2x2_top_3/vpd[0] openDVS_pixel2x2_top_3/vpd[1]
+ openDVS_pixel2x2_top_3/vpd[3] openDVS_pixel2x2_top_3/vpd[2] rowReadOFF[1] rowReadON[1]
+ rowReadON[0] RefrBp PrBp PrSFBp col_periphery_1x2_3/COL_LINE0 pixRst[6] OffBn rowReadOFF[0]
+ pixRst[7] openDVS_pixel2x2_top_9/GndD DiffBn col_periphery_1x2_3/COL_LINE1 GndD
+ VddA18 OnBn openDVS_pixel2x2_top
XopenDVS_pixel2x2_top_474 openDVS_pixel2x2_top_474/vpd[0] openDVS_pixel2x2_top_474/vpd[1]
+ openDVS_pixel2x2_top_474/vpd[3] openDVS_pixel2x2_top_474/vpd[2] rowReadOFF[29] rowReadON[29]
+ rowReadON[28] RefrBp PrBp PrSFBp col_periphery_1x2_26/COL_LINE0 pixRst[52] OffBn
+ rowReadOFF[28] pixRst[53] openDVS_pixel2x2_top_479/GndD DiffBn col_periphery_1x2_26/COL_LINE1
+ GndD VddA18 OnBn openDVS_pixel2x2_top
XopenDVS_pixel2x2_top_441 openDVS_pixel2x2_top_441/vpd[0] openDVS_pixel2x2_top_441/vpd[1]
+ openDVS_pixel2x2_top_441/vpd[3] openDVS_pixel2x2_top_441/vpd[2] rowReadOFF[27] rowReadON[27]
+ rowReadON[26] RefrBp PrBp PrSFBp col_periphery_1x2_25/COL_LINE0 pixRst[50] OffBn
+ rowReadOFF[26] pixRst[51] openDVS_pixel2x2_top_447/GndD DiffBn col_periphery_1x2_25/COL_LINE1
+ GndD VddA18 OnBn openDVS_pixel2x2_top
XopenDVS_pixel2x2_top_496 openDVS_pixel2x2_top_496/vpd[0] openDVS_pixel2x2_top_496/vpd[1]
+ openDVS_pixel2x2_top_496/vpd[3] openDVS_pixel2x2_top_496/vpd[2] rowReadOFF[31] rowReadON[31]
+ rowReadON[30] RefrBp PrBp PrSFBp col_periphery_1x2_16/COL_LINE0 pixRst[32] OffBn
+ rowReadOFF[30] pixRst[33] openDVS_pixel2x2_top_511/GndD DiffBn col_periphery_1x2_16/COL_LINE1
+ GndD VddA18 OnBn openDVS_pixel2x2_top
XopenDVS_pixel2x2_top_463 openDVS_pixel2x2_top_463/vpd[0] openDVS_pixel2x2_top_463/vpd[1]
+ openDVS_pixel2x2_top_463/vpd[3] openDVS_pixel2x2_top_463/vpd[2] rowReadOFF[29] rowReadON[29]
+ rowReadON[28] RefrBp PrBp PrSFBp col_periphery_1x2_15/COL_LINE0 pixRst[30] OffBn
+ rowReadOFF[28] pixRst[31] openDVS_pixel2x2_top_479/GndD DiffBn col_periphery_1x2_15/COL_LINE1
+ GndD VddA18 OnBn openDVS_pixel2x2_top
XopenDVS_pixel2x2_top_430 openDVS_pixel2x2_top_430/vpd[0] openDVS_pixel2x2_top_430/vpd[1]
+ openDVS_pixel2x2_top_430/vpd[3] openDVS_pixel2x2_top_430/vpd[2] rowReadOFF[27] rowReadON[27]
+ rowReadON[26] RefrBp PrBp PrSFBp col_periphery_1x2_14/COL_LINE0 pixRst[28] OffBn
+ rowReadOFF[26] pixRst[29] openDVS_pixel2x2_top_447/GndD DiffBn col_periphery_1x2_14/COL_LINE1
+ GndD VddA18 OnBn openDVS_pixel2x2_top
XopenDVS_pixel2x2_top_485 openDVS_pixel2x2_top_485/vpd[0] openDVS_pixel2x2_top_485/vpd[1]
+ openDVS_pixel2x2_top_485/vpd[3] openDVS_pixel2x2_top_485/vpd[2] rowReadOFF[31] rowReadON[31]
+ rowReadON[30] RefrBp PrBp PrSFBp col_periphery_1x2_5/COL_LINE0 pixRst[10] OffBn
+ rowReadOFF[30] pixRst[11] openDVS_pixel2x2_top_511/GndD DiffBn col_periphery_1x2_5/COL_LINE1
+ GndD VddA18 OnBn openDVS_pixel2x2_top
XopenDVS_pixel2x2_top_452 openDVS_pixel2x2_top_452/vpd[0] openDVS_pixel2x2_top_452/vpd[1]
+ openDVS_pixel2x2_top_452/vpd[3] openDVS_pixel2x2_top_452/vpd[2] rowReadOFF[29] rowReadON[29]
+ rowReadON[28] RefrBp PrBp PrSFBp col_periphery_1x2_4/COL_LINE0 pixRst[8] OffBn rowReadOFF[28]
+ pixRst[9] openDVS_pixel2x2_top_479/GndD DiffBn col_periphery_1x2_4/COL_LINE1 GndD
+ VddA18 OnBn openDVS_pixel2x2_top
XopenDVS_pixel2x2_top_282 openDVS_pixel2x2_top_282/vpd[0] openDVS_pixel2x2_top_282/vpd[1]
+ openDVS_pixel2x2_top_282/vpd[3] openDVS_pixel2x2_top_282/vpd[2] rowReadOFF[17] rowReadON[17]
+ rowReadON[16] RefrBp PrBp PrSFBp col_periphery_1x2_26/COL_LINE0 pixRst[52] OffBn
+ rowReadOFF[16] pixRst[53] openDVS_pixel2x2_top_287/GndD DiffBn col_periphery_1x2_26/COL_LINE1
+ GndD VddA18 OnBn openDVS_pixel2x2_top
XopenDVS_pixel2x2_top_271 openDVS_pixel2x2_top_271/vpd[0] openDVS_pixel2x2_top_271/vpd[1]
+ openDVS_pixel2x2_top_271/vpd[3] openDVS_pixel2x2_top_271/vpd[2] rowReadOFF[17] rowReadON[17]
+ rowReadON[16] RefrBp PrBp PrSFBp col_periphery_1x2_15/COL_LINE0 pixRst[30] OffBn
+ rowReadOFF[16] pixRst[31] openDVS_pixel2x2_top_287/GndD DiffBn col_periphery_1x2_15/COL_LINE1
+ GndD VddA18 OnBn openDVS_pixel2x2_top
XopenDVS_pixel2x2_top_293 openDVS_pixel2x2_top_293/vpd[0] openDVS_pixel2x2_top_293/vpd[1]
+ openDVS_pixel2x2_top_293/vpd[3] openDVS_pixel2x2_top_293/vpd[2] rowReadOFF[19] rowReadON[19]
+ rowReadON[18] RefrBp PrBp PrSFBp col_periphery_1x2_5/COL_LINE0 pixRst[10] OffBn
+ rowReadOFF[18] pixRst[11] openDVS_pixel2x2_top_319/GndD DiffBn col_periphery_1x2_5/COL_LINE1
+ GndD VddA18 OnBn openDVS_pixel2x2_top
XopenDVS_pixel2x2_top_260 openDVS_pixel2x2_top_260/vpd[0] openDVS_pixel2x2_top_260/vpd[1]
+ openDVS_pixel2x2_top_260/vpd[3] openDVS_pixel2x2_top_260/vpd[2] rowReadOFF[17] rowReadON[17]
+ rowReadON[16] RefrBp PrBp PrSFBp col_periphery_1x2_4/COL_LINE0 pixRst[8] OffBn rowReadOFF[16]
+ pixRst[9] openDVS_pixel2x2_top_287/GndD DiffBn col_periphery_1x2_4/COL_LINE1 GndD
+ VddA18 OnBn openDVS_pixel2x2_top
XopenDVS_pixel2x2_top_837 openDVS_pixel2x2_top_837/vpd[0] openDVS_pixel2x2_top_837/vpd[1]
+ openDVS_pixel2x2_top_837/vpd[3] openDVS_pixel2x2_top_837/vpd[2] rowReadOFF[53] rowReadON[53]
+ rowReadON[52] RefrBp PrBp PrSFBp col_periphery_1x2_5/COL_LINE0 pixRst[10] OffBn
+ rowReadOFF[52] pixRst[11] openDVS_pixel2x2_top_863/GndD DiffBn col_periphery_1x2_5/COL_LINE1
+ GndD VddA18 OnBn openDVS_pixel2x2_top
XopenDVS_pixel2x2_top_848 openDVS_pixel2x2_top_848/vpd[0] openDVS_pixel2x2_top_848/vpd[1]
+ openDVS_pixel2x2_top_848/vpd[3] openDVS_pixel2x2_top_848/vpd[2] rowReadOFF[53] rowReadON[53]
+ rowReadON[52] RefrBp PrBp PrSFBp col_periphery_1x2_16/COL_LINE0 pixRst[32] OffBn
+ rowReadOFF[52] pixRst[33] openDVS_pixel2x2_top_863/GndD DiffBn col_periphery_1x2_16/COL_LINE1
+ GndD VddA18 OnBn openDVS_pixel2x2_top
XopenDVS_pixel2x2_top_859 openDVS_pixel2x2_top_859/vpd[0] openDVS_pixel2x2_top_859/vpd[1]
+ openDVS_pixel2x2_top_859/vpd[3] openDVS_pixel2x2_top_859/vpd[2] rowReadOFF[53] rowReadON[53]
+ rowReadON[52] RefrBp PrBp PrSFBp col_periphery_1x2_27/COL_LINE0 pixRst[54] OffBn
+ rowReadOFF[52] pixRst[55] openDVS_pixel2x2_top_863/GndD DiffBn col_periphery_1x2_27/COL_LINE1
+ GndD VddA18 OnBn openDVS_pixel2x2_top
XopenDVS_pixel2x2_top_804 openDVS_pixel2x2_top_804/vpd[0] openDVS_pixel2x2_top_804/vpd[1]
+ openDVS_pixel2x2_top_804/vpd[3] openDVS_pixel2x2_top_804/vpd[2] rowReadOFF[51] rowReadON[51]
+ rowReadON[50] RefrBp PrBp PrSFBp col_periphery_1x2_4/COL_LINE0 pixRst[8] OffBn rowReadOFF[50]
+ pixRst[9] openDVS_pixel2x2_top_831/GndD DiffBn col_periphery_1x2_4/COL_LINE1 GndD
+ VddA18 OnBn openDVS_pixel2x2_top
XopenDVS_pixel2x2_top_815 openDVS_pixel2x2_top_815/vpd[0] openDVS_pixel2x2_top_815/vpd[1]
+ openDVS_pixel2x2_top_815/vpd[3] openDVS_pixel2x2_top_815/vpd[2] rowReadOFF[51] rowReadON[51]
+ rowReadON[50] RefrBp PrBp PrSFBp col_periphery_1x2_15/COL_LINE0 pixRst[30] OffBn
+ rowReadOFF[50] pixRst[31] openDVS_pixel2x2_top_831/GndD DiffBn col_periphery_1x2_15/COL_LINE1
+ GndD VddA18 OnBn openDVS_pixel2x2_top
XopenDVS_pixel2x2_top_826 openDVS_pixel2x2_top_826/vpd[0] openDVS_pixel2x2_top_826/vpd[1]
+ openDVS_pixel2x2_top_826/vpd[3] openDVS_pixel2x2_top_826/vpd[2] rowReadOFF[51] rowReadON[51]
+ rowReadON[50] RefrBp PrBp PrSFBp col_periphery_1x2_26/COL_LINE0 pixRst[52] OffBn
+ rowReadOFF[50] pixRst[53] openDVS_pixel2x2_top_831/GndD DiffBn col_periphery_1x2_26/COL_LINE1
+ GndD VddA18 OnBn openDVS_pixel2x2_top
XopenDVS_pixel2x2_top_667 openDVS_pixel2x2_top_667/vpd[0] openDVS_pixel2x2_top_667/vpd[1]
+ openDVS_pixel2x2_top_667/vpd[3] openDVS_pixel2x2_top_667/vpd[2] rowReadOFF[41] rowReadON[41]
+ rowReadON[40] RefrBp PrBp PrSFBp col_periphery_1x2_27/COL_LINE0 pixRst[54] OffBn
+ rowReadOFF[40] pixRst[55] openDVS_pixel2x2_top_671/GndD DiffBn col_periphery_1x2_27/COL_LINE1
+ GndD VddA18 OnBn openDVS_pixel2x2_top
XopenDVS_pixel2x2_top_634 openDVS_pixel2x2_top_634/vpd[0] openDVS_pixel2x2_top_634/vpd[1]
+ openDVS_pixel2x2_top_634/vpd[3] openDVS_pixel2x2_top_634/vpd[2] rowReadOFF[39] rowReadON[39]
+ rowReadON[38] RefrBp PrBp PrSFBp col_periphery_1x2_26/COL_LINE0 pixRst[52] OffBn
+ rowReadOFF[38] pixRst[53] openDVS_pixel2x2_top_639/GndD DiffBn col_periphery_1x2_26/COL_LINE1
+ GndD VddA18 OnBn openDVS_pixel2x2_top
XopenDVS_pixel2x2_top_601 openDVS_pixel2x2_top_601/vpd[0] openDVS_pixel2x2_top_601/vpd[1]
+ openDVS_pixel2x2_top_601/vpd[3] openDVS_pixel2x2_top_601/vpd[2] rowReadOFF[37] rowReadON[37]
+ rowReadON[36] RefrBp PrBp PrSFBp col_periphery_1x2_25/COL_LINE0 pixRst[50] OffBn
+ rowReadOFF[36] pixRst[51] openDVS_pixel2x2_top_607/GndD DiffBn col_periphery_1x2_25/COL_LINE1
+ GndD VddA18 OnBn openDVS_pixel2x2_top
XopenDVS_pixel2x2_top_656 openDVS_pixel2x2_top_656/vpd[0] openDVS_pixel2x2_top_656/vpd[1]
+ openDVS_pixel2x2_top_656/vpd[3] openDVS_pixel2x2_top_656/vpd[2] rowReadOFF[41] rowReadON[41]
+ rowReadON[40] RefrBp PrBp PrSFBp col_periphery_1x2_16/COL_LINE0 pixRst[32] OffBn
+ rowReadOFF[40] pixRst[33] openDVS_pixel2x2_top_671/GndD DiffBn col_periphery_1x2_16/COL_LINE1
+ GndD VddA18 OnBn openDVS_pixel2x2_top
XopenDVS_pixel2x2_top_623 openDVS_pixel2x2_top_623/vpd[0] openDVS_pixel2x2_top_623/vpd[1]
+ openDVS_pixel2x2_top_623/vpd[3] openDVS_pixel2x2_top_623/vpd[2] rowReadOFF[39] rowReadON[39]
+ rowReadON[38] RefrBp PrBp PrSFBp col_periphery_1x2_15/COL_LINE0 pixRst[30] OffBn
+ rowReadOFF[38] pixRst[31] openDVS_pixel2x2_top_639/GndD DiffBn col_periphery_1x2_15/COL_LINE1
+ GndD VddA18 OnBn openDVS_pixel2x2_top
XopenDVS_pixel2x2_top_678 openDVS_pixel2x2_top_678/vpd[0] openDVS_pixel2x2_top_678/vpd[1]
+ openDVS_pixel2x2_top_678/vpd[3] openDVS_pixel2x2_top_678/vpd[2] rowReadOFF[43] rowReadON[43]
+ rowReadON[42] RefrBp PrBp PrSFBp col_periphery_1x2_6/COL_LINE0 pixRst[12] OffBn
+ rowReadOFF[42] pixRst[13] openDVS_pixel2x2_top_703/GndD DiffBn col_periphery_1x2_6/COL_LINE1
+ GndD VddA18 OnBn openDVS_pixel2x2_top
XopenDVS_pixel2x2_top_689 openDVS_pixel2x2_top_689/vpd[0] openDVS_pixel2x2_top_689/vpd[1]
+ openDVS_pixel2x2_top_689/vpd[3] openDVS_pixel2x2_top_689/vpd[2] rowReadOFF[43] rowReadON[43]
+ rowReadON[42] RefrBp PrBp PrSFBp col_periphery_1x2_17/COL_LINE0 pixRst[34] OffBn
+ rowReadOFF[42] pixRst[35] openDVS_pixel2x2_top_703/GndD DiffBn col_periphery_1x2_17/COL_LINE1
+ GndD VddA18 OnBn openDVS_pixel2x2_top
XopenDVS_pixel2x2_top_612 openDVS_pixel2x2_top_612/vpd[0] openDVS_pixel2x2_top_612/vpd[1]
+ openDVS_pixel2x2_top_612/vpd[3] openDVS_pixel2x2_top_612/vpd[2] rowReadOFF[39] rowReadON[39]
+ rowReadON[38] RefrBp PrBp PrSFBp col_periphery_1x2_4/COL_LINE0 pixRst[8] OffBn rowReadOFF[38]
+ pixRst[9] openDVS_pixel2x2_top_639/GndD DiffBn col_periphery_1x2_4/COL_LINE1 GndD
+ VddA18 OnBn openDVS_pixel2x2_top
XopenDVS_pixel2x2_top_645 openDVS_pixel2x2_top_645/vpd[0] openDVS_pixel2x2_top_645/vpd[1]
+ openDVS_pixel2x2_top_645/vpd[3] openDVS_pixel2x2_top_645/vpd[2] rowReadOFF[41] rowReadON[41]
+ rowReadON[40] RefrBp PrBp PrSFBp col_periphery_1x2_5/COL_LINE0 pixRst[10] OffBn
+ rowReadOFF[40] pixRst[11] openDVS_pixel2x2_top_671/GndD DiffBn col_periphery_1x2_5/COL_LINE1
+ GndD VddA18 OnBn openDVS_pixel2x2_top
XopenDVS_pixel2x2_top_4 openDVS_pixel2x2_top_4/vpd[0] openDVS_pixel2x2_top_4/vpd[1]
+ openDVS_pixel2x2_top_4/vpd[3] openDVS_pixel2x2_top_4/vpd[2] rowReadOFF[1] rowReadON[1]
+ rowReadON[0] RefrBp PrBp PrSFBp col_periphery_1x2_4/COL_LINE0 pixRst[8] OffBn rowReadOFF[0]
+ pixRst[9] openDVS_pixel2x2_top_9/GndD DiffBn col_periphery_1x2_4/COL_LINE1 GndD
+ VddA18 OnBn openDVS_pixel2x2_top
XopenDVS_pixel2x2_top_475 openDVS_pixel2x2_top_475/vpd[0] openDVS_pixel2x2_top_475/vpd[1]
+ openDVS_pixel2x2_top_475/vpd[3] openDVS_pixel2x2_top_475/vpd[2] rowReadOFF[29] rowReadON[29]
+ rowReadON[28] RefrBp PrBp PrSFBp col_periphery_1x2_27/COL_LINE0 pixRst[54] OffBn
+ rowReadOFF[28] pixRst[55] openDVS_pixel2x2_top_479/GndD DiffBn col_periphery_1x2_27/COL_LINE1
+ GndD VddA18 OnBn openDVS_pixel2x2_top
XopenDVS_pixel2x2_top_442 openDVS_pixel2x2_top_442/vpd[0] openDVS_pixel2x2_top_442/vpd[1]
+ openDVS_pixel2x2_top_442/vpd[3] openDVS_pixel2x2_top_442/vpd[2] rowReadOFF[27] rowReadON[27]
+ rowReadON[26] RefrBp PrBp PrSFBp col_periphery_1x2_26/COL_LINE0 pixRst[52] OffBn
+ rowReadOFF[26] pixRst[53] openDVS_pixel2x2_top_447/GndD DiffBn col_periphery_1x2_26/COL_LINE1
+ GndD VddA18 OnBn openDVS_pixel2x2_top
XopenDVS_pixel2x2_top_464 openDVS_pixel2x2_top_464/vpd[0] openDVS_pixel2x2_top_464/vpd[1]
+ openDVS_pixel2x2_top_464/vpd[3] openDVS_pixel2x2_top_464/vpd[2] rowReadOFF[29] rowReadON[29]
+ rowReadON[28] RefrBp PrBp PrSFBp col_periphery_1x2_16/COL_LINE0 pixRst[32] OffBn
+ rowReadOFF[28] pixRst[33] openDVS_pixel2x2_top_479/GndD DiffBn col_periphery_1x2_16/COL_LINE1
+ GndD VddA18 OnBn openDVS_pixel2x2_top
XopenDVS_pixel2x2_top_497 openDVS_pixel2x2_top_497/vpd[0] openDVS_pixel2x2_top_497/vpd[1]
+ openDVS_pixel2x2_top_497/vpd[3] openDVS_pixel2x2_top_497/vpd[2] rowReadOFF[31] rowReadON[31]
+ rowReadON[30] RefrBp PrBp PrSFBp col_periphery_1x2_17/COL_LINE0 pixRst[34] OffBn
+ rowReadOFF[30] pixRst[35] openDVS_pixel2x2_top_511/GndD DiffBn col_periphery_1x2_17/COL_LINE1
+ GndD VddA18 OnBn openDVS_pixel2x2_top
XopenDVS_pixel2x2_top_431 openDVS_pixel2x2_top_431/vpd[0] openDVS_pixel2x2_top_431/vpd[1]
+ openDVS_pixel2x2_top_431/vpd[3] openDVS_pixel2x2_top_431/vpd[2] rowReadOFF[27] rowReadON[27]
+ rowReadON[26] RefrBp PrBp PrSFBp col_periphery_1x2_15/COL_LINE0 pixRst[30] OffBn
+ rowReadOFF[26] pixRst[31] openDVS_pixel2x2_top_447/GndD DiffBn col_periphery_1x2_15/COL_LINE1
+ GndD VddA18 OnBn openDVS_pixel2x2_top
XopenDVS_pixel2x2_top_453 openDVS_pixel2x2_top_453/vpd[0] openDVS_pixel2x2_top_453/vpd[1]
+ openDVS_pixel2x2_top_453/vpd[3] openDVS_pixel2x2_top_453/vpd[2] rowReadOFF[29] rowReadON[29]
+ rowReadON[28] RefrBp PrBp PrSFBp col_periphery_1x2_5/COL_LINE0 pixRst[10] OffBn
+ rowReadOFF[28] pixRst[11] openDVS_pixel2x2_top_479/GndD DiffBn col_periphery_1x2_5/COL_LINE1
+ GndD VddA18 OnBn openDVS_pixel2x2_top
XopenDVS_pixel2x2_top_486 openDVS_pixel2x2_top_486/vpd[0] openDVS_pixel2x2_top_486/vpd[1]
+ openDVS_pixel2x2_top_486/vpd[3] openDVS_pixel2x2_top_486/vpd[2] rowReadOFF[31] rowReadON[31]
+ rowReadON[30] RefrBp PrBp PrSFBp col_periphery_1x2_6/COL_LINE0 pixRst[12] OffBn
+ rowReadOFF[30] pixRst[13] openDVS_pixel2x2_top_511/GndD DiffBn col_periphery_1x2_6/COL_LINE1
+ GndD VddA18 OnBn openDVS_pixel2x2_top
XopenDVS_pixel2x2_top_420 openDVS_pixel2x2_top_420/vpd[0] openDVS_pixel2x2_top_420/vpd[1]
+ openDVS_pixel2x2_top_420/vpd[3] openDVS_pixel2x2_top_420/vpd[2] rowReadOFF[27] rowReadON[27]
+ rowReadON[26] RefrBp PrBp PrSFBp col_periphery_1x2_4/COL_LINE0 pixRst[8] OffBn rowReadOFF[26]
+ pixRst[9] openDVS_pixel2x2_top_447/GndD DiffBn col_periphery_1x2_4/COL_LINE1 GndD
+ VddA18 OnBn openDVS_pixel2x2_top
XopenDVS_pixel2x2_top_283 openDVS_pixel2x2_top_283/vpd[0] openDVS_pixel2x2_top_283/vpd[1]
+ openDVS_pixel2x2_top_283/vpd[3] openDVS_pixel2x2_top_283/vpd[2] rowReadOFF[17] rowReadON[17]
+ rowReadON[16] RefrBp PrBp PrSFBp col_periphery_1x2_27/COL_LINE0 pixRst[54] OffBn
+ rowReadOFF[16] pixRst[55] openDVS_pixel2x2_top_287/GndD DiffBn col_periphery_1x2_27/COL_LINE1
+ GndD VddA18 OnBn openDVS_pixel2x2_top
XopenDVS_pixel2x2_top_250 openDVS_pixel2x2_top_250/vpd[0] openDVS_pixel2x2_top_250/vpd[1]
+ openDVS_pixel2x2_top_250/vpd[3] openDVS_pixel2x2_top_250/vpd[2] rowReadOFF[15] rowReadON[15]
+ rowReadON[14] RefrBp PrBp PrSFBp col_periphery_1x2_26/COL_LINE0 pixRst[52] OffBn
+ rowReadOFF[14] pixRst[53] openDVS_pixel2x2_top_255/GndD DiffBn col_periphery_1x2_26/COL_LINE1
+ GndD VddA18 OnBn openDVS_pixel2x2_top
XopenDVS_pixel2x2_top_272 openDVS_pixel2x2_top_272/vpd[0] openDVS_pixel2x2_top_272/vpd[1]
+ openDVS_pixel2x2_top_272/vpd[3] openDVS_pixel2x2_top_272/vpd[2] rowReadOFF[17] rowReadON[17]
+ rowReadON[16] RefrBp PrBp PrSFBp col_periphery_1x2_16/COL_LINE0 pixRst[32] OffBn
+ rowReadOFF[16] pixRst[33] openDVS_pixel2x2_top_287/GndD DiffBn col_periphery_1x2_16/COL_LINE1
+ GndD VddA18 OnBn openDVS_pixel2x2_top
XopenDVS_pixel2x2_top_261 openDVS_pixel2x2_top_261/vpd[0] openDVS_pixel2x2_top_261/vpd[1]
+ openDVS_pixel2x2_top_261/vpd[3] openDVS_pixel2x2_top_261/vpd[2] rowReadOFF[17] rowReadON[17]
+ rowReadON[16] RefrBp PrBp PrSFBp col_periphery_1x2_5/COL_LINE0 pixRst[10] OffBn
+ rowReadOFF[16] pixRst[11] openDVS_pixel2x2_top_287/GndD DiffBn col_periphery_1x2_5/COL_LINE1
+ GndD VddA18 OnBn openDVS_pixel2x2_top
XopenDVS_pixel2x2_top_294 openDVS_pixel2x2_top_294/vpd[0] openDVS_pixel2x2_top_294/vpd[1]
+ openDVS_pixel2x2_top_294/vpd[3] openDVS_pixel2x2_top_294/vpd[2] rowReadOFF[19] rowReadON[19]
+ rowReadON[18] RefrBp PrBp PrSFBp col_periphery_1x2_6/COL_LINE0 pixRst[12] OffBn
+ rowReadOFF[18] pixRst[13] openDVS_pixel2x2_top_319/GndD DiffBn col_periphery_1x2_6/COL_LINE1
+ GndD VddA18 OnBn openDVS_pixel2x2_top
XopenDVS_pixel2x2_top_838 openDVS_pixel2x2_top_838/vpd[0] openDVS_pixel2x2_top_838/vpd[1]
+ openDVS_pixel2x2_top_838/vpd[3] openDVS_pixel2x2_top_838/vpd[2] rowReadOFF[53] rowReadON[53]
+ rowReadON[52] RefrBp PrBp PrSFBp col_periphery_1x2_6/COL_LINE0 pixRst[12] OffBn
+ rowReadOFF[52] pixRst[13] openDVS_pixel2x2_top_863/GndD DiffBn col_periphery_1x2_6/COL_LINE1
+ GndD VddA18 OnBn openDVS_pixel2x2_top
XopenDVS_pixel2x2_top_849 openDVS_pixel2x2_top_849/vpd[0] openDVS_pixel2x2_top_849/vpd[1]
+ openDVS_pixel2x2_top_849/vpd[3] openDVS_pixel2x2_top_849/vpd[2] rowReadOFF[53] rowReadON[53]
+ rowReadON[52] RefrBp PrBp PrSFBp col_periphery_1x2_17/COL_LINE0 pixRst[34] OffBn
+ rowReadOFF[52] pixRst[35] openDVS_pixel2x2_top_863/GndD DiffBn col_periphery_1x2_17/COL_LINE1
+ GndD VddA18 OnBn openDVS_pixel2x2_top
XopenDVS_pixel2x2_top_805 openDVS_pixel2x2_top_805/vpd[0] openDVS_pixel2x2_top_805/vpd[1]
+ openDVS_pixel2x2_top_805/vpd[3] openDVS_pixel2x2_top_805/vpd[2] rowReadOFF[51] rowReadON[51]
+ rowReadON[50] RefrBp PrBp PrSFBp col_periphery_1x2_5/COL_LINE0 pixRst[10] OffBn
+ rowReadOFF[50] pixRst[11] openDVS_pixel2x2_top_831/GndD DiffBn col_periphery_1x2_5/COL_LINE1
+ GndD VddA18 OnBn openDVS_pixel2x2_top
XopenDVS_pixel2x2_top_816 openDVS_pixel2x2_top_816/vpd[0] openDVS_pixel2x2_top_816/vpd[1]
+ openDVS_pixel2x2_top_816/vpd[3] openDVS_pixel2x2_top_816/vpd[2] rowReadOFF[51] rowReadON[51]
+ rowReadON[50] RefrBp PrBp PrSFBp col_periphery_1x2_16/COL_LINE0 pixRst[32] OffBn
+ rowReadOFF[50] pixRst[33] openDVS_pixel2x2_top_831/GndD DiffBn col_periphery_1x2_16/COL_LINE1
+ GndD VddA18 OnBn openDVS_pixel2x2_top
XopenDVS_pixel2x2_top_827 openDVS_pixel2x2_top_827/vpd[0] openDVS_pixel2x2_top_827/vpd[1]
+ openDVS_pixel2x2_top_827/vpd[3] openDVS_pixel2x2_top_827/vpd[2] rowReadOFF[51] rowReadON[51]
+ rowReadON[50] RefrBp PrBp PrSFBp col_periphery_1x2_27/COL_LINE0 pixRst[54] OffBn
+ rowReadOFF[50] pixRst[55] openDVS_pixel2x2_top_831/GndD DiffBn col_periphery_1x2_27/COL_LINE1
+ GndD VddA18 OnBn openDVS_pixel2x2_top
XopenDVS_pixel2x2_top_635 openDVS_pixel2x2_top_635/vpd[0] openDVS_pixel2x2_top_635/vpd[1]
+ openDVS_pixel2x2_top_635/vpd[3] openDVS_pixel2x2_top_635/vpd[2] rowReadOFF[39] rowReadON[39]
+ rowReadON[38] RefrBp PrBp PrSFBp col_periphery_1x2_27/COL_LINE0 pixRst[54] OffBn
+ rowReadOFF[38] pixRst[55] openDVS_pixel2x2_top_639/GndD DiffBn col_periphery_1x2_27/COL_LINE1
+ GndD VddA18 OnBn openDVS_pixel2x2_top
XopenDVS_pixel2x2_top_668 openDVS_pixel2x2_top_668/vpd[0] openDVS_pixel2x2_top_668/vpd[1]
+ openDVS_pixel2x2_top_668/vpd[3] openDVS_pixel2x2_top_668/vpd[2] rowReadOFF[41] rowReadON[41]
+ rowReadON[40] RefrBp PrBp PrSFBp col_periphery_1x2_28/COL_LINE0 pixRst[56] OffBn
+ rowReadOFF[40] pixRst[57] openDVS_pixel2x2_top_671/GndD DiffBn col_periphery_1x2_28/COL_LINE1
+ GndD VddA18 OnBn openDVS_pixel2x2_top
XopenDVS_pixel2x2_top_602 openDVS_pixel2x2_top_602/vpd[0] openDVS_pixel2x2_top_602/vpd[1]
+ openDVS_pixel2x2_top_602/vpd[3] openDVS_pixel2x2_top_602/vpd[2] rowReadOFF[37] rowReadON[37]
+ rowReadON[36] RefrBp PrBp PrSFBp col_periphery_1x2_26/COL_LINE0 pixRst[52] OffBn
+ rowReadOFF[36] pixRst[53] openDVS_pixel2x2_top_607/GndD DiffBn col_periphery_1x2_26/COL_LINE1
+ GndD VddA18 OnBn openDVS_pixel2x2_top
XopenDVS_pixel2x2_top_624 openDVS_pixel2x2_top_624/vpd[0] openDVS_pixel2x2_top_624/vpd[1]
+ openDVS_pixel2x2_top_624/vpd[3] openDVS_pixel2x2_top_624/vpd[2] rowReadOFF[39] rowReadON[39]
+ rowReadON[38] RefrBp PrBp PrSFBp col_periphery_1x2_16/COL_LINE0 pixRst[32] OffBn
+ rowReadOFF[38] pixRst[33] openDVS_pixel2x2_top_639/GndD DiffBn col_periphery_1x2_16/COL_LINE1
+ GndD VddA18 OnBn openDVS_pixel2x2_top
XopenDVS_pixel2x2_top_657 openDVS_pixel2x2_top_657/vpd[0] openDVS_pixel2x2_top_657/vpd[1]
+ openDVS_pixel2x2_top_657/vpd[3] openDVS_pixel2x2_top_657/vpd[2] rowReadOFF[41] rowReadON[41]
+ rowReadON[40] RefrBp PrBp PrSFBp col_periphery_1x2_17/COL_LINE0 pixRst[34] OffBn
+ rowReadOFF[40] pixRst[35] openDVS_pixel2x2_top_671/GndD DiffBn col_periphery_1x2_17/COL_LINE1
+ GndD VddA18 OnBn openDVS_pixel2x2_top
XopenDVS_pixel2x2_top_679 openDVS_pixel2x2_top_679/vpd[0] openDVS_pixel2x2_top_679/vpd[1]
+ openDVS_pixel2x2_top_679/vpd[3] openDVS_pixel2x2_top_679/vpd[2] rowReadOFF[43] rowReadON[43]
+ rowReadON[42] RefrBp PrBp PrSFBp col_periphery_1x2_7/COL_LINE0 pixRst[14] OffBn
+ rowReadOFF[42] pixRst[15] openDVS_pixel2x2_top_703/GndD DiffBn col_periphery_1x2_7/COL_LINE1
+ GndD VddA18 OnBn openDVS_pixel2x2_top
XopenDVS_pixel2x2_top_646 openDVS_pixel2x2_top_646/vpd[0] openDVS_pixel2x2_top_646/vpd[1]
+ openDVS_pixel2x2_top_646/vpd[3] openDVS_pixel2x2_top_646/vpd[2] rowReadOFF[41] rowReadON[41]
+ rowReadON[40] RefrBp PrBp PrSFBp col_periphery_1x2_6/COL_LINE0 pixRst[12] OffBn
+ rowReadOFF[40] pixRst[13] openDVS_pixel2x2_top_671/GndD DiffBn col_periphery_1x2_6/COL_LINE1
+ GndD VddA18 OnBn openDVS_pixel2x2_top
XopenDVS_pixel2x2_top_613 openDVS_pixel2x2_top_613/vpd[0] openDVS_pixel2x2_top_613/vpd[1]
+ openDVS_pixel2x2_top_613/vpd[3] openDVS_pixel2x2_top_613/vpd[2] rowReadOFF[39] rowReadON[39]
+ rowReadON[38] RefrBp PrBp PrSFBp col_periphery_1x2_5/COL_LINE0 pixRst[10] OffBn
+ rowReadOFF[38] pixRst[11] openDVS_pixel2x2_top_639/GndD DiffBn col_periphery_1x2_5/COL_LINE1
+ GndD VddA18 OnBn openDVS_pixel2x2_top
XopenDVS_pixel2x2_top_5 openDVS_pixel2x2_top_5/vpd[0] openDVS_pixel2x2_top_5/vpd[1]
+ openDVS_pixel2x2_top_5/vpd[3] openDVS_pixel2x2_top_5/vpd[2] rowReadOFF[1] rowReadON[1]
+ rowReadON[0] RefrBp PrBp PrSFBp col_periphery_1x2_5/COL_LINE0 pixRst[10] OffBn rowReadOFF[0]
+ pixRst[11] openDVS_pixel2x2_top_9/GndD DiffBn col_periphery_1x2_5/COL_LINE1 GndD
+ VddA18 OnBn openDVS_pixel2x2_top
XopenDVS_pixel2x2_top_410 openDVS_pixel2x2_top_410/vpd[0] openDVS_pixel2x2_top_410/vpd[1]
+ openDVS_pixel2x2_top_410/vpd[3] openDVS_pixel2x2_top_410/vpd[2] rowReadOFF[25] rowReadON[25]
+ rowReadON[24] RefrBp PrBp PrSFBp col_periphery_1x2_26/COL_LINE0 pixRst[52] OffBn
+ rowReadOFF[24] pixRst[53] openDVS_pixel2x2_top_415/GndD DiffBn col_periphery_1x2_26/COL_LINE1
+ GndD VddA18 OnBn openDVS_pixel2x2_top
XopenDVS_pixel2x2_top_421 openDVS_pixel2x2_top_421/vpd[0] openDVS_pixel2x2_top_421/vpd[1]
+ openDVS_pixel2x2_top_421/vpd[3] openDVS_pixel2x2_top_421/vpd[2] rowReadOFF[27] rowReadON[27]
+ rowReadON[26] RefrBp PrBp PrSFBp col_periphery_1x2_5/COL_LINE0 pixRst[10] OffBn
+ rowReadOFF[26] pixRst[11] openDVS_pixel2x2_top_447/GndD DiffBn col_periphery_1x2_5/COL_LINE1
+ GndD VddA18 OnBn openDVS_pixel2x2_top
XopenDVS_pixel2x2_top_443 openDVS_pixel2x2_top_443/vpd[0] openDVS_pixel2x2_top_443/vpd[1]
+ openDVS_pixel2x2_top_443/vpd[3] openDVS_pixel2x2_top_443/vpd[2] rowReadOFF[27] rowReadON[27]
+ rowReadON[26] RefrBp PrBp PrSFBp col_periphery_1x2_27/COL_LINE0 pixRst[54] OffBn
+ rowReadOFF[26] pixRst[55] openDVS_pixel2x2_top_447/GndD DiffBn col_periphery_1x2_27/COL_LINE1
+ GndD VddA18 OnBn openDVS_pixel2x2_top
XopenDVS_pixel2x2_top_476 openDVS_pixel2x2_top_476/vpd[0] openDVS_pixel2x2_top_476/vpd[1]
+ openDVS_pixel2x2_top_476/vpd[3] openDVS_pixel2x2_top_476/vpd[2] rowReadOFF[29] rowReadON[29]
+ rowReadON[28] RefrBp PrBp PrSFBp col_periphery_1x2_28/COL_LINE0 pixRst[56] OffBn
+ rowReadOFF[28] pixRst[57] openDVS_pixel2x2_top_479/GndD DiffBn col_periphery_1x2_28/COL_LINE1
+ GndD VddA18 OnBn openDVS_pixel2x2_top
XopenDVS_pixel2x2_top_498 openDVS_pixel2x2_top_498/vpd[0] openDVS_pixel2x2_top_498/vpd[1]
+ openDVS_pixel2x2_top_498/vpd[3] openDVS_pixel2x2_top_498/vpd[2] rowReadOFF[31] rowReadON[31]
+ rowReadON[30] RefrBp PrBp PrSFBp col_periphery_1x2_18/COL_LINE0 pixRst[36] OffBn
+ rowReadOFF[30] pixRst[37] openDVS_pixel2x2_top_511/GndD DiffBn col_periphery_1x2_18/COL_LINE1
+ GndD VddA18 OnBn openDVS_pixel2x2_top
XopenDVS_pixel2x2_top_432 openDVS_pixel2x2_top_432/vpd[0] openDVS_pixel2x2_top_432/vpd[1]
+ openDVS_pixel2x2_top_432/vpd[3] openDVS_pixel2x2_top_432/vpd[2] rowReadOFF[27] rowReadON[27]
+ rowReadON[26] RefrBp PrBp PrSFBp col_periphery_1x2_16/COL_LINE0 pixRst[32] OffBn
+ rowReadOFF[26] pixRst[33] openDVS_pixel2x2_top_447/GndD DiffBn col_periphery_1x2_16/COL_LINE1
+ GndD VddA18 OnBn openDVS_pixel2x2_top
XopenDVS_pixel2x2_top_465 openDVS_pixel2x2_top_465/vpd[0] openDVS_pixel2x2_top_465/vpd[1]
+ openDVS_pixel2x2_top_465/vpd[3] openDVS_pixel2x2_top_465/vpd[2] rowReadOFF[29] rowReadON[29]
+ rowReadON[28] RefrBp PrBp PrSFBp col_periphery_1x2_17/COL_LINE0 pixRst[34] OffBn
+ rowReadOFF[28] pixRst[35] openDVS_pixel2x2_top_479/GndD DiffBn col_periphery_1x2_17/COL_LINE1
+ GndD VddA18 OnBn openDVS_pixel2x2_top
XopenDVS_pixel2x2_top_487 openDVS_pixel2x2_top_487/vpd[0] openDVS_pixel2x2_top_487/vpd[1]
+ openDVS_pixel2x2_top_487/vpd[3] openDVS_pixel2x2_top_487/vpd[2] rowReadOFF[31] rowReadON[31]
+ rowReadON[30] RefrBp PrBp PrSFBp col_periphery_1x2_7/COL_LINE0 pixRst[14] OffBn
+ rowReadOFF[30] pixRst[15] openDVS_pixel2x2_top_511/GndD DiffBn col_periphery_1x2_7/COL_LINE1
+ GndD VddA18 OnBn openDVS_pixel2x2_top
XopenDVS_pixel2x2_top_454 openDVS_pixel2x2_top_454/vpd[0] openDVS_pixel2x2_top_454/vpd[1]
+ openDVS_pixel2x2_top_454/vpd[3] openDVS_pixel2x2_top_454/vpd[2] rowReadOFF[29] rowReadON[29]
+ rowReadON[28] RefrBp PrBp PrSFBp col_periphery_1x2_6/COL_LINE0 pixRst[12] OffBn
+ rowReadOFF[28] pixRst[13] openDVS_pixel2x2_top_479/GndD DiffBn col_periphery_1x2_6/COL_LINE1
+ GndD VddA18 OnBn openDVS_pixel2x2_top
XopenDVS_pixel2x2_top_251 openDVS_pixel2x2_top_251/vpd[0] openDVS_pixel2x2_top_251/vpd[1]
+ openDVS_pixel2x2_top_251/vpd[3] openDVS_pixel2x2_top_251/vpd[2] rowReadOFF[15] rowReadON[15]
+ rowReadON[14] RefrBp PrBp PrSFBp col_periphery_1x2_27/COL_LINE0 pixRst[54] OffBn
+ rowReadOFF[14] pixRst[55] openDVS_pixel2x2_top_255/GndD DiffBn col_periphery_1x2_27/COL_LINE1
+ GndD VddA18 OnBn openDVS_pixel2x2_top
XopenDVS_pixel2x2_top_284 openDVS_pixel2x2_top_284/vpd[0] openDVS_pixel2x2_top_284/vpd[1]
+ openDVS_pixel2x2_top_284/vpd[3] openDVS_pixel2x2_top_284/vpd[2] rowReadOFF[17] rowReadON[17]
+ rowReadON[16] RefrBp PrBp PrSFBp col_periphery_1x2_28/COL_LINE0 pixRst[56] OffBn
+ rowReadOFF[16] pixRst[57] openDVS_pixel2x2_top_287/GndD DiffBn col_periphery_1x2_28/COL_LINE1
+ GndD VddA18 OnBn openDVS_pixel2x2_top
XopenDVS_pixel2x2_top_240 openDVS_pixel2x2_top_240/vpd[0] openDVS_pixel2x2_top_240/vpd[1]
+ openDVS_pixel2x2_top_240/vpd[3] openDVS_pixel2x2_top_240/vpd[2] rowReadOFF[15] rowReadON[15]
+ rowReadON[14] RefrBp PrBp PrSFBp col_periphery_1x2_16/COL_LINE0 pixRst[32] OffBn
+ rowReadOFF[14] pixRst[33] openDVS_pixel2x2_top_255/GndD DiffBn col_periphery_1x2_16/COL_LINE1
+ GndD VddA18 OnBn openDVS_pixel2x2_top
XopenDVS_pixel2x2_top_273 openDVS_pixel2x2_top_273/vpd[0] openDVS_pixel2x2_top_273/vpd[1]
+ openDVS_pixel2x2_top_273/vpd[3] openDVS_pixel2x2_top_273/vpd[2] rowReadOFF[17] rowReadON[17]
+ rowReadON[16] RefrBp PrBp PrSFBp col_periphery_1x2_17/COL_LINE0 pixRst[34] OffBn
+ rowReadOFF[16] pixRst[35] openDVS_pixel2x2_top_287/GndD DiffBn col_periphery_1x2_17/COL_LINE1
+ GndD VddA18 OnBn openDVS_pixel2x2_top
XopenDVS_pixel2x2_top_295 openDVS_pixel2x2_top_295/vpd[0] openDVS_pixel2x2_top_295/vpd[1]
+ openDVS_pixel2x2_top_295/vpd[3] openDVS_pixel2x2_top_295/vpd[2] rowReadOFF[19] rowReadON[19]
+ rowReadON[18] RefrBp PrBp PrSFBp col_periphery_1x2_7/COL_LINE0 pixRst[14] OffBn
+ rowReadOFF[18] pixRst[15] openDVS_pixel2x2_top_319/GndD DiffBn col_periphery_1x2_7/COL_LINE1
+ GndD VddA18 OnBn openDVS_pixel2x2_top
XopenDVS_pixel2x2_top_262 openDVS_pixel2x2_top_262/vpd[0] openDVS_pixel2x2_top_262/vpd[1]
+ openDVS_pixel2x2_top_262/vpd[3] openDVS_pixel2x2_top_262/vpd[2] rowReadOFF[17] rowReadON[17]
+ rowReadON[16] RefrBp PrBp PrSFBp col_periphery_1x2_6/COL_LINE0 pixRst[12] OffBn
+ rowReadOFF[16] pixRst[13] openDVS_pixel2x2_top_287/GndD DiffBn col_periphery_1x2_6/COL_LINE1
+ GndD VddA18 OnBn openDVS_pixel2x2_top
XopenDVS_pixel2x2_top_839 openDVS_pixel2x2_top_839/vpd[0] openDVS_pixel2x2_top_839/vpd[1]
+ openDVS_pixel2x2_top_839/vpd[3] openDVS_pixel2x2_top_839/vpd[2] rowReadOFF[53] rowReadON[53]
+ rowReadON[52] RefrBp PrBp PrSFBp col_periphery_1x2_7/COL_LINE0 pixRst[14] OffBn
+ rowReadOFF[52] pixRst[15] openDVS_pixel2x2_top_863/GndD DiffBn col_periphery_1x2_7/COL_LINE1
+ GndD VddA18 OnBn openDVS_pixel2x2_top
XopenDVS_pixel2x2_top_806 openDVS_pixel2x2_top_806/vpd[0] openDVS_pixel2x2_top_806/vpd[1]
+ openDVS_pixel2x2_top_806/vpd[3] openDVS_pixel2x2_top_806/vpd[2] rowReadOFF[51] rowReadON[51]
+ rowReadON[50] RefrBp PrBp PrSFBp col_periphery_1x2_6/COL_LINE0 pixRst[12] OffBn
+ rowReadOFF[50] pixRst[13] openDVS_pixel2x2_top_831/GndD DiffBn col_periphery_1x2_6/COL_LINE1
+ GndD VddA18 OnBn openDVS_pixel2x2_top
XopenDVS_pixel2x2_top_817 openDVS_pixel2x2_top_817/vpd[0] openDVS_pixel2x2_top_817/vpd[1]
+ openDVS_pixel2x2_top_817/vpd[3] openDVS_pixel2x2_top_817/vpd[2] rowReadOFF[51] rowReadON[51]
+ rowReadON[50] RefrBp PrBp PrSFBp col_periphery_1x2_17/COL_LINE0 pixRst[34] OffBn
+ rowReadOFF[50] pixRst[35] openDVS_pixel2x2_top_831/GndD DiffBn col_periphery_1x2_17/COL_LINE1
+ GndD VddA18 OnBn openDVS_pixel2x2_top
XopenDVS_pixel2x2_top_828 openDVS_pixel2x2_top_828/vpd[0] openDVS_pixel2x2_top_828/vpd[1]
+ openDVS_pixel2x2_top_828/vpd[3] openDVS_pixel2x2_top_828/vpd[2] rowReadOFF[51] rowReadON[51]
+ rowReadON[50] RefrBp PrBp PrSFBp col_periphery_1x2_28/COL_LINE0 pixRst[56] OffBn
+ rowReadOFF[50] pixRst[57] openDVS_pixel2x2_top_831/GndD DiffBn col_periphery_1x2_28/COL_LINE1
+ GndD VddA18 OnBn openDVS_pixel2x2_top
XopenDVS_pixel2x2_top_669 openDVS_pixel2x2_top_669/vpd[0] openDVS_pixel2x2_top_669/vpd[1]
+ openDVS_pixel2x2_top_669/vpd[3] openDVS_pixel2x2_top_669/vpd[2] rowReadOFF[41] rowReadON[41]
+ rowReadON[40] RefrBp PrBp PrSFBp col_periphery_1x2_29/COL_LINE0 pixRst[58] OffBn
+ rowReadOFF[40] pixRst[59] openDVS_pixel2x2_top_671/GndD DiffBn col_periphery_1x2_29/COL_LINE1
+ GndD VddA18 OnBn openDVS_pixel2x2_top
XopenDVS_pixel2x2_top_603 openDVS_pixel2x2_top_603/vpd[0] openDVS_pixel2x2_top_603/vpd[1]
+ openDVS_pixel2x2_top_603/vpd[3] openDVS_pixel2x2_top_603/vpd[2] rowReadOFF[37] rowReadON[37]
+ rowReadON[36] RefrBp PrBp PrSFBp col_periphery_1x2_27/COL_LINE0 pixRst[54] OffBn
+ rowReadOFF[36] pixRst[55] openDVS_pixel2x2_top_607/GndD DiffBn col_periphery_1x2_27/COL_LINE1
+ GndD VddA18 OnBn openDVS_pixel2x2_top
XopenDVS_pixel2x2_top_636 openDVS_pixel2x2_top_636/vpd[0] openDVS_pixel2x2_top_636/vpd[1]
+ openDVS_pixel2x2_top_636/vpd[3] openDVS_pixel2x2_top_636/vpd[2] rowReadOFF[39] rowReadON[39]
+ rowReadON[38] RefrBp PrBp PrSFBp col_periphery_1x2_28/COL_LINE0 pixRst[56] OffBn
+ rowReadOFF[38] pixRst[57] openDVS_pixel2x2_top_639/GndD DiffBn col_periphery_1x2_28/COL_LINE1
+ GndD VddA18 OnBn openDVS_pixel2x2_top
XopenDVS_pixel2x2_top_658 openDVS_pixel2x2_top_658/vpd[0] openDVS_pixel2x2_top_658/vpd[1]
+ openDVS_pixel2x2_top_658/vpd[3] openDVS_pixel2x2_top_658/vpd[2] rowReadOFF[41] rowReadON[41]
+ rowReadON[40] RefrBp PrBp PrSFBp col_periphery_1x2_18/COL_LINE0 pixRst[36] OffBn
+ rowReadOFF[40] pixRst[37] openDVS_pixel2x2_top_671/GndD DiffBn col_periphery_1x2_18/COL_LINE1
+ GndD VddA18 OnBn openDVS_pixel2x2_top
XopenDVS_pixel2x2_top_625 openDVS_pixel2x2_top_625/vpd[0] openDVS_pixel2x2_top_625/vpd[1]
+ openDVS_pixel2x2_top_625/vpd[3] openDVS_pixel2x2_top_625/vpd[2] rowReadOFF[39] rowReadON[39]
+ rowReadON[38] RefrBp PrBp PrSFBp col_periphery_1x2_17/COL_LINE0 pixRst[34] OffBn
+ rowReadOFF[38] pixRst[35] openDVS_pixel2x2_top_639/GndD DiffBn col_periphery_1x2_17/COL_LINE1
+ GndD VddA18 OnBn openDVS_pixel2x2_top
XopenDVS_pixel2x2_top_647 openDVS_pixel2x2_top_647/vpd[0] openDVS_pixel2x2_top_647/vpd[1]
+ openDVS_pixel2x2_top_647/vpd[3] openDVS_pixel2x2_top_647/vpd[2] rowReadOFF[41] rowReadON[41]
+ rowReadON[40] RefrBp PrBp PrSFBp col_periphery_1x2_7/COL_LINE0 pixRst[14] OffBn
+ rowReadOFF[40] pixRst[15] openDVS_pixel2x2_top_671/GndD DiffBn col_periphery_1x2_7/COL_LINE1
+ GndD VddA18 OnBn openDVS_pixel2x2_top
XopenDVS_pixel2x2_top_614 openDVS_pixel2x2_top_614/vpd[0] openDVS_pixel2x2_top_614/vpd[1]
+ openDVS_pixel2x2_top_614/vpd[3] openDVS_pixel2x2_top_614/vpd[2] rowReadOFF[39] rowReadON[39]
+ rowReadON[38] RefrBp PrBp PrSFBp col_periphery_1x2_6/COL_LINE0 pixRst[12] OffBn
+ rowReadOFF[38] pixRst[13] openDVS_pixel2x2_top_639/GndD DiffBn col_periphery_1x2_6/COL_LINE1
+ GndD VddA18 OnBn openDVS_pixel2x2_top
XopenDVS_pixel2x2_top_6 openDVS_pixel2x2_top_6/vpd[0] openDVS_pixel2x2_top_6/vpd[1]
+ openDVS_pixel2x2_top_6/vpd[3] openDVS_pixel2x2_top_6/vpd[2] rowReadOFF[1] rowReadON[1]
+ rowReadON[0] RefrBp PrBp PrSFBp col_periphery_1x2_6/COL_LINE0 pixRst[12] OffBn rowReadOFF[0]
+ pixRst[13] openDVS_pixel2x2_top_9/GndD DiffBn col_periphery_1x2_6/COL_LINE1 GndD
+ VddA18 OnBn openDVS_pixel2x2_top
XopenDVS_pixel2x2_top_477 openDVS_pixel2x2_top_477/vpd[0] openDVS_pixel2x2_top_477/vpd[1]
+ openDVS_pixel2x2_top_477/vpd[3] openDVS_pixel2x2_top_477/vpd[2] rowReadOFF[29] rowReadON[29]
+ rowReadON[28] RefrBp PrBp PrSFBp col_periphery_1x2_29/COL_LINE0 pixRst[58] OffBn
+ rowReadOFF[28] pixRst[59] openDVS_pixel2x2_top_479/GndD DiffBn col_periphery_1x2_29/COL_LINE1
+ GndD VddA18 OnBn openDVS_pixel2x2_top
XopenDVS_pixel2x2_top_411 openDVS_pixel2x2_top_411/vpd[0] openDVS_pixel2x2_top_411/vpd[1]
+ openDVS_pixel2x2_top_411/vpd[3] openDVS_pixel2x2_top_411/vpd[2] rowReadOFF[25] rowReadON[25]
+ rowReadON[24] RefrBp PrBp PrSFBp col_periphery_1x2_27/COL_LINE0 pixRst[54] OffBn
+ rowReadOFF[24] pixRst[55] openDVS_pixel2x2_top_415/GndD DiffBn col_periphery_1x2_27/COL_LINE1
+ GndD VddA18 OnBn openDVS_pixel2x2_top
XopenDVS_pixel2x2_top_444 openDVS_pixel2x2_top_444/vpd[0] openDVS_pixel2x2_top_444/vpd[1]
+ openDVS_pixel2x2_top_444/vpd[3] openDVS_pixel2x2_top_444/vpd[2] rowReadOFF[27] rowReadON[27]
+ rowReadON[26] RefrBp PrBp PrSFBp col_periphery_1x2_28/COL_LINE0 pixRst[56] OffBn
+ rowReadOFF[26] pixRst[57] openDVS_pixel2x2_top_447/GndD DiffBn col_periphery_1x2_28/COL_LINE1
+ GndD VddA18 OnBn openDVS_pixel2x2_top
XopenDVS_pixel2x2_top_499 openDVS_pixel2x2_top_499/vpd[0] openDVS_pixel2x2_top_499/vpd[1]
+ openDVS_pixel2x2_top_499/vpd[3] openDVS_pixel2x2_top_499/vpd[2] rowReadOFF[31] rowReadON[31]
+ rowReadON[30] RefrBp PrBp PrSFBp col_periphery_1x2_19/COL_LINE0 pixRst[38] OffBn
+ rowReadOFF[30] pixRst[39] openDVS_pixel2x2_top_511/GndD DiffBn col_periphery_1x2_19/COL_LINE1
+ GndD VddA18 OnBn openDVS_pixel2x2_top
XopenDVS_pixel2x2_top_466 openDVS_pixel2x2_top_466/vpd[0] openDVS_pixel2x2_top_466/vpd[1]
+ openDVS_pixel2x2_top_466/vpd[3] openDVS_pixel2x2_top_466/vpd[2] rowReadOFF[29] rowReadON[29]
+ rowReadON[28] RefrBp PrBp PrSFBp col_periphery_1x2_18/COL_LINE0 pixRst[36] OffBn
+ rowReadOFF[28] pixRst[37] openDVS_pixel2x2_top_479/GndD DiffBn col_periphery_1x2_18/COL_LINE1
+ GndD VddA18 OnBn openDVS_pixel2x2_top
XopenDVS_pixel2x2_top_400 openDVS_pixel2x2_top_400/vpd[0] openDVS_pixel2x2_top_400/vpd[1]
+ openDVS_pixel2x2_top_400/vpd[3] openDVS_pixel2x2_top_400/vpd[2] rowReadOFF[25] rowReadON[25]
+ rowReadON[24] RefrBp PrBp PrSFBp col_periphery_1x2_16/COL_LINE0 pixRst[32] OffBn
+ rowReadOFF[24] pixRst[33] openDVS_pixel2x2_top_415/GndD DiffBn col_periphery_1x2_16/COL_LINE1
+ GndD VddA18 OnBn openDVS_pixel2x2_top
XopenDVS_pixel2x2_top_433 openDVS_pixel2x2_top_433/vpd[0] openDVS_pixel2x2_top_433/vpd[1]
+ openDVS_pixel2x2_top_433/vpd[3] openDVS_pixel2x2_top_433/vpd[2] rowReadOFF[27] rowReadON[27]
+ rowReadON[26] RefrBp PrBp PrSFBp col_periphery_1x2_17/COL_LINE0 pixRst[34] OffBn
+ rowReadOFF[26] pixRst[35] openDVS_pixel2x2_top_447/GndD DiffBn col_periphery_1x2_17/COL_LINE1
+ GndD VddA18 OnBn openDVS_pixel2x2_top
XopenDVS_pixel2x2_top_488 openDVS_pixel2x2_top_488/vpd[0] openDVS_pixel2x2_top_488/vpd[1]
+ openDVS_pixel2x2_top_488/vpd[3] openDVS_pixel2x2_top_488/vpd[2] rowReadOFF[31] rowReadON[31]
+ rowReadON[30] RefrBp PrBp PrSFBp col_periphery_1x2_8/COL_LINE0 pixRst[16] OffBn
+ rowReadOFF[30] pixRst[17] openDVS_pixel2x2_top_511/GndD DiffBn col_periphery_1x2_8/COL_LINE1
+ GndD VddA18 OnBn openDVS_pixel2x2_top
XopenDVS_pixel2x2_top_455 openDVS_pixel2x2_top_455/vpd[0] openDVS_pixel2x2_top_455/vpd[1]
+ openDVS_pixel2x2_top_455/vpd[3] openDVS_pixel2x2_top_455/vpd[2] rowReadOFF[29] rowReadON[29]
+ rowReadON[28] RefrBp PrBp PrSFBp col_periphery_1x2_7/COL_LINE0 pixRst[14] OffBn
+ rowReadOFF[28] pixRst[15] openDVS_pixel2x2_top_479/GndD DiffBn col_periphery_1x2_7/COL_LINE1
+ GndD VddA18 OnBn openDVS_pixel2x2_top
XopenDVS_pixel2x2_top_422 openDVS_pixel2x2_top_422/vpd[0] openDVS_pixel2x2_top_422/vpd[1]
+ openDVS_pixel2x2_top_422/vpd[3] openDVS_pixel2x2_top_422/vpd[2] rowReadOFF[27] rowReadON[27]
+ rowReadON[26] RefrBp PrBp PrSFBp col_periphery_1x2_6/COL_LINE0 pixRst[12] OffBn
+ rowReadOFF[26] pixRst[13] openDVS_pixel2x2_top_447/GndD DiffBn col_periphery_1x2_6/COL_LINE1
+ GndD VddA18 OnBn openDVS_pixel2x2_top
XopenDVS_pixel2x2_top_285 openDVS_pixel2x2_top_285/vpd[0] openDVS_pixel2x2_top_285/vpd[1]
+ openDVS_pixel2x2_top_285/vpd[3] openDVS_pixel2x2_top_285/vpd[2] rowReadOFF[17] rowReadON[17]
+ rowReadON[16] RefrBp PrBp PrSFBp col_periphery_1x2_29/COL_LINE0 pixRst[58] OffBn
+ rowReadOFF[16] pixRst[59] openDVS_pixel2x2_top_287/GndD DiffBn col_periphery_1x2_29/COL_LINE1
+ GndD VddA18 OnBn openDVS_pixel2x2_top
XopenDVS_pixel2x2_top_252 openDVS_pixel2x2_top_252/vpd[0] openDVS_pixel2x2_top_252/vpd[1]
+ openDVS_pixel2x2_top_252/vpd[3] openDVS_pixel2x2_top_252/vpd[2] rowReadOFF[15] rowReadON[15]
+ rowReadON[14] RefrBp PrBp PrSFBp col_periphery_1x2_28/COL_LINE0 pixRst[56] OffBn
+ rowReadOFF[14] pixRst[57] openDVS_pixel2x2_top_255/GndD DiffBn col_periphery_1x2_28/COL_LINE1
+ GndD VddA18 OnBn openDVS_pixel2x2_top
XopenDVS_pixel2x2_top_274 openDVS_pixel2x2_top_274/vpd[0] openDVS_pixel2x2_top_274/vpd[1]
+ openDVS_pixel2x2_top_274/vpd[3] openDVS_pixel2x2_top_274/vpd[2] rowReadOFF[17] rowReadON[17]
+ rowReadON[16] RefrBp PrBp PrSFBp col_periphery_1x2_18/COL_LINE0 pixRst[36] OffBn
+ rowReadOFF[16] pixRst[37] openDVS_pixel2x2_top_287/GndD DiffBn col_periphery_1x2_18/COL_LINE1
+ GndD VddA18 OnBn openDVS_pixel2x2_top
XopenDVS_pixel2x2_top_241 openDVS_pixel2x2_top_241/vpd[0] openDVS_pixel2x2_top_241/vpd[1]
+ openDVS_pixel2x2_top_241/vpd[3] openDVS_pixel2x2_top_241/vpd[2] rowReadOFF[15] rowReadON[15]
+ rowReadON[14] RefrBp PrBp PrSFBp col_periphery_1x2_17/COL_LINE0 pixRst[34] OffBn
+ rowReadOFF[14] pixRst[35] openDVS_pixel2x2_top_255/GndD DiffBn col_periphery_1x2_17/COL_LINE1
+ GndD VddA18 OnBn openDVS_pixel2x2_top
XopenDVS_pixel2x2_top_296 openDVS_pixel2x2_top_296/vpd[0] openDVS_pixel2x2_top_296/vpd[1]
+ openDVS_pixel2x2_top_296/vpd[3] openDVS_pixel2x2_top_296/vpd[2] rowReadOFF[19] rowReadON[19]
+ rowReadON[18] RefrBp PrBp PrSFBp col_periphery_1x2_8/COL_LINE0 pixRst[16] OffBn
+ rowReadOFF[18] pixRst[17] openDVS_pixel2x2_top_319/GndD DiffBn col_periphery_1x2_8/COL_LINE1
+ GndD VddA18 OnBn openDVS_pixel2x2_top
XopenDVS_pixel2x2_top_263 openDVS_pixel2x2_top_263/vpd[0] openDVS_pixel2x2_top_263/vpd[1]
+ openDVS_pixel2x2_top_263/vpd[3] openDVS_pixel2x2_top_263/vpd[2] rowReadOFF[17] rowReadON[17]
+ rowReadON[16] RefrBp PrBp PrSFBp col_periphery_1x2_7/COL_LINE0 pixRst[14] OffBn
+ rowReadOFF[16] pixRst[15] openDVS_pixel2x2_top_287/GndD DiffBn col_periphery_1x2_7/COL_LINE1
+ GndD VddA18 OnBn openDVS_pixel2x2_top
XopenDVS_pixel2x2_top_230 openDVS_pixel2x2_top_230/vpd[0] openDVS_pixel2x2_top_230/vpd[1]
+ openDVS_pixel2x2_top_230/vpd[3] openDVS_pixel2x2_top_230/vpd[2] rowReadOFF[15] rowReadON[15]
+ rowReadON[14] RefrBp PrBp PrSFBp col_periphery_1x2_6/COL_LINE0 pixRst[12] OffBn
+ rowReadOFF[14] pixRst[13] openDVS_pixel2x2_top_255/GndD DiffBn col_periphery_1x2_6/COL_LINE1
+ GndD VddA18 OnBn openDVS_pixel2x2_top
XopenDVS_pixel2x2_top_807 openDVS_pixel2x2_top_807/vpd[0] openDVS_pixel2x2_top_807/vpd[1]
+ openDVS_pixel2x2_top_807/vpd[3] openDVS_pixel2x2_top_807/vpd[2] rowReadOFF[51] rowReadON[51]
+ rowReadON[50] RefrBp PrBp PrSFBp col_periphery_1x2_7/COL_LINE0 pixRst[14] OffBn
+ rowReadOFF[50] pixRst[15] openDVS_pixel2x2_top_831/GndD DiffBn col_periphery_1x2_7/COL_LINE1
+ GndD VddA18 OnBn openDVS_pixel2x2_top
XopenDVS_pixel2x2_top_818 openDVS_pixel2x2_top_818/vpd[0] openDVS_pixel2x2_top_818/vpd[1]
+ openDVS_pixel2x2_top_818/vpd[3] openDVS_pixel2x2_top_818/vpd[2] rowReadOFF[51] rowReadON[51]
+ rowReadON[50] RefrBp PrBp PrSFBp col_periphery_1x2_18/COL_LINE0 pixRst[36] OffBn
+ rowReadOFF[50] pixRst[37] openDVS_pixel2x2_top_831/GndD DiffBn col_periphery_1x2_18/COL_LINE1
+ GndD VddA18 OnBn openDVS_pixel2x2_top
XopenDVS_pixel2x2_top_829 openDVS_pixel2x2_top_829/vpd[0] openDVS_pixel2x2_top_829/vpd[1]
+ openDVS_pixel2x2_top_829/vpd[3] openDVS_pixel2x2_top_829/vpd[2] rowReadOFF[51] rowReadON[51]
+ rowReadON[50] RefrBp PrBp PrSFBp col_periphery_1x2_29/COL_LINE0 pixRst[58] OffBn
+ rowReadOFF[50] pixRst[59] openDVS_pixel2x2_top_831/GndD DiffBn col_periphery_1x2_29/COL_LINE1
+ GndD VddA18 OnBn openDVS_pixel2x2_top
XopenDVS_pixel2x2_top_637 openDVS_pixel2x2_top_637/vpd[0] openDVS_pixel2x2_top_637/vpd[1]
+ openDVS_pixel2x2_top_637/vpd[3] openDVS_pixel2x2_top_637/vpd[2] rowReadOFF[39] rowReadON[39]
+ rowReadON[38] RefrBp PrBp PrSFBp col_periphery_1x2_29/COL_LINE0 pixRst[58] OffBn
+ rowReadOFF[38] pixRst[59] openDVS_pixel2x2_top_639/GndD DiffBn col_periphery_1x2_29/COL_LINE1
+ GndD VddA18 OnBn openDVS_pixel2x2_top
XopenDVS_pixel2x2_top_604 openDVS_pixel2x2_top_604/vpd[0] openDVS_pixel2x2_top_604/vpd[1]
+ openDVS_pixel2x2_top_604/vpd[3] openDVS_pixel2x2_top_604/vpd[2] rowReadOFF[37] rowReadON[37]
+ rowReadON[36] RefrBp PrBp PrSFBp col_periphery_1x2_28/COL_LINE0 pixRst[56] OffBn
+ rowReadOFF[36] pixRst[57] openDVS_pixel2x2_top_607/GndD DiffBn col_periphery_1x2_28/COL_LINE1
+ GndD VddA18 OnBn openDVS_pixel2x2_top
XopenDVS_pixel2x2_top_659 openDVS_pixel2x2_top_659/vpd[0] openDVS_pixel2x2_top_659/vpd[1]
+ openDVS_pixel2x2_top_659/vpd[3] openDVS_pixel2x2_top_659/vpd[2] rowReadOFF[41] rowReadON[41]
+ rowReadON[40] RefrBp PrBp PrSFBp col_periphery_1x2_19/COL_LINE0 pixRst[38] OffBn
+ rowReadOFF[40] pixRst[39] openDVS_pixel2x2_top_671/GndD DiffBn col_periphery_1x2_19/COL_LINE1
+ GndD VddA18 OnBn openDVS_pixel2x2_top
XopenDVS_pixel2x2_top_626 openDVS_pixel2x2_top_626/vpd[0] openDVS_pixel2x2_top_626/vpd[1]
+ openDVS_pixel2x2_top_626/vpd[3] openDVS_pixel2x2_top_626/vpd[2] rowReadOFF[39] rowReadON[39]
+ rowReadON[38] RefrBp PrBp PrSFBp col_periphery_1x2_18/COL_LINE0 pixRst[36] OffBn
+ rowReadOFF[38] pixRst[37] openDVS_pixel2x2_top_639/GndD DiffBn col_periphery_1x2_18/COL_LINE1
+ GndD VddA18 OnBn openDVS_pixel2x2_top
XopenDVS_pixel2x2_top_648 openDVS_pixel2x2_top_648/vpd[0] openDVS_pixel2x2_top_648/vpd[1]
+ openDVS_pixel2x2_top_648/vpd[3] openDVS_pixel2x2_top_648/vpd[2] rowReadOFF[41] rowReadON[41]
+ rowReadON[40] RefrBp PrBp PrSFBp col_periphery_1x2_8/COL_LINE0 pixRst[16] OffBn
+ rowReadOFF[40] pixRst[17] openDVS_pixel2x2_top_671/GndD DiffBn col_periphery_1x2_8/COL_LINE1
+ GndD VddA18 OnBn openDVS_pixel2x2_top
XopenDVS_pixel2x2_top_615 openDVS_pixel2x2_top_615/vpd[0] openDVS_pixel2x2_top_615/vpd[1]
+ openDVS_pixel2x2_top_615/vpd[3] openDVS_pixel2x2_top_615/vpd[2] rowReadOFF[39] rowReadON[39]
+ rowReadON[38] RefrBp PrBp PrSFBp col_periphery_1x2_7/COL_LINE0 pixRst[14] OffBn
+ rowReadOFF[38] pixRst[15] openDVS_pixel2x2_top_639/GndD DiffBn col_periphery_1x2_7/COL_LINE1
+ GndD VddA18 OnBn openDVS_pixel2x2_top
XopenDVS_pixel2x2_top_7 openDVS_pixel2x2_top_7/vpd[0] openDVS_pixel2x2_top_7/vpd[1]
+ openDVS_pixel2x2_top_7/vpd[3] openDVS_pixel2x2_top_7/vpd[2] rowReadOFF[1] rowReadON[1]
+ rowReadON[0] RefrBp PrBp PrSFBp col_periphery_1x2_7/COL_LINE0 pixRst[14] OffBn rowReadOFF[0]
+ pixRst[15] openDVS_pixel2x2_top_9/GndD DiffBn col_periphery_1x2_7/COL_LINE1 GndD
+ VddA18 OnBn openDVS_pixel2x2_top
XopenDVS_pixel2x2_top_478 openDVS_pixel2x2_top_478/vpd[0] openDVS_pixel2x2_top_478/vpd[1]
+ openDVS_pixel2x2_top_478/vpd[3] openDVS_pixel2x2_top_478/vpd[2] rowReadOFF[29] rowReadON[29]
+ rowReadON[28] RefrBp PrBp PrSFBp col_periphery_1x2_30/COL_LINE0 pixRst[60] OffBn
+ rowReadOFF[28] pixRst[61] openDVS_pixel2x2_top_479/GndD DiffBn col_periphery_1x2_30/COL_LINE1
+ GndD VddA18 OnBn openDVS_pixel2x2_top
XopenDVS_pixel2x2_top_445 openDVS_pixel2x2_top_445/vpd[0] openDVS_pixel2x2_top_445/vpd[1]
+ openDVS_pixel2x2_top_445/vpd[3] openDVS_pixel2x2_top_445/vpd[2] rowReadOFF[27] rowReadON[27]
+ rowReadON[26] RefrBp PrBp PrSFBp col_periphery_1x2_29/COL_LINE0 pixRst[58] OffBn
+ rowReadOFF[26] pixRst[59] openDVS_pixel2x2_top_447/GndD DiffBn col_periphery_1x2_29/COL_LINE1
+ GndD VddA18 OnBn openDVS_pixel2x2_top
XopenDVS_pixel2x2_top_412 openDVS_pixel2x2_top_412/vpd[0] openDVS_pixel2x2_top_412/vpd[1]
+ openDVS_pixel2x2_top_412/vpd[3] openDVS_pixel2x2_top_412/vpd[2] rowReadOFF[25] rowReadON[25]
+ rowReadON[24] RefrBp PrBp PrSFBp col_periphery_1x2_28/COL_LINE0 pixRst[56] OffBn
+ rowReadOFF[24] pixRst[57] openDVS_pixel2x2_top_415/GndD DiffBn col_periphery_1x2_28/COL_LINE1
+ GndD VddA18 OnBn openDVS_pixel2x2_top
XopenDVS_pixel2x2_top_467 openDVS_pixel2x2_top_467/vpd[0] openDVS_pixel2x2_top_467/vpd[1]
+ openDVS_pixel2x2_top_467/vpd[3] openDVS_pixel2x2_top_467/vpd[2] rowReadOFF[29] rowReadON[29]
+ rowReadON[28] RefrBp PrBp PrSFBp col_periphery_1x2_19/COL_LINE0 pixRst[38] OffBn
+ rowReadOFF[28] pixRst[39] openDVS_pixel2x2_top_479/GndD DiffBn col_periphery_1x2_19/COL_LINE1
+ GndD VddA18 OnBn openDVS_pixel2x2_top
XopenDVS_pixel2x2_top_434 openDVS_pixel2x2_top_434/vpd[0] openDVS_pixel2x2_top_434/vpd[1]
+ openDVS_pixel2x2_top_434/vpd[3] openDVS_pixel2x2_top_434/vpd[2] rowReadOFF[27] rowReadON[27]
+ rowReadON[26] RefrBp PrBp PrSFBp col_periphery_1x2_18/COL_LINE0 pixRst[36] OffBn
+ rowReadOFF[26] pixRst[37] openDVS_pixel2x2_top_447/GndD DiffBn col_periphery_1x2_18/COL_LINE1
+ GndD VddA18 OnBn openDVS_pixel2x2_top
XopenDVS_pixel2x2_top_401 openDVS_pixel2x2_top_401/vpd[0] openDVS_pixel2x2_top_401/vpd[1]
+ openDVS_pixel2x2_top_401/vpd[3] openDVS_pixel2x2_top_401/vpd[2] rowReadOFF[25] rowReadON[25]
+ rowReadON[24] RefrBp PrBp PrSFBp col_periphery_1x2_17/COL_LINE0 pixRst[34] OffBn
+ rowReadOFF[24] pixRst[35] openDVS_pixel2x2_top_415/GndD DiffBn col_periphery_1x2_17/COL_LINE1
+ GndD VddA18 OnBn openDVS_pixel2x2_top
XopenDVS_pixel2x2_top_489 openDVS_pixel2x2_top_489/vpd[0] openDVS_pixel2x2_top_489/vpd[1]
+ openDVS_pixel2x2_top_489/vpd[3] openDVS_pixel2x2_top_489/vpd[2] rowReadOFF[31] rowReadON[31]
+ rowReadON[30] RefrBp PrBp PrSFBp col_periphery_1x2_9/COL_LINE0 pixRst[18] OffBn
+ rowReadOFF[30] pixRst[19] openDVS_pixel2x2_top_511/GndD DiffBn col_periphery_1x2_9/COL_LINE1
+ GndD VddA18 OnBn openDVS_pixel2x2_top
XopenDVS_pixel2x2_top_456 openDVS_pixel2x2_top_456/vpd[0] openDVS_pixel2x2_top_456/vpd[1]
+ openDVS_pixel2x2_top_456/vpd[3] openDVS_pixel2x2_top_456/vpd[2] rowReadOFF[29] rowReadON[29]
+ rowReadON[28] RefrBp PrBp PrSFBp col_periphery_1x2_8/COL_LINE0 pixRst[16] OffBn
+ rowReadOFF[28] pixRst[17] openDVS_pixel2x2_top_479/GndD DiffBn col_periphery_1x2_8/COL_LINE1
+ GndD VddA18 OnBn openDVS_pixel2x2_top
XopenDVS_pixel2x2_top_423 openDVS_pixel2x2_top_423/vpd[0] openDVS_pixel2x2_top_423/vpd[1]
+ openDVS_pixel2x2_top_423/vpd[3] openDVS_pixel2x2_top_423/vpd[2] rowReadOFF[27] rowReadON[27]
+ rowReadON[26] RefrBp PrBp PrSFBp col_periphery_1x2_7/COL_LINE0 pixRst[14] OffBn
+ rowReadOFF[26] pixRst[15] openDVS_pixel2x2_top_447/GndD DiffBn col_periphery_1x2_7/COL_LINE1
+ GndD VddA18 OnBn openDVS_pixel2x2_top
XopenDVS_pixel2x2_top_990 openDVS_pixel2x2_top_990/vpd[0] openDVS_pixel2x2_top_990/vpd[1]
+ openDVS_pixel2x2_top_990/vpd[3] openDVS_pixel2x2_top_990/vpd[2] rowReadOFF[61] rowReadON[61]
+ rowReadON[60] RefrBp PrBp PrSFBp col_periphery_1x2_30/COL_LINE0 pixRst[60] OffBn
+ rowReadOFF[60] pixRst[61] openDVS_pixel2x2_top_991/GndD DiffBn col_periphery_1x2_30/COL_LINE1
+ GndD VddA18 OnBn openDVS_pixel2x2_top
XopenDVS_pixel2x2_top_286 openDVS_pixel2x2_top_286/vpd[0] openDVS_pixel2x2_top_286/vpd[1]
+ openDVS_pixel2x2_top_286/vpd[3] openDVS_pixel2x2_top_286/vpd[2] rowReadOFF[17] rowReadON[17]
+ rowReadON[16] RefrBp PrBp PrSFBp col_periphery_1x2_30/COL_LINE0 pixRst[60] OffBn
+ rowReadOFF[16] pixRst[61] openDVS_pixel2x2_top_287/GndD DiffBn col_periphery_1x2_30/COL_LINE1
+ GndD VddA18 OnBn openDVS_pixel2x2_top
XopenDVS_pixel2x2_top_253 openDVS_pixel2x2_top_253/vpd[0] openDVS_pixel2x2_top_253/vpd[1]
+ openDVS_pixel2x2_top_253/vpd[3] openDVS_pixel2x2_top_253/vpd[2] rowReadOFF[15] rowReadON[15]
+ rowReadON[14] RefrBp PrBp PrSFBp col_periphery_1x2_29/COL_LINE0 pixRst[58] OffBn
+ rowReadOFF[14] pixRst[59] openDVS_pixel2x2_top_255/GndD DiffBn col_periphery_1x2_29/COL_LINE1
+ GndD VddA18 OnBn openDVS_pixel2x2_top
XopenDVS_pixel2x2_top_220 openDVS_pixel2x2_top_220/vpd[0] openDVS_pixel2x2_top_220/vpd[1]
+ openDVS_pixel2x2_top_220/vpd[3] openDVS_pixel2x2_top_220/vpd[2] rowReadOFF[13] rowReadON[13]
+ rowReadON[12] RefrBp PrBp PrSFBp col_periphery_1x2_28/COL_LINE0 pixRst[56] OffBn
+ rowReadOFF[12] pixRst[57] openDVS_pixel2x2_top_223/GndD DiffBn col_periphery_1x2_28/COL_LINE1
+ GndD VddA18 OnBn openDVS_pixel2x2_top
XopenDVS_pixel2x2_top_275 openDVS_pixel2x2_top_275/vpd[0] openDVS_pixel2x2_top_275/vpd[1]
+ openDVS_pixel2x2_top_275/vpd[3] openDVS_pixel2x2_top_275/vpd[2] rowReadOFF[17] rowReadON[17]
+ rowReadON[16] RefrBp PrBp PrSFBp col_periphery_1x2_19/COL_LINE0 pixRst[38] OffBn
+ rowReadOFF[16] pixRst[39] openDVS_pixel2x2_top_287/GndD DiffBn col_periphery_1x2_19/COL_LINE1
+ GndD VddA18 OnBn openDVS_pixel2x2_top
XopenDVS_pixel2x2_top_242 openDVS_pixel2x2_top_242/vpd[0] openDVS_pixel2x2_top_242/vpd[1]
+ openDVS_pixel2x2_top_242/vpd[3] openDVS_pixel2x2_top_242/vpd[2] rowReadOFF[15] rowReadON[15]
+ rowReadON[14] RefrBp PrBp PrSFBp col_periphery_1x2_18/COL_LINE0 pixRst[36] OffBn
+ rowReadOFF[14] pixRst[37] openDVS_pixel2x2_top_255/GndD DiffBn col_periphery_1x2_18/COL_LINE1
+ GndD VddA18 OnBn openDVS_pixel2x2_top
XopenDVS_pixel2x2_top_297 openDVS_pixel2x2_top_297/vpd[0] openDVS_pixel2x2_top_297/vpd[1]
+ openDVS_pixel2x2_top_297/vpd[3] openDVS_pixel2x2_top_297/vpd[2] rowReadOFF[19] rowReadON[19]
+ rowReadON[18] RefrBp PrBp PrSFBp col_periphery_1x2_9/COL_LINE0 pixRst[18] OffBn
+ rowReadOFF[18] pixRst[19] openDVS_pixel2x2_top_319/GndD DiffBn col_periphery_1x2_9/COL_LINE1
+ GndD VddA18 OnBn openDVS_pixel2x2_top
XopenDVS_pixel2x2_top_264 openDVS_pixel2x2_top_264/vpd[0] openDVS_pixel2x2_top_264/vpd[1]
+ openDVS_pixel2x2_top_264/vpd[3] openDVS_pixel2x2_top_264/vpd[2] rowReadOFF[17] rowReadON[17]
+ rowReadON[16] RefrBp PrBp PrSFBp col_periphery_1x2_8/COL_LINE0 pixRst[16] OffBn
+ rowReadOFF[16] pixRst[17] openDVS_pixel2x2_top_287/GndD DiffBn col_periphery_1x2_8/COL_LINE1
+ GndD VddA18 OnBn openDVS_pixel2x2_top
XopenDVS_pixel2x2_top_231 openDVS_pixel2x2_top_231/vpd[0] openDVS_pixel2x2_top_231/vpd[1]
+ openDVS_pixel2x2_top_231/vpd[3] openDVS_pixel2x2_top_231/vpd[2] rowReadOFF[15] rowReadON[15]
+ rowReadON[14] RefrBp PrBp PrSFBp col_periphery_1x2_7/COL_LINE0 pixRst[14] OffBn
+ rowReadOFF[14] pixRst[15] openDVS_pixel2x2_top_255/GndD DiffBn col_periphery_1x2_7/COL_LINE1
+ GndD VddA18 OnBn openDVS_pixel2x2_top
XopenDVS_pixel2x2_top_808 openDVS_pixel2x2_top_808/vpd[0] openDVS_pixel2x2_top_808/vpd[1]
+ openDVS_pixel2x2_top_808/vpd[3] openDVS_pixel2x2_top_808/vpd[2] rowReadOFF[51] rowReadON[51]
+ rowReadON[50] RefrBp PrBp PrSFBp col_periphery_1x2_8/COL_LINE0 pixRst[16] OffBn
+ rowReadOFF[50] pixRst[17] openDVS_pixel2x2_top_831/GndD DiffBn col_periphery_1x2_8/COL_LINE1
+ GndD VddA18 OnBn openDVS_pixel2x2_top
XopenDVS_pixel2x2_top_819 openDVS_pixel2x2_top_819/vpd[0] openDVS_pixel2x2_top_819/vpd[1]
+ openDVS_pixel2x2_top_819/vpd[3] openDVS_pixel2x2_top_819/vpd[2] rowReadOFF[51] rowReadON[51]
+ rowReadON[50] RefrBp PrBp PrSFBp col_periphery_1x2_19/COL_LINE0 pixRst[38] OffBn
+ rowReadOFF[50] pixRst[39] openDVS_pixel2x2_top_831/GndD DiffBn col_periphery_1x2_19/COL_LINE1
+ GndD VddA18 OnBn openDVS_pixel2x2_top
XopenDVS_pixel2x2_top_638 openDVS_pixel2x2_top_638/vpd[0] openDVS_pixel2x2_top_638/vpd[1]
+ openDVS_pixel2x2_top_638/vpd[3] openDVS_pixel2x2_top_638/vpd[2] rowReadOFF[39] rowReadON[39]
+ rowReadON[38] RefrBp PrBp PrSFBp col_periphery_1x2_30/COL_LINE0 pixRst[60] OffBn
+ rowReadOFF[38] pixRst[61] openDVS_pixel2x2_top_639/GndD DiffBn col_periphery_1x2_30/COL_LINE1
+ GndD VddA18 OnBn openDVS_pixel2x2_top
XopenDVS_pixel2x2_top_605 openDVS_pixel2x2_top_605/vpd[0] openDVS_pixel2x2_top_605/vpd[1]
+ openDVS_pixel2x2_top_605/vpd[3] openDVS_pixel2x2_top_605/vpd[2] rowReadOFF[37] rowReadON[37]
+ rowReadON[36] RefrBp PrBp PrSFBp col_periphery_1x2_29/COL_LINE0 pixRst[58] OffBn
+ rowReadOFF[36] pixRst[59] openDVS_pixel2x2_top_607/GndD DiffBn col_periphery_1x2_29/COL_LINE1
+ GndD VddA18 OnBn openDVS_pixel2x2_top
XopenDVS_pixel2x2_top_627 openDVS_pixel2x2_top_627/vpd[0] openDVS_pixel2x2_top_627/vpd[1]
+ openDVS_pixel2x2_top_627/vpd[3] openDVS_pixel2x2_top_627/vpd[2] rowReadOFF[39] rowReadON[39]
+ rowReadON[38] RefrBp PrBp PrSFBp col_periphery_1x2_19/COL_LINE0 pixRst[38] OffBn
+ rowReadOFF[38] pixRst[39] openDVS_pixel2x2_top_639/GndD DiffBn col_periphery_1x2_19/COL_LINE1
+ GndD VddA18 OnBn openDVS_pixel2x2_top
XopenDVS_pixel2x2_top_649 openDVS_pixel2x2_top_649/vpd[0] openDVS_pixel2x2_top_649/vpd[1]
+ openDVS_pixel2x2_top_649/vpd[3] openDVS_pixel2x2_top_649/vpd[2] rowReadOFF[41] rowReadON[41]
+ rowReadON[40] RefrBp PrBp PrSFBp col_periphery_1x2_9/COL_LINE0 pixRst[18] OffBn
+ rowReadOFF[40] pixRst[19] openDVS_pixel2x2_top_671/GndD DiffBn col_periphery_1x2_9/COL_LINE1
+ GndD VddA18 OnBn openDVS_pixel2x2_top
XopenDVS_pixel2x2_top_616 openDVS_pixel2x2_top_616/vpd[0] openDVS_pixel2x2_top_616/vpd[1]
+ openDVS_pixel2x2_top_616/vpd[3] openDVS_pixel2x2_top_616/vpd[2] rowReadOFF[39] rowReadON[39]
+ rowReadON[38] RefrBp PrBp PrSFBp col_periphery_1x2_8/COL_LINE0 pixRst[16] OffBn
+ rowReadOFF[38] pixRst[17] openDVS_pixel2x2_top_639/GndD DiffBn col_periphery_1x2_8/COL_LINE1
+ GndD VddA18 OnBn openDVS_pixel2x2_top
XopenDVS_pixel2x2_top_8 openDVS_pixel2x2_top_8/vpd[0] openDVS_pixel2x2_top_8/vpd[1]
+ openDVS_pixel2x2_top_8/vpd[3] openDVS_pixel2x2_top_8/vpd[2] rowReadOFF[1] rowReadON[1]
+ rowReadON[0] RefrBp PrBp PrSFBp col_periphery_1x2_8/COL_LINE0 pixRst[16] OffBn rowReadOFF[0]
+ pixRst[17] openDVS_pixel2x2_top_9/GndD DiffBn col_periphery_1x2_8/COL_LINE1 GndD
+ VddA18 OnBn openDVS_pixel2x2_top
XopenDVS_pixel2x2_top_479 openDVS_pixel2x2_top_479/vpd[0] openDVS_pixel2x2_top_479/vpd[1]
+ openDVS_pixel2x2_top_479/vpd[3] openDVS_pixel2x2_top_479/vpd[2] rowReadOFF[29] rowReadON[29]
+ rowReadON[28] RefrBp PrBp PrSFBp col_periphery_1x2_31/COL_LINE0 pixRst[62] OffBn
+ rowReadOFF[28] pixRst[63] openDVS_pixel2x2_top_479/GndD DiffBn col_periphery_1x2_31/COL_LINE1
+ GndD VddA18 OnBn openDVS_pixel2x2_top
XopenDVS_pixel2x2_top_446 openDVS_pixel2x2_top_446/vpd[0] openDVS_pixel2x2_top_446/vpd[1]
+ openDVS_pixel2x2_top_446/vpd[3] openDVS_pixel2x2_top_446/vpd[2] rowReadOFF[27] rowReadON[27]
+ rowReadON[26] RefrBp PrBp PrSFBp col_periphery_1x2_30/COL_LINE0 pixRst[60] OffBn
+ rowReadOFF[26] pixRst[61] openDVS_pixel2x2_top_447/GndD DiffBn col_periphery_1x2_30/COL_LINE1
+ GndD VddA18 OnBn openDVS_pixel2x2_top
XopenDVS_pixel2x2_top_413 openDVS_pixel2x2_top_413/vpd[0] openDVS_pixel2x2_top_413/vpd[1]
+ openDVS_pixel2x2_top_413/vpd[3] openDVS_pixel2x2_top_413/vpd[2] rowReadOFF[25] rowReadON[25]
+ rowReadON[24] RefrBp PrBp PrSFBp col_periphery_1x2_29/COL_LINE0 pixRst[58] OffBn
+ rowReadOFF[24] pixRst[59] openDVS_pixel2x2_top_415/GndD DiffBn col_periphery_1x2_29/COL_LINE1
+ GndD VddA18 OnBn openDVS_pixel2x2_top
XopenDVS_pixel2x2_top_468 openDVS_pixel2x2_top_468/vpd[0] openDVS_pixel2x2_top_468/vpd[1]
+ openDVS_pixel2x2_top_468/vpd[3] openDVS_pixel2x2_top_468/vpd[2] rowReadOFF[29] rowReadON[29]
+ rowReadON[28] RefrBp PrBp PrSFBp col_periphery_1x2_20/COL_LINE0 pixRst[40] OffBn
+ rowReadOFF[28] pixRst[41] openDVS_pixel2x2_top_479/GndD DiffBn col_periphery_1x2_20/COL_LINE1
+ GndD VddA18 OnBn openDVS_pixel2x2_top
XopenDVS_pixel2x2_top_435 openDVS_pixel2x2_top_435/vpd[0] openDVS_pixel2x2_top_435/vpd[1]
+ openDVS_pixel2x2_top_435/vpd[3] openDVS_pixel2x2_top_435/vpd[2] rowReadOFF[27] rowReadON[27]
+ rowReadON[26] RefrBp PrBp PrSFBp col_periphery_1x2_19/COL_LINE0 pixRst[38] OffBn
+ rowReadOFF[26] pixRst[39] openDVS_pixel2x2_top_447/GndD DiffBn col_periphery_1x2_19/COL_LINE1
+ GndD VddA18 OnBn openDVS_pixel2x2_top
XopenDVS_pixel2x2_top_402 openDVS_pixel2x2_top_402/vpd[0] openDVS_pixel2x2_top_402/vpd[1]
+ openDVS_pixel2x2_top_402/vpd[3] openDVS_pixel2x2_top_402/vpd[2] rowReadOFF[25] rowReadON[25]
+ rowReadON[24] RefrBp PrBp PrSFBp col_periphery_1x2_18/COL_LINE0 pixRst[36] OffBn
+ rowReadOFF[24] pixRst[37] openDVS_pixel2x2_top_415/GndD DiffBn col_periphery_1x2_18/COL_LINE1
+ GndD VddA18 OnBn openDVS_pixel2x2_top
XopenDVS_pixel2x2_top_457 openDVS_pixel2x2_top_457/vpd[0] openDVS_pixel2x2_top_457/vpd[1]
+ openDVS_pixel2x2_top_457/vpd[3] openDVS_pixel2x2_top_457/vpd[2] rowReadOFF[29] rowReadON[29]
+ rowReadON[28] RefrBp PrBp PrSFBp col_periphery_1x2_9/COL_LINE0 pixRst[18] OffBn
+ rowReadOFF[28] pixRst[19] openDVS_pixel2x2_top_479/GndD DiffBn col_periphery_1x2_9/COL_LINE1
+ GndD VddA18 OnBn openDVS_pixel2x2_top
XopenDVS_pixel2x2_top_424 openDVS_pixel2x2_top_424/vpd[0] openDVS_pixel2x2_top_424/vpd[1]
+ openDVS_pixel2x2_top_424/vpd[3] openDVS_pixel2x2_top_424/vpd[2] rowReadOFF[27] rowReadON[27]
+ rowReadON[26] RefrBp PrBp PrSFBp col_periphery_1x2_8/COL_LINE0 pixRst[16] OffBn
+ rowReadOFF[26] pixRst[17] openDVS_pixel2x2_top_447/GndD DiffBn col_periphery_1x2_8/COL_LINE1
+ GndD VddA18 OnBn openDVS_pixel2x2_top
XopenDVS_pixel2x2_top_980 openDVS_pixel2x2_top_980/vpd[0] openDVS_pixel2x2_top_980/vpd[1]
+ openDVS_pixel2x2_top_980/vpd[3] openDVS_pixel2x2_top_980/vpd[2] rowReadOFF[61] rowReadON[61]
+ rowReadON[60] RefrBp PrBp PrSFBp col_periphery_1x2_20/COL_LINE0 pixRst[40] OffBn
+ rowReadOFF[60] pixRst[41] openDVS_pixel2x2_top_991/GndD DiffBn col_periphery_1x2_20/COL_LINE1
+ GndD VddA18 OnBn openDVS_pixel2x2_top
XopenDVS_pixel2x2_top_991 openDVS_pixel2x2_top_991/vpd[0] openDVS_pixel2x2_top_991/vpd[1]
+ openDVS_pixel2x2_top_991/vpd[3] openDVS_pixel2x2_top_991/vpd[2] rowReadOFF[61] rowReadON[61]
+ rowReadON[60] RefrBp PrBp PrSFBp col_periphery_1x2_31/COL_LINE0 pixRst[62] OffBn
+ rowReadOFF[60] pixRst[63] openDVS_pixel2x2_top_991/GndD DiffBn col_periphery_1x2_31/COL_LINE1
+ GndD VddA18 OnBn openDVS_pixel2x2_top
XopenDVS_pixel2x2_top_287 openDVS_pixel2x2_top_287/vpd[0] openDVS_pixel2x2_top_287/vpd[1]
+ openDVS_pixel2x2_top_287/vpd[3] openDVS_pixel2x2_top_287/vpd[2] rowReadOFF[17] rowReadON[17]
+ rowReadON[16] RefrBp PrBp PrSFBp col_periphery_1x2_31/COL_LINE0 pixRst[62] OffBn
+ rowReadOFF[16] pixRst[63] openDVS_pixel2x2_top_287/GndD DiffBn col_periphery_1x2_31/COL_LINE1
+ GndD VddA18 OnBn openDVS_pixel2x2_top
XopenDVS_pixel2x2_top_254 openDVS_pixel2x2_top_254/vpd[0] openDVS_pixel2x2_top_254/vpd[1]
+ openDVS_pixel2x2_top_254/vpd[3] openDVS_pixel2x2_top_254/vpd[2] rowReadOFF[15] rowReadON[15]
+ rowReadON[14] RefrBp PrBp PrSFBp col_periphery_1x2_30/COL_LINE0 pixRst[60] OffBn
+ rowReadOFF[14] pixRst[61] openDVS_pixel2x2_top_255/GndD DiffBn col_periphery_1x2_30/COL_LINE1
+ GndD VddA18 OnBn openDVS_pixel2x2_top
XopenDVS_pixel2x2_top_221 openDVS_pixel2x2_top_221/vpd[0] openDVS_pixel2x2_top_221/vpd[1]
+ openDVS_pixel2x2_top_221/vpd[3] openDVS_pixel2x2_top_221/vpd[2] rowReadOFF[13] rowReadON[13]
+ rowReadON[12] RefrBp PrBp PrSFBp col_periphery_1x2_29/COL_LINE0 pixRst[58] OffBn
+ rowReadOFF[12] pixRst[59] openDVS_pixel2x2_top_223/GndD DiffBn col_periphery_1x2_29/COL_LINE1
+ GndD VddA18 OnBn openDVS_pixel2x2_top
XopenDVS_pixel2x2_top_276 openDVS_pixel2x2_top_276/vpd[0] openDVS_pixel2x2_top_276/vpd[1]
+ openDVS_pixel2x2_top_276/vpd[3] openDVS_pixel2x2_top_276/vpd[2] rowReadOFF[17] rowReadON[17]
+ rowReadON[16] RefrBp PrBp PrSFBp col_periphery_1x2_20/COL_LINE0 pixRst[40] OffBn
+ rowReadOFF[16] pixRst[41] openDVS_pixel2x2_top_287/GndD DiffBn col_periphery_1x2_20/COL_LINE1
+ GndD VddA18 OnBn openDVS_pixel2x2_top
XopenDVS_pixel2x2_top_243 openDVS_pixel2x2_top_243/vpd[0] openDVS_pixel2x2_top_243/vpd[1]
+ openDVS_pixel2x2_top_243/vpd[3] openDVS_pixel2x2_top_243/vpd[2] rowReadOFF[15] rowReadON[15]
+ rowReadON[14] RefrBp PrBp PrSFBp col_periphery_1x2_19/COL_LINE0 pixRst[38] OffBn
+ rowReadOFF[14] pixRst[39] openDVS_pixel2x2_top_255/GndD DiffBn col_periphery_1x2_19/COL_LINE1
+ GndD VddA18 OnBn openDVS_pixel2x2_top
XopenDVS_pixel2x2_top_210 openDVS_pixel2x2_top_210/vpd[0] openDVS_pixel2x2_top_210/vpd[1]
+ openDVS_pixel2x2_top_210/vpd[3] openDVS_pixel2x2_top_210/vpd[2] rowReadOFF[13] rowReadON[13]
+ rowReadON[12] RefrBp PrBp PrSFBp col_periphery_1x2_18/COL_LINE0 pixRst[36] OffBn
+ rowReadOFF[12] pixRst[37] openDVS_pixel2x2_top_223/GndD DiffBn col_periphery_1x2_18/COL_LINE1
+ GndD VddA18 OnBn openDVS_pixel2x2_top
XopenDVS_pixel2x2_top_298 openDVS_pixel2x2_top_298/vpd[0] openDVS_pixel2x2_top_298/vpd[1]
+ openDVS_pixel2x2_top_298/vpd[3] openDVS_pixel2x2_top_298/vpd[2] rowReadOFF[19] rowReadON[19]
+ rowReadON[18] RefrBp PrBp PrSFBp col_periphery_1x2_10/COL_LINE0 pixRst[20] OffBn
+ rowReadOFF[18] pixRst[21] openDVS_pixel2x2_top_319/GndD DiffBn col_periphery_1x2_10/COL_LINE1
+ GndD VddA18 OnBn openDVS_pixel2x2_top
XopenDVS_pixel2x2_top_265 openDVS_pixel2x2_top_265/vpd[0] openDVS_pixel2x2_top_265/vpd[1]
+ openDVS_pixel2x2_top_265/vpd[3] openDVS_pixel2x2_top_265/vpd[2] rowReadOFF[17] rowReadON[17]
+ rowReadON[16] RefrBp PrBp PrSFBp col_periphery_1x2_9/COL_LINE0 pixRst[18] OffBn
+ rowReadOFF[16] pixRst[19] openDVS_pixel2x2_top_287/GndD DiffBn col_periphery_1x2_9/COL_LINE1
+ GndD VddA18 OnBn openDVS_pixel2x2_top
XopenDVS_pixel2x2_top_232 openDVS_pixel2x2_top_232/vpd[0] openDVS_pixel2x2_top_232/vpd[1]
+ openDVS_pixel2x2_top_232/vpd[3] openDVS_pixel2x2_top_232/vpd[2] rowReadOFF[15] rowReadON[15]
+ rowReadON[14] RefrBp PrBp PrSFBp col_periphery_1x2_8/COL_LINE0 pixRst[16] OffBn
+ rowReadOFF[14] pixRst[17] openDVS_pixel2x2_top_255/GndD DiffBn col_periphery_1x2_8/COL_LINE1
+ GndD VddA18 OnBn openDVS_pixel2x2_top
XopenDVS_pixel2x2_top_809 openDVS_pixel2x2_top_809/vpd[0] openDVS_pixel2x2_top_809/vpd[1]
+ openDVS_pixel2x2_top_809/vpd[3] openDVS_pixel2x2_top_809/vpd[2] rowReadOFF[51] rowReadON[51]
+ rowReadON[50] RefrBp PrBp PrSFBp col_periphery_1x2_9/COL_LINE0 pixRst[18] OffBn
+ rowReadOFF[50] pixRst[19] openDVS_pixel2x2_top_831/GndD DiffBn col_periphery_1x2_9/COL_LINE1
+ GndD VddA18 OnBn openDVS_pixel2x2_top
XopenDVS_pixel2x2_top_639 openDVS_pixel2x2_top_639/vpd[0] openDVS_pixel2x2_top_639/vpd[1]
+ openDVS_pixel2x2_top_639/vpd[3] openDVS_pixel2x2_top_639/vpd[2] rowReadOFF[39] rowReadON[39]
+ rowReadON[38] RefrBp PrBp PrSFBp col_periphery_1x2_31/COL_LINE0 pixRst[62] OffBn
+ rowReadOFF[38] pixRst[63] openDVS_pixel2x2_top_639/GndD DiffBn col_periphery_1x2_31/COL_LINE1
+ GndD VddA18 OnBn openDVS_pixel2x2_top
XopenDVS_pixel2x2_top_606 openDVS_pixel2x2_top_606/vpd[0] openDVS_pixel2x2_top_606/vpd[1]
+ openDVS_pixel2x2_top_606/vpd[3] openDVS_pixel2x2_top_606/vpd[2] rowReadOFF[37] rowReadON[37]
+ rowReadON[36] RefrBp PrBp PrSFBp col_periphery_1x2_30/COL_LINE0 pixRst[60] OffBn
+ rowReadOFF[36] pixRst[61] openDVS_pixel2x2_top_607/GndD DiffBn col_periphery_1x2_30/COL_LINE1
+ GndD VddA18 OnBn openDVS_pixel2x2_top
XopenDVS_pixel2x2_top_628 openDVS_pixel2x2_top_628/vpd[0] openDVS_pixel2x2_top_628/vpd[1]
+ openDVS_pixel2x2_top_628/vpd[3] openDVS_pixel2x2_top_628/vpd[2] rowReadOFF[39] rowReadON[39]
+ rowReadON[38] RefrBp PrBp PrSFBp col_periphery_1x2_20/COL_LINE0 pixRst[40] OffBn
+ rowReadOFF[38] pixRst[41] openDVS_pixel2x2_top_639/GndD DiffBn col_periphery_1x2_20/COL_LINE1
+ GndD VddA18 OnBn openDVS_pixel2x2_top
XopenDVS_pixel2x2_top_617 openDVS_pixel2x2_top_617/vpd[0] openDVS_pixel2x2_top_617/vpd[1]
+ openDVS_pixel2x2_top_617/vpd[3] openDVS_pixel2x2_top_617/vpd[2] rowReadOFF[39] rowReadON[39]
+ rowReadON[38] RefrBp PrBp PrSFBp col_periphery_1x2_9/COL_LINE0 pixRst[18] OffBn
+ rowReadOFF[38] pixRst[19] openDVS_pixel2x2_top_639/GndD DiffBn col_periphery_1x2_9/COL_LINE1
+ GndD VddA18 OnBn openDVS_pixel2x2_top
XopenDVS_pixel2x2_top_9 openDVS_pixel2x2_top_9/vpd[0] openDVS_pixel2x2_top_9/vpd[1]
+ openDVS_pixel2x2_top_9/vpd[3] openDVS_pixel2x2_top_9/vpd[2] rowReadOFF[1] rowReadON[1]
+ rowReadON[0] RefrBp PrBp PrSFBp col_periphery_1x2_9/COL_LINE0 pixRst[18] OffBn rowReadOFF[0]
+ pixRst[19] openDVS_pixel2x2_top_9/GndD DiffBn col_periphery_1x2_9/COL_LINE1 GndD
+ VddA18 OnBn openDVS_pixel2x2_top
XopenDVS_pixel2x2_top_447 openDVS_pixel2x2_top_447/vpd[0] openDVS_pixel2x2_top_447/vpd[1]
+ openDVS_pixel2x2_top_447/vpd[3] openDVS_pixel2x2_top_447/vpd[2] rowReadOFF[27] rowReadON[27]
+ rowReadON[26] RefrBp PrBp PrSFBp col_periphery_1x2_31/COL_LINE0 pixRst[62] OffBn
+ rowReadOFF[26] pixRst[63] openDVS_pixel2x2_top_447/GndD DiffBn col_periphery_1x2_31/COL_LINE1
+ GndD VddA18 OnBn openDVS_pixel2x2_top
XopenDVS_pixel2x2_top_414 openDVS_pixel2x2_top_414/vpd[0] openDVS_pixel2x2_top_414/vpd[1]
+ openDVS_pixel2x2_top_414/vpd[3] openDVS_pixel2x2_top_414/vpd[2] rowReadOFF[25] rowReadON[25]
+ rowReadON[24] RefrBp PrBp PrSFBp col_periphery_1x2_30/COL_LINE0 pixRst[60] OffBn
+ rowReadOFF[24] pixRst[61] openDVS_pixel2x2_top_415/GndD DiffBn col_periphery_1x2_30/COL_LINE1
+ GndD VddA18 OnBn openDVS_pixel2x2_top
XopenDVS_pixel2x2_top_469 openDVS_pixel2x2_top_469/vpd[0] openDVS_pixel2x2_top_469/vpd[1]
+ openDVS_pixel2x2_top_469/vpd[3] openDVS_pixel2x2_top_469/vpd[2] rowReadOFF[29] rowReadON[29]
+ rowReadON[28] RefrBp PrBp PrSFBp col_periphery_1x2_21/COL_LINE0 pixRst[42] OffBn
+ rowReadOFF[28] pixRst[43] openDVS_pixel2x2_top_479/GndD DiffBn col_periphery_1x2_21/COL_LINE1
+ GndD VddA18 OnBn openDVS_pixel2x2_top
XopenDVS_pixel2x2_top_436 openDVS_pixel2x2_top_436/vpd[0] openDVS_pixel2x2_top_436/vpd[1]
+ openDVS_pixel2x2_top_436/vpd[3] openDVS_pixel2x2_top_436/vpd[2] rowReadOFF[27] rowReadON[27]
+ rowReadON[26] RefrBp PrBp PrSFBp col_periphery_1x2_20/COL_LINE0 pixRst[40] OffBn
+ rowReadOFF[26] pixRst[41] openDVS_pixel2x2_top_447/GndD DiffBn col_periphery_1x2_20/COL_LINE1
+ GndD VddA18 OnBn openDVS_pixel2x2_top
XopenDVS_pixel2x2_top_403 openDVS_pixel2x2_top_403/vpd[0] openDVS_pixel2x2_top_403/vpd[1]
+ openDVS_pixel2x2_top_403/vpd[3] openDVS_pixel2x2_top_403/vpd[2] rowReadOFF[25] rowReadON[25]
+ rowReadON[24] RefrBp PrBp PrSFBp col_periphery_1x2_19/COL_LINE0 pixRst[38] OffBn
+ rowReadOFF[24] pixRst[39] openDVS_pixel2x2_top_415/GndD DiffBn col_periphery_1x2_19/COL_LINE1
+ GndD VddA18 OnBn openDVS_pixel2x2_top
XopenDVS_pixel2x2_top_458 openDVS_pixel2x2_top_458/vpd[0] openDVS_pixel2x2_top_458/vpd[1]
+ openDVS_pixel2x2_top_458/vpd[3] openDVS_pixel2x2_top_458/vpd[2] rowReadOFF[29] rowReadON[29]
+ rowReadON[28] RefrBp PrBp PrSFBp col_periphery_1x2_10/COL_LINE0 pixRst[20] OffBn
+ rowReadOFF[28] pixRst[21] openDVS_pixel2x2_top_479/GndD DiffBn col_periphery_1x2_10/COL_LINE1
+ GndD VddA18 OnBn openDVS_pixel2x2_top
XopenDVS_pixel2x2_top_425 openDVS_pixel2x2_top_425/vpd[0] openDVS_pixel2x2_top_425/vpd[1]
+ openDVS_pixel2x2_top_425/vpd[3] openDVS_pixel2x2_top_425/vpd[2] rowReadOFF[27] rowReadON[27]
+ rowReadON[26] RefrBp PrBp PrSFBp col_periphery_1x2_9/COL_LINE0 pixRst[18] OffBn
+ rowReadOFF[26] pixRst[19] openDVS_pixel2x2_top_447/GndD DiffBn col_periphery_1x2_9/COL_LINE1
+ GndD VddA18 OnBn openDVS_pixel2x2_top
XopenDVS_pixel2x2_top_970 openDVS_pixel2x2_top_970/vpd[0] openDVS_pixel2x2_top_970/vpd[1]
+ openDVS_pixel2x2_top_970/vpd[3] openDVS_pixel2x2_top_970/vpd[2] rowReadOFF[61] rowReadON[61]
+ rowReadON[60] RefrBp PrBp PrSFBp col_periphery_1x2_10/COL_LINE0 pixRst[20] OffBn
+ rowReadOFF[60] pixRst[21] openDVS_pixel2x2_top_991/GndD DiffBn col_periphery_1x2_10/COL_LINE1
+ GndD VddA18 OnBn openDVS_pixel2x2_top
XopenDVS_pixel2x2_top_992 openDVS_pixel2x2_top_992/vpd[0] openDVS_pixel2x2_top_992/vpd[1]
+ openDVS_pixel2x2_top_992/vpd[3] openDVS_pixel2x2_top_992/vpd[2] rowReadOFF[63] rowReadON[63]
+ rowReadON[62] RefrBp PrBp PrSFBp col_periphery_1x2_0/COL_LINE0 pixRst[0] OffBn rowReadOFF[62]
+ pixRst[1] openDVS_pixel2x2_top_999/GndD DiffBn col_periphery_1x2_0/COL_LINE1 GndD
+ VddA18 OnBn openDVS_pixel2x2_top
XopenDVS_pixel2x2_top_981 openDVS_pixel2x2_top_981/vpd[0] openDVS_pixel2x2_top_981/vpd[1]
+ openDVS_pixel2x2_top_981/vpd[3] openDVS_pixel2x2_top_981/vpd[2] rowReadOFF[61] rowReadON[61]
+ rowReadON[60] RefrBp PrBp PrSFBp col_periphery_1x2_21/COL_LINE0 pixRst[42] OffBn
+ rowReadOFF[60] pixRst[43] openDVS_pixel2x2_top_991/GndD DiffBn col_periphery_1x2_21/COL_LINE1
+ GndD VddA18 OnBn openDVS_pixel2x2_top
XopenDVS_pixel2x2_top_255 openDVS_pixel2x2_top_255/vpd[0] openDVS_pixel2x2_top_255/vpd[1]
+ openDVS_pixel2x2_top_255/vpd[3] openDVS_pixel2x2_top_255/vpd[2] rowReadOFF[15] rowReadON[15]
+ rowReadON[14] RefrBp PrBp PrSFBp col_periphery_1x2_31/COL_LINE0 pixRst[62] OffBn
+ rowReadOFF[14] pixRst[63] openDVS_pixel2x2_top_255/GndD DiffBn col_periphery_1x2_31/COL_LINE1
+ GndD VddA18 OnBn openDVS_pixel2x2_top
XopenDVS_pixel2x2_top_222 openDVS_pixel2x2_top_222/vpd[0] openDVS_pixel2x2_top_222/vpd[1]
+ openDVS_pixel2x2_top_222/vpd[3] openDVS_pixel2x2_top_222/vpd[2] rowReadOFF[13] rowReadON[13]
+ rowReadON[12] RefrBp PrBp PrSFBp col_periphery_1x2_30/COL_LINE0 pixRst[60] OffBn
+ rowReadOFF[12] pixRst[61] openDVS_pixel2x2_top_223/GndD DiffBn col_periphery_1x2_30/COL_LINE1
+ GndD VddA18 OnBn openDVS_pixel2x2_top
XopenDVS_pixel2x2_top_277 openDVS_pixel2x2_top_277/vpd[0] openDVS_pixel2x2_top_277/vpd[1]
+ openDVS_pixel2x2_top_277/vpd[3] openDVS_pixel2x2_top_277/vpd[2] rowReadOFF[17] rowReadON[17]
+ rowReadON[16] RefrBp PrBp PrSFBp col_periphery_1x2_21/COL_LINE0 pixRst[42] OffBn
+ rowReadOFF[16] pixRst[43] openDVS_pixel2x2_top_287/GndD DiffBn col_periphery_1x2_21/COL_LINE1
+ GndD VddA18 OnBn openDVS_pixel2x2_top
XopenDVS_pixel2x2_top_244 openDVS_pixel2x2_top_244/vpd[0] openDVS_pixel2x2_top_244/vpd[1]
+ openDVS_pixel2x2_top_244/vpd[3] openDVS_pixel2x2_top_244/vpd[2] rowReadOFF[15] rowReadON[15]
+ rowReadON[14] RefrBp PrBp PrSFBp col_periphery_1x2_20/COL_LINE0 pixRst[40] OffBn
+ rowReadOFF[14] pixRst[41] openDVS_pixel2x2_top_255/GndD DiffBn col_periphery_1x2_20/COL_LINE1
+ GndD VddA18 OnBn openDVS_pixel2x2_top
XopenDVS_pixel2x2_top_211 openDVS_pixel2x2_top_211/vpd[0] openDVS_pixel2x2_top_211/vpd[1]
+ openDVS_pixel2x2_top_211/vpd[3] openDVS_pixel2x2_top_211/vpd[2] rowReadOFF[13] rowReadON[13]
+ rowReadON[12] RefrBp PrBp PrSFBp col_periphery_1x2_19/COL_LINE0 pixRst[38] OffBn
+ rowReadOFF[12] pixRst[39] openDVS_pixel2x2_top_223/GndD DiffBn col_periphery_1x2_19/COL_LINE1
+ GndD VddA18 OnBn openDVS_pixel2x2_top
XopenDVS_pixel2x2_top_266 openDVS_pixel2x2_top_266/vpd[0] openDVS_pixel2x2_top_266/vpd[1]
+ openDVS_pixel2x2_top_266/vpd[3] openDVS_pixel2x2_top_266/vpd[2] rowReadOFF[17] rowReadON[17]
+ rowReadON[16] RefrBp PrBp PrSFBp col_periphery_1x2_10/COL_LINE0 pixRst[20] OffBn
+ rowReadOFF[16] pixRst[21] openDVS_pixel2x2_top_287/GndD DiffBn col_periphery_1x2_10/COL_LINE1
+ GndD VddA18 OnBn openDVS_pixel2x2_top
XopenDVS_pixel2x2_top_299 openDVS_pixel2x2_top_299/vpd[0] openDVS_pixel2x2_top_299/vpd[1]
+ openDVS_pixel2x2_top_299/vpd[3] openDVS_pixel2x2_top_299/vpd[2] rowReadOFF[19] rowReadON[19]
+ rowReadON[18] RefrBp PrBp PrSFBp col_periphery_1x2_11/COL_LINE0 pixRst[22] OffBn
+ rowReadOFF[18] pixRst[23] openDVS_pixel2x2_top_319/GndD DiffBn col_periphery_1x2_11/COL_LINE1
+ GndD VddA18 OnBn openDVS_pixel2x2_top
XopenDVS_pixel2x2_top_233 openDVS_pixel2x2_top_233/vpd[0] openDVS_pixel2x2_top_233/vpd[1]
+ openDVS_pixel2x2_top_233/vpd[3] openDVS_pixel2x2_top_233/vpd[2] rowReadOFF[15] rowReadON[15]
+ rowReadON[14] RefrBp PrBp PrSFBp col_periphery_1x2_9/COL_LINE0 pixRst[18] OffBn
+ rowReadOFF[14] pixRst[19] openDVS_pixel2x2_top_255/GndD DiffBn col_periphery_1x2_9/COL_LINE1
+ GndD VddA18 OnBn openDVS_pixel2x2_top
XopenDVS_pixel2x2_top_200 openDVS_pixel2x2_top_200/vpd[0] openDVS_pixel2x2_top_200/vpd[1]
+ openDVS_pixel2x2_top_200/vpd[3] openDVS_pixel2x2_top_200/vpd[2] rowReadOFF[13] rowReadON[13]
+ rowReadON[12] RefrBp PrBp PrSFBp col_periphery_1x2_8/COL_LINE0 pixRst[16] OffBn
+ rowReadOFF[12] pixRst[17] openDVS_pixel2x2_top_223/GndD DiffBn col_periphery_1x2_8/COL_LINE1
+ GndD VddA18 OnBn openDVS_pixel2x2_top
XopenDVS_pixel2x2_top_288 openDVS_pixel2x2_top_288/vpd[0] openDVS_pixel2x2_top_288/vpd[1]
+ openDVS_pixel2x2_top_288/vpd[3] openDVS_pixel2x2_top_288/vpd[2] rowReadOFF[19] rowReadON[19]
+ rowReadON[18] RefrBp PrBp PrSFBp col_periphery_1x2_0/COL_LINE0 pixRst[0] OffBn rowReadOFF[18]
+ pixRst[1] openDVS_pixel2x2_top_319/GndD DiffBn col_periphery_1x2_0/COL_LINE1 GndD
+ VddA18 OnBn openDVS_pixel2x2_top
Xcol_periphery_1x2_30 pixRst[61] col_periphery_1x2_30/COL_LINE0 col_periphery_1x2_30/COL_LINE1
+ nDETECT col_periphery_1x2_9/VDD DETECT VTHRESH voutn[60] GndD NCHARGE voutn[61]
+ pixRst[60] col_periphery_1x2
XopenDVS_pixel2x2_top_607 openDVS_pixel2x2_top_607/vpd[0] openDVS_pixel2x2_top_607/vpd[1]
+ openDVS_pixel2x2_top_607/vpd[3] openDVS_pixel2x2_top_607/vpd[2] rowReadOFF[37] rowReadON[37]
+ rowReadON[36] RefrBp PrBp PrSFBp col_periphery_1x2_31/COL_LINE0 pixRst[62] OffBn
+ rowReadOFF[36] pixRst[63] openDVS_pixel2x2_top_607/GndD DiffBn col_periphery_1x2_31/COL_LINE1
+ GndD VddA18 OnBn openDVS_pixel2x2_top
XopenDVS_pixel2x2_top_629 openDVS_pixel2x2_top_629/vpd[0] openDVS_pixel2x2_top_629/vpd[1]
+ openDVS_pixel2x2_top_629/vpd[3] openDVS_pixel2x2_top_629/vpd[2] rowReadOFF[39] rowReadON[39]
+ rowReadON[38] RefrBp PrBp PrSFBp col_periphery_1x2_21/COL_LINE0 pixRst[42] OffBn
+ rowReadOFF[38] pixRst[43] openDVS_pixel2x2_top_639/GndD DiffBn col_periphery_1x2_21/COL_LINE1
+ GndD VddA18 OnBn openDVS_pixel2x2_top
XopenDVS_pixel2x2_top_618 openDVS_pixel2x2_top_618/vpd[0] openDVS_pixel2x2_top_618/vpd[1]
+ openDVS_pixel2x2_top_618/vpd[3] openDVS_pixel2x2_top_618/vpd[2] rowReadOFF[39] rowReadON[39]
+ rowReadON[38] RefrBp PrBp PrSFBp col_periphery_1x2_10/COL_LINE0 pixRst[20] OffBn
+ rowReadOFF[38] pixRst[21] openDVS_pixel2x2_top_639/GndD DiffBn col_periphery_1x2_10/COL_LINE1
+ GndD VddA18 OnBn openDVS_pixel2x2_top
XopenDVS_pixel2x2_top_415 openDVS_pixel2x2_top_415/vpd[0] openDVS_pixel2x2_top_415/vpd[1]
+ openDVS_pixel2x2_top_415/vpd[3] openDVS_pixel2x2_top_415/vpd[2] rowReadOFF[25] rowReadON[25]
+ rowReadON[24] RefrBp PrBp PrSFBp col_periphery_1x2_31/COL_LINE0 pixRst[62] OffBn
+ rowReadOFF[24] pixRst[63] openDVS_pixel2x2_top_415/GndD DiffBn col_periphery_1x2_31/COL_LINE1
+ GndD VddA18 OnBn openDVS_pixel2x2_top
XopenDVS_pixel2x2_top_437 openDVS_pixel2x2_top_437/vpd[0] openDVS_pixel2x2_top_437/vpd[1]
+ openDVS_pixel2x2_top_437/vpd[3] openDVS_pixel2x2_top_437/vpd[2] rowReadOFF[27] rowReadON[27]
+ rowReadON[26] RefrBp PrBp PrSFBp col_periphery_1x2_21/COL_LINE0 pixRst[42] OffBn
+ rowReadOFF[26] pixRst[43] openDVS_pixel2x2_top_447/GndD DiffBn col_periphery_1x2_21/COL_LINE1
+ GndD VddA18 OnBn openDVS_pixel2x2_top
XopenDVS_pixel2x2_top_404 openDVS_pixel2x2_top_404/vpd[0] openDVS_pixel2x2_top_404/vpd[1]
+ openDVS_pixel2x2_top_404/vpd[3] openDVS_pixel2x2_top_404/vpd[2] rowReadOFF[25] rowReadON[25]
+ rowReadON[24] RefrBp PrBp PrSFBp col_periphery_1x2_20/COL_LINE0 pixRst[40] OffBn
+ rowReadOFF[24] pixRst[41] openDVS_pixel2x2_top_415/GndD DiffBn col_periphery_1x2_20/COL_LINE1
+ GndD VddA18 OnBn openDVS_pixel2x2_top
XopenDVS_pixel2x2_top_426 openDVS_pixel2x2_top_426/vpd[0] openDVS_pixel2x2_top_426/vpd[1]
+ openDVS_pixel2x2_top_426/vpd[3] openDVS_pixel2x2_top_426/vpd[2] rowReadOFF[27] rowReadON[27]
+ rowReadON[26] RefrBp PrBp PrSFBp col_periphery_1x2_10/COL_LINE0 pixRst[20] OffBn
+ rowReadOFF[26] pixRst[21] openDVS_pixel2x2_top_447/GndD DiffBn col_periphery_1x2_10/COL_LINE1
+ GndD VddA18 OnBn openDVS_pixel2x2_top
XopenDVS_pixel2x2_top_459 openDVS_pixel2x2_top_459/vpd[0] openDVS_pixel2x2_top_459/vpd[1]
+ openDVS_pixel2x2_top_459/vpd[3] openDVS_pixel2x2_top_459/vpd[2] rowReadOFF[29] rowReadON[29]
+ rowReadON[28] RefrBp PrBp PrSFBp col_periphery_1x2_11/COL_LINE0 pixRst[22] OffBn
+ rowReadOFF[28] pixRst[23] openDVS_pixel2x2_top_479/GndD DiffBn col_periphery_1x2_11/COL_LINE1
+ GndD VddA18 OnBn openDVS_pixel2x2_top
XopenDVS_pixel2x2_top_448 openDVS_pixel2x2_top_448/vpd[0] openDVS_pixel2x2_top_448/vpd[1]
+ openDVS_pixel2x2_top_448/vpd[3] openDVS_pixel2x2_top_448/vpd[2] rowReadOFF[29] rowReadON[29]
+ rowReadON[28] RefrBp PrBp PrSFBp col_periphery_1x2_0/COL_LINE0 pixRst[0] OffBn rowReadOFF[28]
+ pixRst[1] openDVS_pixel2x2_top_479/GndD DiffBn col_periphery_1x2_0/COL_LINE1 GndD
+ VddA18 OnBn openDVS_pixel2x2_top
XopenDVS_pixel2x2_top_971 openDVS_pixel2x2_top_971/vpd[0] openDVS_pixel2x2_top_971/vpd[1]
+ openDVS_pixel2x2_top_971/vpd[3] openDVS_pixel2x2_top_971/vpd[2] rowReadOFF[61] rowReadON[61]
+ rowReadON[60] RefrBp PrBp PrSFBp col_periphery_1x2_11/COL_LINE0 pixRst[22] OffBn
+ rowReadOFF[60] pixRst[23] openDVS_pixel2x2_top_991/GndD DiffBn col_periphery_1x2_11/COL_LINE1
+ GndD VddA18 OnBn openDVS_pixel2x2_top
XopenDVS_pixel2x2_top_960 openDVS_pixel2x2_top_960/vpd[0] openDVS_pixel2x2_top_960/vpd[1]
+ openDVS_pixel2x2_top_960/vpd[3] openDVS_pixel2x2_top_960/vpd[2] rowReadOFF[61] rowReadON[61]
+ rowReadON[60] RefrBp PrBp PrSFBp col_periphery_1x2_0/COL_LINE0 pixRst[0] OffBn rowReadOFF[60]
+ pixRst[1] openDVS_pixel2x2_top_991/GndD DiffBn col_periphery_1x2_0/COL_LINE1 GndD
+ VddA18 OnBn openDVS_pixel2x2_top
XopenDVS_pixel2x2_top_982 openDVS_pixel2x2_top_982/vpd[0] openDVS_pixel2x2_top_982/vpd[1]
+ openDVS_pixel2x2_top_982/vpd[3] openDVS_pixel2x2_top_982/vpd[2] rowReadOFF[61] rowReadON[61]
+ rowReadON[60] RefrBp PrBp PrSFBp col_periphery_1x2_22/COL_LINE0 pixRst[44] OffBn
+ rowReadOFF[60] pixRst[45] openDVS_pixel2x2_top_991/GndD DiffBn col_periphery_1x2_22/COL_LINE1
+ GndD VddA18 OnBn openDVS_pixel2x2_top
XopenDVS_pixel2x2_top_993 openDVS_pixel2x2_top_993/vpd[0] openDVS_pixel2x2_top_993/vpd[1]
+ openDVS_pixel2x2_top_993/vpd[3] openDVS_pixel2x2_top_993/vpd[2] rowReadOFF[63] rowReadON[63]
+ rowReadON[62] RefrBp PrBp PrSFBp col_periphery_1x2_1/COL_LINE0 pixRst[2] OffBn rowReadOFF[62]
+ pixRst[3] openDVS_pixel2x2_top_999/GndD DiffBn col_periphery_1x2_1/COL_LINE1 GndD
+ VddA18 OnBn openDVS_pixel2x2_top
XopenDVS_pixel2x2_top_223 openDVS_pixel2x2_top_223/vpd[0] openDVS_pixel2x2_top_223/vpd[1]
+ openDVS_pixel2x2_top_223/vpd[3] openDVS_pixel2x2_top_223/vpd[2] rowReadOFF[13] rowReadON[13]
+ rowReadON[12] RefrBp PrBp PrSFBp col_periphery_1x2_31/COL_LINE0 pixRst[62] OffBn
+ rowReadOFF[12] pixRst[63] openDVS_pixel2x2_top_223/GndD DiffBn col_periphery_1x2_31/COL_LINE1
+ GndD VddA18 OnBn openDVS_pixel2x2_top
XopenDVS_pixel2x2_top_245 openDVS_pixel2x2_top_245/vpd[0] openDVS_pixel2x2_top_245/vpd[1]
+ openDVS_pixel2x2_top_245/vpd[3] openDVS_pixel2x2_top_245/vpd[2] rowReadOFF[15] rowReadON[15]
+ rowReadON[14] RefrBp PrBp PrSFBp col_periphery_1x2_21/COL_LINE0 pixRst[42] OffBn
+ rowReadOFF[14] pixRst[43] openDVS_pixel2x2_top_255/GndD DiffBn col_periphery_1x2_21/COL_LINE1
+ GndD VddA18 OnBn openDVS_pixel2x2_top
XopenDVS_pixel2x2_top_278 openDVS_pixel2x2_top_278/vpd[0] openDVS_pixel2x2_top_278/vpd[1]
+ openDVS_pixel2x2_top_278/vpd[3] openDVS_pixel2x2_top_278/vpd[2] rowReadOFF[17] rowReadON[17]
+ rowReadON[16] RefrBp PrBp PrSFBp col_periphery_1x2_22/COL_LINE0 pixRst[44] OffBn
+ rowReadOFF[16] pixRst[45] openDVS_pixel2x2_top_287/GndD DiffBn col_periphery_1x2_22/COL_LINE1
+ GndD VddA18 OnBn openDVS_pixel2x2_top
XopenDVS_pixel2x2_top_212 openDVS_pixel2x2_top_212/vpd[0] openDVS_pixel2x2_top_212/vpd[1]
+ openDVS_pixel2x2_top_212/vpd[3] openDVS_pixel2x2_top_212/vpd[2] rowReadOFF[13] rowReadON[13]
+ rowReadON[12] RefrBp PrBp PrSFBp col_periphery_1x2_20/COL_LINE0 pixRst[40] OffBn
+ rowReadOFF[12] pixRst[41] openDVS_pixel2x2_top_223/GndD DiffBn col_periphery_1x2_20/COL_LINE1
+ GndD VddA18 OnBn openDVS_pixel2x2_top
XopenDVS_pixel2x2_top_234 openDVS_pixel2x2_top_234/vpd[0] openDVS_pixel2x2_top_234/vpd[1]
+ openDVS_pixel2x2_top_234/vpd[3] openDVS_pixel2x2_top_234/vpd[2] rowReadOFF[15] rowReadON[15]
+ rowReadON[14] RefrBp PrBp PrSFBp col_periphery_1x2_10/COL_LINE0 pixRst[20] OffBn
+ rowReadOFF[14] pixRst[21] openDVS_pixel2x2_top_255/GndD DiffBn col_periphery_1x2_10/COL_LINE1
+ GndD VddA18 OnBn openDVS_pixel2x2_top
XopenDVS_pixel2x2_top_267 openDVS_pixel2x2_top_267/vpd[0] openDVS_pixel2x2_top_267/vpd[1]
+ openDVS_pixel2x2_top_267/vpd[3] openDVS_pixel2x2_top_267/vpd[2] rowReadOFF[17] rowReadON[17]
+ rowReadON[16] RefrBp PrBp PrSFBp col_periphery_1x2_11/COL_LINE0 pixRst[22] OffBn
+ rowReadOFF[16] pixRst[23] openDVS_pixel2x2_top_287/GndD DiffBn col_periphery_1x2_11/COL_LINE1
+ GndD VddA18 OnBn openDVS_pixel2x2_top
XopenDVS_pixel2x2_top_201 openDVS_pixel2x2_top_201/vpd[0] openDVS_pixel2x2_top_201/vpd[1]
+ openDVS_pixel2x2_top_201/vpd[3] openDVS_pixel2x2_top_201/vpd[2] rowReadOFF[13] rowReadON[13]
+ rowReadON[12] RefrBp PrBp PrSFBp col_periphery_1x2_9/COL_LINE0 pixRst[18] OffBn
+ rowReadOFF[12] pixRst[19] openDVS_pixel2x2_top_223/GndD DiffBn col_periphery_1x2_9/COL_LINE1
+ GndD VddA18 OnBn openDVS_pixel2x2_top
XopenDVS_pixel2x2_top_256 openDVS_pixel2x2_top_256/vpd[0] openDVS_pixel2x2_top_256/vpd[1]
+ openDVS_pixel2x2_top_256/vpd[3] openDVS_pixel2x2_top_256/vpd[2] rowReadOFF[17] rowReadON[17]
+ rowReadON[16] RefrBp PrBp PrSFBp col_periphery_1x2_0/COL_LINE0 pixRst[0] OffBn rowReadOFF[16]
+ pixRst[1] openDVS_pixel2x2_top_287/GndD DiffBn col_periphery_1x2_0/COL_LINE1 GndD
+ VddA18 OnBn openDVS_pixel2x2_top
XopenDVS_pixel2x2_top_289 openDVS_pixel2x2_top_289/vpd[0] openDVS_pixel2x2_top_289/vpd[1]
+ openDVS_pixel2x2_top_289/vpd[3] openDVS_pixel2x2_top_289/vpd[2] rowReadOFF[19] rowReadON[19]
+ rowReadON[18] RefrBp PrBp PrSFBp col_periphery_1x2_1/COL_LINE0 pixRst[2] OffBn rowReadOFF[18]
+ pixRst[3] openDVS_pixel2x2_top_319/GndD DiffBn col_periphery_1x2_1/COL_LINE1 GndD
+ VddA18 OnBn openDVS_pixel2x2_top
XopenDVS_pixel2x2_top_790 openDVS_pixel2x2_top_790/vpd[0] openDVS_pixel2x2_top_790/vpd[1]
+ openDVS_pixel2x2_top_790/vpd[3] openDVS_pixel2x2_top_790/vpd[2] rowReadOFF[49] rowReadON[49]
+ rowReadON[48] RefrBp PrBp PrSFBp col_periphery_1x2_22/COL_LINE0 pixRst[44] OffBn
+ rowReadOFF[48] pixRst[45] openDVS_pixel2x2_top_799/GndD DiffBn col_periphery_1x2_22/COL_LINE1
+ GndD VddA18 OnBn openDVS_pixel2x2_top
Xcol_periphery_1x2_31 pixRst[63] col_periphery_1x2_31/COL_LINE0 col_periphery_1x2_31/COL_LINE1
+ nDETECT col_periphery_1x2_9/VDD DETECT VTHRESH voutn[62] GndD NCHARGE voutn[63]
+ pixRst[62] col_periphery_1x2
Xcol_periphery_1x2_20 pixRst[41] col_periphery_1x2_20/COL_LINE0 col_periphery_1x2_20/COL_LINE1
+ nDETECT col_periphery_1x2_9/VDD DETECT VTHRESH voutn[40] GndD NCHARGE voutn[41]
+ pixRst[40] col_periphery_1x2
XopenDVS_pixel2x2_top_619 openDVS_pixel2x2_top_619/vpd[0] openDVS_pixel2x2_top_619/vpd[1]
+ openDVS_pixel2x2_top_619/vpd[3] openDVS_pixel2x2_top_619/vpd[2] rowReadOFF[39] rowReadON[39]
+ rowReadON[38] RefrBp PrBp PrSFBp col_periphery_1x2_11/COL_LINE0 pixRst[22] OffBn
+ rowReadOFF[38] pixRst[23] openDVS_pixel2x2_top_639/GndD DiffBn col_periphery_1x2_11/COL_LINE1
+ GndD VddA18 OnBn openDVS_pixel2x2_top
XopenDVS_pixel2x2_top_608 openDVS_pixel2x2_top_608/vpd[0] openDVS_pixel2x2_top_608/vpd[1]
+ openDVS_pixel2x2_top_608/vpd[3] openDVS_pixel2x2_top_608/vpd[2] rowReadOFF[39] rowReadON[39]
+ rowReadON[38] RefrBp PrBp PrSFBp col_periphery_1x2_0/COL_LINE0 pixRst[0] OffBn rowReadOFF[38]
+ pixRst[1] openDVS_pixel2x2_top_639/GndD DiffBn col_periphery_1x2_0/COL_LINE1 GndD
+ VddA18 OnBn openDVS_pixel2x2_top
XopenDVS_pixel2x2_top_405 openDVS_pixel2x2_top_405/vpd[0] openDVS_pixel2x2_top_405/vpd[1]
+ openDVS_pixel2x2_top_405/vpd[3] openDVS_pixel2x2_top_405/vpd[2] rowReadOFF[25] rowReadON[25]
+ rowReadON[24] RefrBp PrBp PrSFBp col_periphery_1x2_21/COL_LINE0 pixRst[42] OffBn
+ rowReadOFF[24] pixRst[43] openDVS_pixel2x2_top_415/GndD DiffBn col_periphery_1x2_21/COL_LINE1
+ GndD VddA18 OnBn openDVS_pixel2x2_top
XopenDVS_pixel2x2_top_438 openDVS_pixel2x2_top_438/vpd[0] openDVS_pixel2x2_top_438/vpd[1]
+ openDVS_pixel2x2_top_438/vpd[3] openDVS_pixel2x2_top_438/vpd[2] rowReadOFF[27] rowReadON[27]
+ rowReadON[26] RefrBp PrBp PrSFBp col_periphery_1x2_22/COL_LINE0 pixRst[44] OffBn
+ rowReadOFF[26] pixRst[45] openDVS_pixel2x2_top_447/GndD DiffBn col_periphery_1x2_22/COL_LINE1
+ GndD VddA18 OnBn openDVS_pixel2x2_top
XopenDVS_pixel2x2_top_427 openDVS_pixel2x2_top_427/vpd[0] openDVS_pixel2x2_top_427/vpd[1]
+ openDVS_pixel2x2_top_427/vpd[3] openDVS_pixel2x2_top_427/vpd[2] rowReadOFF[27] rowReadON[27]
+ rowReadON[26] RefrBp PrBp PrSFBp col_periphery_1x2_11/COL_LINE0 pixRst[22] OffBn
+ rowReadOFF[26] pixRst[23] openDVS_pixel2x2_top_447/GndD DiffBn col_periphery_1x2_11/COL_LINE1
+ GndD VddA18 OnBn openDVS_pixel2x2_top
XopenDVS_pixel2x2_top_416 openDVS_pixel2x2_top_416/vpd[0] openDVS_pixel2x2_top_416/vpd[1]
+ openDVS_pixel2x2_top_416/vpd[3] openDVS_pixel2x2_top_416/vpd[2] rowReadOFF[27] rowReadON[27]
+ rowReadON[26] RefrBp PrBp PrSFBp col_periphery_1x2_0/COL_LINE0 pixRst[0] OffBn rowReadOFF[26]
+ pixRst[1] openDVS_pixel2x2_top_447/GndD DiffBn col_periphery_1x2_0/COL_LINE1 GndD
+ VddA18 OnBn openDVS_pixel2x2_top
XopenDVS_pixel2x2_top_449 openDVS_pixel2x2_top_449/vpd[0] openDVS_pixel2x2_top_449/vpd[1]
+ openDVS_pixel2x2_top_449/vpd[3] openDVS_pixel2x2_top_449/vpd[2] rowReadOFF[29] rowReadON[29]
+ rowReadON[28] RefrBp PrBp PrSFBp col_periphery_1x2_1/COL_LINE0 pixRst[2] OffBn rowReadOFF[28]
+ pixRst[3] openDVS_pixel2x2_top_479/GndD DiffBn col_periphery_1x2_1/COL_LINE1 GndD
+ VddA18 OnBn openDVS_pixel2x2_top
XopenDVS_pixel2x2_top_972 openDVS_pixel2x2_top_972/vpd[0] openDVS_pixel2x2_top_972/vpd[1]
+ openDVS_pixel2x2_top_972/vpd[3] openDVS_pixel2x2_top_972/vpd[2] rowReadOFF[61] rowReadON[61]
+ rowReadON[60] RefrBp PrBp PrSFBp col_periphery_1x2_12/COL_LINE0 pixRst[24] OffBn
+ rowReadOFF[60] pixRst[25] openDVS_pixel2x2_top_991/GndD DiffBn col_periphery_1x2_12/COL_LINE1
+ GndD VddA18 OnBn openDVS_pixel2x2_top
XopenDVS_pixel2x2_top_994 openDVS_pixel2x2_top_994/vpd[0] openDVS_pixel2x2_top_994/vpd[1]
+ openDVS_pixel2x2_top_994/vpd[3] openDVS_pixel2x2_top_994/vpd[2] rowReadOFF[63] rowReadON[63]
+ rowReadON[62] RefrBp PrBp PrSFBp col_periphery_1x2_2/COL_LINE0 pixRst[4] OffBn rowReadOFF[62]
+ pixRst[5] openDVS_pixel2x2_top_999/GndD DiffBn col_periphery_1x2_2/COL_LINE1 GndD
+ VddA18 OnBn openDVS_pixel2x2_top
XopenDVS_pixel2x2_top_961 openDVS_pixel2x2_top_961/vpd[0] openDVS_pixel2x2_top_961/vpd[1]
+ openDVS_pixel2x2_top_961/vpd[3] openDVS_pixel2x2_top_961/vpd[2] rowReadOFF[61] rowReadON[61]
+ rowReadON[60] RefrBp PrBp PrSFBp col_periphery_1x2_1/COL_LINE0 pixRst[2] OffBn rowReadOFF[60]
+ pixRst[3] openDVS_pixel2x2_top_991/GndD DiffBn col_periphery_1x2_1/COL_LINE1 GndD
+ VddA18 OnBn openDVS_pixel2x2_top
XopenDVS_pixel2x2_top_950 openDVS_pixel2x2_top_950/vpd[0] openDVS_pixel2x2_top_950/vpd[1]
+ openDVS_pixel2x2_top_950/vpd[3] openDVS_pixel2x2_top_950/vpd[2] rowReadOFF[59] rowReadON[59]
+ rowReadON[58] RefrBp PrBp PrSFBp col_periphery_1x2_22/COL_LINE0 pixRst[44] OffBn
+ rowReadOFF[58] pixRst[45] openDVS_pixel2x2_top_959/GndD DiffBn col_periphery_1x2_22/COL_LINE1
+ GndD VddA18 OnBn openDVS_pixel2x2_top
XopenDVS_pixel2x2_top_983 openDVS_pixel2x2_top_983/vpd[0] openDVS_pixel2x2_top_983/vpd[1]
+ openDVS_pixel2x2_top_983/vpd[3] openDVS_pixel2x2_top_983/vpd[2] rowReadOFF[61] rowReadON[61]
+ rowReadON[60] RefrBp PrBp PrSFBp col_periphery_1x2_23/COL_LINE0 pixRst[46] OffBn
+ rowReadOFF[60] pixRst[47] openDVS_pixel2x2_top_991/GndD DiffBn col_periphery_1x2_23/COL_LINE1
+ GndD VddA18 OnBn openDVS_pixel2x2_top
XopenDVS_pixel2x2_top_279 openDVS_pixel2x2_top_279/vpd[0] openDVS_pixel2x2_top_279/vpd[1]
+ openDVS_pixel2x2_top_279/vpd[3] openDVS_pixel2x2_top_279/vpd[2] rowReadOFF[17] rowReadON[17]
+ rowReadON[16] RefrBp PrBp PrSFBp col_periphery_1x2_23/COL_LINE0 pixRst[46] OffBn
+ rowReadOFF[16] pixRst[47] openDVS_pixel2x2_top_287/GndD DiffBn col_periphery_1x2_23/COL_LINE1
+ GndD VddA18 OnBn openDVS_pixel2x2_top
XopenDVS_pixel2x2_top_213 openDVS_pixel2x2_top_213/vpd[0] openDVS_pixel2x2_top_213/vpd[1]
+ openDVS_pixel2x2_top_213/vpd[3] openDVS_pixel2x2_top_213/vpd[2] rowReadOFF[13] rowReadON[13]
+ rowReadON[12] RefrBp PrBp PrSFBp col_periphery_1x2_21/COL_LINE0 pixRst[42] OffBn
+ rowReadOFF[12] pixRst[43] openDVS_pixel2x2_top_223/GndD DiffBn col_periphery_1x2_21/COL_LINE1
+ GndD VddA18 OnBn openDVS_pixel2x2_top
XopenDVS_pixel2x2_top_246 openDVS_pixel2x2_top_246/vpd[0] openDVS_pixel2x2_top_246/vpd[1]
+ openDVS_pixel2x2_top_246/vpd[3] openDVS_pixel2x2_top_246/vpd[2] rowReadOFF[15] rowReadON[15]
+ rowReadON[14] RefrBp PrBp PrSFBp col_periphery_1x2_22/COL_LINE0 pixRst[44] OffBn
+ rowReadOFF[14] pixRst[45] openDVS_pixel2x2_top_255/GndD DiffBn col_periphery_1x2_22/COL_LINE1
+ GndD VddA18 OnBn openDVS_pixel2x2_top
XopenDVS_pixel2x2_top_268 openDVS_pixel2x2_top_268/vpd[0] openDVS_pixel2x2_top_268/vpd[1]
+ openDVS_pixel2x2_top_268/vpd[3] openDVS_pixel2x2_top_268/vpd[2] rowReadOFF[17] rowReadON[17]
+ rowReadON[16] RefrBp PrBp PrSFBp col_periphery_1x2_12/COL_LINE0 pixRst[24] OffBn
+ rowReadOFF[16] pixRst[25] openDVS_pixel2x2_top_287/GndD DiffBn col_periphery_1x2_12/COL_LINE1
+ GndD VddA18 OnBn openDVS_pixel2x2_top
XopenDVS_pixel2x2_top_202 openDVS_pixel2x2_top_202/vpd[0] openDVS_pixel2x2_top_202/vpd[1]
+ openDVS_pixel2x2_top_202/vpd[3] openDVS_pixel2x2_top_202/vpd[2] rowReadOFF[13] rowReadON[13]
+ rowReadON[12] RefrBp PrBp PrSFBp col_periphery_1x2_10/COL_LINE0 pixRst[20] OffBn
+ rowReadOFF[12] pixRst[21] openDVS_pixel2x2_top_223/GndD DiffBn col_periphery_1x2_10/COL_LINE1
+ GndD VddA18 OnBn openDVS_pixel2x2_top
XopenDVS_pixel2x2_top_235 openDVS_pixel2x2_top_235/vpd[0] openDVS_pixel2x2_top_235/vpd[1]
+ openDVS_pixel2x2_top_235/vpd[3] openDVS_pixel2x2_top_235/vpd[2] rowReadOFF[15] rowReadON[15]
+ rowReadON[14] RefrBp PrBp PrSFBp col_periphery_1x2_11/COL_LINE0 pixRst[22] OffBn
+ rowReadOFF[14] pixRst[23] openDVS_pixel2x2_top_255/GndD DiffBn col_periphery_1x2_11/COL_LINE1
+ GndD VddA18 OnBn openDVS_pixel2x2_top
XopenDVS_pixel2x2_top_224 openDVS_pixel2x2_top_224/vpd[0] openDVS_pixel2x2_top_224/vpd[1]
+ openDVS_pixel2x2_top_224/vpd[3] openDVS_pixel2x2_top_224/vpd[2] rowReadOFF[15] rowReadON[15]
+ rowReadON[14] RefrBp PrBp PrSFBp col_periphery_1x2_0/COL_LINE0 pixRst[0] OffBn rowReadOFF[14]
+ pixRst[1] openDVS_pixel2x2_top_255/GndD DiffBn col_periphery_1x2_0/COL_LINE1 GndD
+ VddA18 OnBn openDVS_pixel2x2_top
XopenDVS_pixel2x2_top_257 openDVS_pixel2x2_top_257/vpd[0] openDVS_pixel2x2_top_257/vpd[1]
+ openDVS_pixel2x2_top_257/vpd[3] openDVS_pixel2x2_top_257/vpd[2] rowReadOFF[17] rowReadON[17]
+ rowReadON[16] RefrBp PrBp PrSFBp col_periphery_1x2_1/COL_LINE0 pixRst[2] OffBn rowReadOFF[16]
+ pixRst[3] openDVS_pixel2x2_top_287/GndD DiffBn col_periphery_1x2_1/COL_LINE1 GndD
+ VddA18 OnBn openDVS_pixel2x2_top
XopenDVS_pixel2x2_top_780 openDVS_pixel2x2_top_780/vpd[0] openDVS_pixel2x2_top_780/vpd[1]
+ openDVS_pixel2x2_top_780/vpd[3] openDVS_pixel2x2_top_780/vpd[2] rowReadOFF[49] rowReadON[49]
+ rowReadON[48] RefrBp PrBp PrSFBp col_periphery_1x2_12/COL_LINE0 pixRst[24] OffBn
+ rowReadOFF[48] pixRst[25] openDVS_pixel2x2_top_799/GndD DiffBn col_periphery_1x2_12/COL_LINE1
+ GndD VddA18 OnBn openDVS_pixel2x2_top
XopenDVS_pixel2x2_top_791 openDVS_pixel2x2_top_791/vpd[0] openDVS_pixel2x2_top_791/vpd[1]
+ openDVS_pixel2x2_top_791/vpd[3] openDVS_pixel2x2_top_791/vpd[2] rowReadOFF[49] rowReadON[49]
+ rowReadON[48] RefrBp PrBp PrSFBp col_periphery_1x2_23/COL_LINE0 pixRst[46] OffBn
+ rowReadOFF[48] pixRst[47] openDVS_pixel2x2_top_799/GndD DiffBn col_periphery_1x2_23/COL_LINE1
+ GndD VddA18 OnBn openDVS_pixel2x2_top
Xcol_periphery_1x2_21 pixRst[43] col_periphery_1x2_21/COL_LINE0 col_periphery_1x2_21/COL_LINE1
+ nDETECT col_periphery_1x2_9/VDD DETECT VTHRESH voutn[42] GndD NCHARGE voutn[43]
+ pixRst[42] col_periphery_1x2
Xcol_periphery_1x2_10 pixRst[21] col_periphery_1x2_10/COL_LINE0 col_periphery_1x2_10/COL_LINE1
+ nDETECT col_periphery_1x2_9/VDD DETECT VTHRESH voutn[20] GndD NCHARGE voutn[21]
+ pixRst[20] col_periphery_1x2
XopenDVS_pixel2x2_top_609 openDVS_pixel2x2_top_609/vpd[0] openDVS_pixel2x2_top_609/vpd[1]
+ openDVS_pixel2x2_top_609/vpd[3] openDVS_pixel2x2_top_609/vpd[2] rowReadOFF[39] rowReadON[39]
+ rowReadON[38] RefrBp PrBp PrSFBp col_periphery_1x2_1/COL_LINE0 pixRst[2] OffBn rowReadOFF[38]
+ pixRst[3] openDVS_pixel2x2_top_639/GndD DiffBn col_periphery_1x2_1/COL_LINE1 GndD
+ VddA18 OnBn openDVS_pixel2x2_top
XopenDVS_pixel2x2_top_439 openDVS_pixel2x2_top_439/vpd[0] openDVS_pixel2x2_top_439/vpd[1]
+ openDVS_pixel2x2_top_439/vpd[3] openDVS_pixel2x2_top_439/vpd[2] rowReadOFF[27] rowReadON[27]
+ rowReadON[26] RefrBp PrBp PrSFBp col_periphery_1x2_23/COL_LINE0 pixRst[46] OffBn
+ rowReadOFF[26] pixRst[47] openDVS_pixel2x2_top_447/GndD DiffBn col_periphery_1x2_23/COL_LINE1
+ GndD VddA18 OnBn openDVS_pixel2x2_top
XopenDVS_pixel2x2_top_406 openDVS_pixel2x2_top_406/vpd[0] openDVS_pixel2x2_top_406/vpd[1]
+ openDVS_pixel2x2_top_406/vpd[3] openDVS_pixel2x2_top_406/vpd[2] rowReadOFF[25] rowReadON[25]
+ rowReadON[24] RefrBp PrBp PrSFBp col_periphery_1x2_22/COL_LINE0 pixRst[44] OffBn
+ rowReadOFF[24] pixRst[45] openDVS_pixel2x2_top_415/GndD DiffBn col_periphery_1x2_22/COL_LINE1
+ GndD VddA18 OnBn openDVS_pixel2x2_top
XopenDVS_pixel2x2_top_428 openDVS_pixel2x2_top_428/vpd[0] openDVS_pixel2x2_top_428/vpd[1]
+ openDVS_pixel2x2_top_428/vpd[3] openDVS_pixel2x2_top_428/vpd[2] rowReadOFF[27] rowReadON[27]
+ rowReadON[26] RefrBp PrBp PrSFBp col_periphery_1x2_12/COL_LINE0 pixRst[24] OffBn
+ rowReadOFF[26] pixRst[25] openDVS_pixel2x2_top_447/GndD DiffBn col_periphery_1x2_12/COL_LINE1
+ GndD VddA18 OnBn openDVS_pixel2x2_top
XopenDVS_pixel2x2_top_417 openDVS_pixel2x2_top_417/vpd[0] openDVS_pixel2x2_top_417/vpd[1]
+ openDVS_pixel2x2_top_417/vpd[3] openDVS_pixel2x2_top_417/vpd[2] rowReadOFF[27] rowReadON[27]
+ rowReadON[26] RefrBp PrBp PrSFBp col_periphery_1x2_1/COL_LINE0 pixRst[2] OffBn rowReadOFF[26]
+ pixRst[3] openDVS_pixel2x2_top_447/GndD DiffBn col_periphery_1x2_1/COL_LINE1 GndD
+ VddA18 OnBn openDVS_pixel2x2_top
XopenDVS_pixel2x2_top_973 openDVS_pixel2x2_top_973/vpd[0] openDVS_pixel2x2_top_973/vpd[1]
+ openDVS_pixel2x2_top_973/vpd[3] openDVS_pixel2x2_top_973/vpd[2] rowReadOFF[61] rowReadON[61]
+ rowReadON[60] RefrBp PrBp PrSFBp col_periphery_1x2_13/COL_LINE0 pixRst[26] OffBn
+ rowReadOFF[60] pixRst[27] openDVS_pixel2x2_top_991/GndD DiffBn col_periphery_1x2_13/COL_LINE1
+ GndD VddA18 OnBn openDVS_pixel2x2_top
XopenDVS_pixel2x2_top_940 openDVS_pixel2x2_top_940/vpd[0] openDVS_pixel2x2_top_940/vpd[1]
+ openDVS_pixel2x2_top_940/vpd[3] openDVS_pixel2x2_top_940/vpd[2] rowReadOFF[59] rowReadON[59]
+ rowReadON[58] RefrBp PrBp PrSFBp col_periphery_1x2_12/COL_LINE0 pixRst[24] OffBn
+ rowReadOFF[58] pixRst[25] openDVS_pixel2x2_top_959/GndD DiffBn col_periphery_1x2_12/COL_LINE1
+ GndD VddA18 OnBn openDVS_pixel2x2_top
XopenDVS_pixel2x2_top_995 openDVS_pixel2x2_top_995/vpd[0] openDVS_pixel2x2_top_995/vpd[1]
+ openDVS_pixel2x2_top_995/vpd[3] openDVS_pixel2x2_top_995/vpd[2] rowReadOFF[63] rowReadON[63]
+ rowReadON[62] RefrBp PrBp PrSFBp col_periphery_1x2_3/COL_LINE0 pixRst[6] OffBn rowReadOFF[62]
+ pixRst[7] openDVS_pixel2x2_top_999/GndD DiffBn col_periphery_1x2_3/COL_LINE1 GndD
+ VddA18 OnBn openDVS_pixel2x2_top
XopenDVS_pixel2x2_top_962 openDVS_pixel2x2_top_962/vpd[0] openDVS_pixel2x2_top_962/vpd[1]
+ openDVS_pixel2x2_top_962/vpd[3] openDVS_pixel2x2_top_962/vpd[2] rowReadOFF[61] rowReadON[61]
+ rowReadON[60] RefrBp PrBp PrSFBp col_periphery_1x2_2/COL_LINE0 pixRst[4] OffBn rowReadOFF[60]
+ pixRst[5] openDVS_pixel2x2_top_991/GndD DiffBn col_periphery_1x2_2/COL_LINE1 GndD
+ VddA18 OnBn openDVS_pixel2x2_top
XopenDVS_pixel2x2_top_951 openDVS_pixel2x2_top_951/vpd[0] openDVS_pixel2x2_top_951/vpd[1]
+ openDVS_pixel2x2_top_951/vpd[3] openDVS_pixel2x2_top_951/vpd[2] rowReadOFF[59] rowReadON[59]
+ rowReadON[58] RefrBp PrBp PrSFBp col_periphery_1x2_23/COL_LINE0 pixRst[46] OffBn
+ rowReadOFF[58] pixRst[47] openDVS_pixel2x2_top_959/GndD DiffBn col_periphery_1x2_23/COL_LINE1
+ GndD VddA18 OnBn openDVS_pixel2x2_top
XopenDVS_pixel2x2_top_984 openDVS_pixel2x2_top_984/vpd[0] openDVS_pixel2x2_top_984/vpd[1]
+ openDVS_pixel2x2_top_984/vpd[3] openDVS_pixel2x2_top_984/vpd[2] rowReadOFF[61] rowReadON[61]
+ rowReadON[60] RefrBp PrBp PrSFBp col_periphery_1x2_24/COL_LINE0 pixRst[48] OffBn
+ rowReadOFF[60] pixRst[49] openDVS_pixel2x2_top_991/GndD DiffBn col_periphery_1x2_24/COL_LINE1
+ GndD VddA18 OnBn openDVS_pixel2x2_top
XopenDVS_pixel2x2_top_247 openDVS_pixel2x2_top_247/vpd[0] openDVS_pixel2x2_top_247/vpd[1]
+ openDVS_pixel2x2_top_247/vpd[3] openDVS_pixel2x2_top_247/vpd[2] rowReadOFF[15] rowReadON[15]
+ rowReadON[14] RefrBp PrBp PrSFBp col_periphery_1x2_23/COL_LINE0 pixRst[46] OffBn
+ rowReadOFF[14] pixRst[47] openDVS_pixel2x2_top_255/GndD DiffBn col_periphery_1x2_23/COL_LINE1
+ GndD VddA18 OnBn openDVS_pixel2x2_top
XopenDVS_pixel2x2_top_214 openDVS_pixel2x2_top_214/vpd[0] openDVS_pixel2x2_top_214/vpd[1]
+ openDVS_pixel2x2_top_214/vpd[3] openDVS_pixel2x2_top_214/vpd[2] rowReadOFF[13] rowReadON[13]
+ rowReadON[12] RefrBp PrBp PrSFBp col_periphery_1x2_22/COL_LINE0 pixRst[44] OffBn
+ rowReadOFF[12] pixRst[45] openDVS_pixel2x2_top_223/GndD DiffBn col_periphery_1x2_22/COL_LINE1
+ GndD VddA18 OnBn openDVS_pixel2x2_top
XopenDVS_pixel2x2_top_269 openDVS_pixel2x2_top_269/vpd[0] openDVS_pixel2x2_top_269/vpd[1]
+ openDVS_pixel2x2_top_269/vpd[3] openDVS_pixel2x2_top_269/vpd[2] rowReadOFF[17] rowReadON[17]
+ rowReadON[16] RefrBp PrBp PrSFBp col_periphery_1x2_13/COL_LINE0 pixRst[26] OffBn
+ rowReadOFF[16] pixRst[27] openDVS_pixel2x2_top_287/GndD DiffBn col_periphery_1x2_13/COL_LINE1
+ GndD VddA18 OnBn openDVS_pixel2x2_top
XopenDVS_pixel2x2_top_236 openDVS_pixel2x2_top_236/vpd[0] openDVS_pixel2x2_top_236/vpd[1]
+ openDVS_pixel2x2_top_236/vpd[3] openDVS_pixel2x2_top_236/vpd[2] rowReadOFF[15] rowReadON[15]
+ rowReadON[14] RefrBp PrBp PrSFBp col_periphery_1x2_12/COL_LINE0 pixRst[24] OffBn
+ rowReadOFF[14] pixRst[25] openDVS_pixel2x2_top_255/GndD DiffBn col_periphery_1x2_12/COL_LINE1
+ GndD VddA18 OnBn openDVS_pixel2x2_top
XopenDVS_pixel2x2_top_203 openDVS_pixel2x2_top_203/vpd[0] openDVS_pixel2x2_top_203/vpd[1]
+ openDVS_pixel2x2_top_203/vpd[3] openDVS_pixel2x2_top_203/vpd[2] rowReadOFF[13] rowReadON[13]
+ rowReadON[12] RefrBp PrBp PrSFBp col_periphery_1x2_11/COL_LINE0 pixRst[22] OffBn
+ rowReadOFF[12] pixRst[23] openDVS_pixel2x2_top_223/GndD DiffBn col_periphery_1x2_11/COL_LINE1
+ GndD VddA18 OnBn openDVS_pixel2x2_top
XopenDVS_pixel2x2_top_258 openDVS_pixel2x2_top_258/vpd[0] openDVS_pixel2x2_top_258/vpd[1]
+ openDVS_pixel2x2_top_258/vpd[3] openDVS_pixel2x2_top_258/vpd[2] rowReadOFF[17] rowReadON[17]
+ rowReadON[16] RefrBp PrBp PrSFBp col_periphery_1x2_2/COL_LINE0 pixRst[4] OffBn rowReadOFF[16]
+ pixRst[5] openDVS_pixel2x2_top_287/GndD DiffBn col_periphery_1x2_2/COL_LINE1 GndD
+ VddA18 OnBn openDVS_pixel2x2_top
XopenDVS_pixel2x2_top_225 openDVS_pixel2x2_top_225/vpd[0] openDVS_pixel2x2_top_225/vpd[1]
+ openDVS_pixel2x2_top_225/vpd[3] openDVS_pixel2x2_top_225/vpd[2] rowReadOFF[15] rowReadON[15]
+ rowReadON[14] RefrBp PrBp PrSFBp col_periphery_1x2_1/COL_LINE0 pixRst[2] OffBn rowReadOFF[14]
+ pixRst[3] openDVS_pixel2x2_top_255/GndD DiffBn col_periphery_1x2_1/COL_LINE1 GndD
+ VddA18 OnBn openDVS_pixel2x2_top
XopenDVS_pixel2x2_top_770 openDVS_pixel2x2_top_770/vpd[0] openDVS_pixel2x2_top_770/vpd[1]
+ openDVS_pixel2x2_top_770/vpd[3] openDVS_pixel2x2_top_770/vpd[2] rowReadOFF[49] rowReadON[49]
+ rowReadON[48] RefrBp PrBp PrSFBp col_periphery_1x2_2/COL_LINE0 pixRst[4] OffBn rowReadOFF[48]
+ pixRst[5] openDVS_pixel2x2_top_799/GndD DiffBn col_periphery_1x2_2/COL_LINE1 GndD
+ VddA18 OnBn openDVS_pixel2x2_top
XopenDVS_pixel2x2_top_781 openDVS_pixel2x2_top_781/vpd[0] openDVS_pixel2x2_top_781/vpd[1]
+ openDVS_pixel2x2_top_781/vpd[3] openDVS_pixel2x2_top_781/vpd[2] rowReadOFF[49] rowReadON[49]
+ rowReadON[48] RefrBp PrBp PrSFBp col_periphery_1x2_13/COL_LINE0 pixRst[26] OffBn
+ rowReadOFF[48] pixRst[27] openDVS_pixel2x2_top_799/GndD DiffBn col_periphery_1x2_13/COL_LINE1
+ GndD VddA18 OnBn openDVS_pixel2x2_top
XopenDVS_pixel2x2_top_792 openDVS_pixel2x2_top_792/vpd[0] openDVS_pixel2x2_top_792/vpd[1]
+ openDVS_pixel2x2_top_792/vpd[3] openDVS_pixel2x2_top_792/vpd[2] rowReadOFF[49] rowReadON[49]
+ rowReadON[48] RefrBp PrBp PrSFBp col_periphery_1x2_24/COL_LINE0 pixRst[48] OffBn
+ rowReadOFF[48] pixRst[49] openDVS_pixel2x2_top_799/GndD DiffBn col_periphery_1x2_24/COL_LINE1
+ GndD VddA18 OnBn openDVS_pixel2x2_top
Xcol_periphery_1x2_22 pixRst[45] col_periphery_1x2_22/COL_LINE0 col_periphery_1x2_22/COL_LINE1
+ nDETECT col_periphery_1x2_9/VDD DETECT VTHRESH voutn[44] GndD NCHARGE voutn[45]
+ pixRst[44] col_periphery_1x2
Xcol_periphery_1x2_11 pixRst[23] col_periphery_1x2_11/COL_LINE0 col_periphery_1x2_11/COL_LINE1
+ nDETECT col_periphery_1x2_9/VDD DETECT VTHRESH voutn[22] GndD NCHARGE voutn[23]
+ pixRst[22] col_periphery_1x2
XopenDVS_pixel2x2_top_407 openDVS_pixel2x2_top_407/vpd[0] openDVS_pixel2x2_top_407/vpd[1]
+ openDVS_pixel2x2_top_407/vpd[3] openDVS_pixel2x2_top_407/vpd[2] rowReadOFF[25] rowReadON[25]
+ rowReadON[24] RefrBp PrBp PrSFBp col_periphery_1x2_23/COL_LINE0 pixRst[46] OffBn
+ rowReadOFF[24] pixRst[47] openDVS_pixel2x2_top_415/GndD DiffBn col_periphery_1x2_23/COL_LINE1
+ GndD VddA18 OnBn openDVS_pixel2x2_top
XopenDVS_pixel2x2_top_429 openDVS_pixel2x2_top_429/vpd[0] openDVS_pixel2x2_top_429/vpd[1]
+ openDVS_pixel2x2_top_429/vpd[3] openDVS_pixel2x2_top_429/vpd[2] rowReadOFF[27] rowReadON[27]
+ rowReadON[26] RefrBp PrBp PrSFBp col_periphery_1x2_13/COL_LINE0 pixRst[26] OffBn
+ rowReadOFF[26] pixRst[27] openDVS_pixel2x2_top_447/GndD DiffBn col_periphery_1x2_13/COL_LINE1
+ GndD VddA18 OnBn openDVS_pixel2x2_top
XopenDVS_pixel2x2_top_418 openDVS_pixel2x2_top_418/vpd[0] openDVS_pixel2x2_top_418/vpd[1]
+ openDVS_pixel2x2_top_418/vpd[3] openDVS_pixel2x2_top_418/vpd[2] rowReadOFF[27] rowReadON[27]
+ rowReadON[26] RefrBp PrBp PrSFBp col_periphery_1x2_2/COL_LINE0 pixRst[4] OffBn rowReadOFF[26]
+ pixRst[5] openDVS_pixel2x2_top_447/GndD DiffBn col_periphery_1x2_2/COL_LINE1 GndD
+ VddA18 OnBn openDVS_pixel2x2_top
XopenDVS_pixel2x2_top_974 openDVS_pixel2x2_top_974/vpd[0] openDVS_pixel2x2_top_974/vpd[1]
+ openDVS_pixel2x2_top_974/vpd[3] openDVS_pixel2x2_top_974/vpd[2] rowReadOFF[61] rowReadON[61]
+ rowReadON[60] RefrBp PrBp PrSFBp col_periphery_1x2_14/COL_LINE0 pixRst[28] OffBn
+ rowReadOFF[60] pixRst[29] openDVS_pixel2x2_top_991/GndD DiffBn col_periphery_1x2_14/COL_LINE1
+ GndD VddA18 OnBn openDVS_pixel2x2_top
XopenDVS_pixel2x2_top_941 openDVS_pixel2x2_top_941/vpd[0] openDVS_pixel2x2_top_941/vpd[1]
+ openDVS_pixel2x2_top_941/vpd[3] openDVS_pixel2x2_top_941/vpd[2] rowReadOFF[59] rowReadON[59]
+ rowReadON[58] RefrBp PrBp PrSFBp col_periphery_1x2_13/COL_LINE0 pixRst[26] OffBn
+ rowReadOFF[58] pixRst[27] openDVS_pixel2x2_top_959/GndD DiffBn col_periphery_1x2_13/COL_LINE1
+ GndD VddA18 OnBn openDVS_pixel2x2_top
XopenDVS_pixel2x2_top_996 openDVS_pixel2x2_top_996/vpd[0] openDVS_pixel2x2_top_996/vpd[1]
+ openDVS_pixel2x2_top_996/vpd[3] openDVS_pixel2x2_top_996/vpd[2] rowReadOFF[63] rowReadON[63]
+ rowReadON[62] RefrBp PrBp PrSFBp col_periphery_1x2_4/COL_LINE0 pixRst[8] OffBn rowReadOFF[62]
+ pixRst[9] openDVS_pixel2x2_top_999/GndD DiffBn col_periphery_1x2_4/COL_LINE1 GndD
+ VddA18 OnBn openDVS_pixel2x2_top
XopenDVS_pixel2x2_top_963 openDVS_pixel2x2_top_963/vpd[0] openDVS_pixel2x2_top_963/vpd[1]
+ openDVS_pixel2x2_top_963/vpd[3] openDVS_pixel2x2_top_963/vpd[2] rowReadOFF[61] rowReadON[61]
+ rowReadON[60] RefrBp PrBp PrSFBp col_periphery_1x2_3/COL_LINE0 pixRst[6] OffBn rowReadOFF[60]
+ pixRst[7] openDVS_pixel2x2_top_991/GndD DiffBn col_periphery_1x2_3/COL_LINE1 GndD
+ VddA18 OnBn openDVS_pixel2x2_top
XopenDVS_pixel2x2_top_930 openDVS_pixel2x2_top_930/vpd[0] openDVS_pixel2x2_top_930/vpd[1]
+ openDVS_pixel2x2_top_930/vpd[3] openDVS_pixel2x2_top_930/vpd[2] rowReadOFF[59] rowReadON[59]
+ rowReadON[58] RefrBp PrBp PrSFBp col_periphery_1x2_2/COL_LINE0 pixRst[4] OffBn rowReadOFF[58]
+ pixRst[5] openDVS_pixel2x2_top_959/GndD DiffBn col_periphery_1x2_2/COL_LINE1 GndD
+ VddA18 OnBn openDVS_pixel2x2_top
XopenDVS_pixel2x2_top_952 openDVS_pixel2x2_top_952/vpd[0] openDVS_pixel2x2_top_952/vpd[1]
+ openDVS_pixel2x2_top_952/vpd[3] openDVS_pixel2x2_top_952/vpd[2] rowReadOFF[59] rowReadON[59]
+ rowReadON[58] RefrBp PrBp PrSFBp col_periphery_1x2_24/COL_LINE0 pixRst[48] OffBn
+ rowReadOFF[58] pixRst[49] openDVS_pixel2x2_top_959/GndD DiffBn col_periphery_1x2_24/COL_LINE1
+ GndD VddA18 OnBn openDVS_pixel2x2_top
XopenDVS_pixel2x2_top_985 openDVS_pixel2x2_top_985/vpd[0] openDVS_pixel2x2_top_985/vpd[1]
+ openDVS_pixel2x2_top_985/vpd[3] openDVS_pixel2x2_top_985/vpd[2] rowReadOFF[61] rowReadON[61]
+ rowReadON[60] RefrBp PrBp PrSFBp col_periphery_1x2_25/COL_LINE0 pixRst[50] OffBn
+ rowReadOFF[60] pixRst[51] openDVS_pixel2x2_top_991/GndD DiffBn col_periphery_1x2_25/COL_LINE1
+ GndD VddA18 OnBn openDVS_pixel2x2_top
XopenDVS_pixel2x2_top_248 openDVS_pixel2x2_top_248/vpd[0] openDVS_pixel2x2_top_248/vpd[1]
+ openDVS_pixel2x2_top_248/vpd[3] openDVS_pixel2x2_top_248/vpd[2] rowReadOFF[15] rowReadON[15]
+ rowReadON[14] RefrBp PrBp PrSFBp col_periphery_1x2_24/COL_LINE0 pixRst[48] OffBn
+ rowReadOFF[14] pixRst[49] openDVS_pixel2x2_top_255/GndD DiffBn col_periphery_1x2_24/COL_LINE1
+ GndD VddA18 OnBn openDVS_pixel2x2_top
XopenDVS_pixel2x2_top_215 openDVS_pixel2x2_top_215/vpd[0] openDVS_pixel2x2_top_215/vpd[1]
+ openDVS_pixel2x2_top_215/vpd[3] openDVS_pixel2x2_top_215/vpd[2] rowReadOFF[13] rowReadON[13]
+ rowReadON[12] RefrBp PrBp PrSFBp col_periphery_1x2_23/COL_LINE0 pixRst[46] OffBn
+ rowReadOFF[12] pixRst[47] openDVS_pixel2x2_top_223/GndD DiffBn col_periphery_1x2_23/COL_LINE1
+ GndD VddA18 OnBn openDVS_pixel2x2_top
XopenDVS_pixel2x2_top_237 openDVS_pixel2x2_top_237/vpd[0] openDVS_pixel2x2_top_237/vpd[1]
+ openDVS_pixel2x2_top_237/vpd[3] openDVS_pixel2x2_top_237/vpd[2] rowReadOFF[15] rowReadON[15]
+ rowReadON[14] RefrBp PrBp PrSFBp col_periphery_1x2_13/COL_LINE0 pixRst[26] OffBn
+ rowReadOFF[14] pixRst[27] openDVS_pixel2x2_top_255/GndD DiffBn col_periphery_1x2_13/COL_LINE1
+ GndD VddA18 OnBn openDVS_pixel2x2_top
XopenDVS_pixel2x2_top_204 openDVS_pixel2x2_top_204/vpd[0] openDVS_pixel2x2_top_204/vpd[1]
+ openDVS_pixel2x2_top_204/vpd[3] openDVS_pixel2x2_top_204/vpd[2] rowReadOFF[13] rowReadON[13]
+ rowReadON[12] RefrBp PrBp PrSFBp col_periphery_1x2_12/COL_LINE0 pixRst[24] OffBn
+ rowReadOFF[12] pixRst[25] openDVS_pixel2x2_top_223/GndD DiffBn col_periphery_1x2_12/COL_LINE1
+ GndD VddA18 OnBn openDVS_pixel2x2_top
XopenDVS_pixel2x2_top_259 openDVS_pixel2x2_top_259/vpd[0] openDVS_pixel2x2_top_259/vpd[1]
+ openDVS_pixel2x2_top_259/vpd[3] openDVS_pixel2x2_top_259/vpd[2] rowReadOFF[17] rowReadON[17]
+ rowReadON[16] RefrBp PrBp PrSFBp col_periphery_1x2_3/COL_LINE0 pixRst[6] OffBn rowReadOFF[16]
+ pixRst[7] openDVS_pixel2x2_top_287/GndD DiffBn col_periphery_1x2_3/COL_LINE1 GndD
+ VddA18 OnBn openDVS_pixel2x2_top
XopenDVS_pixel2x2_top_226 openDVS_pixel2x2_top_226/vpd[0] openDVS_pixel2x2_top_226/vpd[1]
+ openDVS_pixel2x2_top_226/vpd[3] openDVS_pixel2x2_top_226/vpd[2] rowReadOFF[15] rowReadON[15]
+ rowReadON[14] RefrBp PrBp PrSFBp col_periphery_1x2_2/COL_LINE0 pixRst[4] OffBn rowReadOFF[14]
+ pixRst[5] openDVS_pixel2x2_top_255/GndD DiffBn col_periphery_1x2_2/COL_LINE1 GndD
+ VddA18 OnBn openDVS_pixel2x2_top
XopenDVS_pixel2x2_top_771 openDVS_pixel2x2_top_771/vpd[0] openDVS_pixel2x2_top_771/vpd[1]
+ openDVS_pixel2x2_top_771/vpd[3] openDVS_pixel2x2_top_771/vpd[2] rowReadOFF[49] rowReadON[49]
+ rowReadON[48] RefrBp PrBp PrSFBp col_periphery_1x2_3/COL_LINE0 pixRst[6] OffBn rowReadOFF[48]
+ pixRst[7] openDVS_pixel2x2_top_799/GndD DiffBn col_periphery_1x2_3/COL_LINE1 GndD
+ VddA18 OnBn openDVS_pixel2x2_top
XopenDVS_pixel2x2_top_782 openDVS_pixel2x2_top_782/vpd[0] openDVS_pixel2x2_top_782/vpd[1]
+ openDVS_pixel2x2_top_782/vpd[3] openDVS_pixel2x2_top_782/vpd[2] rowReadOFF[49] rowReadON[49]
+ rowReadON[48] RefrBp PrBp PrSFBp col_periphery_1x2_14/COL_LINE0 pixRst[28] OffBn
+ rowReadOFF[48] pixRst[29] openDVS_pixel2x2_top_799/GndD DiffBn col_periphery_1x2_14/COL_LINE1
+ GndD VddA18 OnBn openDVS_pixel2x2_top
XopenDVS_pixel2x2_top_760 openDVS_pixel2x2_top_760/vpd[0] openDVS_pixel2x2_top_760/vpd[1]
+ openDVS_pixel2x2_top_760/vpd[3] openDVS_pixel2x2_top_760/vpd[2] rowReadOFF[47] rowReadON[47]
+ rowReadON[46] RefrBp PrBp PrSFBp col_periphery_1x2_24/COL_LINE0 pixRst[48] OffBn
+ rowReadOFF[46] pixRst[49] openDVS_pixel2x2_top_767/GndD DiffBn col_periphery_1x2_24/COL_LINE1
+ GndD VddA18 OnBn openDVS_pixel2x2_top
XopenDVS_pixel2x2_top_793 openDVS_pixel2x2_top_793/vpd[0] openDVS_pixel2x2_top_793/vpd[1]
+ openDVS_pixel2x2_top_793/vpd[3] openDVS_pixel2x2_top_793/vpd[2] rowReadOFF[49] rowReadON[49]
+ rowReadON[48] RefrBp PrBp PrSFBp col_periphery_1x2_25/COL_LINE0 pixRst[50] OffBn
+ rowReadOFF[48] pixRst[51] openDVS_pixel2x2_top_799/GndD DiffBn col_periphery_1x2_25/COL_LINE1
+ GndD VddA18 OnBn openDVS_pixel2x2_top
Xcol_periphery_1x2_23 pixRst[47] col_periphery_1x2_23/COL_LINE0 col_periphery_1x2_23/COL_LINE1
+ nDETECT col_periphery_1x2_9/VDD DETECT VTHRESH voutn[46] GndD NCHARGE voutn[47]
+ pixRst[46] col_periphery_1x2
Xcol_periphery_1x2_12 pixRst[25] col_periphery_1x2_12/COL_LINE0 col_periphery_1x2_12/COL_LINE1
+ nDETECT col_periphery_1x2_9/VDD DETECT VTHRESH voutn[24] GndD NCHARGE voutn[25]
+ pixRst[24] col_periphery_1x2
XopenDVS_pixel2x2_top_590 openDVS_pixel2x2_top_590/vpd[0] openDVS_pixel2x2_top_590/vpd[1]
+ openDVS_pixel2x2_top_590/vpd[3] openDVS_pixel2x2_top_590/vpd[2] rowReadOFF[37] rowReadON[37]
+ rowReadON[36] RefrBp PrBp PrSFBp col_periphery_1x2_14/COL_LINE0 pixRst[28] OffBn
+ rowReadOFF[36] pixRst[29] openDVS_pixel2x2_top_607/GndD DiffBn col_periphery_1x2_14/COL_LINE1
+ GndD VddA18 OnBn openDVS_pixel2x2_top
XopenDVS_pixel2x2_top_90 openDVS_pixel2x2_top_90/vpd[0] openDVS_pixel2x2_top_90/vpd[1]
+ openDVS_pixel2x2_top_90/vpd[3] openDVS_pixel2x2_top_90/vpd[2] rowReadOFF[5] rowReadON[5]
+ rowReadON[4] RefrBp PrBp PrSFBp col_periphery_1x2_26/COL_LINE0 pixRst[52] OffBn
+ rowReadOFF[4] pixRst[53] openDVS_pixel2x2_top_95/GndD DiffBn col_periphery_1x2_26/COL_LINE1
+ GndD VddA18 OnBn openDVS_pixel2x2_top
XopenDVS_pixel2x2_top_408 openDVS_pixel2x2_top_408/vpd[0] openDVS_pixel2x2_top_408/vpd[1]
+ openDVS_pixel2x2_top_408/vpd[3] openDVS_pixel2x2_top_408/vpd[2] rowReadOFF[25] rowReadON[25]
+ rowReadON[24] RefrBp PrBp PrSFBp col_periphery_1x2_24/COL_LINE0 pixRst[48] OffBn
+ rowReadOFF[24] pixRst[49] openDVS_pixel2x2_top_415/GndD DiffBn col_periphery_1x2_24/COL_LINE1
+ GndD VddA18 OnBn openDVS_pixel2x2_top
XopenDVS_pixel2x2_top_419 openDVS_pixel2x2_top_419/vpd[0] openDVS_pixel2x2_top_419/vpd[1]
+ openDVS_pixel2x2_top_419/vpd[3] openDVS_pixel2x2_top_419/vpd[2] rowReadOFF[27] rowReadON[27]
+ rowReadON[26] RefrBp PrBp PrSFBp col_periphery_1x2_3/COL_LINE0 pixRst[6] OffBn rowReadOFF[26]
+ pixRst[7] openDVS_pixel2x2_top_447/GndD DiffBn col_periphery_1x2_3/COL_LINE1 GndD
+ VddA18 OnBn openDVS_pixel2x2_top
XopenDVS_pixel2x2_top_975 openDVS_pixel2x2_top_975/vpd[0] openDVS_pixel2x2_top_975/vpd[1]
+ openDVS_pixel2x2_top_975/vpd[3] openDVS_pixel2x2_top_975/vpd[2] rowReadOFF[61] rowReadON[61]
+ rowReadON[60] RefrBp PrBp PrSFBp col_periphery_1x2_15/COL_LINE0 pixRst[30] OffBn
+ rowReadOFF[60] pixRst[31] openDVS_pixel2x2_top_991/GndD DiffBn col_periphery_1x2_15/COL_LINE1
+ GndD VddA18 OnBn openDVS_pixel2x2_top
XopenDVS_pixel2x2_top_942 openDVS_pixel2x2_top_942/vpd[0] openDVS_pixel2x2_top_942/vpd[1]
+ openDVS_pixel2x2_top_942/vpd[3] openDVS_pixel2x2_top_942/vpd[2] rowReadOFF[59] rowReadON[59]
+ rowReadON[58] RefrBp PrBp PrSFBp col_periphery_1x2_14/COL_LINE0 pixRst[28] OffBn
+ rowReadOFF[58] pixRst[29] openDVS_pixel2x2_top_959/GndD DiffBn col_periphery_1x2_14/COL_LINE1
+ GndD VddA18 OnBn openDVS_pixel2x2_top
XopenDVS_pixel2x2_top_997 openDVS_pixel2x2_top_997/vpd[0] openDVS_pixel2x2_top_997/vpd[1]
+ openDVS_pixel2x2_top_997/vpd[3] openDVS_pixel2x2_top_997/vpd[2] rowReadOFF[63] rowReadON[63]
+ rowReadON[62] RefrBp PrBp PrSFBp col_periphery_1x2_5/COL_LINE0 pixRst[10] OffBn
+ rowReadOFF[62] pixRst[11] openDVS_pixel2x2_top_999/GndD DiffBn col_periphery_1x2_5/COL_LINE1
+ GndD VddA18 OnBn openDVS_pixel2x2_top
XopenDVS_pixel2x2_top_964 openDVS_pixel2x2_top_964/vpd[0] openDVS_pixel2x2_top_964/vpd[1]
+ openDVS_pixel2x2_top_964/vpd[3] openDVS_pixel2x2_top_964/vpd[2] rowReadOFF[61] rowReadON[61]
+ rowReadON[60] RefrBp PrBp PrSFBp col_periphery_1x2_4/COL_LINE0 pixRst[8] OffBn rowReadOFF[60]
+ pixRst[9] openDVS_pixel2x2_top_991/GndD DiffBn col_periphery_1x2_4/COL_LINE1 GndD
+ VddA18 OnBn openDVS_pixel2x2_top
XopenDVS_pixel2x2_top_931 openDVS_pixel2x2_top_931/vpd[0] openDVS_pixel2x2_top_931/vpd[1]
+ openDVS_pixel2x2_top_931/vpd[3] openDVS_pixel2x2_top_931/vpd[2] rowReadOFF[59] rowReadON[59]
+ rowReadON[58] RefrBp PrBp PrSFBp col_periphery_1x2_3/COL_LINE0 pixRst[6] OffBn rowReadOFF[58]
+ pixRst[7] openDVS_pixel2x2_top_959/GndD DiffBn col_periphery_1x2_3/COL_LINE1 GndD
+ VddA18 OnBn openDVS_pixel2x2_top
XopenDVS_pixel2x2_top_920 openDVS_pixel2x2_top_920/vpd[0] openDVS_pixel2x2_top_920/vpd[1]
+ openDVS_pixel2x2_top_920/vpd[3] openDVS_pixel2x2_top_920/vpd[2] rowReadOFF[57] rowReadON[57]
+ rowReadON[56] RefrBp PrBp PrSFBp col_periphery_1x2_24/COL_LINE0 pixRst[48] OffBn
+ rowReadOFF[56] pixRst[49] openDVS_pixel2x2_top_927/GndD DiffBn col_periphery_1x2_24/COL_LINE1
+ GndD VddA18 OnBn openDVS_pixel2x2_top
XopenDVS_pixel2x2_top_953 openDVS_pixel2x2_top_953/vpd[0] openDVS_pixel2x2_top_953/vpd[1]
+ openDVS_pixel2x2_top_953/vpd[3] openDVS_pixel2x2_top_953/vpd[2] rowReadOFF[59] rowReadON[59]
+ rowReadON[58] RefrBp PrBp PrSFBp col_periphery_1x2_25/COL_LINE0 pixRst[50] OffBn
+ rowReadOFF[58] pixRst[51] openDVS_pixel2x2_top_959/GndD DiffBn col_periphery_1x2_25/COL_LINE1
+ GndD VddA18 OnBn openDVS_pixel2x2_top
XopenDVS_pixel2x2_top_986 openDVS_pixel2x2_top_986/vpd[0] openDVS_pixel2x2_top_986/vpd[1]
+ openDVS_pixel2x2_top_986/vpd[3] openDVS_pixel2x2_top_986/vpd[2] rowReadOFF[61] rowReadON[61]
+ rowReadON[60] RefrBp PrBp PrSFBp col_periphery_1x2_26/COL_LINE0 pixRst[52] OffBn
+ rowReadOFF[60] pixRst[53] openDVS_pixel2x2_top_991/GndD DiffBn col_periphery_1x2_26/COL_LINE1
+ GndD VddA18 OnBn openDVS_pixel2x2_top
XopenDVS_pixel2x2_top_249 openDVS_pixel2x2_top_249/vpd[0] openDVS_pixel2x2_top_249/vpd[1]
+ openDVS_pixel2x2_top_249/vpd[3] openDVS_pixel2x2_top_249/vpd[2] rowReadOFF[15] rowReadON[15]
+ rowReadON[14] RefrBp PrBp PrSFBp col_periphery_1x2_25/COL_LINE0 pixRst[50] OffBn
+ rowReadOFF[14] pixRst[51] openDVS_pixel2x2_top_255/GndD DiffBn col_periphery_1x2_25/COL_LINE1
+ GndD VddA18 OnBn openDVS_pixel2x2_top
XopenDVS_pixel2x2_top_216 openDVS_pixel2x2_top_216/vpd[0] openDVS_pixel2x2_top_216/vpd[1]
+ openDVS_pixel2x2_top_216/vpd[3] openDVS_pixel2x2_top_216/vpd[2] rowReadOFF[13] rowReadON[13]
+ rowReadON[12] RefrBp PrBp PrSFBp col_periphery_1x2_24/COL_LINE0 pixRst[48] OffBn
+ rowReadOFF[12] pixRst[49] openDVS_pixel2x2_top_223/GndD DiffBn col_periphery_1x2_24/COL_LINE1
+ GndD VddA18 OnBn openDVS_pixel2x2_top
XopenDVS_pixel2x2_top_238 openDVS_pixel2x2_top_238/vpd[0] openDVS_pixel2x2_top_238/vpd[1]
+ openDVS_pixel2x2_top_238/vpd[3] openDVS_pixel2x2_top_238/vpd[2] rowReadOFF[15] rowReadON[15]
+ rowReadON[14] RefrBp PrBp PrSFBp col_periphery_1x2_14/COL_LINE0 pixRst[28] OffBn
+ rowReadOFF[14] pixRst[29] openDVS_pixel2x2_top_255/GndD DiffBn col_periphery_1x2_14/COL_LINE1
+ GndD VddA18 OnBn openDVS_pixel2x2_top
XopenDVS_pixel2x2_top_205 openDVS_pixel2x2_top_205/vpd[0] openDVS_pixel2x2_top_205/vpd[1]
+ openDVS_pixel2x2_top_205/vpd[3] openDVS_pixel2x2_top_205/vpd[2] rowReadOFF[13] rowReadON[13]
+ rowReadON[12] RefrBp PrBp PrSFBp col_periphery_1x2_13/COL_LINE0 pixRst[26] OffBn
+ rowReadOFF[12] pixRst[27] openDVS_pixel2x2_top_223/GndD DiffBn col_periphery_1x2_13/COL_LINE1
+ GndD VddA18 OnBn openDVS_pixel2x2_top
XopenDVS_pixel2x2_top_227 openDVS_pixel2x2_top_227/vpd[0] openDVS_pixel2x2_top_227/vpd[1]
+ openDVS_pixel2x2_top_227/vpd[3] openDVS_pixel2x2_top_227/vpd[2] rowReadOFF[15] rowReadON[15]
+ rowReadON[14] RefrBp PrBp PrSFBp col_periphery_1x2_3/COL_LINE0 pixRst[6] OffBn rowReadOFF[14]
+ pixRst[7] openDVS_pixel2x2_top_255/GndD DiffBn col_periphery_1x2_3/COL_LINE1 GndD
+ VddA18 OnBn openDVS_pixel2x2_top
XopenDVS_pixel2x2_top_772 openDVS_pixel2x2_top_772/vpd[0] openDVS_pixel2x2_top_772/vpd[1]
+ openDVS_pixel2x2_top_772/vpd[3] openDVS_pixel2x2_top_772/vpd[2] rowReadOFF[49] rowReadON[49]
+ rowReadON[48] RefrBp PrBp PrSFBp col_periphery_1x2_4/COL_LINE0 pixRst[8] OffBn rowReadOFF[48]
+ pixRst[9] openDVS_pixel2x2_top_799/GndD DiffBn col_periphery_1x2_4/COL_LINE1 GndD
+ VddA18 OnBn openDVS_pixel2x2_top
XopenDVS_pixel2x2_top_750 openDVS_pixel2x2_top_750/vpd[0] openDVS_pixel2x2_top_750/vpd[1]
+ openDVS_pixel2x2_top_750/vpd[3] openDVS_pixel2x2_top_750/vpd[2] rowReadOFF[47] rowReadON[47]
+ rowReadON[46] RefrBp PrBp PrSFBp col_periphery_1x2_14/COL_LINE0 pixRst[28] OffBn
+ rowReadOFF[46] pixRst[29] openDVS_pixel2x2_top_767/GndD DiffBn col_periphery_1x2_14/COL_LINE1
+ GndD VddA18 OnBn openDVS_pixel2x2_top
XopenDVS_pixel2x2_top_783 openDVS_pixel2x2_top_783/vpd[0] openDVS_pixel2x2_top_783/vpd[1]
+ openDVS_pixel2x2_top_783/vpd[3] openDVS_pixel2x2_top_783/vpd[2] rowReadOFF[49] rowReadON[49]
+ rowReadON[48] RefrBp PrBp PrSFBp col_periphery_1x2_15/COL_LINE0 pixRst[30] OffBn
+ rowReadOFF[48] pixRst[31] openDVS_pixel2x2_top_799/GndD DiffBn col_periphery_1x2_15/COL_LINE1
+ GndD VddA18 OnBn openDVS_pixel2x2_top
XopenDVS_pixel2x2_top_761 openDVS_pixel2x2_top_761/vpd[0] openDVS_pixel2x2_top_761/vpd[1]
+ openDVS_pixel2x2_top_761/vpd[3] openDVS_pixel2x2_top_761/vpd[2] rowReadOFF[47] rowReadON[47]
+ rowReadON[46] RefrBp PrBp PrSFBp col_periphery_1x2_25/COL_LINE0 pixRst[50] OffBn
+ rowReadOFF[46] pixRst[51] openDVS_pixel2x2_top_767/GndD DiffBn col_periphery_1x2_25/COL_LINE1
+ GndD VddA18 OnBn openDVS_pixel2x2_top
XopenDVS_pixel2x2_top_794 openDVS_pixel2x2_top_794/vpd[0] openDVS_pixel2x2_top_794/vpd[1]
+ openDVS_pixel2x2_top_794/vpd[3] openDVS_pixel2x2_top_794/vpd[2] rowReadOFF[49] rowReadON[49]
+ rowReadON[48] RefrBp PrBp PrSFBp col_periphery_1x2_26/COL_LINE0 pixRst[52] OffBn
+ rowReadOFF[48] pixRst[53] openDVS_pixel2x2_top_799/GndD DiffBn col_periphery_1x2_26/COL_LINE1
+ GndD VddA18 OnBn openDVS_pixel2x2_top
Xcol_periphery_1x2_24 pixRst[49] col_periphery_1x2_24/COL_LINE0 col_periphery_1x2_24/COL_LINE1
+ nDETECT col_periphery_1x2_9/VDD DETECT VTHRESH voutn[48] GndD NCHARGE voutn[49]
+ pixRst[48] col_periphery_1x2
Xcol_periphery_1x2_13 pixRst[27] col_periphery_1x2_13/COL_LINE0 col_periphery_1x2_13/COL_LINE1
+ nDETECT col_periphery_1x2_9/VDD DETECT VTHRESH voutn[26] GndD NCHARGE voutn[27]
+ pixRst[26] col_periphery_1x2
XopenDVS_pixel2x2_top_591 openDVS_pixel2x2_top_591/vpd[0] openDVS_pixel2x2_top_591/vpd[1]
+ openDVS_pixel2x2_top_591/vpd[3] openDVS_pixel2x2_top_591/vpd[2] rowReadOFF[37] rowReadON[37]
+ rowReadON[36] RefrBp PrBp PrSFBp col_periphery_1x2_15/COL_LINE0 pixRst[30] OffBn
+ rowReadOFF[36] pixRst[31] openDVS_pixel2x2_top_607/GndD DiffBn col_periphery_1x2_15/COL_LINE1
+ GndD VddA18 OnBn openDVS_pixel2x2_top
XopenDVS_pixel2x2_top_580 openDVS_pixel2x2_top_580/vpd[0] openDVS_pixel2x2_top_580/vpd[1]
+ openDVS_pixel2x2_top_580/vpd[3] openDVS_pixel2x2_top_580/vpd[2] rowReadOFF[37] rowReadON[37]
+ rowReadON[36] RefrBp PrBp PrSFBp col_periphery_1x2_4/COL_LINE0 pixRst[8] OffBn rowReadOFF[36]
+ pixRst[9] openDVS_pixel2x2_top_607/GndD DiffBn col_periphery_1x2_4/COL_LINE1 GndD
+ VddA18 OnBn openDVS_pixel2x2_top
XopenDVS_pixel2x2_top_91 openDVS_pixel2x2_top_91/vpd[0] openDVS_pixel2x2_top_91/vpd[1]
+ openDVS_pixel2x2_top_91/vpd[3] openDVS_pixel2x2_top_91/vpd[2] rowReadOFF[5] rowReadON[5]
+ rowReadON[4] RefrBp PrBp PrSFBp col_periphery_1x2_27/COL_LINE0 pixRst[54] OffBn
+ rowReadOFF[4] pixRst[55] openDVS_pixel2x2_top_95/GndD DiffBn col_periphery_1x2_27/COL_LINE1
+ GndD VddA18 OnBn openDVS_pixel2x2_top
XopenDVS_pixel2x2_top_80 openDVS_pixel2x2_top_80/vpd[0] openDVS_pixel2x2_top_80/vpd[1]
+ openDVS_pixel2x2_top_80/vpd[3] openDVS_pixel2x2_top_80/vpd[2] rowReadOFF[5] rowReadON[5]
+ rowReadON[4] RefrBp PrBp PrSFBp col_periphery_1x2_16/COL_LINE0 pixRst[32] OffBn
+ rowReadOFF[4] pixRst[33] openDVS_pixel2x2_top_95/GndD DiffBn col_periphery_1x2_16/COL_LINE1
+ GndD VddA18 OnBn openDVS_pixel2x2_top
XopenDVS_pixel2x2_top_409 openDVS_pixel2x2_top_409/vpd[0] openDVS_pixel2x2_top_409/vpd[1]
+ openDVS_pixel2x2_top_409/vpd[3] openDVS_pixel2x2_top_409/vpd[2] rowReadOFF[25] rowReadON[25]
+ rowReadON[24] RefrBp PrBp PrSFBp col_periphery_1x2_25/COL_LINE0 pixRst[50] OffBn
+ rowReadOFF[24] pixRst[51] openDVS_pixel2x2_top_415/GndD DiffBn col_periphery_1x2_25/COL_LINE1
+ GndD VddA18 OnBn openDVS_pixel2x2_top
XopenDVS_pixel2x2_top_943 openDVS_pixel2x2_top_943/vpd[0] openDVS_pixel2x2_top_943/vpd[1]
+ openDVS_pixel2x2_top_943/vpd[3] openDVS_pixel2x2_top_943/vpd[2] rowReadOFF[59] rowReadON[59]
+ rowReadON[58] RefrBp PrBp PrSFBp col_periphery_1x2_15/COL_LINE0 pixRst[30] OffBn
+ rowReadOFF[58] pixRst[31] openDVS_pixel2x2_top_959/GndD DiffBn col_periphery_1x2_15/COL_LINE1
+ GndD VddA18 OnBn openDVS_pixel2x2_top
XopenDVS_pixel2x2_top_910 openDVS_pixel2x2_top_910/vpd[0] openDVS_pixel2x2_top_910/vpd[1]
+ openDVS_pixel2x2_top_910/vpd[3] openDVS_pixel2x2_top_910/vpd[2] rowReadOFF[57] rowReadON[57]
+ rowReadON[56] RefrBp PrBp PrSFBp col_periphery_1x2_14/COL_LINE0 pixRst[28] OffBn
+ rowReadOFF[56] pixRst[29] openDVS_pixel2x2_top_927/GndD DiffBn col_periphery_1x2_14/COL_LINE1
+ GndD VddA18 OnBn openDVS_pixel2x2_top
XopenDVS_pixel2x2_top_965 openDVS_pixel2x2_top_965/vpd[0] openDVS_pixel2x2_top_965/vpd[1]
+ openDVS_pixel2x2_top_965/vpd[3] openDVS_pixel2x2_top_965/vpd[2] rowReadOFF[61] rowReadON[61]
+ rowReadON[60] RefrBp PrBp PrSFBp col_periphery_1x2_5/COL_LINE0 pixRst[10] OffBn
+ rowReadOFF[60] pixRst[11] openDVS_pixel2x2_top_991/GndD DiffBn col_periphery_1x2_5/COL_LINE1
+ GndD VddA18 OnBn openDVS_pixel2x2_top
XopenDVS_pixel2x2_top_998 openDVS_pixel2x2_top_998/vpd[0] openDVS_pixel2x2_top_998/vpd[1]
+ openDVS_pixel2x2_top_998/vpd[3] openDVS_pixel2x2_top_998/vpd[2] rowReadOFF[63] rowReadON[63]
+ rowReadON[62] RefrBp PrBp PrSFBp col_periphery_1x2_6/COL_LINE0 pixRst[12] OffBn
+ rowReadOFF[62] pixRst[13] openDVS_pixel2x2_top_999/GndD DiffBn col_periphery_1x2_6/COL_LINE1
+ GndD VddA18 OnBn openDVS_pixel2x2_top
XopenDVS_pixel2x2_top_932 openDVS_pixel2x2_top_932/vpd[0] openDVS_pixel2x2_top_932/vpd[1]
+ openDVS_pixel2x2_top_932/vpd[3] openDVS_pixel2x2_top_932/vpd[2] rowReadOFF[59] rowReadON[59]
+ rowReadON[58] RefrBp PrBp PrSFBp col_periphery_1x2_4/COL_LINE0 pixRst[8] OffBn rowReadOFF[58]
+ pixRst[9] openDVS_pixel2x2_top_959/GndD DiffBn col_periphery_1x2_4/COL_LINE1 GndD
+ VddA18 OnBn openDVS_pixel2x2_top
XopenDVS_pixel2x2_top_976 openDVS_pixel2x2_top_976/vpd[0] openDVS_pixel2x2_top_976/vpd[1]
+ openDVS_pixel2x2_top_976/vpd[3] openDVS_pixel2x2_top_976/vpd[2] rowReadOFF[61] rowReadON[61]
+ rowReadON[60] RefrBp PrBp PrSFBp col_periphery_1x2_16/COL_LINE0 pixRst[32] OffBn
+ rowReadOFF[60] pixRst[33] openDVS_pixel2x2_top_991/GndD DiffBn col_periphery_1x2_16/COL_LINE1
+ GndD VddA18 OnBn openDVS_pixel2x2_top
XopenDVS_pixel2x2_top_921 openDVS_pixel2x2_top_921/vpd[0] openDVS_pixel2x2_top_921/vpd[1]
+ openDVS_pixel2x2_top_921/vpd[3] openDVS_pixel2x2_top_921/vpd[2] rowReadOFF[57] rowReadON[57]
+ rowReadON[56] RefrBp PrBp PrSFBp col_periphery_1x2_25/COL_LINE0 pixRst[50] OffBn
+ rowReadOFF[56] pixRst[51] openDVS_pixel2x2_top_927/GndD DiffBn col_periphery_1x2_25/COL_LINE1
+ GndD VddA18 OnBn openDVS_pixel2x2_top
XopenDVS_pixel2x2_top_954 openDVS_pixel2x2_top_954/vpd[0] openDVS_pixel2x2_top_954/vpd[1]
+ openDVS_pixel2x2_top_954/vpd[3] openDVS_pixel2x2_top_954/vpd[2] rowReadOFF[59] rowReadON[59]
+ rowReadON[58] RefrBp PrBp PrSFBp col_periphery_1x2_26/COL_LINE0 pixRst[52] OffBn
+ rowReadOFF[58] pixRst[53] openDVS_pixel2x2_top_959/GndD DiffBn col_periphery_1x2_26/COL_LINE1
+ GndD VddA18 OnBn openDVS_pixel2x2_top
XopenDVS_pixel2x2_top_987 openDVS_pixel2x2_top_987/vpd[0] openDVS_pixel2x2_top_987/vpd[1]
+ openDVS_pixel2x2_top_987/vpd[3] openDVS_pixel2x2_top_987/vpd[2] rowReadOFF[61] rowReadON[61]
+ rowReadON[60] RefrBp PrBp PrSFBp col_periphery_1x2_27/COL_LINE0 pixRst[54] OffBn
+ rowReadOFF[60] pixRst[55] openDVS_pixel2x2_top_991/GndD DiffBn col_periphery_1x2_27/COL_LINE1
+ GndD VddA18 OnBn openDVS_pixel2x2_top
XopenDVS_pixel2x2_top_217 openDVS_pixel2x2_top_217/vpd[0] openDVS_pixel2x2_top_217/vpd[1]
+ openDVS_pixel2x2_top_217/vpd[3] openDVS_pixel2x2_top_217/vpd[2] rowReadOFF[13] rowReadON[13]
+ rowReadON[12] RefrBp PrBp PrSFBp col_periphery_1x2_25/COL_LINE0 pixRst[50] OffBn
+ rowReadOFF[12] pixRst[51] openDVS_pixel2x2_top_223/GndD DiffBn col_periphery_1x2_25/COL_LINE1
+ GndD VddA18 OnBn openDVS_pixel2x2_top
XopenDVS_pixel2x2_top_239 openDVS_pixel2x2_top_239/vpd[0] openDVS_pixel2x2_top_239/vpd[1]
+ openDVS_pixel2x2_top_239/vpd[3] openDVS_pixel2x2_top_239/vpd[2] rowReadOFF[15] rowReadON[15]
+ rowReadON[14] RefrBp PrBp PrSFBp col_periphery_1x2_15/COL_LINE0 pixRst[30] OffBn
+ rowReadOFF[14] pixRst[31] openDVS_pixel2x2_top_255/GndD DiffBn col_periphery_1x2_15/COL_LINE1
+ GndD VddA18 OnBn openDVS_pixel2x2_top
XopenDVS_pixel2x2_top_206 openDVS_pixel2x2_top_206/vpd[0] openDVS_pixel2x2_top_206/vpd[1]
+ openDVS_pixel2x2_top_206/vpd[3] openDVS_pixel2x2_top_206/vpd[2] rowReadOFF[13] rowReadON[13]
+ rowReadON[12] RefrBp PrBp PrSFBp col_periphery_1x2_14/COL_LINE0 pixRst[28] OffBn
+ rowReadOFF[12] pixRst[29] openDVS_pixel2x2_top_223/GndD DiffBn col_periphery_1x2_14/COL_LINE1
+ GndD VddA18 OnBn openDVS_pixel2x2_top
XopenDVS_pixel2x2_top_228 openDVS_pixel2x2_top_228/vpd[0] openDVS_pixel2x2_top_228/vpd[1]
+ openDVS_pixel2x2_top_228/vpd[3] openDVS_pixel2x2_top_228/vpd[2] rowReadOFF[15] rowReadON[15]
+ rowReadON[14] RefrBp PrBp PrSFBp col_periphery_1x2_4/COL_LINE0 pixRst[8] OffBn rowReadOFF[14]
+ pixRst[9] openDVS_pixel2x2_top_255/GndD DiffBn col_periphery_1x2_4/COL_LINE1 GndD
+ VddA18 OnBn openDVS_pixel2x2_top
XopenDVS_pixel2x2_top_740 openDVS_pixel2x2_top_740/vpd[0] openDVS_pixel2x2_top_740/vpd[1]
+ openDVS_pixel2x2_top_740/vpd[3] openDVS_pixel2x2_top_740/vpd[2] rowReadOFF[47] rowReadON[47]
+ rowReadON[46] RefrBp PrBp PrSFBp col_periphery_1x2_4/COL_LINE0 pixRst[8] OffBn rowReadOFF[46]
+ pixRst[9] openDVS_pixel2x2_top_767/GndD DiffBn col_periphery_1x2_4/COL_LINE1 GndD
+ VddA18 OnBn openDVS_pixel2x2_top
XopenDVS_pixel2x2_top_773 openDVS_pixel2x2_top_773/vpd[0] openDVS_pixel2x2_top_773/vpd[1]
+ openDVS_pixel2x2_top_773/vpd[3] openDVS_pixel2x2_top_773/vpd[2] rowReadOFF[49] rowReadON[49]
+ rowReadON[48] RefrBp PrBp PrSFBp col_periphery_1x2_5/COL_LINE0 pixRst[10] OffBn
+ rowReadOFF[48] pixRst[11] openDVS_pixel2x2_top_799/GndD DiffBn col_periphery_1x2_5/COL_LINE1
+ GndD VddA18 OnBn openDVS_pixel2x2_top
XopenDVS_pixel2x2_top_751 openDVS_pixel2x2_top_751/vpd[0] openDVS_pixel2x2_top_751/vpd[1]
+ openDVS_pixel2x2_top_751/vpd[3] openDVS_pixel2x2_top_751/vpd[2] rowReadOFF[47] rowReadON[47]
+ rowReadON[46] RefrBp PrBp PrSFBp col_periphery_1x2_15/COL_LINE0 pixRst[30] OffBn
+ rowReadOFF[46] pixRst[31] openDVS_pixel2x2_top_767/GndD DiffBn col_periphery_1x2_15/COL_LINE1
+ GndD VddA18 OnBn openDVS_pixel2x2_top
XopenDVS_pixel2x2_top_784 openDVS_pixel2x2_top_784/vpd[0] openDVS_pixel2x2_top_784/vpd[1]
+ openDVS_pixel2x2_top_784/vpd[3] openDVS_pixel2x2_top_784/vpd[2] rowReadOFF[49] rowReadON[49]
+ rowReadON[48] RefrBp PrBp PrSFBp col_periphery_1x2_16/COL_LINE0 pixRst[32] OffBn
+ rowReadOFF[48] pixRst[33] openDVS_pixel2x2_top_799/GndD DiffBn col_periphery_1x2_16/COL_LINE1
+ GndD VddA18 OnBn openDVS_pixel2x2_top
XopenDVS_pixel2x2_top_762 openDVS_pixel2x2_top_762/vpd[0] openDVS_pixel2x2_top_762/vpd[1]
+ openDVS_pixel2x2_top_762/vpd[3] openDVS_pixel2x2_top_762/vpd[2] rowReadOFF[47] rowReadON[47]
+ rowReadON[46] RefrBp PrBp PrSFBp col_periphery_1x2_26/COL_LINE0 pixRst[52] OffBn
+ rowReadOFF[46] pixRst[53] openDVS_pixel2x2_top_767/GndD DiffBn col_periphery_1x2_26/COL_LINE1
+ GndD VddA18 OnBn openDVS_pixel2x2_top
XopenDVS_pixel2x2_top_795 openDVS_pixel2x2_top_795/vpd[0] openDVS_pixel2x2_top_795/vpd[1]
+ openDVS_pixel2x2_top_795/vpd[3] openDVS_pixel2x2_top_795/vpd[2] rowReadOFF[49] rowReadON[49]
+ rowReadON[48] RefrBp PrBp PrSFBp col_periphery_1x2_27/COL_LINE0 pixRst[54] OffBn
+ rowReadOFF[48] pixRst[55] openDVS_pixel2x2_top_799/GndD DiffBn col_periphery_1x2_27/COL_LINE1
+ GndD VddA18 OnBn openDVS_pixel2x2_top
Xcol_periphery_1x2_25 pixRst[51] col_periphery_1x2_25/COL_LINE0 col_periphery_1x2_25/COL_LINE1
+ nDETECT col_periphery_1x2_9/VDD DETECT VTHRESH voutn[50] GndD NCHARGE voutn[51]
+ pixRst[50] col_periphery_1x2
Xcol_periphery_1x2_14 pixRst[29] col_periphery_1x2_14/COL_LINE0 col_periphery_1x2_14/COL_LINE1
+ nDETECT col_periphery_1x2_9/VDD DETECT VTHRESH voutn[28] GndD NCHARGE voutn[29]
+ pixRst[28] col_periphery_1x2
XopenDVS_pixel2x2_top_570 openDVS_pixel2x2_top_570/vpd[0] openDVS_pixel2x2_top_570/vpd[1]
+ openDVS_pixel2x2_top_570/vpd[3] openDVS_pixel2x2_top_570/vpd[2] rowReadOFF[35] rowReadON[35]
+ rowReadON[34] RefrBp PrBp PrSFBp col_periphery_1x2_26/COL_LINE0 pixRst[52] OffBn
+ rowReadOFF[34] pixRst[53] openDVS_pixel2x2_top_575/GndD DiffBn col_periphery_1x2_26/COL_LINE1
+ GndD VddA18 OnBn openDVS_pixel2x2_top
XopenDVS_pixel2x2_top_592 openDVS_pixel2x2_top_592/vpd[0] openDVS_pixel2x2_top_592/vpd[1]
+ openDVS_pixel2x2_top_592/vpd[3] openDVS_pixel2x2_top_592/vpd[2] rowReadOFF[37] rowReadON[37]
+ rowReadON[36] RefrBp PrBp PrSFBp col_periphery_1x2_16/COL_LINE0 pixRst[32] OffBn
+ rowReadOFF[36] pixRst[33] openDVS_pixel2x2_top_607/GndD DiffBn col_periphery_1x2_16/COL_LINE1
+ GndD VddA18 OnBn openDVS_pixel2x2_top
XopenDVS_pixel2x2_top_581 openDVS_pixel2x2_top_581/vpd[0] openDVS_pixel2x2_top_581/vpd[1]
+ openDVS_pixel2x2_top_581/vpd[3] openDVS_pixel2x2_top_581/vpd[2] rowReadOFF[37] rowReadON[37]
+ rowReadON[36] RefrBp PrBp PrSFBp col_periphery_1x2_5/COL_LINE0 pixRst[10] OffBn
+ rowReadOFF[36] pixRst[11] openDVS_pixel2x2_top_607/GndD DiffBn col_periphery_1x2_5/COL_LINE1
+ GndD VddA18 OnBn openDVS_pixel2x2_top
XopenDVS_pixel2x2_top_92 openDVS_pixel2x2_top_92/vpd[0] openDVS_pixel2x2_top_92/vpd[1]
+ openDVS_pixel2x2_top_92/vpd[3] openDVS_pixel2x2_top_92/vpd[2] rowReadOFF[5] rowReadON[5]
+ rowReadON[4] RefrBp PrBp PrSFBp col_periphery_1x2_28/COL_LINE0 pixRst[56] OffBn
+ rowReadOFF[4] pixRst[57] openDVS_pixel2x2_top_95/GndD DiffBn col_periphery_1x2_28/COL_LINE1
+ GndD VddA18 OnBn openDVS_pixel2x2_top
XopenDVS_pixel2x2_top_81 openDVS_pixel2x2_top_81/vpd[0] openDVS_pixel2x2_top_81/vpd[1]
+ openDVS_pixel2x2_top_81/vpd[3] openDVS_pixel2x2_top_81/vpd[2] rowReadOFF[5] rowReadON[5]
+ rowReadON[4] RefrBp PrBp PrSFBp col_periphery_1x2_17/COL_LINE0 pixRst[34] OffBn
+ rowReadOFF[4] pixRst[35] openDVS_pixel2x2_top_95/GndD DiffBn col_periphery_1x2_17/COL_LINE1
+ GndD VddA18 OnBn openDVS_pixel2x2_top
XopenDVS_pixel2x2_top_70 openDVS_pixel2x2_top_70/vpd[0] openDVS_pixel2x2_top_70/vpd[1]
+ openDVS_pixel2x2_top_70/vpd[3] openDVS_pixel2x2_top_70/vpd[2] rowReadOFF[5] rowReadON[5]
+ rowReadON[4] RefrBp PrBp PrSFBp col_periphery_1x2_6/COL_LINE0 pixRst[12] OffBn rowReadOFF[4]
+ pixRst[13] openDVS_pixel2x2_top_95/GndD DiffBn col_periphery_1x2_6/COL_LINE1 GndD
+ VddA18 OnBn openDVS_pixel2x2_top
XopenDVS_pixel2x2_top_911 openDVS_pixel2x2_top_911/vpd[0] openDVS_pixel2x2_top_911/vpd[1]
+ openDVS_pixel2x2_top_911/vpd[3] openDVS_pixel2x2_top_911/vpd[2] rowReadOFF[57] rowReadON[57]
+ rowReadON[56] RefrBp PrBp PrSFBp col_periphery_1x2_15/COL_LINE0 pixRst[30] OffBn
+ rowReadOFF[56] pixRst[31] openDVS_pixel2x2_top_927/GndD DiffBn col_periphery_1x2_15/COL_LINE1
+ GndD VddA18 OnBn openDVS_pixel2x2_top
XopenDVS_pixel2x2_top_999 openDVS_pixel2x2_top_999/vpd[0] openDVS_pixel2x2_top_999/vpd[1]
+ openDVS_pixel2x2_top_999/vpd[3] openDVS_pixel2x2_top_999/vpd[2] rowReadOFF[63] rowReadON[63]
+ rowReadON[62] RefrBp PrBp PrSFBp col_periphery_1x2_7/COL_LINE0 pixRst[14] OffBn
+ rowReadOFF[62] pixRst[15] openDVS_pixel2x2_top_999/GndD DiffBn col_periphery_1x2_7/COL_LINE1
+ GndD VddA18 OnBn openDVS_pixel2x2_top
XopenDVS_pixel2x2_top_933 openDVS_pixel2x2_top_933/vpd[0] openDVS_pixel2x2_top_933/vpd[1]
+ openDVS_pixel2x2_top_933/vpd[3] openDVS_pixel2x2_top_933/vpd[2] rowReadOFF[59] rowReadON[59]
+ rowReadON[58] RefrBp PrBp PrSFBp col_periphery_1x2_5/COL_LINE0 pixRst[10] OffBn
+ rowReadOFF[58] pixRst[11] openDVS_pixel2x2_top_959/GndD DiffBn col_periphery_1x2_5/COL_LINE1
+ GndD VddA18 OnBn openDVS_pixel2x2_top
XopenDVS_pixel2x2_top_966 openDVS_pixel2x2_top_966/vpd[0] openDVS_pixel2x2_top_966/vpd[1]
+ openDVS_pixel2x2_top_966/vpd[3] openDVS_pixel2x2_top_966/vpd[2] rowReadOFF[61] rowReadON[61]
+ rowReadON[60] RefrBp PrBp PrSFBp col_periphery_1x2_6/COL_LINE0 pixRst[12] OffBn
+ rowReadOFF[60] pixRst[13] openDVS_pixel2x2_top_991/GndD DiffBn col_periphery_1x2_6/COL_LINE1
+ GndD VddA18 OnBn openDVS_pixel2x2_top
XopenDVS_pixel2x2_top_900 openDVS_pixel2x2_top_900/vpd[0] openDVS_pixel2x2_top_900/vpd[1]
+ openDVS_pixel2x2_top_900/vpd[3] openDVS_pixel2x2_top_900/vpd[2] rowReadOFF[57] rowReadON[57]
+ rowReadON[56] RefrBp PrBp PrSFBp col_periphery_1x2_4/COL_LINE0 pixRst[8] OffBn rowReadOFF[56]
+ pixRst[9] openDVS_pixel2x2_top_927/GndD DiffBn col_periphery_1x2_4/COL_LINE1 GndD
+ VddA18 OnBn openDVS_pixel2x2_top
XopenDVS_pixel2x2_top_977 openDVS_pixel2x2_top_977/vpd[0] openDVS_pixel2x2_top_977/vpd[1]
+ openDVS_pixel2x2_top_977/vpd[3] openDVS_pixel2x2_top_977/vpd[2] rowReadOFF[61] rowReadON[61]
+ rowReadON[60] RefrBp PrBp PrSFBp col_periphery_1x2_17/COL_LINE0 pixRst[34] OffBn
+ rowReadOFF[60] pixRst[35] openDVS_pixel2x2_top_991/GndD DiffBn col_periphery_1x2_17/COL_LINE1
+ GndD VddA18 OnBn openDVS_pixel2x2_top
XopenDVS_pixel2x2_top_944 openDVS_pixel2x2_top_944/vpd[0] openDVS_pixel2x2_top_944/vpd[1]
+ openDVS_pixel2x2_top_944/vpd[3] openDVS_pixel2x2_top_944/vpd[2] rowReadOFF[59] rowReadON[59]
+ rowReadON[58] RefrBp PrBp PrSFBp col_periphery_1x2_16/COL_LINE0 pixRst[32] OffBn
+ rowReadOFF[58] pixRst[33] openDVS_pixel2x2_top_959/GndD DiffBn col_periphery_1x2_16/COL_LINE1
+ GndD VddA18 OnBn openDVS_pixel2x2_top
XopenDVS_pixel2x2_top_922 openDVS_pixel2x2_top_922/vpd[0] openDVS_pixel2x2_top_922/vpd[1]
+ openDVS_pixel2x2_top_922/vpd[3] openDVS_pixel2x2_top_922/vpd[2] rowReadOFF[57] rowReadON[57]
+ rowReadON[56] RefrBp PrBp PrSFBp col_periphery_1x2_26/COL_LINE0 pixRst[52] OffBn
+ rowReadOFF[56] pixRst[53] openDVS_pixel2x2_top_927/GndD DiffBn col_periphery_1x2_26/COL_LINE1
+ GndD VddA18 OnBn openDVS_pixel2x2_top
XopenDVS_pixel2x2_top_988 openDVS_pixel2x2_top_988/vpd[0] openDVS_pixel2x2_top_988/vpd[1]
+ openDVS_pixel2x2_top_988/vpd[3] openDVS_pixel2x2_top_988/vpd[2] rowReadOFF[61] rowReadON[61]
+ rowReadON[60] RefrBp PrBp PrSFBp col_periphery_1x2_28/COL_LINE0 pixRst[56] OffBn
+ rowReadOFF[60] pixRst[57] openDVS_pixel2x2_top_991/GndD DiffBn col_periphery_1x2_28/COL_LINE1
+ GndD VddA18 OnBn openDVS_pixel2x2_top
XopenDVS_pixel2x2_top_955 openDVS_pixel2x2_top_955/vpd[0] openDVS_pixel2x2_top_955/vpd[1]
+ openDVS_pixel2x2_top_955/vpd[3] openDVS_pixel2x2_top_955/vpd[2] rowReadOFF[59] rowReadON[59]
+ rowReadON[58] RefrBp PrBp PrSFBp col_periphery_1x2_27/COL_LINE0 pixRst[54] OffBn
+ rowReadOFF[58] pixRst[55] openDVS_pixel2x2_top_959/GndD DiffBn col_periphery_1x2_27/COL_LINE1
+ GndD VddA18 OnBn openDVS_pixel2x2_top
XopenDVS_pixel2x2_top_218 openDVS_pixel2x2_top_218/vpd[0] openDVS_pixel2x2_top_218/vpd[1]
+ openDVS_pixel2x2_top_218/vpd[3] openDVS_pixel2x2_top_218/vpd[2] rowReadOFF[13] rowReadON[13]
+ rowReadON[12] RefrBp PrBp PrSFBp col_periphery_1x2_26/COL_LINE0 pixRst[52] OffBn
+ rowReadOFF[12] pixRst[53] openDVS_pixel2x2_top_223/GndD DiffBn col_periphery_1x2_26/COL_LINE1
+ GndD VddA18 OnBn openDVS_pixel2x2_top
XopenDVS_pixel2x2_top_207 openDVS_pixel2x2_top_207/vpd[0] openDVS_pixel2x2_top_207/vpd[1]
+ openDVS_pixel2x2_top_207/vpd[3] openDVS_pixel2x2_top_207/vpd[2] rowReadOFF[13] rowReadON[13]
+ rowReadON[12] RefrBp PrBp PrSFBp col_periphery_1x2_15/COL_LINE0 pixRst[30] OffBn
+ rowReadOFF[12] pixRst[31] openDVS_pixel2x2_top_223/GndD DiffBn col_periphery_1x2_15/COL_LINE1
+ GndD VddA18 OnBn openDVS_pixel2x2_top
XopenDVS_pixel2x2_top_229 openDVS_pixel2x2_top_229/vpd[0] openDVS_pixel2x2_top_229/vpd[1]
+ openDVS_pixel2x2_top_229/vpd[3] openDVS_pixel2x2_top_229/vpd[2] rowReadOFF[15] rowReadON[15]
+ rowReadON[14] RefrBp PrBp PrSFBp col_periphery_1x2_5/COL_LINE0 pixRst[10] OffBn
+ rowReadOFF[14] pixRst[11] openDVS_pixel2x2_top_255/GndD DiffBn col_periphery_1x2_5/COL_LINE1
+ GndD VddA18 OnBn openDVS_pixel2x2_top
XopenDVS_pixel2x2_top_774 openDVS_pixel2x2_top_774/vpd[0] openDVS_pixel2x2_top_774/vpd[1]
+ openDVS_pixel2x2_top_774/vpd[3] openDVS_pixel2x2_top_774/vpd[2] rowReadOFF[49] rowReadON[49]
+ rowReadON[48] RefrBp PrBp PrSFBp col_periphery_1x2_6/COL_LINE0 pixRst[12] OffBn
+ rowReadOFF[48] pixRst[13] openDVS_pixel2x2_top_799/GndD DiffBn col_periphery_1x2_6/COL_LINE1
+ GndD VddA18 OnBn openDVS_pixel2x2_top
XopenDVS_pixel2x2_top_741 openDVS_pixel2x2_top_741/vpd[0] openDVS_pixel2x2_top_741/vpd[1]
+ openDVS_pixel2x2_top_741/vpd[3] openDVS_pixel2x2_top_741/vpd[2] rowReadOFF[47] rowReadON[47]
+ rowReadON[46] RefrBp PrBp PrSFBp col_periphery_1x2_5/COL_LINE0 pixRst[10] OffBn
+ rowReadOFF[46] pixRst[11] openDVS_pixel2x2_top_767/GndD DiffBn col_periphery_1x2_5/COL_LINE1
+ GndD VddA18 OnBn openDVS_pixel2x2_top
XopenDVS_pixel2x2_top_785 openDVS_pixel2x2_top_785/vpd[0] openDVS_pixel2x2_top_785/vpd[1]
+ openDVS_pixel2x2_top_785/vpd[3] openDVS_pixel2x2_top_785/vpd[2] rowReadOFF[49] rowReadON[49]
+ rowReadON[48] RefrBp PrBp PrSFBp col_periphery_1x2_17/COL_LINE0 pixRst[34] OffBn
+ rowReadOFF[48] pixRst[35] openDVS_pixel2x2_top_799/GndD DiffBn col_periphery_1x2_17/COL_LINE1
+ GndD VddA18 OnBn openDVS_pixel2x2_top
XopenDVS_pixel2x2_top_752 openDVS_pixel2x2_top_752/vpd[0] openDVS_pixel2x2_top_752/vpd[1]
+ openDVS_pixel2x2_top_752/vpd[3] openDVS_pixel2x2_top_752/vpd[2] rowReadOFF[47] rowReadON[47]
+ rowReadON[46] RefrBp PrBp PrSFBp col_periphery_1x2_16/COL_LINE0 pixRst[32] OffBn
+ rowReadOFF[46] pixRst[33] openDVS_pixel2x2_top_767/GndD DiffBn col_periphery_1x2_16/COL_LINE1
+ GndD VddA18 OnBn openDVS_pixel2x2_top
XopenDVS_pixel2x2_top_730 openDVS_pixel2x2_top_730/vpd[0] openDVS_pixel2x2_top_730/vpd[1]
+ openDVS_pixel2x2_top_730/vpd[3] openDVS_pixel2x2_top_730/vpd[2] rowReadOFF[45] rowReadON[45]
+ rowReadON[44] RefrBp PrBp PrSFBp col_periphery_1x2_26/COL_LINE0 pixRst[52] OffBn
+ rowReadOFF[44] pixRst[53] openDVS_pixel2x2_top_735/GndD DiffBn col_periphery_1x2_26/COL_LINE1
+ GndD VddA18 OnBn openDVS_pixel2x2_top
XopenDVS_pixel2x2_top_796 openDVS_pixel2x2_top_796/vpd[0] openDVS_pixel2x2_top_796/vpd[1]
+ openDVS_pixel2x2_top_796/vpd[3] openDVS_pixel2x2_top_796/vpd[2] rowReadOFF[49] rowReadON[49]
+ rowReadON[48] RefrBp PrBp PrSFBp col_periphery_1x2_28/COL_LINE0 pixRst[56] OffBn
+ rowReadOFF[48] pixRst[57] openDVS_pixel2x2_top_799/GndD DiffBn col_periphery_1x2_28/COL_LINE1
+ GndD VddA18 OnBn openDVS_pixel2x2_top
XopenDVS_pixel2x2_top_763 openDVS_pixel2x2_top_763/vpd[0] openDVS_pixel2x2_top_763/vpd[1]
+ openDVS_pixel2x2_top_763/vpd[3] openDVS_pixel2x2_top_763/vpd[2] rowReadOFF[47] rowReadON[47]
+ rowReadON[46] RefrBp PrBp PrSFBp col_periphery_1x2_27/COL_LINE0 pixRst[54] OffBn
+ rowReadOFF[46] pixRst[55] openDVS_pixel2x2_top_767/GndD DiffBn col_periphery_1x2_27/COL_LINE1
+ GndD VddA18 OnBn openDVS_pixel2x2_top
Xcol_periphery_1x2_26 pixRst[53] col_periphery_1x2_26/COL_LINE0 col_periphery_1x2_26/COL_LINE1
+ nDETECT col_periphery_1x2_9/VDD DETECT VTHRESH voutn[52] GndD NCHARGE voutn[53]
+ pixRst[52] col_periphery_1x2
Xcol_periphery_1x2_15 pixRst[31] col_periphery_1x2_15/COL_LINE0 col_periphery_1x2_15/COL_LINE1
+ nDETECT col_periphery_1x2_9/VDD DETECT VTHRESH voutn[30] GndD NCHARGE voutn[31]
+ pixRst[30] col_periphery_1x2
XopenDVS_pixel2x2_top_571 openDVS_pixel2x2_top_571/vpd[0] openDVS_pixel2x2_top_571/vpd[1]
+ openDVS_pixel2x2_top_571/vpd[3] openDVS_pixel2x2_top_571/vpd[2] rowReadOFF[35] rowReadON[35]
+ rowReadON[34] RefrBp PrBp PrSFBp col_periphery_1x2_27/COL_LINE0 pixRst[54] OffBn
+ rowReadOFF[34] pixRst[55] openDVS_pixel2x2_top_575/GndD DiffBn col_periphery_1x2_27/COL_LINE1
+ GndD VddA18 OnBn openDVS_pixel2x2_top
XopenDVS_pixel2x2_top_560 openDVS_pixel2x2_top_560/vpd[0] openDVS_pixel2x2_top_560/vpd[1]
+ openDVS_pixel2x2_top_560/vpd[3] openDVS_pixel2x2_top_560/vpd[2] rowReadOFF[35] rowReadON[35]
+ rowReadON[34] RefrBp PrBp PrSFBp col_periphery_1x2_16/COL_LINE0 pixRst[32] OffBn
+ rowReadOFF[34] pixRst[33] openDVS_pixel2x2_top_575/GndD DiffBn col_periphery_1x2_16/COL_LINE1
+ GndD VddA18 OnBn openDVS_pixel2x2_top
XopenDVS_pixel2x2_top_593 openDVS_pixel2x2_top_593/vpd[0] openDVS_pixel2x2_top_593/vpd[1]
+ openDVS_pixel2x2_top_593/vpd[3] openDVS_pixel2x2_top_593/vpd[2] rowReadOFF[37] rowReadON[37]
+ rowReadON[36] RefrBp PrBp PrSFBp col_periphery_1x2_17/COL_LINE0 pixRst[34] OffBn
+ rowReadOFF[36] pixRst[35] openDVS_pixel2x2_top_607/GndD DiffBn col_periphery_1x2_17/COL_LINE1
+ GndD VddA18 OnBn openDVS_pixel2x2_top
XopenDVS_pixel2x2_top_582 openDVS_pixel2x2_top_582/vpd[0] openDVS_pixel2x2_top_582/vpd[1]
+ openDVS_pixel2x2_top_582/vpd[3] openDVS_pixel2x2_top_582/vpd[2] rowReadOFF[37] rowReadON[37]
+ rowReadON[36] RefrBp PrBp PrSFBp col_periphery_1x2_6/COL_LINE0 pixRst[12] OffBn
+ rowReadOFF[36] pixRst[13] openDVS_pixel2x2_top_607/GndD DiffBn col_periphery_1x2_6/COL_LINE1
+ GndD VddA18 OnBn openDVS_pixel2x2_top
XopenDVS_pixel2x2_top_390 openDVS_pixel2x2_top_390/vpd[0] openDVS_pixel2x2_top_390/vpd[1]
+ openDVS_pixel2x2_top_390/vpd[3] openDVS_pixel2x2_top_390/vpd[2] rowReadOFF[25] rowReadON[25]
+ rowReadON[24] RefrBp PrBp PrSFBp col_periphery_1x2_6/COL_LINE0 pixRst[12] OffBn
+ rowReadOFF[24] pixRst[13] openDVS_pixel2x2_top_415/GndD DiffBn col_periphery_1x2_6/COL_LINE1
+ GndD VddA18 OnBn openDVS_pixel2x2_top
XopenDVS_pixel2x2_top_93 openDVS_pixel2x2_top_93/vpd[0] openDVS_pixel2x2_top_93/vpd[1]
+ openDVS_pixel2x2_top_93/vpd[3] openDVS_pixel2x2_top_93/vpd[2] rowReadOFF[5] rowReadON[5]
+ rowReadON[4] RefrBp PrBp PrSFBp col_periphery_1x2_29/COL_LINE0 pixRst[58] OffBn
+ rowReadOFF[4] pixRst[59] openDVS_pixel2x2_top_95/GndD DiffBn col_periphery_1x2_29/COL_LINE1
+ GndD VddA18 OnBn openDVS_pixel2x2_top
XopenDVS_pixel2x2_top_60 openDVS_pixel2x2_top_60/vpd[0] openDVS_pixel2x2_top_60/vpd[1]
+ openDVS_pixel2x2_top_60/vpd[3] openDVS_pixel2x2_top_60/vpd[2] rowReadOFF[3] rowReadON[3]
+ rowReadON[2] RefrBp PrBp PrSFBp col_periphery_1x2_28/COL_LINE0 pixRst[56] OffBn
+ rowReadOFF[2] pixRst[57] openDVS_pixel2x2_top_63/GndD DiffBn col_periphery_1x2_28/COL_LINE1
+ GndD VddA18 OnBn openDVS_pixel2x2_top
XopenDVS_pixel2x2_top_82 openDVS_pixel2x2_top_82/vpd[0] openDVS_pixel2x2_top_82/vpd[1]
+ openDVS_pixel2x2_top_82/vpd[3] openDVS_pixel2x2_top_82/vpd[2] rowReadOFF[5] rowReadON[5]
+ rowReadON[4] RefrBp PrBp PrSFBp col_periphery_1x2_18/COL_LINE0 pixRst[36] OffBn
+ rowReadOFF[4] pixRst[37] openDVS_pixel2x2_top_95/GndD DiffBn col_periphery_1x2_18/COL_LINE1
+ GndD VddA18 OnBn openDVS_pixel2x2_top
XopenDVS_pixel2x2_top_71 openDVS_pixel2x2_top_71/vpd[0] openDVS_pixel2x2_top_71/vpd[1]
+ openDVS_pixel2x2_top_71/vpd[3] openDVS_pixel2x2_top_71/vpd[2] rowReadOFF[5] rowReadON[5]
+ rowReadON[4] RefrBp PrBp PrSFBp col_periphery_1x2_7/COL_LINE0 pixRst[14] OffBn rowReadOFF[4]
+ pixRst[15] openDVS_pixel2x2_top_95/GndD DiffBn col_periphery_1x2_7/COL_LINE1 GndD
+ VddA18 OnBn openDVS_pixel2x2_top
XopenDVS_pixel2x2_top_967 openDVS_pixel2x2_top_967/vpd[0] openDVS_pixel2x2_top_967/vpd[1]
+ openDVS_pixel2x2_top_967/vpd[3] openDVS_pixel2x2_top_967/vpd[2] rowReadOFF[61] rowReadON[61]
+ rowReadON[60] RefrBp PrBp PrSFBp col_periphery_1x2_7/COL_LINE0 pixRst[14] OffBn
+ rowReadOFF[60] pixRst[15] openDVS_pixel2x2_top_991/GndD DiffBn col_periphery_1x2_7/COL_LINE1
+ GndD VddA18 OnBn openDVS_pixel2x2_top
XopenDVS_pixel2x2_top_901 openDVS_pixel2x2_top_901/vpd[0] openDVS_pixel2x2_top_901/vpd[1]
+ openDVS_pixel2x2_top_901/vpd[3] openDVS_pixel2x2_top_901/vpd[2] rowReadOFF[57] rowReadON[57]
+ rowReadON[56] RefrBp PrBp PrSFBp col_periphery_1x2_5/COL_LINE0 pixRst[10] OffBn
+ rowReadOFF[56] pixRst[11] openDVS_pixel2x2_top_927/GndD DiffBn col_periphery_1x2_5/COL_LINE1
+ GndD VddA18 OnBn openDVS_pixel2x2_top
XopenDVS_pixel2x2_top_934 openDVS_pixel2x2_top_934/vpd[0] openDVS_pixel2x2_top_934/vpd[1]
+ openDVS_pixel2x2_top_934/vpd[3] openDVS_pixel2x2_top_934/vpd[2] rowReadOFF[59] rowReadON[59]
+ rowReadON[58] RefrBp PrBp PrSFBp col_periphery_1x2_6/COL_LINE0 pixRst[12] OffBn
+ rowReadOFF[58] pixRst[13] openDVS_pixel2x2_top_959/GndD DiffBn col_periphery_1x2_6/COL_LINE1
+ GndD VddA18 OnBn openDVS_pixel2x2_top
XopenDVS_pixel2x2_top_945 openDVS_pixel2x2_top_945/vpd[0] openDVS_pixel2x2_top_945/vpd[1]
+ openDVS_pixel2x2_top_945/vpd[3] openDVS_pixel2x2_top_945/vpd[2] rowReadOFF[59] rowReadON[59]
+ rowReadON[58] RefrBp PrBp PrSFBp col_periphery_1x2_17/COL_LINE0 pixRst[34] OffBn
+ rowReadOFF[58] pixRst[35] openDVS_pixel2x2_top_959/GndD DiffBn col_periphery_1x2_17/COL_LINE1
+ GndD VddA18 OnBn openDVS_pixel2x2_top
XopenDVS_pixel2x2_top_912 openDVS_pixel2x2_top_912/vpd[0] openDVS_pixel2x2_top_912/vpd[1]
+ openDVS_pixel2x2_top_912/vpd[3] openDVS_pixel2x2_top_912/vpd[2] rowReadOFF[57] rowReadON[57]
+ rowReadON[56] RefrBp PrBp PrSFBp col_periphery_1x2_16/COL_LINE0 pixRst[32] OffBn
+ rowReadOFF[56] pixRst[33] openDVS_pixel2x2_top_927/GndD DiffBn col_periphery_1x2_16/COL_LINE1
+ GndD VddA18 OnBn openDVS_pixel2x2_top
XopenDVS_pixel2x2_top_978 openDVS_pixel2x2_top_978/vpd[0] openDVS_pixel2x2_top_978/vpd[1]
+ openDVS_pixel2x2_top_978/vpd[3] openDVS_pixel2x2_top_978/vpd[2] rowReadOFF[61] rowReadON[61]
+ rowReadON[60] RefrBp PrBp PrSFBp col_periphery_1x2_18/COL_LINE0 pixRst[36] OffBn
+ rowReadOFF[60] pixRst[37] openDVS_pixel2x2_top_991/GndD DiffBn col_periphery_1x2_18/COL_LINE1
+ GndD VddA18 OnBn openDVS_pixel2x2_top
XopenDVS_pixel2x2_top_956 openDVS_pixel2x2_top_956/vpd[0] openDVS_pixel2x2_top_956/vpd[1]
+ openDVS_pixel2x2_top_956/vpd[3] openDVS_pixel2x2_top_956/vpd[2] rowReadOFF[59] rowReadON[59]
+ rowReadON[58] RefrBp PrBp PrSFBp col_periphery_1x2_28/COL_LINE0 pixRst[56] OffBn
+ rowReadOFF[58] pixRst[57] openDVS_pixel2x2_top_959/GndD DiffBn col_periphery_1x2_28/COL_LINE1
+ GndD VddA18 OnBn openDVS_pixel2x2_top
XopenDVS_pixel2x2_top_923 openDVS_pixel2x2_top_923/vpd[0] openDVS_pixel2x2_top_923/vpd[1]
+ openDVS_pixel2x2_top_923/vpd[3] openDVS_pixel2x2_top_923/vpd[2] rowReadOFF[57] rowReadON[57]
+ rowReadON[56] RefrBp PrBp PrSFBp col_periphery_1x2_27/COL_LINE0 pixRst[54] OffBn
+ rowReadOFF[56] pixRst[55] openDVS_pixel2x2_top_927/GndD DiffBn col_periphery_1x2_27/COL_LINE1
+ GndD VddA18 OnBn openDVS_pixel2x2_top
XopenDVS_pixel2x2_top_989 openDVS_pixel2x2_top_989/vpd[0] openDVS_pixel2x2_top_989/vpd[1]
+ openDVS_pixel2x2_top_989/vpd[3] openDVS_pixel2x2_top_989/vpd[2] rowReadOFF[61] rowReadON[61]
+ rowReadON[60] RefrBp PrBp PrSFBp col_periphery_1x2_29/COL_LINE0 pixRst[58] OffBn
+ rowReadOFF[60] pixRst[59] openDVS_pixel2x2_top_991/GndD DiffBn col_periphery_1x2_29/COL_LINE1
+ GndD VddA18 OnBn openDVS_pixel2x2_top
XopenDVS_pixel2x2_top_208 openDVS_pixel2x2_top_208/vpd[0] openDVS_pixel2x2_top_208/vpd[1]
+ openDVS_pixel2x2_top_208/vpd[3] openDVS_pixel2x2_top_208/vpd[2] rowReadOFF[13] rowReadON[13]
+ rowReadON[12] RefrBp PrBp PrSFBp col_periphery_1x2_16/COL_LINE0 pixRst[32] OffBn
+ rowReadOFF[12] pixRst[33] openDVS_pixel2x2_top_223/GndD DiffBn col_periphery_1x2_16/COL_LINE1
+ GndD VddA18 OnBn openDVS_pixel2x2_top
XopenDVS_pixel2x2_top_219 openDVS_pixel2x2_top_219/vpd[0] openDVS_pixel2x2_top_219/vpd[1]
+ openDVS_pixel2x2_top_219/vpd[3] openDVS_pixel2x2_top_219/vpd[2] rowReadOFF[13] rowReadON[13]
+ rowReadON[12] RefrBp PrBp PrSFBp col_periphery_1x2_27/COL_LINE0 pixRst[54] OffBn
+ rowReadOFF[12] pixRst[55] openDVS_pixel2x2_top_223/GndD DiffBn col_periphery_1x2_27/COL_LINE1
+ GndD VddA18 OnBn openDVS_pixel2x2_top
XopenDVS_pixel2x2_top_742 openDVS_pixel2x2_top_742/vpd[0] openDVS_pixel2x2_top_742/vpd[1]
+ openDVS_pixel2x2_top_742/vpd[3] openDVS_pixel2x2_top_742/vpd[2] rowReadOFF[47] rowReadON[47]
+ rowReadON[46] RefrBp PrBp PrSFBp col_periphery_1x2_6/COL_LINE0 pixRst[12] OffBn
+ rowReadOFF[46] pixRst[13] openDVS_pixel2x2_top_767/GndD DiffBn col_periphery_1x2_6/COL_LINE1
+ GndD VddA18 OnBn openDVS_pixel2x2_top
XopenDVS_pixel2x2_top_753 openDVS_pixel2x2_top_753/vpd[0] openDVS_pixel2x2_top_753/vpd[1]
+ openDVS_pixel2x2_top_753/vpd[3] openDVS_pixel2x2_top_753/vpd[2] rowReadOFF[47] rowReadON[47]
+ rowReadON[46] RefrBp PrBp PrSFBp col_periphery_1x2_17/COL_LINE0 pixRst[34] OffBn
+ rowReadOFF[46] pixRst[35] openDVS_pixel2x2_top_767/GndD DiffBn col_periphery_1x2_17/COL_LINE1
+ GndD VddA18 OnBn openDVS_pixel2x2_top
XopenDVS_pixel2x2_top_720 openDVS_pixel2x2_top_720/vpd[0] openDVS_pixel2x2_top_720/vpd[1]
+ openDVS_pixel2x2_top_720/vpd[3] openDVS_pixel2x2_top_720/vpd[2] rowReadOFF[45] rowReadON[45]
+ rowReadON[44] RefrBp PrBp PrSFBp col_periphery_1x2_16/COL_LINE0 pixRst[32] OffBn
+ rowReadOFF[44] pixRst[33] openDVS_pixel2x2_top_735/GndD DiffBn col_periphery_1x2_16/COL_LINE1
+ GndD VddA18 OnBn openDVS_pixel2x2_top
XopenDVS_pixel2x2_top_764 openDVS_pixel2x2_top_764/vpd[0] openDVS_pixel2x2_top_764/vpd[1]
+ openDVS_pixel2x2_top_764/vpd[3] openDVS_pixel2x2_top_764/vpd[2] rowReadOFF[47] rowReadON[47]
+ rowReadON[46] RefrBp PrBp PrSFBp col_periphery_1x2_28/COL_LINE0 pixRst[56] OffBn
+ rowReadOFF[46] pixRst[57] openDVS_pixel2x2_top_767/GndD DiffBn col_periphery_1x2_28/COL_LINE1
+ GndD VddA18 OnBn openDVS_pixel2x2_top
XopenDVS_pixel2x2_top_731 openDVS_pixel2x2_top_731/vpd[0] openDVS_pixel2x2_top_731/vpd[1]
+ openDVS_pixel2x2_top_731/vpd[3] openDVS_pixel2x2_top_731/vpd[2] rowReadOFF[45] rowReadON[45]
+ rowReadON[44] RefrBp PrBp PrSFBp col_periphery_1x2_27/COL_LINE0 pixRst[54] OffBn
+ rowReadOFF[44] pixRst[55] openDVS_pixel2x2_top_735/GndD DiffBn col_periphery_1x2_27/COL_LINE1
+ GndD VddA18 OnBn openDVS_pixel2x2_top
XopenDVS_pixel2x2_top_775 openDVS_pixel2x2_top_775/vpd[0] openDVS_pixel2x2_top_775/vpd[1]
+ openDVS_pixel2x2_top_775/vpd[3] openDVS_pixel2x2_top_775/vpd[2] rowReadOFF[49] rowReadON[49]
+ rowReadON[48] RefrBp PrBp PrSFBp col_periphery_1x2_7/COL_LINE0 pixRst[14] OffBn
+ rowReadOFF[48] pixRst[15] openDVS_pixel2x2_top_799/GndD DiffBn col_periphery_1x2_7/COL_LINE1
+ GndD VddA18 OnBn openDVS_pixel2x2_top
XopenDVS_pixel2x2_top_786 openDVS_pixel2x2_top_786/vpd[0] openDVS_pixel2x2_top_786/vpd[1]
+ openDVS_pixel2x2_top_786/vpd[3] openDVS_pixel2x2_top_786/vpd[2] rowReadOFF[49] rowReadON[49]
+ rowReadON[48] RefrBp PrBp PrSFBp col_periphery_1x2_18/COL_LINE0 pixRst[36] OffBn
+ rowReadOFF[48] pixRst[37] openDVS_pixel2x2_top_799/GndD DiffBn col_periphery_1x2_18/COL_LINE1
+ GndD VddA18 OnBn openDVS_pixel2x2_top
XopenDVS_pixel2x2_top_797 openDVS_pixel2x2_top_797/vpd[0] openDVS_pixel2x2_top_797/vpd[1]
+ openDVS_pixel2x2_top_797/vpd[3] openDVS_pixel2x2_top_797/vpd[2] rowReadOFF[49] rowReadON[49]
+ rowReadON[48] RefrBp PrBp PrSFBp col_periphery_1x2_29/COL_LINE0 pixRst[58] OffBn
+ rowReadOFF[48] pixRst[59] openDVS_pixel2x2_top_799/GndD DiffBn col_periphery_1x2_29/COL_LINE1
+ GndD VddA18 OnBn openDVS_pixel2x2_top
Xcol_periphery_1x2_27 pixRst[55] col_periphery_1x2_27/COL_LINE0 col_periphery_1x2_27/COL_LINE1
+ nDETECT col_periphery_1x2_9/VDD DETECT VTHRESH voutn[54] GndD NCHARGE voutn[55]
+ pixRst[54] col_periphery_1x2
Xcol_periphery_1x2_16 pixRst[33] col_periphery_1x2_16/COL_LINE0 col_periphery_1x2_16/COL_LINE1
+ nDETECT col_periphery_1x2_9/VDD DETECT VTHRESH voutn[32] GndD NCHARGE voutn[33]
+ pixRst[32] col_periphery_1x2
XopenDVS_pixel2x2_top_572 openDVS_pixel2x2_top_572/vpd[0] openDVS_pixel2x2_top_572/vpd[1]
+ openDVS_pixel2x2_top_572/vpd[3] openDVS_pixel2x2_top_572/vpd[2] rowReadOFF[35] rowReadON[35]
+ rowReadON[34] RefrBp PrBp PrSFBp col_periphery_1x2_28/COL_LINE0 pixRst[56] OffBn
+ rowReadOFF[34] pixRst[57] openDVS_pixel2x2_top_575/GndD DiffBn col_periphery_1x2_28/COL_LINE1
+ GndD VddA18 OnBn openDVS_pixel2x2_top
XopenDVS_pixel2x2_top_594 openDVS_pixel2x2_top_594/vpd[0] openDVS_pixel2x2_top_594/vpd[1]
+ openDVS_pixel2x2_top_594/vpd[3] openDVS_pixel2x2_top_594/vpd[2] rowReadOFF[37] rowReadON[37]
+ rowReadON[36] RefrBp PrBp PrSFBp col_periphery_1x2_18/COL_LINE0 pixRst[36] OffBn
+ rowReadOFF[36] pixRst[37] openDVS_pixel2x2_top_607/GndD DiffBn col_periphery_1x2_18/COL_LINE1
+ GndD VddA18 OnBn openDVS_pixel2x2_top
XopenDVS_pixel2x2_top_561 openDVS_pixel2x2_top_561/vpd[0] openDVS_pixel2x2_top_561/vpd[1]
+ openDVS_pixel2x2_top_561/vpd[3] openDVS_pixel2x2_top_561/vpd[2] rowReadOFF[35] rowReadON[35]
+ rowReadON[34] RefrBp PrBp PrSFBp col_periphery_1x2_17/COL_LINE0 pixRst[34] OffBn
+ rowReadOFF[34] pixRst[35] openDVS_pixel2x2_top_575/GndD DiffBn col_periphery_1x2_17/COL_LINE1
+ GndD VddA18 OnBn openDVS_pixel2x2_top
XopenDVS_pixel2x2_top_583 openDVS_pixel2x2_top_583/vpd[0] openDVS_pixel2x2_top_583/vpd[1]
+ openDVS_pixel2x2_top_583/vpd[3] openDVS_pixel2x2_top_583/vpd[2] rowReadOFF[37] rowReadON[37]
+ rowReadON[36] RefrBp PrBp PrSFBp col_periphery_1x2_7/COL_LINE0 pixRst[14] OffBn
+ rowReadOFF[36] pixRst[15] openDVS_pixel2x2_top_607/GndD DiffBn col_periphery_1x2_7/COL_LINE1
+ GndD VddA18 OnBn openDVS_pixel2x2_top
XopenDVS_pixel2x2_top_550 openDVS_pixel2x2_top_550/vpd[0] openDVS_pixel2x2_top_550/vpd[1]
+ openDVS_pixel2x2_top_550/vpd[3] openDVS_pixel2x2_top_550/vpd[2] rowReadOFF[35] rowReadON[35]
+ rowReadON[34] RefrBp PrBp PrSFBp col_periphery_1x2_6/COL_LINE0 pixRst[12] OffBn
+ rowReadOFF[34] pixRst[13] openDVS_pixel2x2_top_575/GndD DiffBn col_periphery_1x2_6/COL_LINE1
+ GndD VddA18 OnBn openDVS_pixel2x2_top
XopenDVS_pixel2x2_top_380 openDVS_pixel2x2_top_380/vpd[0] openDVS_pixel2x2_top_380/vpd[1]
+ openDVS_pixel2x2_top_380/vpd[3] openDVS_pixel2x2_top_380/vpd[2] rowReadOFF[23] rowReadON[23]
+ rowReadON[22] RefrBp PrBp PrSFBp col_periphery_1x2_28/COL_LINE0 pixRst[56] OffBn
+ rowReadOFF[22] pixRst[57] openDVS_pixel2x2_top_383/GndD DiffBn col_periphery_1x2_28/COL_LINE1
+ GndD VddA18 OnBn openDVS_pixel2x2_top
XopenDVS_pixel2x2_top_391 openDVS_pixel2x2_top_391/vpd[0] openDVS_pixel2x2_top_391/vpd[1]
+ openDVS_pixel2x2_top_391/vpd[3] openDVS_pixel2x2_top_391/vpd[2] rowReadOFF[25] rowReadON[25]
+ rowReadON[24] RefrBp PrBp PrSFBp col_periphery_1x2_7/COL_LINE0 pixRst[14] OffBn
+ rowReadOFF[24] pixRst[15] openDVS_pixel2x2_top_415/GndD DiffBn col_periphery_1x2_7/COL_LINE1
+ GndD VddA18 OnBn openDVS_pixel2x2_top
XopenDVS_pixel2x2_top_94 openDVS_pixel2x2_top_94/vpd[0] openDVS_pixel2x2_top_94/vpd[1]
+ openDVS_pixel2x2_top_94/vpd[3] openDVS_pixel2x2_top_94/vpd[2] rowReadOFF[5] rowReadON[5]
+ rowReadON[4] RefrBp PrBp PrSFBp col_periphery_1x2_30/COL_LINE0 pixRst[60] OffBn
+ rowReadOFF[4] pixRst[61] openDVS_pixel2x2_top_95/GndD DiffBn col_periphery_1x2_30/COL_LINE1
+ GndD VddA18 OnBn openDVS_pixel2x2_top
XopenDVS_pixel2x2_top_61 openDVS_pixel2x2_top_61/vpd[0] openDVS_pixel2x2_top_61/vpd[1]
+ openDVS_pixel2x2_top_61/vpd[3] openDVS_pixel2x2_top_61/vpd[2] rowReadOFF[3] rowReadON[3]
+ rowReadON[2] RefrBp PrBp PrSFBp col_periphery_1x2_29/COL_LINE0 pixRst[58] OffBn
+ rowReadOFF[2] pixRst[59] openDVS_pixel2x2_top_63/GndD DiffBn col_periphery_1x2_29/COL_LINE1
+ GndD VddA18 OnBn openDVS_pixel2x2_top
XopenDVS_pixel2x2_top_83 openDVS_pixel2x2_top_83/vpd[0] openDVS_pixel2x2_top_83/vpd[1]
+ openDVS_pixel2x2_top_83/vpd[3] openDVS_pixel2x2_top_83/vpd[2] rowReadOFF[5] rowReadON[5]
+ rowReadON[4] RefrBp PrBp PrSFBp col_periphery_1x2_19/COL_LINE0 pixRst[38] OffBn
+ rowReadOFF[4] pixRst[39] openDVS_pixel2x2_top_95/GndD DiffBn col_periphery_1x2_19/COL_LINE1
+ GndD VddA18 OnBn openDVS_pixel2x2_top
XopenDVS_pixel2x2_top_50 openDVS_pixel2x2_top_50/vpd[0] openDVS_pixel2x2_top_50/vpd[1]
+ openDVS_pixel2x2_top_50/vpd[3] openDVS_pixel2x2_top_50/vpd[2] rowReadOFF[3] rowReadON[3]
+ rowReadON[2] RefrBp PrBp PrSFBp col_periphery_1x2_18/COL_LINE0 pixRst[36] OffBn
+ rowReadOFF[2] pixRst[37] openDVS_pixel2x2_top_63/GndD DiffBn col_periphery_1x2_18/COL_LINE1
+ GndD VddA18 OnBn openDVS_pixel2x2_top
XopenDVS_pixel2x2_top_72 openDVS_pixel2x2_top_72/vpd[0] openDVS_pixel2x2_top_72/vpd[1]
+ openDVS_pixel2x2_top_72/vpd[3] openDVS_pixel2x2_top_72/vpd[2] rowReadOFF[5] rowReadON[5]
+ rowReadON[4] RefrBp PrBp PrSFBp col_periphery_1x2_8/COL_LINE0 pixRst[16] OffBn rowReadOFF[4]
+ pixRst[17] openDVS_pixel2x2_top_95/GndD DiffBn col_periphery_1x2_8/COL_LINE1 GndD
+ VddA18 OnBn openDVS_pixel2x2_top
XopenDVS_pixel2x2_top_968 openDVS_pixel2x2_top_968/vpd[0] openDVS_pixel2x2_top_968/vpd[1]
+ openDVS_pixel2x2_top_968/vpd[3] openDVS_pixel2x2_top_968/vpd[2] rowReadOFF[61] rowReadON[61]
+ rowReadON[60] RefrBp PrBp PrSFBp col_periphery_1x2_8/COL_LINE0 pixRst[16] OffBn
+ rowReadOFF[60] pixRst[17] openDVS_pixel2x2_top_991/GndD DiffBn col_periphery_1x2_8/COL_LINE1
+ GndD VddA18 OnBn openDVS_pixel2x2_top
XopenDVS_pixel2x2_top_935 openDVS_pixel2x2_top_935/vpd[0] openDVS_pixel2x2_top_935/vpd[1]
+ openDVS_pixel2x2_top_935/vpd[3] openDVS_pixel2x2_top_935/vpd[2] rowReadOFF[59] rowReadON[59]
+ rowReadON[58] RefrBp PrBp PrSFBp col_periphery_1x2_7/COL_LINE0 pixRst[14] OffBn
+ rowReadOFF[58] pixRst[15] openDVS_pixel2x2_top_959/GndD DiffBn col_periphery_1x2_7/COL_LINE1
+ GndD VddA18 OnBn openDVS_pixel2x2_top
XopenDVS_pixel2x2_top_902 openDVS_pixel2x2_top_902/vpd[0] openDVS_pixel2x2_top_902/vpd[1]
+ openDVS_pixel2x2_top_902/vpd[3] openDVS_pixel2x2_top_902/vpd[2] rowReadOFF[57] rowReadON[57]
+ rowReadON[56] RefrBp PrBp PrSFBp col_periphery_1x2_6/COL_LINE0 pixRst[12] OffBn
+ rowReadOFF[56] pixRst[13] openDVS_pixel2x2_top_927/GndD DiffBn col_periphery_1x2_6/COL_LINE1
+ GndD VddA18 OnBn openDVS_pixel2x2_top
XopenDVS_pixel2x2_top_913 openDVS_pixel2x2_top_913/vpd[0] openDVS_pixel2x2_top_913/vpd[1]
+ openDVS_pixel2x2_top_913/vpd[3] openDVS_pixel2x2_top_913/vpd[2] rowReadOFF[57] rowReadON[57]
+ rowReadON[56] RefrBp PrBp PrSFBp col_periphery_1x2_17/COL_LINE0 pixRst[34] OffBn
+ rowReadOFF[56] pixRst[35] openDVS_pixel2x2_top_927/GndD DiffBn col_periphery_1x2_17/COL_LINE1
+ GndD VddA18 OnBn openDVS_pixel2x2_top
XopenDVS_pixel2x2_top_946 openDVS_pixel2x2_top_946/vpd[0] openDVS_pixel2x2_top_946/vpd[1]
+ openDVS_pixel2x2_top_946/vpd[3] openDVS_pixel2x2_top_946/vpd[2] rowReadOFF[59] rowReadON[59]
+ rowReadON[58] RefrBp PrBp PrSFBp col_periphery_1x2_18/COL_LINE0 pixRst[36] OffBn
+ rowReadOFF[58] pixRst[37] openDVS_pixel2x2_top_959/GndD DiffBn col_periphery_1x2_18/COL_LINE1
+ GndD VddA18 OnBn openDVS_pixel2x2_top
XopenDVS_pixel2x2_top_979 openDVS_pixel2x2_top_979/vpd[0] openDVS_pixel2x2_top_979/vpd[1]
+ openDVS_pixel2x2_top_979/vpd[3] openDVS_pixel2x2_top_979/vpd[2] rowReadOFF[61] rowReadON[61]
+ rowReadON[60] RefrBp PrBp PrSFBp col_periphery_1x2_19/COL_LINE0 pixRst[38] OffBn
+ rowReadOFF[60] pixRst[39] openDVS_pixel2x2_top_991/GndD DiffBn col_periphery_1x2_19/COL_LINE1
+ GndD VddA18 OnBn openDVS_pixel2x2_top
XopenDVS_pixel2x2_top_924 openDVS_pixel2x2_top_924/vpd[0] openDVS_pixel2x2_top_924/vpd[1]
+ openDVS_pixel2x2_top_924/vpd[3] openDVS_pixel2x2_top_924/vpd[2] rowReadOFF[57] rowReadON[57]
+ rowReadON[56] RefrBp PrBp PrSFBp col_periphery_1x2_28/COL_LINE0 pixRst[56] OffBn
+ rowReadOFF[56] pixRst[57] openDVS_pixel2x2_top_927/GndD DiffBn col_periphery_1x2_28/COL_LINE1
+ GndD VddA18 OnBn openDVS_pixel2x2_top
XopenDVS_pixel2x2_top_957 openDVS_pixel2x2_top_957/vpd[0] openDVS_pixel2x2_top_957/vpd[1]
+ openDVS_pixel2x2_top_957/vpd[3] openDVS_pixel2x2_top_957/vpd[2] rowReadOFF[59] rowReadON[59]
+ rowReadON[58] RefrBp PrBp PrSFBp col_periphery_1x2_29/COL_LINE0 pixRst[58] OffBn
+ rowReadOFF[58] pixRst[59] openDVS_pixel2x2_top_959/GndD DiffBn col_periphery_1x2_29/COL_LINE1
+ GndD VddA18 OnBn openDVS_pixel2x2_top
XopenDVS_pixel2x2_top_209 openDVS_pixel2x2_top_209/vpd[0] openDVS_pixel2x2_top_209/vpd[1]
+ openDVS_pixel2x2_top_209/vpd[3] openDVS_pixel2x2_top_209/vpd[2] rowReadOFF[13] rowReadON[13]
+ rowReadON[12] RefrBp PrBp PrSFBp col_periphery_1x2_17/COL_LINE0 pixRst[34] OffBn
+ rowReadOFF[12] pixRst[35] openDVS_pixel2x2_top_223/GndD DiffBn col_periphery_1x2_17/COL_LINE1
+ GndD VddA18 OnBn openDVS_pixel2x2_top
XopenDVS_pixel2x2_top_710 openDVS_pixel2x2_top_710/vpd[0] openDVS_pixel2x2_top_710/vpd[1]
+ openDVS_pixel2x2_top_710/vpd[3] openDVS_pixel2x2_top_710/vpd[2] rowReadOFF[45] rowReadON[45]
+ rowReadON[44] RefrBp PrBp PrSFBp col_periphery_1x2_6/COL_LINE0 pixRst[12] OffBn
+ rowReadOFF[44] pixRst[13] openDVS_pixel2x2_top_735/GndD DiffBn col_periphery_1x2_6/COL_LINE1
+ GndD VddA18 OnBn openDVS_pixel2x2_top
XopenDVS_pixel2x2_top_743 openDVS_pixel2x2_top_743/vpd[0] openDVS_pixel2x2_top_743/vpd[1]
+ openDVS_pixel2x2_top_743/vpd[3] openDVS_pixel2x2_top_743/vpd[2] rowReadOFF[47] rowReadON[47]
+ rowReadON[46] RefrBp PrBp PrSFBp col_periphery_1x2_7/COL_LINE0 pixRst[14] OffBn
+ rowReadOFF[46] pixRst[15] openDVS_pixel2x2_top_767/GndD DiffBn col_periphery_1x2_7/COL_LINE1
+ GndD VddA18 OnBn openDVS_pixel2x2_top
XopenDVS_pixel2x2_top_776 openDVS_pixel2x2_top_776/vpd[0] openDVS_pixel2x2_top_776/vpd[1]
+ openDVS_pixel2x2_top_776/vpd[3] openDVS_pixel2x2_top_776/vpd[2] rowReadOFF[49] rowReadON[49]
+ rowReadON[48] RefrBp PrBp PrSFBp col_periphery_1x2_8/COL_LINE0 pixRst[16] OffBn
+ rowReadOFF[48] pixRst[17] openDVS_pixel2x2_top_799/GndD DiffBn col_periphery_1x2_8/COL_LINE1
+ GndD VddA18 OnBn openDVS_pixel2x2_top
XopenDVS_pixel2x2_top_721 openDVS_pixel2x2_top_721/vpd[0] openDVS_pixel2x2_top_721/vpd[1]
+ openDVS_pixel2x2_top_721/vpd[3] openDVS_pixel2x2_top_721/vpd[2] rowReadOFF[45] rowReadON[45]
+ rowReadON[44] RefrBp PrBp PrSFBp col_periphery_1x2_17/COL_LINE0 pixRst[34] OffBn
+ rowReadOFF[44] pixRst[35] openDVS_pixel2x2_top_735/GndD DiffBn col_periphery_1x2_17/COL_LINE1
+ GndD VddA18 OnBn openDVS_pixel2x2_top
XopenDVS_pixel2x2_top_754 openDVS_pixel2x2_top_754/vpd[0] openDVS_pixel2x2_top_754/vpd[1]
+ openDVS_pixel2x2_top_754/vpd[3] openDVS_pixel2x2_top_754/vpd[2] rowReadOFF[47] rowReadON[47]
+ rowReadON[46] RefrBp PrBp PrSFBp col_periphery_1x2_18/COL_LINE0 pixRst[36] OffBn
+ rowReadOFF[46] pixRst[37] openDVS_pixel2x2_top_767/GndD DiffBn col_periphery_1x2_18/COL_LINE1
+ GndD VddA18 OnBn openDVS_pixel2x2_top
XopenDVS_pixel2x2_top_787 openDVS_pixel2x2_top_787/vpd[0] openDVS_pixel2x2_top_787/vpd[1]
+ openDVS_pixel2x2_top_787/vpd[3] openDVS_pixel2x2_top_787/vpd[2] rowReadOFF[49] rowReadON[49]
+ rowReadON[48] RefrBp PrBp PrSFBp col_periphery_1x2_19/COL_LINE0 pixRst[38] OffBn
+ rowReadOFF[48] pixRst[39] openDVS_pixel2x2_top_799/GndD DiffBn col_periphery_1x2_19/COL_LINE1
+ GndD VddA18 OnBn openDVS_pixel2x2_top
XopenDVS_pixel2x2_top_732 openDVS_pixel2x2_top_732/vpd[0] openDVS_pixel2x2_top_732/vpd[1]
+ openDVS_pixel2x2_top_732/vpd[3] openDVS_pixel2x2_top_732/vpd[2] rowReadOFF[45] rowReadON[45]
+ rowReadON[44] RefrBp PrBp PrSFBp col_periphery_1x2_28/COL_LINE0 pixRst[56] OffBn
+ rowReadOFF[44] pixRst[57] openDVS_pixel2x2_top_735/GndD DiffBn col_periphery_1x2_28/COL_LINE1
+ GndD VddA18 OnBn openDVS_pixel2x2_top
XopenDVS_pixel2x2_top_765 openDVS_pixel2x2_top_765/vpd[0] openDVS_pixel2x2_top_765/vpd[1]
+ openDVS_pixel2x2_top_765/vpd[3] openDVS_pixel2x2_top_765/vpd[2] rowReadOFF[47] rowReadON[47]
+ rowReadON[46] RefrBp PrBp PrSFBp col_periphery_1x2_29/COL_LINE0 pixRst[58] OffBn
+ rowReadOFF[46] pixRst[59] openDVS_pixel2x2_top_767/GndD DiffBn col_periphery_1x2_29/COL_LINE1
+ GndD VddA18 OnBn openDVS_pixel2x2_top
XopenDVS_pixel2x2_top_798 openDVS_pixel2x2_top_798/vpd[0] openDVS_pixel2x2_top_798/vpd[1]
+ openDVS_pixel2x2_top_798/vpd[3] openDVS_pixel2x2_top_798/vpd[2] rowReadOFF[49] rowReadON[49]
+ rowReadON[48] RefrBp PrBp PrSFBp col_periphery_1x2_30/COL_LINE0 pixRst[60] OffBn
+ rowReadOFF[48] pixRst[61] openDVS_pixel2x2_top_799/GndD DiffBn col_periphery_1x2_30/COL_LINE1
+ GndD VddA18 OnBn openDVS_pixel2x2_top
Xcol_periphery_1x2_28 pixRst[57] col_periphery_1x2_28/COL_LINE0 col_periphery_1x2_28/COL_LINE1
+ nDETECT col_periphery_1x2_9/VDD DETECT VTHRESH voutn[56] GndD NCHARGE voutn[57]
+ pixRst[56] col_periphery_1x2
Xcol_periphery_1x2_17 pixRst[35] col_periphery_1x2_17/COL_LINE0 col_periphery_1x2_17/COL_LINE1
+ nDETECT col_periphery_1x2_9/VDD DETECT VTHRESH voutn[34] GndD NCHARGE voutn[35]
+ pixRst[34] col_periphery_1x2
XopenDVS_pixel2x2_top_573 openDVS_pixel2x2_top_573/vpd[0] openDVS_pixel2x2_top_573/vpd[1]
+ openDVS_pixel2x2_top_573/vpd[3] openDVS_pixel2x2_top_573/vpd[2] rowReadOFF[35] rowReadON[35]
+ rowReadON[34] RefrBp PrBp PrSFBp col_periphery_1x2_29/COL_LINE0 pixRst[58] OffBn
+ rowReadOFF[34] pixRst[59] openDVS_pixel2x2_top_575/GndD DiffBn col_periphery_1x2_29/COL_LINE1
+ GndD VddA18 OnBn openDVS_pixel2x2_top
XopenDVS_pixel2x2_top_540 openDVS_pixel2x2_top_540/vpd[0] openDVS_pixel2x2_top_540/vpd[1]
+ openDVS_pixel2x2_top_540/vpd[3] openDVS_pixel2x2_top_540/vpd[2] rowReadOFF[33] rowReadON[33]
+ rowReadON[32] RefrBp PrBp PrSFBp col_periphery_1x2_28/COL_LINE0 pixRst[56] OffBn
+ rowReadOFF[32] pixRst[57] openDVS_pixel2x2_top_543/GndD DiffBn col_periphery_1x2_28/COL_LINE1
+ GndD VddA18 OnBn openDVS_pixel2x2_top
XopenDVS_pixel2x2_top_595 openDVS_pixel2x2_top_595/vpd[0] openDVS_pixel2x2_top_595/vpd[1]
+ openDVS_pixel2x2_top_595/vpd[3] openDVS_pixel2x2_top_595/vpd[2] rowReadOFF[37] rowReadON[37]
+ rowReadON[36] RefrBp PrBp PrSFBp col_periphery_1x2_19/COL_LINE0 pixRst[38] OffBn
+ rowReadOFF[36] pixRst[39] openDVS_pixel2x2_top_607/GndD DiffBn col_periphery_1x2_19/COL_LINE1
+ GndD VddA18 OnBn openDVS_pixel2x2_top
XopenDVS_pixel2x2_top_562 openDVS_pixel2x2_top_562/vpd[0] openDVS_pixel2x2_top_562/vpd[1]
+ openDVS_pixel2x2_top_562/vpd[3] openDVS_pixel2x2_top_562/vpd[2] rowReadOFF[35] rowReadON[35]
+ rowReadON[34] RefrBp PrBp PrSFBp col_periphery_1x2_18/COL_LINE0 pixRst[36] OffBn
+ rowReadOFF[34] pixRst[37] openDVS_pixel2x2_top_575/GndD DiffBn col_periphery_1x2_18/COL_LINE1
+ GndD VddA18 OnBn openDVS_pixel2x2_top
XopenDVS_pixel2x2_top_584 openDVS_pixel2x2_top_584/vpd[0] openDVS_pixel2x2_top_584/vpd[1]
+ openDVS_pixel2x2_top_584/vpd[3] openDVS_pixel2x2_top_584/vpd[2] rowReadOFF[37] rowReadON[37]
+ rowReadON[36] RefrBp PrBp PrSFBp col_periphery_1x2_8/COL_LINE0 pixRst[16] OffBn
+ rowReadOFF[36] pixRst[17] openDVS_pixel2x2_top_607/GndD DiffBn col_periphery_1x2_8/COL_LINE1
+ GndD VddA18 OnBn openDVS_pixel2x2_top
XopenDVS_pixel2x2_top_551 openDVS_pixel2x2_top_551/vpd[0] openDVS_pixel2x2_top_551/vpd[1]
+ openDVS_pixel2x2_top_551/vpd[3] openDVS_pixel2x2_top_551/vpd[2] rowReadOFF[35] rowReadON[35]
+ rowReadON[34] RefrBp PrBp PrSFBp col_periphery_1x2_7/COL_LINE0 pixRst[14] OffBn
+ rowReadOFF[34] pixRst[15] openDVS_pixel2x2_top_575/GndD DiffBn col_periphery_1x2_7/COL_LINE1
+ GndD VddA18 OnBn openDVS_pixel2x2_top
XopenDVS_pixel2x2_top_381 openDVS_pixel2x2_top_381/vpd[0] openDVS_pixel2x2_top_381/vpd[1]
+ openDVS_pixel2x2_top_381/vpd[3] openDVS_pixel2x2_top_381/vpd[2] rowReadOFF[23] rowReadON[23]
+ rowReadON[22] RefrBp PrBp PrSFBp col_periphery_1x2_29/COL_LINE0 pixRst[58] OffBn
+ rowReadOFF[22] pixRst[59] openDVS_pixel2x2_top_383/GndD DiffBn col_periphery_1x2_29/COL_LINE1
+ GndD VddA18 OnBn openDVS_pixel2x2_top
XopenDVS_pixel2x2_top_370 openDVS_pixel2x2_top_370/vpd[0] openDVS_pixel2x2_top_370/vpd[1]
+ openDVS_pixel2x2_top_370/vpd[3] openDVS_pixel2x2_top_370/vpd[2] rowReadOFF[23] rowReadON[23]
+ rowReadON[22] RefrBp PrBp PrSFBp col_periphery_1x2_18/COL_LINE0 pixRst[36] OffBn
+ rowReadOFF[22] pixRst[37] openDVS_pixel2x2_top_383/GndD DiffBn col_periphery_1x2_18/COL_LINE1
+ GndD VddA18 OnBn openDVS_pixel2x2_top
XopenDVS_pixel2x2_top_392 openDVS_pixel2x2_top_392/vpd[0] openDVS_pixel2x2_top_392/vpd[1]
+ openDVS_pixel2x2_top_392/vpd[3] openDVS_pixel2x2_top_392/vpd[2] rowReadOFF[25] rowReadON[25]
+ rowReadON[24] RefrBp PrBp PrSFBp col_periphery_1x2_8/COL_LINE0 pixRst[16] OffBn
+ rowReadOFF[24] pixRst[17] openDVS_pixel2x2_top_415/GndD DiffBn col_periphery_1x2_8/COL_LINE1
+ GndD VddA18 OnBn openDVS_pixel2x2_top
XopenDVS_pixel2x2_top_95 openDVS_pixel2x2_top_95/vpd[0] openDVS_pixel2x2_top_95/vpd[1]
+ openDVS_pixel2x2_top_95/vpd[3] openDVS_pixel2x2_top_95/vpd[2] rowReadOFF[5] rowReadON[5]
+ rowReadON[4] RefrBp PrBp PrSFBp col_periphery_1x2_31/COL_LINE0 pixRst[62] OffBn
+ rowReadOFF[4] pixRst[63] openDVS_pixel2x2_top_95/GndD DiffBn col_periphery_1x2_31/COL_LINE1
+ GndD VddA18 OnBn openDVS_pixel2x2_top
XopenDVS_pixel2x2_top_62 openDVS_pixel2x2_top_62/vpd[0] openDVS_pixel2x2_top_62/vpd[1]
+ openDVS_pixel2x2_top_62/vpd[3] openDVS_pixel2x2_top_62/vpd[2] rowReadOFF[3] rowReadON[3]
+ rowReadON[2] RefrBp PrBp PrSFBp col_periphery_1x2_30/COL_LINE0 pixRst[60] OffBn
+ rowReadOFF[2] pixRst[61] openDVS_pixel2x2_top_63/GndD DiffBn col_periphery_1x2_30/COL_LINE1
+ GndD VddA18 OnBn openDVS_pixel2x2_top
XopenDVS_pixel2x2_top_84 openDVS_pixel2x2_top_84/vpd[0] openDVS_pixel2x2_top_84/vpd[1]
+ openDVS_pixel2x2_top_84/vpd[3] openDVS_pixel2x2_top_84/vpd[2] rowReadOFF[5] rowReadON[5]
+ rowReadON[4] RefrBp PrBp PrSFBp col_periphery_1x2_20/COL_LINE0 pixRst[40] OffBn
+ rowReadOFF[4] pixRst[41] openDVS_pixel2x2_top_95/GndD DiffBn col_periphery_1x2_20/COL_LINE1
+ GndD VddA18 OnBn openDVS_pixel2x2_top
XopenDVS_pixel2x2_top_51 openDVS_pixel2x2_top_51/vpd[0] openDVS_pixel2x2_top_51/vpd[1]
+ openDVS_pixel2x2_top_51/vpd[3] openDVS_pixel2x2_top_51/vpd[2] rowReadOFF[3] rowReadON[3]
+ rowReadON[2] RefrBp PrBp PrSFBp col_periphery_1x2_19/COL_LINE0 pixRst[38] OffBn
+ rowReadOFF[2] pixRst[39] openDVS_pixel2x2_top_63/GndD DiffBn col_periphery_1x2_19/COL_LINE1
+ GndD VddA18 OnBn openDVS_pixel2x2_top
XopenDVS_pixel2x2_top_73 openDVS_pixel2x2_top_73/vpd[0] openDVS_pixel2x2_top_73/vpd[1]
+ openDVS_pixel2x2_top_73/vpd[3] openDVS_pixel2x2_top_73/vpd[2] rowReadOFF[5] rowReadON[5]
+ rowReadON[4] RefrBp PrBp PrSFBp col_periphery_1x2_9/COL_LINE0 pixRst[18] OffBn rowReadOFF[4]
+ pixRst[19] openDVS_pixel2x2_top_95/GndD DiffBn col_periphery_1x2_9/COL_LINE1 GndD
+ VddA18 OnBn openDVS_pixel2x2_top
XopenDVS_pixel2x2_top_40 openDVS_pixel2x2_top_40/vpd[0] openDVS_pixel2x2_top_40/vpd[1]
+ openDVS_pixel2x2_top_40/vpd[3] openDVS_pixel2x2_top_40/vpd[2] rowReadOFF[3] rowReadON[3]
+ rowReadON[2] RefrBp PrBp PrSFBp col_periphery_1x2_8/COL_LINE0 pixRst[16] OffBn rowReadOFF[2]
+ pixRst[17] openDVS_pixel2x2_top_63/GndD DiffBn col_periphery_1x2_8/COL_LINE1 GndD
+ VddA18 OnBn openDVS_pixel2x2_top
XopenDVS_pixel2x2_top_969 openDVS_pixel2x2_top_969/vpd[0] openDVS_pixel2x2_top_969/vpd[1]
+ openDVS_pixel2x2_top_969/vpd[3] openDVS_pixel2x2_top_969/vpd[2] rowReadOFF[61] rowReadON[61]
+ rowReadON[60] RefrBp PrBp PrSFBp col_periphery_1x2_9/COL_LINE0 pixRst[18] OffBn
+ rowReadOFF[60] pixRst[19] openDVS_pixel2x2_top_991/GndD DiffBn col_periphery_1x2_9/COL_LINE1
+ GndD VddA18 OnBn openDVS_pixel2x2_top
XopenDVS_pixel2x2_top_936 openDVS_pixel2x2_top_936/vpd[0] openDVS_pixel2x2_top_936/vpd[1]
+ openDVS_pixel2x2_top_936/vpd[3] openDVS_pixel2x2_top_936/vpd[2] rowReadOFF[59] rowReadON[59]
+ rowReadON[58] RefrBp PrBp PrSFBp col_periphery_1x2_8/COL_LINE0 pixRst[16] OffBn
+ rowReadOFF[58] pixRst[17] openDVS_pixel2x2_top_959/GndD DiffBn col_periphery_1x2_8/COL_LINE1
+ GndD VddA18 OnBn openDVS_pixel2x2_top
XopenDVS_pixel2x2_top_903 openDVS_pixel2x2_top_903/vpd[0] openDVS_pixel2x2_top_903/vpd[1]
+ openDVS_pixel2x2_top_903/vpd[3] openDVS_pixel2x2_top_903/vpd[2] rowReadOFF[57] rowReadON[57]
+ rowReadON[56] RefrBp PrBp PrSFBp col_periphery_1x2_7/COL_LINE0 pixRst[14] OffBn
+ rowReadOFF[56] pixRst[15] openDVS_pixel2x2_top_927/GndD DiffBn col_periphery_1x2_7/COL_LINE1
+ GndD VddA18 OnBn openDVS_pixel2x2_top
XopenDVS_pixel2x2_top_914 openDVS_pixel2x2_top_914/vpd[0] openDVS_pixel2x2_top_914/vpd[1]
+ openDVS_pixel2x2_top_914/vpd[3] openDVS_pixel2x2_top_914/vpd[2] rowReadOFF[57] rowReadON[57]
+ rowReadON[56] RefrBp PrBp PrSFBp col_periphery_1x2_18/COL_LINE0 pixRst[36] OffBn
+ rowReadOFF[56] pixRst[37] openDVS_pixel2x2_top_927/GndD DiffBn col_periphery_1x2_18/COL_LINE1
+ GndD VddA18 OnBn openDVS_pixel2x2_top
XopenDVS_pixel2x2_top_947 openDVS_pixel2x2_top_947/vpd[0] openDVS_pixel2x2_top_947/vpd[1]
+ openDVS_pixel2x2_top_947/vpd[3] openDVS_pixel2x2_top_947/vpd[2] rowReadOFF[59] rowReadON[59]
+ rowReadON[58] RefrBp PrBp PrSFBp col_periphery_1x2_19/COL_LINE0 pixRst[38] OffBn
+ rowReadOFF[58] pixRst[39] openDVS_pixel2x2_top_959/GndD DiffBn col_periphery_1x2_19/COL_LINE1
+ GndD VddA18 OnBn openDVS_pixel2x2_top
XopenDVS_pixel2x2_top_925 openDVS_pixel2x2_top_925/vpd[0] openDVS_pixel2x2_top_925/vpd[1]
+ openDVS_pixel2x2_top_925/vpd[3] openDVS_pixel2x2_top_925/vpd[2] rowReadOFF[57] rowReadON[57]
+ rowReadON[56] RefrBp PrBp PrSFBp col_periphery_1x2_29/COL_LINE0 pixRst[58] OffBn
+ rowReadOFF[56] pixRst[59] openDVS_pixel2x2_top_927/GndD DiffBn col_periphery_1x2_29/COL_LINE1
+ GndD VddA18 OnBn openDVS_pixel2x2_top
XopenDVS_pixel2x2_top_958 openDVS_pixel2x2_top_958/vpd[0] openDVS_pixel2x2_top_958/vpd[1]
+ openDVS_pixel2x2_top_958/vpd[3] openDVS_pixel2x2_top_958/vpd[2] rowReadOFF[59] rowReadON[59]
+ rowReadON[58] RefrBp PrBp PrSFBp col_periphery_1x2_30/COL_LINE0 pixRst[60] OffBn
+ rowReadOFF[58] pixRst[61] openDVS_pixel2x2_top_959/GndD DiffBn col_periphery_1x2_30/COL_LINE1
+ GndD VddA18 OnBn openDVS_pixel2x2_top
XopenDVS_pixel2x2_top_711 openDVS_pixel2x2_top_711/vpd[0] openDVS_pixel2x2_top_711/vpd[1]
+ openDVS_pixel2x2_top_711/vpd[3] openDVS_pixel2x2_top_711/vpd[2] rowReadOFF[45] rowReadON[45]
+ rowReadON[44] RefrBp PrBp PrSFBp col_periphery_1x2_7/COL_LINE0 pixRst[14] OffBn
+ rowReadOFF[44] pixRst[15] openDVS_pixel2x2_top_735/GndD DiffBn col_periphery_1x2_7/COL_LINE1
+ GndD VddA18 OnBn openDVS_pixel2x2_top
XopenDVS_pixel2x2_top_744 openDVS_pixel2x2_top_744/vpd[0] openDVS_pixel2x2_top_744/vpd[1]
+ openDVS_pixel2x2_top_744/vpd[3] openDVS_pixel2x2_top_744/vpd[2] rowReadOFF[47] rowReadON[47]
+ rowReadON[46] RefrBp PrBp PrSFBp col_periphery_1x2_8/COL_LINE0 pixRst[16] OffBn
+ rowReadOFF[46] pixRst[17] openDVS_pixel2x2_top_767/GndD DiffBn col_periphery_1x2_8/COL_LINE1
+ GndD VddA18 OnBn openDVS_pixel2x2_top
XopenDVS_pixel2x2_top_777 openDVS_pixel2x2_top_777/vpd[0] openDVS_pixel2x2_top_777/vpd[1]
+ openDVS_pixel2x2_top_777/vpd[3] openDVS_pixel2x2_top_777/vpd[2] rowReadOFF[49] rowReadON[49]
+ rowReadON[48] RefrBp PrBp PrSFBp col_periphery_1x2_9/COL_LINE0 pixRst[18] OffBn
+ rowReadOFF[48] pixRst[19] openDVS_pixel2x2_top_799/GndD DiffBn col_periphery_1x2_9/COL_LINE1
+ GndD VddA18 OnBn openDVS_pixel2x2_top
XopenDVS_pixel2x2_top_722 openDVS_pixel2x2_top_722/vpd[0] openDVS_pixel2x2_top_722/vpd[1]
+ openDVS_pixel2x2_top_722/vpd[3] openDVS_pixel2x2_top_722/vpd[2] rowReadOFF[45] rowReadON[45]
+ rowReadON[44] RefrBp PrBp PrSFBp col_periphery_1x2_18/COL_LINE0 pixRst[36] OffBn
+ rowReadOFF[44] pixRst[37] openDVS_pixel2x2_top_735/GndD DiffBn col_periphery_1x2_18/COL_LINE1
+ GndD VddA18 OnBn openDVS_pixel2x2_top
XopenDVS_pixel2x2_top_755 openDVS_pixel2x2_top_755/vpd[0] openDVS_pixel2x2_top_755/vpd[1]
+ openDVS_pixel2x2_top_755/vpd[3] openDVS_pixel2x2_top_755/vpd[2] rowReadOFF[47] rowReadON[47]
+ rowReadON[46] RefrBp PrBp PrSFBp col_periphery_1x2_19/COL_LINE0 pixRst[38] OffBn
+ rowReadOFF[46] pixRst[39] openDVS_pixel2x2_top_767/GndD DiffBn col_periphery_1x2_19/COL_LINE1
+ GndD VddA18 OnBn openDVS_pixel2x2_top
XopenDVS_pixel2x2_top_788 openDVS_pixel2x2_top_788/vpd[0] openDVS_pixel2x2_top_788/vpd[1]
+ openDVS_pixel2x2_top_788/vpd[3] openDVS_pixel2x2_top_788/vpd[2] rowReadOFF[49] rowReadON[49]
+ rowReadON[48] RefrBp PrBp PrSFBp col_periphery_1x2_20/COL_LINE0 pixRst[40] OffBn
+ rowReadOFF[48] pixRst[41] openDVS_pixel2x2_top_799/GndD DiffBn col_periphery_1x2_20/COL_LINE1
+ GndD VddA18 OnBn openDVS_pixel2x2_top
XopenDVS_pixel2x2_top_700 openDVS_pixel2x2_top_700/vpd[0] openDVS_pixel2x2_top_700/vpd[1]
+ openDVS_pixel2x2_top_700/vpd[3] openDVS_pixel2x2_top_700/vpd[2] rowReadOFF[43] rowReadON[43]
+ rowReadON[42] RefrBp PrBp PrSFBp col_periphery_1x2_28/COL_LINE0 pixRst[56] OffBn
+ rowReadOFF[42] pixRst[57] openDVS_pixel2x2_top_703/GndD DiffBn col_periphery_1x2_28/COL_LINE1
+ GndD VddA18 OnBn openDVS_pixel2x2_top
XopenDVS_pixel2x2_top_733 openDVS_pixel2x2_top_733/vpd[0] openDVS_pixel2x2_top_733/vpd[1]
+ openDVS_pixel2x2_top_733/vpd[3] openDVS_pixel2x2_top_733/vpd[2] rowReadOFF[45] rowReadON[45]
+ rowReadON[44] RefrBp PrBp PrSFBp col_periphery_1x2_29/COL_LINE0 pixRst[58] OffBn
+ rowReadOFF[44] pixRst[59] openDVS_pixel2x2_top_735/GndD DiffBn col_periphery_1x2_29/COL_LINE1
+ GndD VddA18 OnBn openDVS_pixel2x2_top
XopenDVS_pixel2x2_top_766 openDVS_pixel2x2_top_766/vpd[0] openDVS_pixel2x2_top_766/vpd[1]
+ openDVS_pixel2x2_top_766/vpd[3] openDVS_pixel2x2_top_766/vpd[2] rowReadOFF[47] rowReadON[47]
+ rowReadON[46] RefrBp PrBp PrSFBp col_periphery_1x2_30/COL_LINE0 pixRst[60] OffBn
+ rowReadOFF[46] pixRst[61] openDVS_pixel2x2_top_767/GndD DiffBn col_periphery_1x2_30/COL_LINE1
+ GndD VddA18 OnBn openDVS_pixel2x2_top
XopenDVS_pixel2x2_top_799 openDVS_pixel2x2_top_799/vpd[0] openDVS_pixel2x2_top_799/vpd[1]
+ openDVS_pixel2x2_top_799/vpd[3] openDVS_pixel2x2_top_799/vpd[2] rowReadOFF[49] rowReadON[49]
+ rowReadON[48] RefrBp PrBp PrSFBp col_periphery_1x2_31/COL_LINE0 pixRst[62] OffBn
+ rowReadOFF[48] pixRst[63] openDVS_pixel2x2_top_799/GndD DiffBn col_periphery_1x2_31/COL_LINE1
+ GndD VddA18 OnBn openDVS_pixel2x2_top
Xcol_periphery_1x2_29 pixRst[59] col_periphery_1x2_29/COL_LINE0 col_periphery_1x2_29/COL_LINE1
+ nDETECT col_periphery_1x2_9/VDD DETECT VTHRESH voutn[58] GndD NCHARGE voutn[59]
+ pixRst[58] col_periphery_1x2
Xcol_periphery_1x2_18 pixRst[37] col_periphery_1x2_18/COL_LINE0 col_periphery_1x2_18/COL_LINE1
+ nDETECT col_periphery_1x2_9/VDD DETECT VTHRESH voutn[36] GndD NCHARGE voutn[37]
+ pixRst[36] col_periphery_1x2
XopenDVS_pixel2x2_top_530 openDVS_pixel2x2_top_530/vpd[0] openDVS_pixel2x2_top_530/vpd[1]
+ openDVS_pixel2x2_top_530/vpd[3] openDVS_pixel2x2_top_530/vpd[2] rowReadOFF[33] rowReadON[33]
+ rowReadON[32] RefrBp PrBp PrSFBp col_periphery_1x2_18/COL_LINE0 pixRst[36] OffBn
+ rowReadOFF[32] pixRst[37] openDVS_pixel2x2_top_543/GndD DiffBn col_periphery_1x2_18/COL_LINE1
+ GndD VddA18 OnBn openDVS_pixel2x2_top
XopenDVS_pixel2x2_top_574 openDVS_pixel2x2_top_574/vpd[0] openDVS_pixel2x2_top_574/vpd[1]
+ openDVS_pixel2x2_top_574/vpd[3] openDVS_pixel2x2_top_574/vpd[2] rowReadOFF[35] rowReadON[35]
+ rowReadON[34] RefrBp PrBp PrSFBp col_periphery_1x2_30/COL_LINE0 pixRst[60] OffBn
+ rowReadOFF[34] pixRst[61] openDVS_pixel2x2_top_575/GndD DiffBn col_periphery_1x2_30/COL_LINE1
+ GndD VddA18 OnBn openDVS_pixel2x2_top
XopenDVS_pixel2x2_top_541 openDVS_pixel2x2_top_541/vpd[0] openDVS_pixel2x2_top_541/vpd[1]
+ openDVS_pixel2x2_top_541/vpd[3] openDVS_pixel2x2_top_541/vpd[2] rowReadOFF[33] rowReadON[33]
+ rowReadON[32] RefrBp PrBp PrSFBp col_periphery_1x2_29/COL_LINE0 pixRst[58] OffBn
+ rowReadOFF[32] pixRst[59] openDVS_pixel2x2_top_543/GndD DiffBn col_periphery_1x2_29/COL_LINE1
+ GndD VddA18 OnBn openDVS_pixel2x2_top
XopenDVS_pixel2x2_top_596 openDVS_pixel2x2_top_596/vpd[0] openDVS_pixel2x2_top_596/vpd[1]
+ openDVS_pixel2x2_top_596/vpd[3] openDVS_pixel2x2_top_596/vpd[2] rowReadOFF[37] rowReadON[37]
+ rowReadON[36] RefrBp PrBp PrSFBp col_periphery_1x2_20/COL_LINE0 pixRst[40] OffBn
+ rowReadOFF[36] pixRst[41] openDVS_pixel2x2_top_607/GndD DiffBn col_periphery_1x2_20/COL_LINE1
+ GndD VddA18 OnBn openDVS_pixel2x2_top
XopenDVS_pixel2x2_top_563 openDVS_pixel2x2_top_563/vpd[0] openDVS_pixel2x2_top_563/vpd[1]
+ openDVS_pixel2x2_top_563/vpd[3] openDVS_pixel2x2_top_563/vpd[2] rowReadOFF[35] rowReadON[35]
+ rowReadON[34] RefrBp PrBp PrSFBp col_periphery_1x2_19/COL_LINE0 pixRst[38] OffBn
+ rowReadOFF[34] pixRst[39] openDVS_pixel2x2_top_575/GndD DiffBn col_periphery_1x2_19/COL_LINE1
+ GndD VddA18 OnBn openDVS_pixel2x2_top
XopenDVS_pixel2x2_top_585 openDVS_pixel2x2_top_585/vpd[0] openDVS_pixel2x2_top_585/vpd[1]
+ openDVS_pixel2x2_top_585/vpd[3] openDVS_pixel2x2_top_585/vpd[2] rowReadOFF[37] rowReadON[37]
+ rowReadON[36] RefrBp PrBp PrSFBp col_periphery_1x2_9/COL_LINE0 pixRst[18] OffBn
+ rowReadOFF[36] pixRst[19] openDVS_pixel2x2_top_607/GndD DiffBn col_periphery_1x2_9/COL_LINE1
+ GndD VddA18 OnBn openDVS_pixel2x2_top
XopenDVS_pixel2x2_top_552 openDVS_pixel2x2_top_552/vpd[0] openDVS_pixel2x2_top_552/vpd[1]
+ openDVS_pixel2x2_top_552/vpd[3] openDVS_pixel2x2_top_552/vpd[2] rowReadOFF[35] rowReadON[35]
+ rowReadON[34] RefrBp PrBp PrSFBp col_periphery_1x2_8/COL_LINE0 pixRst[16] OffBn
+ rowReadOFF[34] pixRst[17] openDVS_pixel2x2_top_575/GndD DiffBn col_periphery_1x2_8/COL_LINE1
+ GndD VddA18 OnBn openDVS_pixel2x2_top
XopenDVS_pixel2x2_top_382 openDVS_pixel2x2_top_382/vpd[0] openDVS_pixel2x2_top_382/vpd[1]
+ openDVS_pixel2x2_top_382/vpd[3] openDVS_pixel2x2_top_382/vpd[2] rowReadOFF[23] rowReadON[23]
+ rowReadON[22] RefrBp PrBp PrSFBp col_periphery_1x2_30/COL_LINE0 pixRst[60] OffBn
+ rowReadOFF[22] pixRst[61] openDVS_pixel2x2_top_383/GndD DiffBn col_periphery_1x2_30/COL_LINE1
+ GndD VddA18 OnBn openDVS_pixel2x2_top
XopenDVS_pixel2x2_top_371 openDVS_pixel2x2_top_371/vpd[0] openDVS_pixel2x2_top_371/vpd[1]
+ openDVS_pixel2x2_top_371/vpd[3] openDVS_pixel2x2_top_371/vpd[2] rowReadOFF[23] rowReadON[23]
+ rowReadON[22] RefrBp PrBp PrSFBp col_periphery_1x2_19/COL_LINE0 pixRst[38] OffBn
+ rowReadOFF[22] pixRst[39] openDVS_pixel2x2_top_383/GndD DiffBn col_periphery_1x2_19/COL_LINE1
+ GndD VddA18 OnBn openDVS_pixel2x2_top
XopenDVS_pixel2x2_top_393 openDVS_pixel2x2_top_393/vpd[0] openDVS_pixel2x2_top_393/vpd[1]
+ openDVS_pixel2x2_top_393/vpd[3] openDVS_pixel2x2_top_393/vpd[2] rowReadOFF[25] rowReadON[25]
+ rowReadON[24] RefrBp PrBp PrSFBp col_periphery_1x2_9/COL_LINE0 pixRst[18] OffBn
+ rowReadOFF[24] pixRst[19] openDVS_pixel2x2_top_415/GndD DiffBn col_periphery_1x2_9/COL_LINE1
+ GndD VddA18 OnBn openDVS_pixel2x2_top
XopenDVS_pixel2x2_top_360 openDVS_pixel2x2_top_360/vpd[0] openDVS_pixel2x2_top_360/vpd[1]
+ openDVS_pixel2x2_top_360/vpd[3] openDVS_pixel2x2_top_360/vpd[2] rowReadOFF[23] rowReadON[23]
+ rowReadON[22] RefrBp PrBp PrSFBp col_periphery_1x2_8/COL_LINE0 pixRst[16] OffBn
+ rowReadOFF[22] pixRst[17] openDVS_pixel2x2_top_383/GndD DiffBn col_periphery_1x2_8/COL_LINE1
+ GndD VddA18 OnBn openDVS_pixel2x2_top
XopenDVS_pixel2x2_top_190 openDVS_pixel2x2_top_190/vpd[0] openDVS_pixel2x2_top_190/vpd[1]
+ openDVS_pixel2x2_top_190/vpd[3] openDVS_pixel2x2_top_190/vpd[2] rowReadOFF[11] rowReadON[11]
+ rowReadON[10] RefrBp PrBp PrSFBp col_periphery_1x2_30/COL_LINE0 pixRst[60] OffBn
+ rowReadOFF[10] pixRst[61] openDVS_pixel2x2_top_191/GndD DiffBn col_periphery_1x2_30/COL_LINE1
+ GndD VddA18 OnBn openDVS_pixel2x2_top
XopenDVS_pixel2x2_top_30 openDVS_pixel2x2_top_30/vpd[0] openDVS_pixel2x2_top_30/vpd[1]
+ openDVS_pixel2x2_top_30/vpd[3] openDVS_pixel2x2_top_30/vpd[2] rowReadOFF[1] rowReadON[1]
+ rowReadON[0] RefrBp PrBp PrSFBp col_periphery_1x2_30/COL_LINE0 pixRst[60] OffBn
+ rowReadOFF[0] pixRst[61] openDVS_pixel2x2_top_9/GndD DiffBn col_periphery_1x2_30/COL_LINE1
+ GndD VddA18 OnBn openDVS_pixel2x2_top
XopenDVS_pixel2x2_top_63 openDVS_pixel2x2_top_63/vpd[0] openDVS_pixel2x2_top_63/vpd[1]
+ openDVS_pixel2x2_top_63/vpd[3] openDVS_pixel2x2_top_63/vpd[2] rowReadOFF[3] rowReadON[3]
+ rowReadON[2] RefrBp PrBp PrSFBp col_periphery_1x2_31/COL_LINE0 pixRst[62] OffBn
+ rowReadOFF[2] pixRst[63] openDVS_pixel2x2_top_63/GndD DiffBn col_periphery_1x2_31/COL_LINE1
+ GndD VddA18 OnBn openDVS_pixel2x2_top
XopenDVS_pixel2x2_top_85 openDVS_pixel2x2_top_85/vpd[0] openDVS_pixel2x2_top_85/vpd[1]
+ openDVS_pixel2x2_top_85/vpd[3] openDVS_pixel2x2_top_85/vpd[2] rowReadOFF[5] rowReadON[5]
+ rowReadON[4] RefrBp PrBp PrSFBp col_periphery_1x2_21/COL_LINE0 pixRst[42] OffBn
+ rowReadOFF[4] pixRst[43] openDVS_pixel2x2_top_95/GndD DiffBn col_periphery_1x2_21/COL_LINE1
+ GndD VddA18 OnBn openDVS_pixel2x2_top
XopenDVS_pixel2x2_top_52 openDVS_pixel2x2_top_52/vpd[0] openDVS_pixel2x2_top_52/vpd[1]
+ openDVS_pixel2x2_top_52/vpd[3] openDVS_pixel2x2_top_52/vpd[2] rowReadOFF[3] rowReadON[3]
+ rowReadON[2] RefrBp PrBp PrSFBp col_periphery_1x2_20/COL_LINE0 pixRst[40] OffBn
+ rowReadOFF[2] pixRst[41] openDVS_pixel2x2_top_63/GndD DiffBn col_periphery_1x2_20/COL_LINE1
+ GndD VddA18 OnBn openDVS_pixel2x2_top
XopenDVS_pixel2x2_top_74 openDVS_pixel2x2_top_74/vpd[0] openDVS_pixel2x2_top_74/vpd[1]
+ openDVS_pixel2x2_top_74/vpd[3] openDVS_pixel2x2_top_74/vpd[2] rowReadOFF[5] rowReadON[5]
+ rowReadON[4] RefrBp PrBp PrSFBp col_periphery_1x2_10/COL_LINE0 pixRst[20] OffBn
+ rowReadOFF[4] pixRst[21] openDVS_pixel2x2_top_95/GndD DiffBn col_periphery_1x2_10/COL_LINE1
+ GndD VddA18 OnBn openDVS_pixel2x2_top
XopenDVS_pixel2x2_top_41 openDVS_pixel2x2_top_41/vpd[0] openDVS_pixel2x2_top_41/vpd[1]
+ openDVS_pixel2x2_top_41/vpd[3] openDVS_pixel2x2_top_41/vpd[2] rowReadOFF[3] rowReadON[3]
+ rowReadON[2] RefrBp PrBp PrSFBp col_periphery_1x2_9/COL_LINE0 pixRst[18] OffBn rowReadOFF[2]
+ pixRst[19] openDVS_pixel2x2_top_63/GndD DiffBn col_periphery_1x2_9/COL_LINE1 GndD
+ VddA18 OnBn openDVS_pixel2x2_top
XopenDVS_pixel2x2_top_96 openDVS_pixel2x2_top_96/vpd[0] openDVS_pixel2x2_top_96/vpd[1]
+ openDVS_pixel2x2_top_96/vpd[3] openDVS_pixel2x2_top_96/vpd[2] rowReadOFF[7] rowReadON[7]
+ rowReadON[6] RefrBp PrBp PrSFBp col_periphery_1x2_0/COL_LINE0 pixRst[0] OffBn rowReadOFF[6]
+ pixRst[1] openDVS_pixel2x2_top_99/GndD DiffBn col_periphery_1x2_0/COL_LINE1 GndD
+ VddA18 OnBn openDVS_pixel2x2_top
XopenDVS_pixel2x2_top_937 openDVS_pixel2x2_top_937/vpd[0] openDVS_pixel2x2_top_937/vpd[1]
+ openDVS_pixel2x2_top_937/vpd[3] openDVS_pixel2x2_top_937/vpd[2] rowReadOFF[59] rowReadON[59]
+ rowReadON[58] RefrBp PrBp PrSFBp col_periphery_1x2_9/COL_LINE0 pixRst[18] OffBn
+ rowReadOFF[58] pixRst[19] openDVS_pixel2x2_top_959/GndD DiffBn col_periphery_1x2_9/COL_LINE1
+ GndD VddA18 OnBn openDVS_pixel2x2_top
XopenDVS_pixel2x2_top_904 openDVS_pixel2x2_top_904/vpd[0] openDVS_pixel2x2_top_904/vpd[1]
+ openDVS_pixel2x2_top_904/vpd[3] openDVS_pixel2x2_top_904/vpd[2] rowReadOFF[57] rowReadON[57]
+ rowReadON[56] RefrBp PrBp PrSFBp col_periphery_1x2_8/COL_LINE0 pixRst[16] OffBn
+ rowReadOFF[56] pixRst[17] openDVS_pixel2x2_top_927/GndD DiffBn col_periphery_1x2_8/COL_LINE1
+ GndD VddA18 OnBn openDVS_pixel2x2_top
XopenDVS_pixel2x2_top_915 openDVS_pixel2x2_top_915/vpd[0] openDVS_pixel2x2_top_915/vpd[1]
+ openDVS_pixel2x2_top_915/vpd[3] openDVS_pixel2x2_top_915/vpd[2] rowReadOFF[57] rowReadON[57]
+ rowReadON[56] RefrBp PrBp PrSFBp col_periphery_1x2_19/COL_LINE0 pixRst[38] OffBn
+ rowReadOFF[56] pixRst[39] openDVS_pixel2x2_top_927/GndD DiffBn col_periphery_1x2_19/COL_LINE1
+ GndD VddA18 OnBn openDVS_pixel2x2_top
XopenDVS_pixel2x2_top_948 openDVS_pixel2x2_top_948/vpd[0] openDVS_pixel2x2_top_948/vpd[1]
+ openDVS_pixel2x2_top_948/vpd[3] openDVS_pixel2x2_top_948/vpd[2] rowReadOFF[59] rowReadON[59]
+ rowReadON[58] RefrBp PrBp PrSFBp col_periphery_1x2_20/COL_LINE0 pixRst[40] OffBn
+ rowReadOFF[58] pixRst[41] openDVS_pixel2x2_top_959/GndD DiffBn col_periphery_1x2_20/COL_LINE1
+ GndD VddA18 OnBn openDVS_pixel2x2_top
XopenDVS_pixel2x2_top_926 openDVS_pixel2x2_top_926/vpd[0] openDVS_pixel2x2_top_926/vpd[1]
+ openDVS_pixel2x2_top_926/vpd[3] openDVS_pixel2x2_top_926/vpd[2] rowReadOFF[57] rowReadON[57]
+ rowReadON[56] RefrBp PrBp PrSFBp col_periphery_1x2_30/COL_LINE0 pixRst[60] OffBn
+ rowReadOFF[56] pixRst[61] openDVS_pixel2x2_top_927/GndD DiffBn col_periphery_1x2_30/COL_LINE1
+ GndD VddA18 OnBn openDVS_pixel2x2_top
XopenDVS_pixel2x2_top_959 openDVS_pixel2x2_top_959/vpd[0] openDVS_pixel2x2_top_959/vpd[1]
+ openDVS_pixel2x2_top_959/vpd[3] openDVS_pixel2x2_top_959/vpd[2] rowReadOFF[59] rowReadON[59]
+ rowReadON[58] RefrBp PrBp PrSFBp col_periphery_1x2_31/COL_LINE0 pixRst[62] OffBn
+ rowReadOFF[58] pixRst[63] openDVS_pixel2x2_top_959/GndD DiffBn col_periphery_1x2_31/COL_LINE1
+ GndD VddA18 OnBn openDVS_pixel2x2_top
XopenDVS_pixel2x2_top_712 openDVS_pixel2x2_top_712/vpd[0] openDVS_pixel2x2_top_712/vpd[1]
+ openDVS_pixel2x2_top_712/vpd[3] openDVS_pixel2x2_top_712/vpd[2] rowReadOFF[45] rowReadON[45]
+ rowReadON[44] RefrBp PrBp PrSFBp col_periphery_1x2_8/COL_LINE0 pixRst[16] OffBn
+ rowReadOFF[44] pixRst[17] openDVS_pixel2x2_top_735/GndD DiffBn col_periphery_1x2_8/COL_LINE1
+ GndD VddA18 OnBn openDVS_pixel2x2_top
XopenDVS_pixel2x2_top_745 openDVS_pixel2x2_top_745/vpd[0] openDVS_pixel2x2_top_745/vpd[1]
+ openDVS_pixel2x2_top_745/vpd[3] openDVS_pixel2x2_top_745/vpd[2] rowReadOFF[47] rowReadON[47]
+ rowReadON[46] RefrBp PrBp PrSFBp col_periphery_1x2_9/COL_LINE0 pixRst[18] OffBn
+ rowReadOFF[46] pixRst[19] openDVS_pixel2x2_top_767/GndD DiffBn col_periphery_1x2_9/COL_LINE1
+ GndD VddA18 OnBn openDVS_pixel2x2_top
XopenDVS_pixel2x2_top_778 openDVS_pixel2x2_top_778/vpd[0] openDVS_pixel2x2_top_778/vpd[1]
+ openDVS_pixel2x2_top_778/vpd[3] openDVS_pixel2x2_top_778/vpd[2] rowReadOFF[49] rowReadON[49]
+ rowReadON[48] RefrBp PrBp PrSFBp col_periphery_1x2_10/COL_LINE0 pixRst[20] OffBn
+ rowReadOFF[48] pixRst[21] openDVS_pixel2x2_top_799/GndD DiffBn col_periphery_1x2_10/COL_LINE1
+ GndD VddA18 OnBn openDVS_pixel2x2_top
XopenDVS_pixel2x2_top_723 openDVS_pixel2x2_top_723/vpd[0] openDVS_pixel2x2_top_723/vpd[1]
+ openDVS_pixel2x2_top_723/vpd[3] openDVS_pixel2x2_top_723/vpd[2] rowReadOFF[45] rowReadON[45]
+ rowReadON[44] RefrBp PrBp PrSFBp col_periphery_1x2_19/COL_LINE0 pixRst[38] OffBn
+ rowReadOFF[44] pixRst[39] openDVS_pixel2x2_top_735/GndD DiffBn col_periphery_1x2_19/COL_LINE1
+ GndD VddA18 OnBn openDVS_pixel2x2_top
XopenDVS_pixel2x2_top_756 openDVS_pixel2x2_top_756/vpd[0] openDVS_pixel2x2_top_756/vpd[1]
+ openDVS_pixel2x2_top_756/vpd[3] openDVS_pixel2x2_top_756/vpd[2] rowReadOFF[47] rowReadON[47]
+ rowReadON[46] RefrBp PrBp PrSFBp col_periphery_1x2_20/COL_LINE0 pixRst[40] OffBn
+ rowReadOFF[46] pixRst[41] openDVS_pixel2x2_top_767/GndD DiffBn col_periphery_1x2_20/COL_LINE1
+ GndD VddA18 OnBn openDVS_pixel2x2_top
XopenDVS_pixel2x2_top_789 openDVS_pixel2x2_top_789/vpd[0] openDVS_pixel2x2_top_789/vpd[1]
+ openDVS_pixel2x2_top_789/vpd[3] openDVS_pixel2x2_top_789/vpd[2] rowReadOFF[49] rowReadON[49]
+ rowReadON[48] RefrBp PrBp PrSFBp col_periphery_1x2_21/COL_LINE0 pixRst[42] OffBn
+ rowReadOFF[48] pixRst[43] openDVS_pixel2x2_top_799/GndD DiffBn col_periphery_1x2_21/COL_LINE1
+ GndD VddA18 OnBn openDVS_pixel2x2_top
XopenDVS_pixel2x2_top_701 openDVS_pixel2x2_top_701/vpd[0] openDVS_pixel2x2_top_701/vpd[1]
+ openDVS_pixel2x2_top_701/vpd[3] openDVS_pixel2x2_top_701/vpd[2] rowReadOFF[43] rowReadON[43]
+ rowReadON[42] RefrBp PrBp PrSFBp col_periphery_1x2_29/COL_LINE0 pixRst[58] OffBn
+ rowReadOFF[42] pixRst[59] openDVS_pixel2x2_top_703/GndD DiffBn col_periphery_1x2_29/COL_LINE1
+ GndD VddA18 OnBn openDVS_pixel2x2_top
XopenDVS_pixel2x2_top_734 openDVS_pixel2x2_top_734/vpd[0] openDVS_pixel2x2_top_734/vpd[1]
+ openDVS_pixel2x2_top_734/vpd[3] openDVS_pixel2x2_top_734/vpd[2] rowReadOFF[45] rowReadON[45]
+ rowReadON[44] RefrBp PrBp PrSFBp col_periphery_1x2_30/COL_LINE0 pixRst[60] OffBn
+ rowReadOFF[44] pixRst[61] openDVS_pixel2x2_top_735/GndD DiffBn col_periphery_1x2_30/COL_LINE1
+ GndD VddA18 OnBn openDVS_pixel2x2_top
XopenDVS_pixel2x2_top_767 openDVS_pixel2x2_top_767/vpd[0] openDVS_pixel2x2_top_767/vpd[1]
+ openDVS_pixel2x2_top_767/vpd[3] openDVS_pixel2x2_top_767/vpd[2] rowReadOFF[47] rowReadON[47]
+ rowReadON[46] RefrBp PrBp PrSFBp col_periphery_1x2_31/COL_LINE0 pixRst[62] OffBn
+ rowReadOFF[46] pixRst[63] openDVS_pixel2x2_top_767/GndD DiffBn col_periphery_1x2_31/COL_LINE1
+ GndD VddA18 OnBn openDVS_pixel2x2_top
Xcol_periphery_1x2_19 pixRst[39] col_periphery_1x2_19/COL_LINE0 col_periphery_1x2_19/COL_LINE1
+ nDETECT col_periphery_1x2_9/VDD DETECT VTHRESH voutn[38] GndD NCHARGE voutn[39]
+ pixRst[38] col_periphery_1x2
XopenDVS_pixel2x2_top_575 openDVS_pixel2x2_top_575/vpd[0] openDVS_pixel2x2_top_575/vpd[1]
+ openDVS_pixel2x2_top_575/vpd[3] openDVS_pixel2x2_top_575/vpd[2] rowReadOFF[35] rowReadON[35]
+ rowReadON[34] RefrBp PrBp PrSFBp col_periphery_1x2_31/COL_LINE0 pixRst[62] OffBn
+ rowReadOFF[34] pixRst[63] openDVS_pixel2x2_top_575/GndD DiffBn col_periphery_1x2_31/COL_LINE1
+ GndD VddA18 OnBn openDVS_pixel2x2_top
XopenDVS_pixel2x2_top_542 openDVS_pixel2x2_top_542/vpd[0] openDVS_pixel2x2_top_542/vpd[1]
+ openDVS_pixel2x2_top_542/vpd[3] openDVS_pixel2x2_top_542/vpd[2] rowReadOFF[33] rowReadON[33]
+ rowReadON[32] RefrBp PrBp PrSFBp col_periphery_1x2_30/COL_LINE0 pixRst[60] OffBn
+ rowReadOFF[32] pixRst[61] openDVS_pixel2x2_top_543/GndD DiffBn col_periphery_1x2_30/COL_LINE1
+ GndD VddA18 OnBn openDVS_pixel2x2_top
XopenDVS_pixel2x2_top_597 openDVS_pixel2x2_top_597/vpd[0] openDVS_pixel2x2_top_597/vpd[1]
+ openDVS_pixel2x2_top_597/vpd[3] openDVS_pixel2x2_top_597/vpd[2] rowReadOFF[37] rowReadON[37]
+ rowReadON[36] RefrBp PrBp PrSFBp col_periphery_1x2_21/COL_LINE0 pixRst[42] OffBn
+ rowReadOFF[36] pixRst[43] openDVS_pixel2x2_top_607/GndD DiffBn col_periphery_1x2_21/COL_LINE1
+ GndD VddA18 OnBn openDVS_pixel2x2_top
XopenDVS_pixel2x2_top_564 openDVS_pixel2x2_top_564/vpd[0] openDVS_pixel2x2_top_564/vpd[1]
+ openDVS_pixel2x2_top_564/vpd[3] openDVS_pixel2x2_top_564/vpd[2] rowReadOFF[35] rowReadON[35]
+ rowReadON[34] RefrBp PrBp PrSFBp col_periphery_1x2_20/COL_LINE0 pixRst[40] OffBn
+ rowReadOFF[34] pixRst[41] openDVS_pixel2x2_top_575/GndD DiffBn col_periphery_1x2_20/COL_LINE1
+ GndD VddA18 OnBn openDVS_pixel2x2_top
XopenDVS_pixel2x2_top_531 openDVS_pixel2x2_top_531/vpd[0] openDVS_pixel2x2_top_531/vpd[1]
+ openDVS_pixel2x2_top_531/vpd[3] openDVS_pixel2x2_top_531/vpd[2] rowReadOFF[33] rowReadON[33]
+ rowReadON[32] RefrBp PrBp PrSFBp col_periphery_1x2_19/COL_LINE0 pixRst[38] OffBn
+ rowReadOFF[32] pixRst[39] openDVS_pixel2x2_top_543/GndD DiffBn col_periphery_1x2_19/COL_LINE1
+ GndD VddA18 OnBn openDVS_pixel2x2_top
XopenDVS_pixel2x2_top_586 openDVS_pixel2x2_top_586/vpd[0] openDVS_pixel2x2_top_586/vpd[1]
+ openDVS_pixel2x2_top_586/vpd[3] openDVS_pixel2x2_top_586/vpd[2] rowReadOFF[37] rowReadON[37]
+ rowReadON[36] RefrBp PrBp PrSFBp col_periphery_1x2_10/COL_LINE0 pixRst[20] OffBn
+ rowReadOFF[36] pixRst[21] openDVS_pixel2x2_top_607/GndD DiffBn col_periphery_1x2_10/COL_LINE1
+ GndD VddA18 OnBn openDVS_pixel2x2_top
XopenDVS_pixel2x2_top_553 openDVS_pixel2x2_top_553/vpd[0] openDVS_pixel2x2_top_553/vpd[1]
+ openDVS_pixel2x2_top_553/vpd[3] openDVS_pixel2x2_top_553/vpd[2] rowReadOFF[35] rowReadON[35]
+ rowReadON[34] RefrBp PrBp PrSFBp col_periphery_1x2_9/COL_LINE0 pixRst[18] OffBn
+ rowReadOFF[34] pixRst[19] openDVS_pixel2x2_top_575/GndD DiffBn col_periphery_1x2_9/COL_LINE1
+ GndD VddA18 OnBn openDVS_pixel2x2_top
XopenDVS_pixel2x2_top_520 openDVS_pixel2x2_top_520/vpd[0] openDVS_pixel2x2_top_520/vpd[1]
+ openDVS_pixel2x2_top_520/vpd[3] openDVS_pixel2x2_top_520/vpd[2] rowReadOFF[33] rowReadON[33]
+ rowReadON[32] RefrBp PrBp PrSFBp col_periphery_1x2_8/COL_LINE0 pixRst[16] OffBn
+ rowReadOFF[32] pixRst[17] openDVS_pixel2x2_top_543/GndD DiffBn col_periphery_1x2_8/COL_LINE1
+ GndD VddA18 OnBn openDVS_pixel2x2_top
XopenDVS_pixel2x2_top_350 openDVS_pixel2x2_top_350/vpd[0] openDVS_pixel2x2_top_350/vpd[1]
+ openDVS_pixel2x2_top_350/vpd[3] openDVS_pixel2x2_top_350/vpd[2] rowReadOFF[21] rowReadON[21]
+ rowReadON[20] RefrBp PrBp PrSFBp col_periphery_1x2_30/COL_LINE0 pixRst[60] OffBn
+ rowReadOFF[20] pixRst[61] openDVS_pixel2x2_top_351/GndD DiffBn col_periphery_1x2_30/COL_LINE1
+ GndD VddA18 OnBn openDVS_pixel2x2_top
XopenDVS_pixel2x2_top_383 openDVS_pixel2x2_top_383/vpd[0] openDVS_pixel2x2_top_383/vpd[1]
+ openDVS_pixel2x2_top_383/vpd[3] openDVS_pixel2x2_top_383/vpd[2] rowReadOFF[23] rowReadON[23]
+ rowReadON[22] RefrBp PrBp PrSFBp col_periphery_1x2_31/COL_LINE0 pixRst[62] OffBn
+ rowReadOFF[22] pixRst[63] openDVS_pixel2x2_top_383/GndD DiffBn col_periphery_1x2_31/COL_LINE1
+ GndD VddA18 OnBn openDVS_pixel2x2_top
XopenDVS_pixel2x2_top_372 openDVS_pixel2x2_top_372/vpd[0] openDVS_pixel2x2_top_372/vpd[1]
+ openDVS_pixel2x2_top_372/vpd[3] openDVS_pixel2x2_top_372/vpd[2] rowReadOFF[23] rowReadON[23]
+ rowReadON[22] RefrBp PrBp PrSFBp col_periphery_1x2_20/COL_LINE0 pixRst[40] OffBn
+ rowReadOFF[22] pixRst[41] openDVS_pixel2x2_top_383/GndD DiffBn col_periphery_1x2_20/COL_LINE1
+ GndD VddA18 OnBn openDVS_pixel2x2_top
XopenDVS_pixel2x2_top_394 openDVS_pixel2x2_top_394/vpd[0] openDVS_pixel2x2_top_394/vpd[1]
+ openDVS_pixel2x2_top_394/vpd[3] openDVS_pixel2x2_top_394/vpd[2] rowReadOFF[25] rowReadON[25]
+ rowReadON[24] RefrBp PrBp PrSFBp col_periphery_1x2_10/COL_LINE0 pixRst[20] OffBn
+ rowReadOFF[24] pixRst[21] openDVS_pixel2x2_top_415/GndD DiffBn col_periphery_1x2_10/COL_LINE1
+ GndD VddA18 OnBn openDVS_pixel2x2_top
XopenDVS_pixel2x2_top_361 openDVS_pixel2x2_top_361/vpd[0] openDVS_pixel2x2_top_361/vpd[1]
+ openDVS_pixel2x2_top_361/vpd[3] openDVS_pixel2x2_top_361/vpd[2] rowReadOFF[23] rowReadON[23]
+ rowReadON[22] RefrBp PrBp PrSFBp col_periphery_1x2_9/COL_LINE0 pixRst[18] OffBn
+ rowReadOFF[22] pixRst[19] openDVS_pixel2x2_top_383/GndD DiffBn col_periphery_1x2_9/COL_LINE1
+ GndD VddA18 OnBn openDVS_pixel2x2_top
XopenDVS_pixel2x2_top_191 openDVS_pixel2x2_top_191/vpd[0] openDVS_pixel2x2_top_191/vpd[1]
+ openDVS_pixel2x2_top_191/vpd[3] openDVS_pixel2x2_top_191/vpd[2] rowReadOFF[11] rowReadON[11]
+ rowReadON[10] RefrBp PrBp PrSFBp col_periphery_1x2_31/COL_LINE0 pixRst[62] OffBn
+ rowReadOFF[10] pixRst[63] openDVS_pixel2x2_top_191/GndD DiffBn col_periphery_1x2_31/COL_LINE1
+ GndD VddA18 OnBn openDVS_pixel2x2_top
XopenDVS_pixel2x2_top_180 openDVS_pixel2x2_top_180/vpd[0] openDVS_pixel2x2_top_180/vpd[1]
+ openDVS_pixel2x2_top_180/vpd[3] openDVS_pixel2x2_top_180/vpd[2] rowReadOFF[11] rowReadON[11]
+ rowReadON[10] RefrBp PrBp PrSFBp col_periphery_1x2_20/COL_LINE0 pixRst[40] OffBn
+ rowReadOFF[10] pixRst[41] openDVS_pixel2x2_top_191/GndD DiffBn col_periphery_1x2_20/COL_LINE1
+ GndD VddA18 OnBn openDVS_pixel2x2_top
XopenDVS_pixel2x2_top_31 openDVS_pixel2x2_top_31/vpd[0] openDVS_pixel2x2_top_31/vpd[1]
+ openDVS_pixel2x2_top_31/vpd[3] openDVS_pixel2x2_top_31/vpd[2] rowReadOFF[1] rowReadON[1]
+ rowReadON[0] RefrBp PrBp PrSFBp col_periphery_1x2_31/COL_LINE0 pixRst[62] OffBn
+ rowReadOFF[0] pixRst[63] openDVS_pixel2x2_top_9/GndD DiffBn col_periphery_1x2_31/COL_LINE1
+ GndD VddA18 OnBn openDVS_pixel2x2_top
XopenDVS_pixel2x2_top_20 openDVS_pixel2x2_top_20/vpd[0] openDVS_pixel2x2_top_20/vpd[1]
+ openDVS_pixel2x2_top_20/vpd[3] openDVS_pixel2x2_top_20/vpd[2] rowReadOFF[1] rowReadON[1]
+ rowReadON[0] RefrBp PrBp PrSFBp col_periphery_1x2_20/COL_LINE0 pixRst[40] OffBn
+ rowReadOFF[0] pixRst[41] openDVS_pixel2x2_top_9/GndD DiffBn col_periphery_1x2_20/COL_LINE1
+ GndD VddA18 OnBn openDVS_pixel2x2_top
XopenDVS_pixel2x2_top_53 openDVS_pixel2x2_top_53/vpd[0] openDVS_pixel2x2_top_53/vpd[1]
+ openDVS_pixel2x2_top_53/vpd[3] openDVS_pixel2x2_top_53/vpd[2] rowReadOFF[3] rowReadON[3]
+ rowReadON[2] RefrBp PrBp PrSFBp col_periphery_1x2_21/COL_LINE0 pixRst[42] OffBn
+ rowReadOFF[2] pixRst[43] openDVS_pixel2x2_top_63/GndD DiffBn col_periphery_1x2_21/COL_LINE1
+ GndD VddA18 OnBn openDVS_pixel2x2_top
XopenDVS_pixel2x2_top_86 openDVS_pixel2x2_top_86/vpd[0] openDVS_pixel2x2_top_86/vpd[1]
+ openDVS_pixel2x2_top_86/vpd[3] openDVS_pixel2x2_top_86/vpd[2] rowReadOFF[5] rowReadON[5]
+ rowReadON[4] RefrBp PrBp PrSFBp col_periphery_1x2_22/COL_LINE0 pixRst[44] OffBn
+ rowReadOFF[4] pixRst[45] openDVS_pixel2x2_top_95/GndD DiffBn col_periphery_1x2_22/COL_LINE1
+ GndD VddA18 OnBn openDVS_pixel2x2_top
XopenDVS_pixel2x2_top_42 openDVS_pixel2x2_top_42/vpd[0] openDVS_pixel2x2_top_42/vpd[1]
+ openDVS_pixel2x2_top_42/vpd[3] openDVS_pixel2x2_top_42/vpd[2] rowReadOFF[3] rowReadON[3]
+ rowReadON[2] RefrBp PrBp PrSFBp col_periphery_1x2_10/COL_LINE0 pixRst[20] OffBn
+ rowReadOFF[2] pixRst[21] openDVS_pixel2x2_top_63/GndD DiffBn col_periphery_1x2_10/COL_LINE1
+ GndD VddA18 OnBn openDVS_pixel2x2_top
XopenDVS_pixel2x2_top_75 openDVS_pixel2x2_top_75/vpd[0] openDVS_pixel2x2_top_75/vpd[1]
+ openDVS_pixel2x2_top_75/vpd[3] openDVS_pixel2x2_top_75/vpd[2] rowReadOFF[5] rowReadON[5]
+ rowReadON[4] RefrBp PrBp PrSFBp col_periphery_1x2_11/COL_LINE0 pixRst[22] OffBn
+ rowReadOFF[4] pixRst[23] openDVS_pixel2x2_top_95/GndD DiffBn col_periphery_1x2_11/COL_LINE1
+ GndD VddA18 OnBn openDVS_pixel2x2_top
XopenDVS_pixel2x2_top_64 openDVS_pixel2x2_top_64/vpd[0] openDVS_pixel2x2_top_64/vpd[1]
+ openDVS_pixel2x2_top_64/vpd[3] openDVS_pixel2x2_top_64/vpd[2] rowReadOFF[5] rowReadON[5]
+ rowReadON[4] RefrBp PrBp PrSFBp col_periphery_1x2_0/COL_LINE0 pixRst[0] OffBn rowReadOFF[4]
+ pixRst[1] openDVS_pixel2x2_top_95/GndD DiffBn col_periphery_1x2_0/COL_LINE1 GndD
+ VddA18 OnBn openDVS_pixel2x2_top
XopenDVS_pixel2x2_top_97 openDVS_pixel2x2_top_97/vpd[0] openDVS_pixel2x2_top_97/vpd[1]
+ openDVS_pixel2x2_top_97/vpd[3] openDVS_pixel2x2_top_97/vpd[2] rowReadOFF[7] rowReadON[7]
+ rowReadON[6] RefrBp PrBp PrSFBp col_periphery_1x2_1/COL_LINE0 pixRst[2] OffBn rowReadOFF[6]
+ pixRst[3] openDVS_pixel2x2_top_99/GndD DiffBn col_periphery_1x2_1/COL_LINE1 GndD
+ VddA18 OnBn openDVS_pixel2x2_top
Xcol_periphery_1x2_0 pixRst[1] col_periphery_1x2_0/COL_LINE0 col_periphery_1x2_0/COL_LINE1
+ nDETECT col_periphery_1x2_9/VDD DETECT VTHRESH voutn[0] GndD NCHARGE voutn[1] pixRst[0]
+ col_periphery_1x2
XopenDVS_pixel2x2_top_905 openDVS_pixel2x2_top_905/vpd[0] openDVS_pixel2x2_top_905/vpd[1]
+ openDVS_pixel2x2_top_905/vpd[3] openDVS_pixel2x2_top_905/vpd[2] rowReadOFF[57] rowReadON[57]
+ rowReadON[56] RefrBp PrBp PrSFBp col_periphery_1x2_9/COL_LINE0 pixRst[18] OffBn
+ rowReadOFF[56] pixRst[19] openDVS_pixel2x2_top_927/GndD DiffBn col_periphery_1x2_9/COL_LINE1
+ GndD VddA18 OnBn openDVS_pixel2x2_top
XopenDVS_pixel2x2_top_938 openDVS_pixel2x2_top_938/vpd[0] openDVS_pixel2x2_top_938/vpd[1]
+ openDVS_pixel2x2_top_938/vpd[3] openDVS_pixel2x2_top_938/vpd[2] rowReadOFF[59] rowReadON[59]
+ rowReadON[58] RefrBp PrBp PrSFBp col_periphery_1x2_10/COL_LINE0 pixRst[20] OffBn
+ rowReadOFF[58] pixRst[21] openDVS_pixel2x2_top_959/GndD DiffBn col_periphery_1x2_10/COL_LINE1
+ GndD VddA18 OnBn openDVS_pixel2x2_top
XopenDVS_pixel2x2_top_916 openDVS_pixel2x2_top_916/vpd[0] openDVS_pixel2x2_top_916/vpd[1]
+ openDVS_pixel2x2_top_916/vpd[3] openDVS_pixel2x2_top_916/vpd[2] rowReadOFF[57] rowReadON[57]
+ rowReadON[56] RefrBp PrBp PrSFBp col_periphery_1x2_20/COL_LINE0 pixRst[40] OffBn
+ rowReadOFF[56] pixRst[41] openDVS_pixel2x2_top_927/GndD DiffBn col_periphery_1x2_20/COL_LINE1
+ GndD VddA18 OnBn openDVS_pixel2x2_top
XopenDVS_pixel2x2_top_949 openDVS_pixel2x2_top_949/vpd[0] openDVS_pixel2x2_top_949/vpd[1]
+ openDVS_pixel2x2_top_949/vpd[3] openDVS_pixel2x2_top_949/vpd[2] rowReadOFF[59] rowReadON[59]
+ rowReadON[58] RefrBp PrBp PrSFBp col_periphery_1x2_21/COL_LINE0 pixRst[42] OffBn
+ rowReadOFF[58] pixRst[43] openDVS_pixel2x2_top_959/GndD DiffBn col_periphery_1x2_21/COL_LINE1
+ GndD VddA18 OnBn openDVS_pixel2x2_top
XopenDVS_pixel2x2_top_927 openDVS_pixel2x2_top_927/vpd[0] openDVS_pixel2x2_top_927/vpd[1]
+ openDVS_pixel2x2_top_927/vpd[3] openDVS_pixel2x2_top_927/vpd[2] rowReadOFF[57] rowReadON[57]
+ rowReadON[56] RefrBp PrBp PrSFBp col_periphery_1x2_31/COL_LINE0 pixRst[62] OffBn
+ rowReadOFF[56] pixRst[63] openDVS_pixel2x2_top_927/GndD DiffBn col_periphery_1x2_31/COL_LINE1
+ GndD VddA18 OnBn openDVS_pixel2x2_top
XopenDVS_pixel2x2_top_768 openDVS_pixel2x2_top_768/vpd[0] openDVS_pixel2x2_top_768/vpd[1]
+ openDVS_pixel2x2_top_768/vpd[3] openDVS_pixel2x2_top_768/vpd[2] rowReadOFF[49] rowReadON[49]
+ rowReadON[48] RefrBp PrBp PrSFBp col_periphery_1x2_0/COL_LINE0 pixRst[0] OffBn rowReadOFF[48]
+ pixRst[1] openDVS_pixel2x2_top_799/GndD DiffBn col_periphery_1x2_0/COL_LINE1 GndD
+ VddA18 OnBn openDVS_pixel2x2_top
XopenDVS_pixel2x2_top_713 openDVS_pixel2x2_top_713/vpd[0] openDVS_pixel2x2_top_713/vpd[1]
+ openDVS_pixel2x2_top_713/vpd[3] openDVS_pixel2x2_top_713/vpd[2] rowReadOFF[45] rowReadON[45]
+ rowReadON[44] RefrBp PrBp PrSFBp col_periphery_1x2_9/COL_LINE0 pixRst[18] OffBn
+ rowReadOFF[44] pixRst[19] openDVS_pixel2x2_top_735/GndD DiffBn col_periphery_1x2_9/COL_LINE1
+ GndD VddA18 OnBn openDVS_pixel2x2_top
XopenDVS_pixel2x2_top_779 openDVS_pixel2x2_top_779/vpd[0] openDVS_pixel2x2_top_779/vpd[1]
+ openDVS_pixel2x2_top_779/vpd[3] openDVS_pixel2x2_top_779/vpd[2] rowReadOFF[49] rowReadON[49]
+ rowReadON[48] RefrBp PrBp PrSFBp col_periphery_1x2_11/COL_LINE0 pixRst[22] OffBn
+ rowReadOFF[48] pixRst[23] openDVS_pixel2x2_top_799/GndD DiffBn col_periphery_1x2_11/COL_LINE1
+ GndD VddA18 OnBn openDVS_pixel2x2_top
XopenDVS_pixel2x2_top_746 openDVS_pixel2x2_top_746/vpd[0] openDVS_pixel2x2_top_746/vpd[1]
+ openDVS_pixel2x2_top_746/vpd[3] openDVS_pixel2x2_top_746/vpd[2] rowReadOFF[47] rowReadON[47]
+ rowReadON[46] RefrBp PrBp PrSFBp col_periphery_1x2_10/COL_LINE0 pixRst[20] OffBn
+ rowReadOFF[46] pixRst[21] openDVS_pixel2x2_top_767/GndD DiffBn col_periphery_1x2_10/COL_LINE1
+ GndD VddA18 OnBn openDVS_pixel2x2_top
XopenDVS_pixel2x2_top_724 openDVS_pixel2x2_top_724/vpd[0] openDVS_pixel2x2_top_724/vpd[1]
+ openDVS_pixel2x2_top_724/vpd[3] openDVS_pixel2x2_top_724/vpd[2] rowReadOFF[45] rowReadON[45]
+ rowReadON[44] RefrBp PrBp PrSFBp col_periphery_1x2_20/COL_LINE0 pixRst[40] OffBn
+ rowReadOFF[44] pixRst[41] openDVS_pixel2x2_top_735/GndD DiffBn col_periphery_1x2_20/COL_LINE1
+ GndD VddA18 OnBn openDVS_pixel2x2_top
XopenDVS_pixel2x2_top_757 openDVS_pixel2x2_top_757/vpd[0] openDVS_pixel2x2_top_757/vpd[1]
+ openDVS_pixel2x2_top_757/vpd[3] openDVS_pixel2x2_top_757/vpd[2] rowReadOFF[47] rowReadON[47]
+ rowReadON[46] RefrBp PrBp PrSFBp col_periphery_1x2_21/COL_LINE0 pixRst[42] OffBn
+ rowReadOFF[46] pixRst[43] openDVS_pixel2x2_top_767/GndD DiffBn col_periphery_1x2_21/COL_LINE1
+ GndD VddA18 OnBn openDVS_pixel2x2_top
XopenDVS_pixel2x2_top_702 openDVS_pixel2x2_top_702/vpd[0] openDVS_pixel2x2_top_702/vpd[1]
+ openDVS_pixel2x2_top_702/vpd[3] openDVS_pixel2x2_top_702/vpd[2] rowReadOFF[43] rowReadON[43]
+ rowReadON[42] RefrBp PrBp PrSFBp col_periphery_1x2_30/COL_LINE0 pixRst[60] OffBn
+ rowReadOFF[42] pixRst[61] openDVS_pixel2x2_top_703/GndD DiffBn col_periphery_1x2_30/COL_LINE1
+ GndD VddA18 OnBn openDVS_pixel2x2_top
XopenDVS_pixel2x2_top_735 openDVS_pixel2x2_top_735/vpd[0] openDVS_pixel2x2_top_735/vpd[1]
+ openDVS_pixel2x2_top_735/vpd[3] openDVS_pixel2x2_top_735/vpd[2] rowReadOFF[45] rowReadON[45]
+ rowReadON[44] RefrBp PrBp PrSFBp col_periphery_1x2_31/COL_LINE0 pixRst[62] OffBn
+ rowReadOFF[44] pixRst[63] openDVS_pixel2x2_top_735/GndD DiffBn col_periphery_1x2_31/COL_LINE1
+ GndD VddA18 OnBn openDVS_pixel2x2_top
XopenDVS_pixel2x2_top_510 openDVS_pixel2x2_top_510/vpd[0] openDVS_pixel2x2_top_510/vpd[1]
+ openDVS_pixel2x2_top_510/vpd[3] openDVS_pixel2x2_top_510/vpd[2] rowReadOFF[31] rowReadON[31]
+ rowReadON[30] RefrBp PrBp PrSFBp col_periphery_1x2_30/COL_LINE0 pixRst[60] OffBn
+ rowReadOFF[30] pixRst[61] openDVS_pixel2x2_top_511/GndD DiffBn col_periphery_1x2_30/COL_LINE1
+ GndD VddA18 OnBn openDVS_pixel2x2_top
XopenDVS_pixel2x2_top_543 openDVS_pixel2x2_top_543/vpd[0] openDVS_pixel2x2_top_543/vpd[1]
+ openDVS_pixel2x2_top_543/vpd[3] openDVS_pixel2x2_top_543/vpd[2] rowReadOFF[33] rowReadON[33]
+ rowReadON[32] RefrBp PrBp PrSFBp col_periphery_1x2_31/COL_LINE0 pixRst[62] OffBn
+ rowReadOFF[32] pixRst[63] openDVS_pixel2x2_top_543/GndD DiffBn col_periphery_1x2_31/COL_LINE1
+ GndD VddA18 OnBn openDVS_pixel2x2_top
XopenDVS_pixel2x2_top_565 openDVS_pixel2x2_top_565/vpd[0] openDVS_pixel2x2_top_565/vpd[1]
+ openDVS_pixel2x2_top_565/vpd[3] openDVS_pixel2x2_top_565/vpd[2] rowReadOFF[35] rowReadON[35]
+ rowReadON[34] RefrBp PrBp PrSFBp col_periphery_1x2_21/COL_LINE0 pixRst[42] OffBn
+ rowReadOFF[34] pixRst[43] openDVS_pixel2x2_top_575/GndD DiffBn col_periphery_1x2_21/COL_LINE1
+ GndD VddA18 OnBn openDVS_pixel2x2_top
XopenDVS_pixel2x2_top_598 openDVS_pixel2x2_top_598/vpd[0] openDVS_pixel2x2_top_598/vpd[1]
+ openDVS_pixel2x2_top_598/vpd[3] openDVS_pixel2x2_top_598/vpd[2] rowReadOFF[37] rowReadON[37]
+ rowReadON[36] RefrBp PrBp PrSFBp col_periphery_1x2_22/COL_LINE0 pixRst[44] OffBn
+ rowReadOFF[36] pixRst[45] openDVS_pixel2x2_top_607/GndD DiffBn col_periphery_1x2_22/COL_LINE1
+ GndD VddA18 OnBn openDVS_pixel2x2_top
XopenDVS_pixel2x2_top_532 openDVS_pixel2x2_top_532/vpd[0] openDVS_pixel2x2_top_532/vpd[1]
+ openDVS_pixel2x2_top_532/vpd[3] openDVS_pixel2x2_top_532/vpd[2] rowReadOFF[33] rowReadON[33]
+ rowReadON[32] RefrBp PrBp PrSFBp col_periphery_1x2_20/COL_LINE0 pixRst[40] OffBn
+ rowReadOFF[32] pixRst[41] openDVS_pixel2x2_top_543/GndD DiffBn col_periphery_1x2_20/COL_LINE1
+ GndD VddA18 OnBn openDVS_pixel2x2_top
XopenDVS_pixel2x2_top_554 openDVS_pixel2x2_top_554/vpd[0] openDVS_pixel2x2_top_554/vpd[1]
+ openDVS_pixel2x2_top_554/vpd[3] openDVS_pixel2x2_top_554/vpd[2] rowReadOFF[35] rowReadON[35]
+ rowReadON[34] RefrBp PrBp PrSFBp col_periphery_1x2_10/COL_LINE0 pixRst[20] OffBn
+ rowReadOFF[34] pixRst[21] openDVS_pixel2x2_top_575/GndD DiffBn col_periphery_1x2_10/COL_LINE1
+ GndD VddA18 OnBn openDVS_pixel2x2_top
XopenDVS_pixel2x2_top_587 openDVS_pixel2x2_top_587/vpd[0] openDVS_pixel2x2_top_587/vpd[1]
+ openDVS_pixel2x2_top_587/vpd[3] openDVS_pixel2x2_top_587/vpd[2] rowReadOFF[37] rowReadON[37]
+ rowReadON[36] RefrBp PrBp PrSFBp col_periphery_1x2_11/COL_LINE0 pixRst[22] OffBn
+ rowReadOFF[36] pixRst[23] openDVS_pixel2x2_top_607/GndD DiffBn col_periphery_1x2_11/COL_LINE1
+ GndD VddA18 OnBn openDVS_pixel2x2_top
XopenDVS_pixel2x2_top_521 openDVS_pixel2x2_top_521/vpd[0] openDVS_pixel2x2_top_521/vpd[1]
+ openDVS_pixel2x2_top_521/vpd[3] openDVS_pixel2x2_top_521/vpd[2] rowReadOFF[33] rowReadON[33]
+ rowReadON[32] RefrBp PrBp PrSFBp col_periphery_1x2_9/COL_LINE0 pixRst[18] OffBn
+ rowReadOFF[32] pixRst[19] openDVS_pixel2x2_top_543/GndD DiffBn col_periphery_1x2_9/COL_LINE1
+ GndD VddA18 OnBn openDVS_pixel2x2_top
XopenDVS_pixel2x2_top_576 openDVS_pixel2x2_top_576/vpd[0] openDVS_pixel2x2_top_576/vpd[1]
+ openDVS_pixel2x2_top_576/vpd[3] openDVS_pixel2x2_top_576/vpd[2] rowReadOFF[37] rowReadON[37]
+ rowReadON[36] RefrBp PrBp PrSFBp col_periphery_1x2_0/COL_LINE0 pixRst[0] OffBn rowReadOFF[36]
+ pixRst[1] openDVS_pixel2x2_top_607/GndD DiffBn col_periphery_1x2_0/COL_LINE1 GndD
+ VddA18 OnBn openDVS_pixel2x2_top
XopenDVS_pixel2x2_top_351 openDVS_pixel2x2_top_351/vpd[0] openDVS_pixel2x2_top_351/vpd[1]
+ openDVS_pixel2x2_top_351/vpd[3] openDVS_pixel2x2_top_351/vpd[2] rowReadOFF[21] rowReadON[21]
+ rowReadON[20] RefrBp PrBp PrSFBp col_periphery_1x2_31/COL_LINE0 pixRst[62] OffBn
+ rowReadOFF[20] pixRst[63] openDVS_pixel2x2_top_351/GndD DiffBn col_periphery_1x2_31/COL_LINE1
+ GndD VddA18 OnBn openDVS_pixel2x2_top
XopenDVS_pixel2x2_top_340 openDVS_pixel2x2_top_340/vpd[0] openDVS_pixel2x2_top_340/vpd[1]
+ openDVS_pixel2x2_top_340/vpd[3] openDVS_pixel2x2_top_340/vpd[2] rowReadOFF[21] rowReadON[21]
+ rowReadON[20] RefrBp PrBp PrSFBp col_periphery_1x2_20/COL_LINE0 pixRst[40] OffBn
+ rowReadOFF[20] pixRst[41] openDVS_pixel2x2_top_351/GndD DiffBn col_periphery_1x2_20/COL_LINE1
+ GndD VddA18 OnBn openDVS_pixel2x2_top
XopenDVS_pixel2x2_top_373 openDVS_pixel2x2_top_373/vpd[0] openDVS_pixel2x2_top_373/vpd[1]
+ openDVS_pixel2x2_top_373/vpd[3] openDVS_pixel2x2_top_373/vpd[2] rowReadOFF[23] rowReadON[23]
+ rowReadON[22] RefrBp PrBp PrSFBp col_periphery_1x2_21/COL_LINE0 pixRst[42] OffBn
+ rowReadOFF[22] pixRst[43] openDVS_pixel2x2_top_383/GndD DiffBn col_periphery_1x2_21/COL_LINE1
+ GndD VddA18 OnBn openDVS_pixel2x2_top
XopenDVS_pixel2x2_top_362 openDVS_pixel2x2_top_362/vpd[0] openDVS_pixel2x2_top_362/vpd[1]
+ openDVS_pixel2x2_top_362/vpd[3] openDVS_pixel2x2_top_362/vpd[2] rowReadOFF[23] rowReadON[23]
+ rowReadON[22] RefrBp PrBp PrSFBp col_periphery_1x2_10/COL_LINE0 pixRst[20] OffBn
+ rowReadOFF[22] pixRst[21] openDVS_pixel2x2_top_383/GndD DiffBn col_periphery_1x2_10/COL_LINE1
+ GndD VddA18 OnBn openDVS_pixel2x2_top
XopenDVS_pixel2x2_top_395 openDVS_pixel2x2_top_395/vpd[0] openDVS_pixel2x2_top_395/vpd[1]
+ openDVS_pixel2x2_top_395/vpd[3] openDVS_pixel2x2_top_395/vpd[2] rowReadOFF[25] rowReadON[25]
+ rowReadON[24] RefrBp PrBp PrSFBp col_periphery_1x2_11/COL_LINE0 pixRst[22] OffBn
+ rowReadOFF[24] pixRst[23] openDVS_pixel2x2_top_415/GndD DiffBn col_periphery_1x2_11/COL_LINE1
+ GndD VddA18 OnBn openDVS_pixel2x2_top
XopenDVS_pixel2x2_top_384 openDVS_pixel2x2_top_384/vpd[0] openDVS_pixel2x2_top_384/vpd[1]
+ openDVS_pixel2x2_top_384/vpd[3] openDVS_pixel2x2_top_384/vpd[2] rowReadOFF[25] rowReadON[25]
+ rowReadON[24] RefrBp PrBp PrSFBp col_periphery_1x2_0/COL_LINE0 pixRst[0] OffBn rowReadOFF[24]
+ pixRst[1] openDVS_pixel2x2_top_415/GndD DiffBn col_periphery_1x2_0/COL_LINE1 GndD
+ VddA18 OnBn openDVS_pixel2x2_top
XopenDVS_pixel2x2_top_181 openDVS_pixel2x2_top_181/vpd[0] openDVS_pixel2x2_top_181/vpd[1]
+ openDVS_pixel2x2_top_181/vpd[3] openDVS_pixel2x2_top_181/vpd[2] rowReadOFF[11] rowReadON[11]
+ rowReadON[10] RefrBp PrBp PrSFBp col_periphery_1x2_21/COL_LINE0 pixRst[42] OffBn
+ rowReadOFF[10] pixRst[43] openDVS_pixel2x2_top_191/GndD DiffBn col_periphery_1x2_21/COL_LINE1
+ GndD VddA18 OnBn openDVS_pixel2x2_top
XopenDVS_pixel2x2_top_170 openDVS_pixel2x2_top_170/vpd[0] openDVS_pixel2x2_top_170/vpd[1]
+ openDVS_pixel2x2_top_170/vpd[3] openDVS_pixel2x2_top_170/vpd[2] rowReadOFF[11] rowReadON[11]
+ rowReadON[10] RefrBp PrBp PrSFBp col_periphery_1x2_10/COL_LINE0 pixRst[20] OffBn
+ rowReadOFF[10] pixRst[21] openDVS_pixel2x2_top_191/GndD DiffBn col_periphery_1x2_10/COL_LINE1
+ GndD VddA18 OnBn openDVS_pixel2x2_top
XopenDVS_pixel2x2_top_192 openDVS_pixel2x2_top_192/vpd[0] openDVS_pixel2x2_top_192/vpd[1]
+ openDVS_pixel2x2_top_192/vpd[3] openDVS_pixel2x2_top_192/vpd[2] rowReadOFF[13] rowReadON[13]
+ rowReadON[12] RefrBp PrBp PrSFBp col_periphery_1x2_0/COL_LINE0 pixRst[0] OffBn rowReadOFF[12]
+ pixRst[1] openDVS_pixel2x2_top_223/GndD DiffBn col_periphery_1x2_0/COL_LINE1 GndD
+ VddA18 OnBn openDVS_pixel2x2_top
XopenDVS_pixel2x2_top_21 openDVS_pixel2x2_top_21/vpd[0] openDVS_pixel2x2_top_21/vpd[1]
+ openDVS_pixel2x2_top_21/vpd[3] openDVS_pixel2x2_top_21/vpd[2] rowReadOFF[1] rowReadON[1]
+ rowReadON[0] RefrBp PrBp PrSFBp col_periphery_1x2_21/COL_LINE0 pixRst[42] OffBn
+ rowReadOFF[0] pixRst[43] openDVS_pixel2x2_top_9/GndD DiffBn col_periphery_1x2_21/COL_LINE1
+ GndD VddA18 OnBn openDVS_pixel2x2_top
XopenDVS_pixel2x2_top_10 openDVS_pixel2x2_top_10/vpd[0] openDVS_pixel2x2_top_10/vpd[1]
+ openDVS_pixel2x2_top_10/vpd[3] openDVS_pixel2x2_top_10/vpd[2] rowReadOFF[1] rowReadON[1]
+ rowReadON[0] RefrBp PrBp PrSFBp col_periphery_1x2_10/COL_LINE0 pixRst[20] OffBn
+ rowReadOFF[0] pixRst[21] openDVS_pixel2x2_top_9/GndD DiffBn col_periphery_1x2_10/COL_LINE1
+ GndD VddA18 OnBn openDVS_pixel2x2_top
Xcol_periphery_1x2_1 pixRst[3] col_periphery_1x2_1/COL_LINE0 col_periphery_1x2_1/COL_LINE1
+ nDETECT col_periphery_1x2_9/VDD DETECT VTHRESH voutn[2] GndD NCHARGE voutn[3] pixRst[2]
+ col_periphery_1x2
XopenDVS_pixel2x2_top_87 openDVS_pixel2x2_top_87/vpd[0] openDVS_pixel2x2_top_87/vpd[1]
+ openDVS_pixel2x2_top_87/vpd[3] openDVS_pixel2x2_top_87/vpd[2] rowReadOFF[5] rowReadON[5]
+ rowReadON[4] RefrBp PrBp PrSFBp col_periphery_1x2_23/COL_LINE0 pixRst[46] OffBn
+ rowReadOFF[4] pixRst[47] openDVS_pixel2x2_top_95/GndD DiffBn col_periphery_1x2_23/COL_LINE1
+ GndD VddA18 OnBn openDVS_pixel2x2_top
XopenDVS_pixel2x2_top_54 openDVS_pixel2x2_top_54/vpd[0] openDVS_pixel2x2_top_54/vpd[1]
+ openDVS_pixel2x2_top_54/vpd[3] openDVS_pixel2x2_top_54/vpd[2] rowReadOFF[3] rowReadON[3]
+ rowReadON[2] RefrBp PrBp PrSFBp col_periphery_1x2_22/COL_LINE0 pixRst[44] OffBn
+ rowReadOFF[2] pixRst[45] openDVS_pixel2x2_top_63/GndD DiffBn col_periphery_1x2_22/COL_LINE1
+ GndD VddA18 OnBn openDVS_pixel2x2_top
XopenDVS_pixel2x2_top_76 openDVS_pixel2x2_top_76/vpd[0] openDVS_pixel2x2_top_76/vpd[1]
+ openDVS_pixel2x2_top_76/vpd[3] openDVS_pixel2x2_top_76/vpd[2] rowReadOFF[5] rowReadON[5]
+ rowReadON[4] RefrBp PrBp PrSFBp col_periphery_1x2_12/COL_LINE0 pixRst[24] OffBn
+ rowReadOFF[4] pixRst[25] openDVS_pixel2x2_top_95/GndD DiffBn col_periphery_1x2_12/COL_LINE1
+ GndD VddA18 OnBn openDVS_pixel2x2_top
XopenDVS_pixel2x2_top_43 openDVS_pixel2x2_top_43/vpd[0] openDVS_pixel2x2_top_43/vpd[1]
+ openDVS_pixel2x2_top_43/vpd[3] openDVS_pixel2x2_top_43/vpd[2] rowReadOFF[3] rowReadON[3]
+ rowReadON[2] RefrBp PrBp PrSFBp col_periphery_1x2_11/COL_LINE0 pixRst[22] OffBn
+ rowReadOFF[2] pixRst[23] openDVS_pixel2x2_top_63/GndD DiffBn col_periphery_1x2_11/COL_LINE1
+ GndD VddA18 OnBn openDVS_pixel2x2_top
XopenDVS_pixel2x2_top_98 openDVS_pixel2x2_top_98/vpd[0] openDVS_pixel2x2_top_98/vpd[1]
+ openDVS_pixel2x2_top_98/vpd[3] openDVS_pixel2x2_top_98/vpd[2] rowReadOFF[7] rowReadON[7]
+ rowReadON[6] RefrBp PrBp PrSFBp col_periphery_1x2_2/COL_LINE0 pixRst[4] OffBn rowReadOFF[6]
+ pixRst[5] openDVS_pixel2x2_top_99/GndD DiffBn col_periphery_1x2_2/COL_LINE1 GndD
+ VddA18 OnBn openDVS_pixel2x2_top
XopenDVS_pixel2x2_top_32 openDVS_pixel2x2_top_32/vpd[0] openDVS_pixel2x2_top_32/vpd[1]
+ openDVS_pixel2x2_top_32/vpd[3] openDVS_pixel2x2_top_32/vpd[2] rowReadOFF[3] rowReadON[3]
+ rowReadON[2] RefrBp PrBp PrSFBp col_periphery_1x2_0/COL_LINE0 pixRst[0] OffBn rowReadOFF[2]
+ pixRst[1] openDVS_pixel2x2_top_63/GndD DiffBn col_periphery_1x2_0/COL_LINE1 GndD
+ VddA18 OnBn openDVS_pixel2x2_top
XopenDVS_pixel2x2_top_65 openDVS_pixel2x2_top_65/vpd[0] openDVS_pixel2x2_top_65/vpd[1]
+ openDVS_pixel2x2_top_65/vpd[3] openDVS_pixel2x2_top_65/vpd[2] rowReadOFF[5] rowReadON[5]
+ rowReadON[4] RefrBp PrBp PrSFBp col_periphery_1x2_1/COL_LINE0 pixRst[2] OffBn rowReadOFF[4]
+ pixRst[3] openDVS_pixel2x2_top_95/GndD DiffBn col_periphery_1x2_1/COL_LINE1 GndD
+ VddA18 OnBn openDVS_pixel2x2_top
XopenDVS_pixel2x2_top_906 openDVS_pixel2x2_top_906/vpd[0] openDVS_pixel2x2_top_906/vpd[1]
+ openDVS_pixel2x2_top_906/vpd[3] openDVS_pixel2x2_top_906/vpd[2] rowReadOFF[57] rowReadON[57]
+ rowReadON[56] RefrBp PrBp PrSFBp col_periphery_1x2_10/COL_LINE0 pixRst[20] OffBn
+ rowReadOFF[56] pixRst[21] openDVS_pixel2x2_top_927/GndD DiffBn col_periphery_1x2_10/COL_LINE1
+ GndD VddA18 OnBn openDVS_pixel2x2_top
XopenDVS_pixel2x2_top_939 openDVS_pixel2x2_top_939/vpd[0] openDVS_pixel2x2_top_939/vpd[1]
+ openDVS_pixel2x2_top_939/vpd[3] openDVS_pixel2x2_top_939/vpd[2] rowReadOFF[59] rowReadON[59]
+ rowReadON[58] RefrBp PrBp PrSFBp col_periphery_1x2_11/COL_LINE0 pixRst[22] OffBn
+ rowReadOFF[58] pixRst[23] openDVS_pixel2x2_top_959/GndD DiffBn col_periphery_1x2_11/COL_LINE1
+ GndD VddA18 OnBn openDVS_pixel2x2_top
XopenDVS_pixel2x2_top_928 openDVS_pixel2x2_top_928/vpd[0] openDVS_pixel2x2_top_928/vpd[1]
+ openDVS_pixel2x2_top_928/vpd[3] openDVS_pixel2x2_top_928/vpd[2] rowReadOFF[59] rowReadON[59]
+ rowReadON[58] RefrBp PrBp PrSFBp col_periphery_1x2_0/COL_LINE0 pixRst[0] OffBn rowReadOFF[58]
+ pixRst[1] openDVS_pixel2x2_top_959/GndD DiffBn col_periphery_1x2_0/COL_LINE1 GndD
+ VddA18 OnBn openDVS_pixel2x2_top
XopenDVS_pixel2x2_top_917 openDVS_pixel2x2_top_917/vpd[0] openDVS_pixel2x2_top_917/vpd[1]
+ openDVS_pixel2x2_top_917/vpd[3] openDVS_pixel2x2_top_917/vpd[2] rowReadOFF[57] rowReadON[57]
+ rowReadON[56] RefrBp PrBp PrSFBp col_periphery_1x2_21/COL_LINE0 pixRst[42] OffBn
+ rowReadOFF[56] pixRst[43] openDVS_pixel2x2_top_927/GndD DiffBn col_periphery_1x2_21/COL_LINE1
+ GndD VddA18 OnBn openDVS_pixel2x2_top
XopenDVS_pixel2x2_top_769 openDVS_pixel2x2_top_769/vpd[0] openDVS_pixel2x2_top_769/vpd[1]
+ openDVS_pixel2x2_top_769/vpd[3] openDVS_pixel2x2_top_769/vpd[2] rowReadOFF[49] rowReadON[49]
+ rowReadON[48] RefrBp PrBp PrSFBp col_periphery_1x2_1/COL_LINE0 pixRst[2] OffBn rowReadOFF[48]
+ pixRst[3] openDVS_pixel2x2_top_799/GndD DiffBn col_periphery_1x2_1/COL_LINE1 GndD
+ VddA18 OnBn openDVS_pixel2x2_top
XopenDVS_pixel2x2_top_736 openDVS_pixel2x2_top_736/vpd[0] openDVS_pixel2x2_top_736/vpd[1]
+ openDVS_pixel2x2_top_736/vpd[3] openDVS_pixel2x2_top_736/vpd[2] rowReadOFF[47] rowReadON[47]
+ rowReadON[46] RefrBp PrBp PrSFBp col_periphery_1x2_0/COL_LINE0 pixRst[0] OffBn rowReadOFF[46]
+ pixRst[1] openDVS_pixel2x2_top_767/GndD DiffBn col_periphery_1x2_0/COL_LINE1 GndD
+ VddA18 OnBn openDVS_pixel2x2_top
XopenDVS_pixel2x2_top_747 openDVS_pixel2x2_top_747/vpd[0] openDVS_pixel2x2_top_747/vpd[1]
+ openDVS_pixel2x2_top_747/vpd[3] openDVS_pixel2x2_top_747/vpd[2] rowReadOFF[47] rowReadON[47]
+ rowReadON[46] RefrBp PrBp PrSFBp col_periphery_1x2_11/COL_LINE0 pixRst[22] OffBn
+ rowReadOFF[46] pixRst[23] openDVS_pixel2x2_top_767/GndD DiffBn col_periphery_1x2_11/COL_LINE1
+ GndD VddA18 OnBn openDVS_pixel2x2_top
XopenDVS_pixel2x2_top_714 openDVS_pixel2x2_top_714/vpd[0] openDVS_pixel2x2_top_714/vpd[1]
+ openDVS_pixel2x2_top_714/vpd[3] openDVS_pixel2x2_top_714/vpd[2] rowReadOFF[45] rowReadON[45]
+ rowReadON[44] RefrBp PrBp PrSFBp col_periphery_1x2_10/COL_LINE0 pixRst[20] OffBn
+ rowReadOFF[44] pixRst[21] openDVS_pixel2x2_top_735/GndD DiffBn col_periphery_1x2_10/COL_LINE1
+ GndD VddA18 OnBn openDVS_pixel2x2_top
XopenDVS_pixel2x2_top_758 openDVS_pixel2x2_top_758/vpd[0] openDVS_pixel2x2_top_758/vpd[1]
+ openDVS_pixel2x2_top_758/vpd[3] openDVS_pixel2x2_top_758/vpd[2] rowReadOFF[47] rowReadON[47]
+ rowReadON[46] RefrBp PrBp PrSFBp col_periphery_1x2_22/COL_LINE0 pixRst[44] OffBn
+ rowReadOFF[46] pixRst[45] openDVS_pixel2x2_top_767/GndD DiffBn col_periphery_1x2_22/COL_LINE1
+ GndD VddA18 OnBn openDVS_pixel2x2_top
XopenDVS_pixel2x2_top_725 openDVS_pixel2x2_top_725/vpd[0] openDVS_pixel2x2_top_725/vpd[1]
+ openDVS_pixel2x2_top_725/vpd[3] openDVS_pixel2x2_top_725/vpd[2] rowReadOFF[45] rowReadON[45]
+ rowReadON[44] RefrBp PrBp PrSFBp col_periphery_1x2_21/COL_LINE0 pixRst[42] OffBn
+ rowReadOFF[44] pixRst[43] openDVS_pixel2x2_top_735/GndD DiffBn col_periphery_1x2_21/COL_LINE1
+ GndD VddA18 OnBn openDVS_pixel2x2_top
XopenDVS_pixel2x2_top_703 openDVS_pixel2x2_top_703/vpd[0] openDVS_pixel2x2_top_703/vpd[1]
+ openDVS_pixel2x2_top_703/vpd[3] openDVS_pixel2x2_top_703/vpd[2] rowReadOFF[43] rowReadON[43]
+ rowReadON[42] RefrBp PrBp PrSFBp col_periphery_1x2_31/COL_LINE0 pixRst[62] OffBn
+ rowReadOFF[42] pixRst[63] openDVS_pixel2x2_top_703/GndD DiffBn col_periphery_1x2_31/COL_LINE1
+ GndD VddA18 OnBn openDVS_pixel2x2_top
XopenDVS_pixel2x2_top_511 openDVS_pixel2x2_top_511/vpd[0] openDVS_pixel2x2_top_511/vpd[1]
+ openDVS_pixel2x2_top_511/vpd[3] openDVS_pixel2x2_top_511/vpd[2] rowReadOFF[31] rowReadON[31]
+ rowReadON[30] RefrBp PrBp PrSFBp col_periphery_1x2_31/COL_LINE0 pixRst[62] OffBn
+ rowReadOFF[30] pixRst[63] openDVS_pixel2x2_top_511/GndD DiffBn col_periphery_1x2_31/COL_LINE1
+ GndD VddA18 OnBn openDVS_pixel2x2_top
XopenDVS_pixel2x2_top_500 openDVS_pixel2x2_top_500/vpd[0] openDVS_pixel2x2_top_500/vpd[1]
+ openDVS_pixel2x2_top_500/vpd[3] openDVS_pixel2x2_top_500/vpd[2] rowReadOFF[31] rowReadON[31]
+ rowReadON[30] RefrBp PrBp PrSFBp col_periphery_1x2_20/COL_LINE0 pixRst[40] OffBn
+ rowReadOFF[30] pixRst[41] openDVS_pixel2x2_top_511/GndD DiffBn col_periphery_1x2_20/COL_LINE1
+ GndD VddA18 OnBn openDVS_pixel2x2_top
XopenDVS_pixel2x2_top_599 openDVS_pixel2x2_top_599/vpd[0] openDVS_pixel2x2_top_599/vpd[1]
+ openDVS_pixel2x2_top_599/vpd[3] openDVS_pixel2x2_top_599/vpd[2] rowReadOFF[37] rowReadON[37]
+ rowReadON[36] RefrBp PrBp PrSFBp col_periphery_1x2_23/COL_LINE0 pixRst[46] OffBn
+ rowReadOFF[36] pixRst[47] openDVS_pixel2x2_top_607/GndD DiffBn col_periphery_1x2_23/COL_LINE1
+ GndD VddA18 OnBn openDVS_pixel2x2_top
XopenDVS_pixel2x2_top_533 openDVS_pixel2x2_top_533/vpd[0] openDVS_pixel2x2_top_533/vpd[1]
+ openDVS_pixel2x2_top_533/vpd[3] openDVS_pixel2x2_top_533/vpd[2] rowReadOFF[33] rowReadON[33]
+ rowReadON[32] RefrBp PrBp PrSFBp col_periphery_1x2_21/COL_LINE0 pixRst[42] OffBn
+ rowReadOFF[32] pixRst[43] openDVS_pixel2x2_top_543/GndD DiffBn col_periphery_1x2_21/COL_LINE1
+ GndD VddA18 OnBn openDVS_pixel2x2_top
XopenDVS_pixel2x2_top_566 openDVS_pixel2x2_top_566/vpd[0] openDVS_pixel2x2_top_566/vpd[1]
+ openDVS_pixel2x2_top_566/vpd[3] openDVS_pixel2x2_top_566/vpd[2] rowReadOFF[35] rowReadON[35]
+ rowReadON[34] RefrBp PrBp PrSFBp col_periphery_1x2_22/COL_LINE0 pixRst[44] OffBn
+ rowReadOFF[34] pixRst[45] openDVS_pixel2x2_top_575/GndD DiffBn col_periphery_1x2_22/COL_LINE1
+ GndD VddA18 OnBn openDVS_pixel2x2_top
XopenDVS_pixel2x2_top_588 openDVS_pixel2x2_top_588/vpd[0] openDVS_pixel2x2_top_588/vpd[1]
+ openDVS_pixel2x2_top_588/vpd[3] openDVS_pixel2x2_top_588/vpd[2] rowReadOFF[37] rowReadON[37]
+ rowReadON[36] RefrBp PrBp PrSFBp col_periphery_1x2_12/COL_LINE0 pixRst[24] OffBn
+ rowReadOFF[36] pixRst[25] openDVS_pixel2x2_top_607/GndD DiffBn col_periphery_1x2_12/COL_LINE1
+ GndD VddA18 OnBn openDVS_pixel2x2_top
XopenDVS_pixel2x2_top_522 openDVS_pixel2x2_top_522/vpd[0] openDVS_pixel2x2_top_522/vpd[1]
+ openDVS_pixel2x2_top_522/vpd[3] openDVS_pixel2x2_top_522/vpd[2] rowReadOFF[33] rowReadON[33]
+ rowReadON[32] RefrBp PrBp PrSFBp col_periphery_1x2_10/COL_LINE0 pixRst[20] OffBn
+ rowReadOFF[32] pixRst[21] openDVS_pixel2x2_top_543/GndD DiffBn col_periphery_1x2_10/COL_LINE1
+ GndD VddA18 OnBn openDVS_pixel2x2_top
XopenDVS_pixel2x2_top_555 openDVS_pixel2x2_top_555/vpd[0] openDVS_pixel2x2_top_555/vpd[1]
+ openDVS_pixel2x2_top_555/vpd[3] openDVS_pixel2x2_top_555/vpd[2] rowReadOFF[35] rowReadON[35]
+ rowReadON[34] RefrBp PrBp PrSFBp col_periphery_1x2_11/COL_LINE0 pixRst[22] OffBn
+ rowReadOFF[34] pixRst[23] openDVS_pixel2x2_top_575/GndD DiffBn col_periphery_1x2_11/COL_LINE1
+ GndD VddA18 OnBn openDVS_pixel2x2_top
XopenDVS_pixel2x2_top_577 openDVS_pixel2x2_top_577/vpd[0] openDVS_pixel2x2_top_577/vpd[1]
+ openDVS_pixel2x2_top_577/vpd[3] openDVS_pixel2x2_top_577/vpd[2] rowReadOFF[37] rowReadON[37]
+ rowReadON[36] RefrBp PrBp PrSFBp col_periphery_1x2_1/COL_LINE0 pixRst[2] OffBn rowReadOFF[36]
+ pixRst[3] openDVS_pixel2x2_top_607/GndD DiffBn col_periphery_1x2_1/COL_LINE1 GndD
+ VddA18 OnBn openDVS_pixel2x2_top
XopenDVS_pixel2x2_top_544 openDVS_pixel2x2_top_544/vpd[0] openDVS_pixel2x2_top_544/vpd[1]
+ openDVS_pixel2x2_top_544/vpd[3] openDVS_pixel2x2_top_544/vpd[2] rowReadOFF[35] rowReadON[35]
+ rowReadON[34] RefrBp PrBp PrSFBp col_periphery_1x2_0/COL_LINE0 pixRst[0] OffBn rowReadOFF[34]
+ pixRst[1] openDVS_pixel2x2_top_575/GndD DiffBn col_periphery_1x2_0/COL_LINE1 GndD
+ VddA18 OnBn openDVS_pixel2x2_top
XopenDVS_pixel2x2_top_341 openDVS_pixel2x2_top_341/vpd[0] openDVS_pixel2x2_top_341/vpd[1]
+ openDVS_pixel2x2_top_341/vpd[3] openDVS_pixel2x2_top_341/vpd[2] rowReadOFF[21] rowReadON[21]
+ rowReadON[20] RefrBp PrBp PrSFBp col_periphery_1x2_21/COL_LINE0 pixRst[42] OffBn
+ rowReadOFF[20] pixRst[43] openDVS_pixel2x2_top_351/GndD DiffBn col_periphery_1x2_21/COL_LINE1
+ GndD VddA18 OnBn openDVS_pixel2x2_top
XopenDVS_pixel2x2_top_330 openDVS_pixel2x2_top_330/vpd[0] openDVS_pixel2x2_top_330/vpd[1]
+ openDVS_pixel2x2_top_330/vpd[3] openDVS_pixel2x2_top_330/vpd[2] rowReadOFF[21] rowReadON[21]
+ rowReadON[20] RefrBp PrBp PrSFBp col_periphery_1x2_10/COL_LINE0 pixRst[20] OffBn
+ rowReadOFF[20] pixRst[21] openDVS_pixel2x2_top_351/GndD DiffBn col_periphery_1x2_10/COL_LINE1
+ GndD VddA18 OnBn openDVS_pixel2x2_top
XopenDVS_pixel2x2_top_374 openDVS_pixel2x2_top_374/vpd[0] openDVS_pixel2x2_top_374/vpd[1]
+ openDVS_pixel2x2_top_374/vpd[3] openDVS_pixel2x2_top_374/vpd[2] rowReadOFF[23] rowReadON[23]
+ rowReadON[22] RefrBp PrBp PrSFBp col_periphery_1x2_22/COL_LINE0 pixRst[44] OffBn
+ rowReadOFF[22] pixRst[45] openDVS_pixel2x2_top_383/GndD DiffBn col_periphery_1x2_22/COL_LINE1
+ GndD VddA18 OnBn openDVS_pixel2x2_top
XopenDVS_pixel2x2_top_396 openDVS_pixel2x2_top_396/vpd[0] openDVS_pixel2x2_top_396/vpd[1]
+ openDVS_pixel2x2_top_396/vpd[3] openDVS_pixel2x2_top_396/vpd[2] rowReadOFF[25] rowReadON[25]
+ rowReadON[24] RefrBp PrBp PrSFBp col_periphery_1x2_12/COL_LINE0 pixRst[24] OffBn
+ rowReadOFF[24] pixRst[25] openDVS_pixel2x2_top_415/GndD DiffBn col_periphery_1x2_12/COL_LINE1
+ GndD VddA18 OnBn openDVS_pixel2x2_top
XopenDVS_pixel2x2_top_363 openDVS_pixel2x2_top_363/vpd[0] openDVS_pixel2x2_top_363/vpd[1]
+ openDVS_pixel2x2_top_363/vpd[3] openDVS_pixel2x2_top_363/vpd[2] rowReadOFF[23] rowReadON[23]
+ rowReadON[22] RefrBp PrBp PrSFBp col_periphery_1x2_11/COL_LINE0 pixRst[22] OffBn
+ rowReadOFF[22] pixRst[23] openDVS_pixel2x2_top_383/GndD DiffBn col_periphery_1x2_11/COL_LINE1
+ GndD VddA18 OnBn openDVS_pixel2x2_top
XopenDVS_pixel2x2_top_352 openDVS_pixel2x2_top_352/vpd[0] openDVS_pixel2x2_top_352/vpd[1]
+ openDVS_pixel2x2_top_352/vpd[3] openDVS_pixel2x2_top_352/vpd[2] rowReadOFF[23] rowReadON[23]
+ rowReadON[22] RefrBp PrBp PrSFBp col_periphery_1x2_0/COL_LINE0 pixRst[0] OffBn rowReadOFF[22]
+ pixRst[1] openDVS_pixel2x2_top_383/GndD DiffBn col_periphery_1x2_0/COL_LINE1 GndD
+ VddA18 OnBn openDVS_pixel2x2_top
XopenDVS_pixel2x2_top_385 openDVS_pixel2x2_top_385/vpd[0] openDVS_pixel2x2_top_385/vpd[1]
+ openDVS_pixel2x2_top_385/vpd[3] openDVS_pixel2x2_top_385/vpd[2] rowReadOFF[25] rowReadON[25]
+ rowReadON[24] RefrBp PrBp PrSFBp col_periphery_1x2_1/COL_LINE0 pixRst[2] OffBn rowReadOFF[24]
+ pixRst[3] openDVS_pixel2x2_top_415/GndD DiffBn col_periphery_1x2_1/COL_LINE1 GndD
+ VddA18 OnBn openDVS_pixel2x2_top
XopenDVS_pixel2x2_top_171 openDVS_pixel2x2_top_171/vpd[0] openDVS_pixel2x2_top_171/vpd[1]
+ openDVS_pixel2x2_top_171/vpd[3] openDVS_pixel2x2_top_171/vpd[2] rowReadOFF[11] rowReadON[11]
+ rowReadON[10] RefrBp PrBp PrSFBp col_periphery_1x2_11/COL_LINE0 pixRst[22] OffBn
+ rowReadOFF[10] pixRst[23] openDVS_pixel2x2_top_191/GndD DiffBn col_periphery_1x2_11/COL_LINE1
+ GndD VddA18 OnBn openDVS_pixel2x2_top
XopenDVS_pixel2x2_top_160 openDVS_pixel2x2_top_160/vpd[0] openDVS_pixel2x2_top_160/vpd[1]
+ openDVS_pixel2x2_top_160/vpd[3] openDVS_pixel2x2_top_160/vpd[2] rowReadOFF[11] rowReadON[11]
+ rowReadON[10] RefrBp PrBp PrSFBp col_periphery_1x2_0/COL_LINE0 pixRst[0] OffBn rowReadOFF[10]
+ pixRst[1] openDVS_pixel2x2_top_191/GndD DiffBn col_periphery_1x2_0/COL_LINE1 GndD
+ VddA18 OnBn openDVS_pixel2x2_top
XopenDVS_pixel2x2_top_182 openDVS_pixel2x2_top_182/vpd[0] openDVS_pixel2x2_top_182/vpd[1]
+ openDVS_pixel2x2_top_182/vpd[3] openDVS_pixel2x2_top_182/vpd[2] rowReadOFF[11] rowReadON[11]
+ rowReadON[10] RefrBp PrBp PrSFBp col_periphery_1x2_22/COL_LINE0 pixRst[44] OffBn
+ rowReadOFF[10] pixRst[45] openDVS_pixel2x2_top_191/GndD DiffBn col_periphery_1x2_22/COL_LINE1
+ GndD VddA18 OnBn openDVS_pixel2x2_top
XopenDVS_pixel2x2_top_193 openDVS_pixel2x2_top_193/vpd[0] openDVS_pixel2x2_top_193/vpd[1]
+ openDVS_pixel2x2_top_193/vpd[3] openDVS_pixel2x2_top_193/vpd[2] rowReadOFF[13] rowReadON[13]
+ rowReadON[12] RefrBp PrBp PrSFBp col_periphery_1x2_1/COL_LINE0 pixRst[2] OffBn rowReadOFF[12]
+ pixRst[3] openDVS_pixel2x2_top_223/GndD DiffBn col_periphery_1x2_1/COL_LINE1 GndD
+ VddA18 OnBn openDVS_pixel2x2_top
XopenDVS_pixel2x2_top_22 openDVS_pixel2x2_top_22/vpd[0] openDVS_pixel2x2_top_22/vpd[1]
+ openDVS_pixel2x2_top_22/vpd[3] openDVS_pixel2x2_top_22/vpd[2] rowReadOFF[1] rowReadON[1]
+ rowReadON[0] RefrBp PrBp PrSFBp col_periphery_1x2_22/COL_LINE0 pixRst[44] OffBn
+ rowReadOFF[0] pixRst[45] openDVS_pixel2x2_top_9/GndD DiffBn col_periphery_1x2_22/COL_LINE1
+ GndD VddA18 OnBn openDVS_pixel2x2_top
XopenDVS_pixel2x2_top_11 openDVS_pixel2x2_top_11/vpd[0] openDVS_pixel2x2_top_11/vpd[1]
+ openDVS_pixel2x2_top_11/vpd[3] openDVS_pixel2x2_top_11/vpd[2] rowReadOFF[1] rowReadON[1]
+ rowReadON[0] RefrBp PrBp PrSFBp col_periphery_1x2_11/COL_LINE0 pixRst[22] OffBn
+ rowReadOFF[0] pixRst[23] openDVS_pixel2x2_top_9/GndD DiffBn col_periphery_1x2_11/COL_LINE1
+ GndD VddA18 OnBn openDVS_pixel2x2_top
Xcol_periphery_1x2_2 pixRst[5] col_periphery_1x2_2/COL_LINE0 col_periphery_1x2_2/COL_LINE1
+ nDETECT col_periphery_1x2_9/VDD DETECT VTHRESH voutn[4] GndD NCHARGE voutn[5] pixRst[4]
+ col_periphery_1x2
XopenDVS_pixel2x2_top_88 openDVS_pixel2x2_top_88/vpd[0] openDVS_pixel2x2_top_88/vpd[1]
+ openDVS_pixel2x2_top_88/vpd[3] openDVS_pixel2x2_top_88/vpd[2] rowReadOFF[5] rowReadON[5]
+ rowReadON[4] RefrBp PrBp PrSFBp col_periphery_1x2_24/COL_LINE0 pixRst[48] OffBn
+ rowReadOFF[4] pixRst[49] openDVS_pixel2x2_top_95/GndD DiffBn col_periphery_1x2_24/COL_LINE1
+ GndD VddA18 OnBn openDVS_pixel2x2_top
XopenDVS_pixel2x2_top_55 openDVS_pixel2x2_top_55/vpd[0] openDVS_pixel2x2_top_55/vpd[1]
+ openDVS_pixel2x2_top_55/vpd[3] openDVS_pixel2x2_top_55/vpd[2] rowReadOFF[3] rowReadON[3]
+ rowReadON[2] RefrBp PrBp PrSFBp col_periphery_1x2_23/COL_LINE0 pixRst[46] OffBn
+ rowReadOFF[2] pixRst[47] openDVS_pixel2x2_top_63/GndD DiffBn col_periphery_1x2_23/COL_LINE1
+ GndD VddA18 OnBn openDVS_pixel2x2_top
XopenDVS_pixel2x2_top_77 openDVS_pixel2x2_top_77/vpd[0] openDVS_pixel2x2_top_77/vpd[1]
+ openDVS_pixel2x2_top_77/vpd[3] openDVS_pixel2x2_top_77/vpd[2] rowReadOFF[5] rowReadON[5]
+ rowReadON[4] RefrBp PrBp PrSFBp col_periphery_1x2_13/COL_LINE0 pixRst[26] OffBn
+ rowReadOFF[4] pixRst[27] openDVS_pixel2x2_top_95/GndD DiffBn col_periphery_1x2_13/COL_LINE1
+ GndD VddA18 OnBn openDVS_pixel2x2_top
XopenDVS_pixel2x2_top_44 openDVS_pixel2x2_top_44/vpd[0] openDVS_pixel2x2_top_44/vpd[1]
+ openDVS_pixel2x2_top_44/vpd[3] openDVS_pixel2x2_top_44/vpd[2] rowReadOFF[3] rowReadON[3]
+ rowReadON[2] RefrBp PrBp PrSFBp col_periphery_1x2_12/COL_LINE0 pixRst[24] OffBn
+ rowReadOFF[2] pixRst[25] openDVS_pixel2x2_top_63/GndD DiffBn col_periphery_1x2_12/COL_LINE1
+ GndD VddA18 OnBn openDVS_pixel2x2_top
XopenDVS_pixel2x2_top_99 openDVS_pixel2x2_top_99/vpd[0] openDVS_pixel2x2_top_99/vpd[1]
+ openDVS_pixel2x2_top_99/vpd[3] openDVS_pixel2x2_top_99/vpd[2] rowReadOFF[7] rowReadON[7]
+ rowReadON[6] RefrBp PrBp PrSFBp col_periphery_1x2_3/COL_LINE0 pixRst[6] OffBn rowReadOFF[6]
+ pixRst[7] openDVS_pixel2x2_top_99/GndD DiffBn col_periphery_1x2_3/COL_LINE1 GndD
+ VddA18 OnBn openDVS_pixel2x2_top
XopenDVS_pixel2x2_top_66 openDVS_pixel2x2_top_66/vpd[0] openDVS_pixel2x2_top_66/vpd[1]
+ openDVS_pixel2x2_top_66/vpd[3] openDVS_pixel2x2_top_66/vpd[2] rowReadOFF[5] rowReadON[5]
+ rowReadON[4] RefrBp PrBp PrSFBp col_periphery_1x2_2/COL_LINE0 pixRst[4] OffBn rowReadOFF[4]
+ pixRst[5] openDVS_pixel2x2_top_95/GndD DiffBn col_periphery_1x2_2/COL_LINE1 GndD
+ VddA18 OnBn openDVS_pixel2x2_top
XopenDVS_pixel2x2_top_33 openDVS_pixel2x2_top_33/vpd[0] openDVS_pixel2x2_top_33/vpd[1]
+ openDVS_pixel2x2_top_33/vpd[3] openDVS_pixel2x2_top_33/vpd[2] rowReadOFF[3] rowReadON[3]
+ rowReadON[2] RefrBp PrBp PrSFBp col_periphery_1x2_1/COL_LINE0 pixRst[2] OffBn rowReadOFF[2]
+ pixRst[3] openDVS_pixel2x2_top_63/GndD DiffBn col_periphery_1x2_1/COL_LINE1 GndD
+ VddA18 OnBn openDVS_pixel2x2_top
XopenDVS_pixel2x2_top_907 openDVS_pixel2x2_top_907/vpd[0] openDVS_pixel2x2_top_907/vpd[1]
+ openDVS_pixel2x2_top_907/vpd[3] openDVS_pixel2x2_top_907/vpd[2] rowReadOFF[57] rowReadON[57]
+ rowReadON[56] RefrBp PrBp PrSFBp col_periphery_1x2_11/COL_LINE0 pixRst[22] OffBn
+ rowReadOFF[56] pixRst[23] openDVS_pixel2x2_top_927/GndD DiffBn col_periphery_1x2_11/COL_LINE1
+ GndD VddA18 OnBn openDVS_pixel2x2_top
XopenDVS_pixel2x2_top_929 openDVS_pixel2x2_top_929/vpd[0] openDVS_pixel2x2_top_929/vpd[1]
+ openDVS_pixel2x2_top_929/vpd[3] openDVS_pixel2x2_top_929/vpd[2] rowReadOFF[59] rowReadON[59]
+ rowReadON[58] RefrBp PrBp PrSFBp col_periphery_1x2_1/COL_LINE0 pixRst[2] OffBn rowReadOFF[58]
+ pixRst[3] openDVS_pixel2x2_top_959/GndD DiffBn col_periphery_1x2_1/COL_LINE1 GndD
+ VddA18 OnBn openDVS_pixel2x2_top
XopenDVS_pixel2x2_top_918 openDVS_pixel2x2_top_918/vpd[0] openDVS_pixel2x2_top_918/vpd[1]
+ openDVS_pixel2x2_top_918/vpd[3] openDVS_pixel2x2_top_918/vpd[2] rowReadOFF[57] rowReadON[57]
+ rowReadON[56] RefrBp PrBp PrSFBp col_periphery_1x2_22/COL_LINE0 pixRst[44] OffBn
+ rowReadOFF[56] pixRst[45] openDVS_pixel2x2_top_927/GndD DiffBn col_periphery_1x2_22/COL_LINE1
+ GndD VddA18 OnBn openDVS_pixel2x2_top
XopenDVS_pixel2x2_top_737 openDVS_pixel2x2_top_737/vpd[0] openDVS_pixel2x2_top_737/vpd[1]
+ openDVS_pixel2x2_top_737/vpd[3] openDVS_pixel2x2_top_737/vpd[2] rowReadOFF[47] rowReadON[47]
+ rowReadON[46] RefrBp PrBp PrSFBp col_periphery_1x2_1/COL_LINE0 pixRst[2] OffBn rowReadOFF[46]
+ pixRst[3] openDVS_pixel2x2_top_767/GndD DiffBn col_periphery_1x2_1/COL_LINE1 GndD
+ VddA18 OnBn openDVS_pixel2x2_top
XopenDVS_pixel2x2_top_704 openDVS_pixel2x2_top_704/vpd[0] openDVS_pixel2x2_top_704/vpd[1]
+ openDVS_pixel2x2_top_704/vpd[3] openDVS_pixel2x2_top_704/vpd[2] rowReadOFF[45] rowReadON[45]
+ rowReadON[44] RefrBp PrBp PrSFBp col_periphery_1x2_0/COL_LINE0 pixRst[0] OffBn rowReadOFF[44]
+ pixRst[1] openDVS_pixel2x2_top_735/GndD DiffBn col_periphery_1x2_0/COL_LINE1 GndD
+ VddA18 OnBn openDVS_pixel2x2_top
XopenDVS_pixel2x2_top_715 openDVS_pixel2x2_top_715/vpd[0] openDVS_pixel2x2_top_715/vpd[1]
+ openDVS_pixel2x2_top_715/vpd[3] openDVS_pixel2x2_top_715/vpd[2] rowReadOFF[45] rowReadON[45]
+ rowReadON[44] RefrBp PrBp PrSFBp col_periphery_1x2_11/COL_LINE0 pixRst[22] OffBn
+ rowReadOFF[44] pixRst[23] openDVS_pixel2x2_top_735/GndD DiffBn col_periphery_1x2_11/COL_LINE1
+ GndD VddA18 OnBn openDVS_pixel2x2_top
XopenDVS_pixel2x2_top_748 openDVS_pixel2x2_top_748/vpd[0] openDVS_pixel2x2_top_748/vpd[1]
+ openDVS_pixel2x2_top_748/vpd[3] openDVS_pixel2x2_top_748/vpd[2] rowReadOFF[47] rowReadON[47]
+ rowReadON[46] RefrBp PrBp PrSFBp col_periphery_1x2_12/COL_LINE0 pixRst[24] OffBn
+ rowReadOFF[46] pixRst[25] openDVS_pixel2x2_top_767/GndD DiffBn col_periphery_1x2_12/COL_LINE1
+ GndD VddA18 OnBn openDVS_pixel2x2_top
XopenDVS_pixel2x2_top_726 openDVS_pixel2x2_top_726/vpd[0] openDVS_pixel2x2_top_726/vpd[1]
+ openDVS_pixel2x2_top_726/vpd[3] openDVS_pixel2x2_top_726/vpd[2] rowReadOFF[45] rowReadON[45]
+ rowReadON[44] RefrBp PrBp PrSFBp col_periphery_1x2_22/COL_LINE0 pixRst[44] OffBn
+ rowReadOFF[44] pixRst[45] openDVS_pixel2x2_top_735/GndD DiffBn col_periphery_1x2_22/COL_LINE1
+ GndD VddA18 OnBn openDVS_pixel2x2_top
XopenDVS_pixel2x2_top_759 openDVS_pixel2x2_top_759/vpd[0] openDVS_pixel2x2_top_759/vpd[1]
+ openDVS_pixel2x2_top_759/vpd[3] openDVS_pixel2x2_top_759/vpd[2] rowReadOFF[47] rowReadON[47]
+ rowReadON[46] RefrBp PrBp PrSFBp col_periphery_1x2_23/COL_LINE0 pixRst[46] OffBn
+ rowReadOFF[46] pixRst[47] openDVS_pixel2x2_top_767/GndD DiffBn col_periphery_1x2_23/COL_LINE1
+ GndD VddA18 OnBn openDVS_pixel2x2_top
XopenDVS_pixel2x2_top_501 openDVS_pixel2x2_top_501/vpd[0] openDVS_pixel2x2_top_501/vpd[1]
+ openDVS_pixel2x2_top_501/vpd[3] openDVS_pixel2x2_top_501/vpd[2] rowReadOFF[31] rowReadON[31]
+ rowReadON[30] RefrBp PrBp PrSFBp col_periphery_1x2_21/COL_LINE0 pixRst[42] OffBn
+ rowReadOFF[30] pixRst[43] openDVS_pixel2x2_top_511/GndD DiffBn col_periphery_1x2_21/COL_LINE1
+ GndD VddA18 OnBn openDVS_pixel2x2_top
XopenDVS_pixel2x2_top_567 openDVS_pixel2x2_top_567/vpd[0] openDVS_pixel2x2_top_567/vpd[1]
+ openDVS_pixel2x2_top_567/vpd[3] openDVS_pixel2x2_top_567/vpd[2] rowReadOFF[35] rowReadON[35]
+ rowReadON[34] RefrBp PrBp PrSFBp col_periphery_1x2_23/COL_LINE0 pixRst[46] OffBn
+ rowReadOFF[34] pixRst[47] openDVS_pixel2x2_top_575/GndD DiffBn col_periphery_1x2_23/COL_LINE1
+ GndD VddA18 OnBn openDVS_pixel2x2_top
XopenDVS_pixel2x2_top_534 openDVS_pixel2x2_top_534/vpd[0] openDVS_pixel2x2_top_534/vpd[1]
+ openDVS_pixel2x2_top_534/vpd[3] openDVS_pixel2x2_top_534/vpd[2] rowReadOFF[33] rowReadON[33]
+ rowReadON[32] RefrBp PrBp PrSFBp col_periphery_1x2_22/COL_LINE0 pixRst[44] OffBn
+ rowReadOFF[32] pixRst[45] openDVS_pixel2x2_top_543/GndD DiffBn col_periphery_1x2_22/COL_LINE1
+ GndD VddA18 OnBn openDVS_pixel2x2_top
XopenDVS_pixel2x2_top_589 openDVS_pixel2x2_top_589/vpd[0] openDVS_pixel2x2_top_589/vpd[1]
+ openDVS_pixel2x2_top_589/vpd[3] openDVS_pixel2x2_top_589/vpd[2] rowReadOFF[37] rowReadON[37]
+ rowReadON[36] RefrBp PrBp PrSFBp col_periphery_1x2_13/COL_LINE0 pixRst[26] OffBn
+ rowReadOFF[36] pixRst[27] openDVS_pixel2x2_top_607/GndD DiffBn col_periphery_1x2_13/COL_LINE1
+ GndD VddA18 OnBn openDVS_pixel2x2_top
XopenDVS_pixel2x2_top_556 openDVS_pixel2x2_top_556/vpd[0] openDVS_pixel2x2_top_556/vpd[1]
+ openDVS_pixel2x2_top_556/vpd[3] openDVS_pixel2x2_top_556/vpd[2] rowReadOFF[35] rowReadON[35]
+ rowReadON[34] RefrBp PrBp PrSFBp col_periphery_1x2_12/COL_LINE0 pixRst[24] OffBn
+ rowReadOFF[34] pixRst[25] openDVS_pixel2x2_top_575/GndD DiffBn col_periphery_1x2_12/COL_LINE1
+ GndD VddA18 OnBn openDVS_pixel2x2_top
XopenDVS_pixel2x2_top_523 openDVS_pixel2x2_top_523/vpd[0] openDVS_pixel2x2_top_523/vpd[1]
+ openDVS_pixel2x2_top_523/vpd[3] openDVS_pixel2x2_top_523/vpd[2] rowReadOFF[33] rowReadON[33]
+ rowReadON[32] RefrBp PrBp PrSFBp col_periphery_1x2_11/COL_LINE0 pixRst[22] OffBn
+ rowReadOFF[32] pixRst[23] openDVS_pixel2x2_top_543/GndD DiffBn col_periphery_1x2_11/COL_LINE1
+ GndD VddA18 OnBn openDVS_pixel2x2_top
XopenDVS_pixel2x2_top_545 openDVS_pixel2x2_top_545/vpd[0] openDVS_pixel2x2_top_545/vpd[1]
+ openDVS_pixel2x2_top_545/vpd[3] openDVS_pixel2x2_top_545/vpd[2] rowReadOFF[35] rowReadON[35]
+ rowReadON[34] RefrBp PrBp PrSFBp col_periphery_1x2_1/COL_LINE0 pixRst[2] OffBn rowReadOFF[34]
+ pixRst[3] openDVS_pixel2x2_top_575/GndD DiffBn col_periphery_1x2_1/COL_LINE1 GndD
+ VddA18 OnBn openDVS_pixel2x2_top
XopenDVS_pixel2x2_top_512 openDVS_pixel2x2_top_512/vpd[0] openDVS_pixel2x2_top_512/vpd[1]
+ openDVS_pixel2x2_top_512/vpd[3] openDVS_pixel2x2_top_512/vpd[2] rowReadOFF[33] rowReadON[33]
+ rowReadON[32] RefrBp PrBp PrSFBp col_periphery_1x2_0/COL_LINE0 pixRst[0] OffBn rowReadOFF[32]
+ pixRst[1] openDVS_pixel2x2_top_543/GndD DiffBn col_periphery_1x2_0/COL_LINE1 GndD
+ VddA18 OnBn openDVS_pixel2x2_top
XopenDVS_pixel2x2_top_578 openDVS_pixel2x2_top_578/vpd[0] openDVS_pixel2x2_top_578/vpd[1]
+ openDVS_pixel2x2_top_578/vpd[3] openDVS_pixel2x2_top_578/vpd[2] rowReadOFF[37] rowReadON[37]
+ rowReadON[36] RefrBp PrBp PrSFBp col_periphery_1x2_2/COL_LINE0 pixRst[4] OffBn rowReadOFF[36]
+ pixRst[5] openDVS_pixel2x2_top_607/GndD DiffBn col_periphery_1x2_2/COL_LINE1 GndD
+ VddA18 OnBn openDVS_pixel2x2_top
XopenDVS_pixel2x2_top_342 openDVS_pixel2x2_top_342/vpd[0] openDVS_pixel2x2_top_342/vpd[1]
+ openDVS_pixel2x2_top_342/vpd[3] openDVS_pixel2x2_top_342/vpd[2] rowReadOFF[21] rowReadON[21]
+ rowReadON[20] RefrBp PrBp PrSFBp col_periphery_1x2_22/COL_LINE0 pixRst[44] OffBn
+ rowReadOFF[20] pixRst[45] openDVS_pixel2x2_top_351/GndD DiffBn col_periphery_1x2_22/COL_LINE1
+ GndD VddA18 OnBn openDVS_pixel2x2_top
XopenDVS_pixel2x2_top_331 openDVS_pixel2x2_top_331/vpd[0] openDVS_pixel2x2_top_331/vpd[1]
+ openDVS_pixel2x2_top_331/vpd[3] openDVS_pixel2x2_top_331/vpd[2] rowReadOFF[21] rowReadON[21]
+ rowReadON[20] RefrBp PrBp PrSFBp col_periphery_1x2_11/COL_LINE0 pixRst[22] OffBn
+ rowReadOFF[20] pixRst[23] openDVS_pixel2x2_top_351/GndD DiffBn col_periphery_1x2_11/COL_LINE1
+ GndD VddA18 OnBn openDVS_pixel2x2_top
XopenDVS_pixel2x2_top_320 openDVS_pixel2x2_top_320/vpd[0] openDVS_pixel2x2_top_320/vpd[1]
+ openDVS_pixel2x2_top_320/vpd[3] openDVS_pixel2x2_top_320/vpd[2] rowReadOFF[21] rowReadON[21]
+ rowReadON[20] RefrBp PrBp PrSFBp col_periphery_1x2_0/COL_LINE0 pixRst[0] OffBn rowReadOFF[20]
+ pixRst[1] openDVS_pixel2x2_top_351/GndD DiffBn col_periphery_1x2_0/COL_LINE1 GndD
+ VddA18 OnBn openDVS_pixel2x2_top
XopenDVS_pixel2x2_top_375 openDVS_pixel2x2_top_375/vpd[0] openDVS_pixel2x2_top_375/vpd[1]
+ openDVS_pixel2x2_top_375/vpd[3] openDVS_pixel2x2_top_375/vpd[2] rowReadOFF[23] rowReadON[23]
+ rowReadON[22] RefrBp PrBp PrSFBp col_periphery_1x2_23/COL_LINE0 pixRst[46] OffBn
+ rowReadOFF[22] pixRst[47] openDVS_pixel2x2_top_383/GndD DiffBn col_periphery_1x2_23/COL_LINE1
+ GndD VddA18 OnBn openDVS_pixel2x2_top
XopenDVS_pixel2x2_top_397 openDVS_pixel2x2_top_397/vpd[0] openDVS_pixel2x2_top_397/vpd[1]
+ openDVS_pixel2x2_top_397/vpd[3] openDVS_pixel2x2_top_397/vpd[2] rowReadOFF[25] rowReadON[25]
+ rowReadON[24] RefrBp PrBp PrSFBp col_periphery_1x2_13/COL_LINE0 pixRst[26] OffBn
+ rowReadOFF[24] pixRst[27] openDVS_pixel2x2_top_415/GndD DiffBn col_periphery_1x2_13/COL_LINE1
+ GndD VddA18 OnBn openDVS_pixel2x2_top
XopenDVS_pixel2x2_top_364 openDVS_pixel2x2_top_364/vpd[0] openDVS_pixel2x2_top_364/vpd[1]
+ openDVS_pixel2x2_top_364/vpd[3] openDVS_pixel2x2_top_364/vpd[2] rowReadOFF[23] rowReadON[23]
+ rowReadON[22] RefrBp PrBp PrSFBp col_periphery_1x2_12/COL_LINE0 pixRst[24] OffBn
+ rowReadOFF[22] pixRst[25] openDVS_pixel2x2_top_383/GndD DiffBn col_periphery_1x2_12/COL_LINE1
+ GndD VddA18 OnBn openDVS_pixel2x2_top
XopenDVS_pixel2x2_top_386 openDVS_pixel2x2_top_386/vpd[0] openDVS_pixel2x2_top_386/vpd[1]
+ openDVS_pixel2x2_top_386/vpd[3] openDVS_pixel2x2_top_386/vpd[2] rowReadOFF[25] rowReadON[25]
+ rowReadON[24] RefrBp PrBp PrSFBp col_periphery_1x2_2/COL_LINE0 pixRst[4] OffBn rowReadOFF[24]
+ pixRst[5] openDVS_pixel2x2_top_415/GndD DiffBn col_periphery_1x2_2/COL_LINE1 GndD
+ VddA18 OnBn openDVS_pixel2x2_top
XopenDVS_pixel2x2_top_353 openDVS_pixel2x2_top_353/vpd[0] openDVS_pixel2x2_top_353/vpd[1]
+ openDVS_pixel2x2_top_353/vpd[3] openDVS_pixel2x2_top_353/vpd[2] rowReadOFF[23] rowReadON[23]
+ rowReadON[22] RefrBp PrBp PrSFBp col_periphery_1x2_1/COL_LINE0 pixRst[2] OffBn rowReadOFF[22]
+ pixRst[3] openDVS_pixel2x2_top_383/GndD DiffBn col_periphery_1x2_1/COL_LINE1 GndD
+ VddA18 OnBn openDVS_pixel2x2_top
XopenDVS_pixel2x2_top_183 openDVS_pixel2x2_top_183/vpd[0] openDVS_pixel2x2_top_183/vpd[1]
+ openDVS_pixel2x2_top_183/vpd[3] openDVS_pixel2x2_top_183/vpd[2] rowReadOFF[11] rowReadON[11]
+ rowReadON[10] RefrBp PrBp PrSFBp col_periphery_1x2_23/COL_LINE0 pixRst[46] OffBn
+ rowReadOFF[10] pixRst[47] openDVS_pixel2x2_top_191/GndD DiffBn col_periphery_1x2_23/COL_LINE1
+ GndD VddA18 OnBn openDVS_pixel2x2_top
XopenDVS_pixel2x2_top_150 openDVS_pixel2x2_top_150/vpd[0] openDVS_pixel2x2_top_150/vpd[1]
+ openDVS_pixel2x2_top_150/vpd[3] openDVS_pixel2x2_top_150/vpd[2] rowReadOFF[9] rowReadON[9]
+ rowReadON[8] RefrBp PrBp PrSFBp col_periphery_1x2_22/COL_LINE0 pixRst[44] OffBn
+ rowReadOFF[8] pixRst[45] openDVS_pixel2x2_top_159/GndD DiffBn col_periphery_1x2_22/COL_LINE1
+ GndD VddA18 OnBn openDVS_pixel2x2_top
XopenDVS_pixel2x2_top_172 openDVS_pixel2x2_top_172/vpd[0] openDVS_pixel2x2_top_172/vpd[1]
+ openDVS_pixel2x2_top_172/vpd[3] openDVS_pixel2x2_top_172/vpd[2] rowReadOFF[11] rowReadON[11]
+ rowReadON[10] RefrBp PrBp PrSFBp col_periphery_1x2_12/COL_LINE0 pixRst[24] OffBn
+ rowReadOFF[10] pixRst[25] openDVS_pixel2x2_top_191/GndD DiffBn col_periphery_1x2_12/COL_LINE1
+ GndD VddA18 OnBn openDVS_pixel2x2_top
XopenDVS_pixel2x2_top_161 openDVS_pixel2x2_top_161/vpd[0] openDVS_pixel2x2_top_161/vpd[1]
+ openDVS_pixel2x2_top_161/vpd[3] openDVS_pixel2x2_top_161/vpd[2] rowReadOFF[11] rowReadON[11]
+ rowReadON[10] RefrBp PrBp PrSFBp col_periphery_1x2_1/COL_LINE0 pixRst[2] OffBn rowReadOFF[10]
+ pixRst[3] openDVS_pixel2x2_top_191/GndD DiffBn col_periphery_1x2_1/COL_LINE1 GndD
+ VddA18 OnBn openDVS_pixel2x2_top
XopenDVS_pixel2x2_top_194 openDVS_pixel2x2_top_194/vpd[0] openDVS_pixel2x2_top_194/vpd[1]
+ openDVS_pixel2x2_top_194/vpd[3] openDVS_pixel2x2_top_194/vpd[2] rowReadOFF[13] rowReadON[13]
+ rowReadON[12] RefrBp PrBp PrSFBp col_periphery_1x2_2/COL_LINE0 pixRst[4] OffBn rowReadOFF[12]
+ pixRst[5] openDVS_pixel2x2_top_223/GndD DiffBn col_periphery_1x2_2/COL_LINE1 GndD
+ VddA18 OnBn openDVS_pixel2x2_top
XopenDVS_pixel2x2_top_23 openDVS_pixel2x2_top_23/vpd[0] openDVS_pixel2x2_top_23/vpd[1]
+ openDVS_pixel2x2_top_23/vpd[3] openDVS_pixel2x2_top_23/vpd[2] rowReadOFF[1] rowReadON[1]
+ rowReadON[0] RefrBp PrBp PrSFBp col_periphery_1x2_23/COL_LINE0 pixRst[46] OffBn
+ rowReadOFF[0] pixRst[47] openDVS_pixel2x2_top_9/GndD DiffBn col_periphery_1x2_23/COL_LINE1
+ GndD VddA18 OnBn openDVS_pixel2x2_top
XopenDVS_pixel2x2_top_12 openDVS_pixel2x2_top_12/vpd[0] openDVS_pixel2x2_top_12/vpd[1]
+ openDVS_pixel2x2_top_12/vpd[3] openDVS_pixel2x2_top_12/vpd[2] rowReadOFF[1] rowReadON[1]
+ rowReadON[0] RefrBp PrBp PrSFBp col_periphery_1x2_12/COL_LINE0 pixRst[24] OffBn
+ rowReadOFF[0] pixRst[25] openDVS_pixel2x2_top_9/GndD DiffBn col_periphery_1x2_12/COL_LINE1
+ GndD VddA18 OnBn openDVS_pixel2x2_top
Xcol_periphery_1x2_3 pixRst[7] col_periphery_1x2_3/COL_LINE0 col_periphery_1x2_3/COL_LINE1
+ nDETECT col_periphery_1x2_9/VDD DETECT VTHRESH voutn[6] GndD NCHARGE voutn[7] pixRst[6]
+ col_periphery_1x2
XopenDVS_pixel2x2_top_89 openDVS_pixel2x2_top_89/vpd[0] openDVS_pixel2x2_top_89/vpd[1]
+ openDVS_pixel2x2_top_89/vpd[3] openDVS_pixel2x2_top_89/vpd[2] rowReadOFF[5] rowReadON[5]
+ rowReadON[4] RefrBp PrBp PrSFBp col_periphery_1x2_25/COL_LINE0 pixRst[50] OffBn
+ rowReadOFF[4] pixRst[51] openDVS_pixel2x2_top_95/GndD DiffBn col_periphery_1x2_25/COL_LINE1
+ GndD VddA18 OnBn openDVS_pixel2x2_top
XopenDVS_pixel2x2_top_56 openDVS_pixel2x2_top_56/vpd[0] openDVS_pixel2x2_top_56/vpd[1]
+ openDVS_pixel2x2_top_56/vpd[3] openDVS_pixel2x2_top_56/vpd[2] rowReadOFF[3] rowReadON[3]
+ rowReadON[2] RefrBp PrBp PrSFBp col_periphery_1x2_24/COL_LINE0 pixRst[48] OffBn
+ rowReadOFF[2] pixRst[49] openDVS_pixel2x2_top_63/GndD DiffBn col_periphery_1x2_24/COL_LINE1
+ GndD VddA18 OnBn openDVS_pixel2x2_top
XopenDVS_pixel2x2_top_78 openDVS_pixel2x2_top_78/vpd[0] openDVS_pixel2x2_top_78/vpd[1]
+ openDVS_pixel2x2_top_78/vpd[3] openDVS_pixel2x2_top_78/vpd[2] rowReadOFF[5] rowReadON[5]
+ rowReadON[4] RefrBp PrBp PrSFBp col_periphery_1x2_14/COL_LINE0 pixRst[28] OffBn
+ rowReadOFF[4] pixRst[29] openDVS_pixel2x2_top_95/GndD DiffBn col_periphery_1x2_14/COL_LINE1
+ GndD VddA18 OnBn openDVS_pixel2x2_top
XopenDVS_pixel2x2_top_45 openDVS_pixel2x2_top_45/vpd[0] openDVS_pixel2x2_top_45/vpd[1]
+ openDVS_pixel2x2_top_45/vpd[3] openDVS_pixel2x2_top_45/vpd[2] rowReadOFF[3] rowReadON[3]
+ rowReadON[2] RefrBp PrBp PrSFBp col_periphery_1x2_13/COL_LINE0 pixRst[26] OffBn
+ rowReadOFF[2] pixRst[27] openDVS_pixel2x2_top_63/GndD DiffBn col_periphery_1x2_13/COL_LINE1
+ GndD VddA18 OnBn openDVS_pixel2x2_top
XopenDVS_pixel2x2_top_67 openDVS_pixel2x2_top_67/vpd[0] openDVS_pixel2x2_top_67/vpd[1]
+ openDVS_pixel2x2_top_67/vpd[3] openDVS_pixel2x2_top_67/vpd[2] rowReadOFF[5] rowReadON[5]
+ rowReadON[4] RefrBp PrBp PrSFBp col_periphery_1x2_3/COL_LINE0 pixRst[6] OffBn rowReadOFF[4]
+ pixRst[7] openDVS_pixel2x2_top_95/GndD DiffBn col_periphery_1x2_3/COL_LINE1 GndD
+ VddA18 OnBn openDVS_pixel2x2_top
XopenDVS_pixel2x2_top_34 openDVS_pixel2x2_top_34/vpd[0] openDVS_pixel2x2_top_34/vpd[1]
+ openDVS_pixel2x2_top_34/vpd[3] openDVS_pixel2x2_top_34/vpd[2] rowReadOFF[3] rowReadON[3]
+ rowReadON[2] RefrBp PrBp PrSFBp col_periphery_1x2_2/COL_LINE0 pixRst[4] OffBn rowReadOFF[2]
+ pixRst[5] openDVS_pixel2x2_top_63/GndD DiffBn col_periphery_1x2_2/COL_LINE1 GndD
+ VddA18 OnBn openDVS_pixel2x2_top
XopenDVS_pixel2x2_top_908 openDVS_pixel2x2_top_908/vpd[0] openDVS_pixel2x2_top_908/vpd[1]
+ openDVS_pixel2x2_top_908/vpd[3] openDVS_pixel2x2_top_908/vpd[2] rowReadOFF[57] rowReadON[57]
+ rowReadON[56] RefrBp PrBp PrSFBp col_periphery_1x2_12/COL_LINE0 pixRst[24] OffBn
+ rowReadOFF[56] pixRst[25] openDVS_pixel2x2_top_927/GndD DiffBn col_periphery_1x2_12/COL_LINE1
+ GndD VddA18 OnBn openDVS_pixel2x2_top
XopenDVS_pixel2x2_top_919 openDVS_pixel2x2_top_919/vpd[0] openDVS_pixel2x2_top_919/vpd[1]
+ openDVS_pixel2x2_top_919/vpd[3] openDVS_pixel2x2_top_919/vpd[2] rowReadOFF[57] rowReadON[57]
+ rowReadON[56] RefrBp PrBp PrSFBp col_periphery_1x2_23/COL_LINE0 pixRst[46] OffBn
+ rowReadOFF[56] pixRst[47] openDVS_pixel2x2_top_927/GndD DiffBn col_periphery_1x2_23/COL_LINE1
+ GndD VddA18 OnBn openDVS_pixel2x2_top
XopenDVS_pixel2x2_top_705 openDVS_pixel2x2_top_705/vpd[0] openDVS_pixel2x2_top_705/vpd[1]
+ openDVS_pixel2x2_top_705/vpd[3] openDVS_pixel2x2_top_705/vpd[2] rowReadOFF[45] rowReadON[45]
+ rowReadON[44] RefrBp PrBp PrSFBp col_periphery_1x2_1/COL_LINE0 pixRst[2] OffBn rowReadOFF[44]
+ pixRst[3] openDVS_pixel2x2_top_735/GndD DiffBn col_periphery_1x2_1/COL_LINE1 GndD
+ VddA18 OnBn openDVS_pixel2x2_top
XopenDVS_pixel2x2_top_738 openDVS_pixel2x2_top_738/vpd[0] openDVS_pixel2x2_top_738/vpd[1]
+ openDVS_pixel2x2_top_738/vpd[3] openDVS_pixel2x2_top_738/vpd[2] rowReadOFF[47] rowReadON[47]
+ rowReadON[46] RefrBp PrBp PrSFBp col_periphery_1x2_2/COL_LINE0 pixRst[4] OffBn rowReadOFF[46]
+ pixRst[5] openDVS_pixel2x2_top_767/GndD DiffBn col_periphery_1x2_2/COL_LINE1 GndD
+ VddA18 OnBn openDVS_pixel2x2_top
XopenDVS_pixel2x2_top_716 openDVS_pixel2x2_top_716/vpd[0] openDVS_pixel2x2_top_716/vpd[1]
+ openDVS_pixel2x2_top_716/vpd[3] openDVS_pixel2x2_top_716/vpd[2] rowReadOFF[45] rowReadON[45]
+ rowReadON[44] RefrBp PrBp PrSFBp col_periphery_1x2_12/COL_LINE0 pixRst[24] OffBn
+ rowReadOFF[44] pixRst[25] openDVS_pixel2x2_top_735/GndD DiffBn col_periphery_1x2_12/COL_LINE1
+ GndD VddA18 OnBn openDVS_pixel2x2_top
XopenDVS_pixel2x2_top_749 openDVS_pixel2x2_top_749/vpd[0] openDVS_pixel2x2_top_749/vpd[1]
+ openDVS_pixel2x2_top_749/vpd[3] openDVS_pixel2x2_top_749/vpd[2] rowReadOFF[47] rowReadON[47]
+ rowReadON[46] RefrBp PrBp PrSFBp col_periphery_1x2_13/COL_LINE0 pixRst[26] OffBn
+ rowReadOFF[46] pixRst[27] openDVS_pixel2x2_top_767/GndD DiffBn col_periphery_1x2_13/COL_LINE1
+ GndD VddA18 OnBn openDVS_pixel2x2_top
XopenDVS_pixel2x2_top_727 openDVS_pixel2x2_top_727/vpd[0] openDVS_pixel2x2_top_727/vpd[1]
+ openDVS_pixel2x2_top_727/vpd[3] openDVS_pixel2x2_top_727/vpd[2] rowReadOFF[45] rowReadON[45]
+ rowReadON[44] RefrBp PrBp PrSFBp col_periphery_1x2_23/COL_LINE0 pixRst[46] OffBn
+ rowReadOFF[44] pixRst[47] openDVS_pixel2x2_top_735/GndD DiffBn col_periphery_1x2_23/COL_LINE1
+ GndD VddA18 OnBn openDVS_pixel2x2_top
XopenDVS_pixel2x2_top_502 openDVS_pixel2x2_top_502/vpd[0] openDVS_pixel2x2_top_502/vpd[1]
+ openDVS_pixel2x2_top_502/vpd[3] openDVS_pixel2x2_top_502/vpd[2] rowReadOFF[31] rowReadON[31]
+ rowReadON[30] RefrBp PrBp PrSFBp col_periphery_1x2_22/COL_LINE0 pixRst[44] OffBn
+ rowReadOFF[30] pixRst[45] openDVS_pixel2x2_top_511/GndD DiffBn col_periphery_1x2_22/COL_LINE1
+ GndD VddA18 OnBn openDVS_pixel2x2_top
XopenDVS_pixel2x2_top_535 openDVS_pixel2x2_top_535/vpd[0] openDVS_pixel2x2_top_535/vpd[1]
+ openDVS_pixel2x2_top_535/vpd[3] openDVS_pixel2x2_top_535/vpd[2] rowReadOFF[33] rowReadON[33]
+ rowReadON[32] RefrBp PrBp PrSFBp col_periphery_1x2_23/COL_LINE0 pixRst[46] OffBn
+ rowReadOFF[32] pixRst[47] openDVS_pixel2x2_top_543/GndD DiffBn col_periphery_1x2_23/COL_LINE1
+ GndD VddA18 OnBn openDVS_pixel2x2_top
XopenDVS_pixel2x2_top_524 openDVS_pixel2x2_top_524/vpd[0] openDVS_pixel2x2_top_524/vpd[1]
+ openDVS_pixel2x2_top_524/vpd[3] openDVS_pixel2x2_top_524/vpd[2] rowReadOFF[33] rowReadON[33]
+ rowReadON[32] RefrBp PrBp PrSFBp col_periphery_1x2_12/COL_LINE0 pixRst[24] OffBn
+ rowReadOFF[32] pixRst[25] openDVS_pixel2x2_top_543/GndD DiffBn col_periphery_1x2_12/COL_LINE1
+ GndD VddA18 OnBn openDVS_pixel2x2_top
XopenDVS_pixel2x2_top_513 openDVS_pixel2x2_top_513/vpd[0] openDVS_pixel2x2_top_513/vpd[1]
+ openDVS_pixel2x2_top_513/vpd[3] openDVS_pixel2x2_top_513/vpd[2] rowReadOFF[33] rowReadON[33]
+ rowReadON[32] RefrBp PrBp PrSFBp col_periphery_1x2_1/COL_LINE0 pixRst[2] OffBn rowReadOFF[32]
+ pixRst[3] openDVS_pixel2x2_top_543/GndD DiffBn col_periphery_1x2_1/COL_LINE1 GndD
+ VddA18 OnBn openDVS_pixel2x2_top
XopenDVS_pixel2x2_top_546 openDVS_pixel2x2_top_546/vpd[0] openDVS_pixel2x2_top_546/vpd[1]
+ openDVS_pixel2x2_top_546/vpd[3] openDVS_pixel2x2_top_546/vpd[2] rowReadOFF[35] rowReadON[35]
+ rowReadON[34] RefrBp PrBp PrSFBp col_periphery_1x2_2/COL_LINE0 pixRst[4] OffBn rowReadOFF[34]
+ pixRst[5] openDVS_pixel2x2_top_575/GndD DiffBn col_periphery_1x2_2/COL_LINE1 GndD
+ VddA18 OnBn openDVS_pixel2x2_top
XopenDVS_pixel2x2_top_568 openDVS_pixel2x2_top_568/vpd[0] openDVS_pixel2x2_top_568/vpd[1]
+ openDVS_pixel2x2_top_568/vpd[3] openDVS_pixel2x2_top_568/vpd[2] rowReadOFF[35] rowReadON[35]
+ rowReadON[34] RefrBp PrBp PrSFBp col_periphery_1x2_24/COL_LINE0 pixRst[48] OffBn
+ rowReadOFF[34] pixRst[49] openDVS_pixel2x2_top_575/GndD DiffBn col_periphery_1x2_24/COL_LINE1
+ GndD VddA18 OnBn openDVS_pixel2x2_top
XopenDVS_pixel2x2_top_557 openDVS_pixel2x2_top_557/vpd[0] openDVS_pixel2x2_top_557/vpd[1]
+ openDVS_pixel2x2_top_557/vpd[3] openDVS_pixel2x2_top_557/vpd[2] rowReadOFF[35] rowReadON[35]
+ rowReadON[34] RefrBp PrBp PrSFBp col_periphery_1x2_13/COL_LINE0 pixRst[26] OffBn
+ rowReadOFF[34] pixRst[27] openDVS_pixel2x2_top_575/GndD DiffBn col_periphery_1x2_13/COL_LINE1
+ GndD VddA18 OnBn openDVS_pixel2x2_top
XopenDVS_pixel2x2_top_579 openDVS_pixel2x2_top_579/vpd[0] openDVS_pixel2x2_top_579/vpd[1]
+ openDVS_pixel2x2_top_579/vpd[3] openDVS_pixel2x2_top_579/vpd[2] rowReadOFF[37] rowReadON[37]
+ rowReadON[36] RefrBp PrBp PrSFBp col_periphery_1x2_3/COL_LINE0 pixRst[6] OffBn rowReadOFF[36]
+ pixRst[7] openDVS_pixel2x2_top_607/GndD DiffBn col_periphery_1x2_3/COL_LINE1 GndD
+ VddA18 OnBn openDVS_pixel2x2_top
XopenDVS_pixel2x2_top_343 openDVS_pixel2x2_top_343/vpd[0] openDVS_pixel2x2_top_343/vpd[1]
+ openDVS_pixel2x2_top_343/vpd[3] openDVS_pixel2x2_top_343/vpd[2] rowReadOFF[21] rowReadON[21]
+ rowReadON[20] RefrBp PrBp PrSFBp col_periphery_1x2_23/COL_LINE0 pixRst[46] OffBn
+ rowReadOFF[20] pixRst[47] openDVS_pixel2x2_top_351/GndD DiffBn col_periphery_1x2_23/COL_LINE1
+ GndD VddA18 OnBn openDVS_pixel2x2_top
XopenDVS_pixel2x2_top_310 openDVS_pixel2x2_top_310/vpd[0] openDVS_pixel2x2_top_310/vpd[1]
+ openDVS_pixel2x2_top_310/vpd[3] openDVS_pixel2x2_top_310/vpd[2] rowReadOFF[19] rowReadON[19]
+ rowReadON[18] RefrBp PrBp PrSFBp col_periphery_1x2_22/COL_LINE0 pixRst[44] OffBn
+ rowReadOFF[18] pixRst[45] openDVS_pixel2x2_top_319/GndD DiffBn col_periphery_1x2_22/COL_LINE1
+ GndD VddA18 OnBn openDVS_pixel2x2_top
XopenDVS_pixel2x2_top_332 openDVS_pixel2x2_top_332/vpd[0] openDVS_pixel2x2_top_332/vpd[1]
+ openDVS_pixel2x2_top_332/vpd[3] openDVS_pixel2x2_top_332/vpd[2] rowReadOFF[21] rowReadON[21]
+ rowReadON[20] RefrBp PrBp PrSFBp col_periphery_1x2_12/COL_LINE0 pixRst[24] OffBn
+ rowReadOFF[20] pixRst[25] openDVS_pixel2x2_top_351/GndD DiffBn col_periphery_1x2_12/COL_LINE1
+ GndD VddA18 OnBn openDVS_pixel2x2_top
XopenDVS_pixel2x2_top_321 openDVS_pixel2x2_top_321/vpd[0] openDVS_pixel2x2_top_321/vpd[1]
+ openDVS_pixel2x2_top_321/vpd[3] openDVS_pixel2x2_top_321/vpd[2] rowReadOFF[21] rowReadON[21]
+ rowReadON[20] RefrBp PrBp PrSFBp col_periphery_1x2_1/COL_LINE0 pixRst[2] OffBn rowReadOFF[20]
+ pixRst[3] openDVS_pixel2x2_top_351/GndD DiffBn col_periphery_1x2_1/COL_LINE1 GndD
+ VddA18 OnBn openDVS_pixel2x2_top
XopenDVS_pixel2x2_top_376 openDVS_pixel2x2_top_376/vpd[0] openDVS_pixel2x2_top_376/vpd[1]
+ openDVS_pixel2x2_top_376/vpd[3] openDVS_pixel2x2_top_376/vpd[2] rowReadOFF[23] rowReadON[23]
+ rowReadON[22] RefrBp PrBp PrSFBp col_periphery_1x2_24/COL_LINE0 pixRst[48] OffBn
+ rowReadOFF[22] pixRst[49] openDVS_pixel2x2_top_383/GndD DiffBn col_periphery_1x2_24/COL_LINE1
+ GndD VddA18 OnBn openDVS_pixel2x2_top
XopenDVS_pixel2x2_top_398 openDVS_pixel2x2_top_398/vpd[0] openDVS_pixel2x2_top_398/vpd[1]
+ openDVS_pixel2x2_top_398/vpd[3] openDVS_pixel2x2_top_398/vpd[2] rowReadOFF[25] rowReadON[25]
+ rowReadON[24] RefrBp PrBp PrSFBp col_periphery_1x2_14/COL_LINE0 pixRst[28] OffBn
+ rowReadOFF[24] pixRst[29] openDVS_pixel2x2_top_415/GndD DiffBn col_periphery_1x2_14/COL_LINE1
+ GndD VddA18 OnBn openDVS_pixel2x2_top
XopenDVS_pixel2x2_top_365 openDVS_pixel2x2_top_365/vpd[0] openDVS_pixel2x2_top_365/vpd[1]
+ openDVS_pixel2x2_top_365/vpd[3] openDVS_pixel2x2_top_365/vpd[2] rowReadOFF[23] rowReadON[23]
+ rowReadON[22] RefrBp PrBp PrSFBp col_periphery_1x2_13/COL_LINE0 pixRst[26] OffBn
+ rowReadOFF[22] pixRst[27] openDVS_pixel2x2_top_383/GndD DiffBn col_periphery_1x2_13/COL_LINE1
+ GndD VddA18 OnBn openDVS_pixel2x2_top
XopenDVS_pixel2x2_top_387 openDVS_pixel2x2_top_387/vpd[0] openDVS_pixel2x2_top_387/vpd[1]
+ openDVS_pixel2x2_top_387/vpd[3] openDVS_pixel2x2_top_387/vpd[2] rowReadOFF[25] rowReadON[25]
+ rowReadON[24] RefrBp PrBp PrSFBp col_periphery_1x2_3/COL_LINE0 pixRst[6] OffBn rowReadOFF[24]
+ pixRst[7] openDVS_pixel2x2_top_415/GndD DiffBn col_periphery_1x2_3/COL_LINE1 GndD
+ VddA18 OnBn openDVS_pixel2x2_top
XopenDVS_pixel2x2_top_354 openDVS_pixel2x2_top_354/vpd[0] openDVS_pixel2x2_top_354/vpd[1]
+ openDVS_pixel2x2_top_354/vpd[3] openDVS_pixel2x2_top_354/vpd[2] rowReadOFF[23] rowReadON[23]
+ rowReadON[22] RefrBp PrBp PrSFBp col_periphery_1x2_2/COL_LINE0 pixRst[4] OffBn rowReadOFF[22]
+ pixRst[5] openDVS_pixel2x2_top_383/GndD DiffBn col_periphery_1x2_2/COL_LINE1 GndD
+ VddA18 OnBn openDVS_pixel2x2_top
XopenDVS_pixel2x2_top_184 openDVS_pixel2x2_top_184/vpd[0] openDVS_pixel2x2_top_184/vpd[1]
+ openDVS_pixel2x2_top_184/vpd[3] openDVS_pixel2x2_top_184/vpd[2] rowReadOFF[11] rowReadON[11]
+ rowReadON[10] RefrBp PrBp PrSFBp col_periphery_1x2_24/COL_LINE0 pixRst[48] OffBn
+ rowReadOFF[10] pixRst[49] openDVS_pixel2x2_top_191/GndD DiffBn col_periphery_1x2_24/COL_LINE1
+ GndD VddA18 OnBn openDVS_pixel2x2_top
XopenDVS_pixel2x2_top_151 openDVS_pixel2x2_top_151/vpd[0] openDVS_pixel2x2_top_151/vpd[1]
+ openDVS_pixel2x2_top_151/vpd[3] openDVS_pixel2x2_top_151/vpd[2] rowReadOFF[9] rowReadON[9]
+ rowReadON[8] RefrBp PrBp PrSFBp col_periphery_1x2_23/COL_LINE0 pixRst[46] OffBn
+ rowReadOFF[8] pixRst[47] openDVS_pixel2x2_top_159/GndD DiffBn col_periphery_1x2_23/COL_LINE1
+ GndD VddA18 OnBn openDVS_pixel2x2_top
XopenDVS_pixel2x2_top_173 openDVS_pixel2x2_top_173/vpd[0] openDVS_pixel2x2_top_173/vpd[1]
+ openDVS_pixel2x2_top_173/vpd[3] openDVS_pixel2x2_top_173/vpd[2] rowReadOFF[11] rowReadON[11]
+ rowReadON[10] RefrBp PrBp PrSFBp col_periphery_1x2_13/COL_LINE0 pixRst[26] OffBn
+ rowReadOFF[10] pixRst[27] openDVS_pixel2x2_top_191/GndD DiffBn col_periphery_1x2_13/COL_LINE1
+ GndD VddA18 OnBn openDVS_pixel2x2_top
XopenDVS_pixel2x2_top_140 openDVS_pixel2x2_top_140/vpd[0] openDVS_pixel2x2_top_140/vpd[1]
+ openDVS_pixel2x2_top_140/vpd[3] openDVS_pixel2x2_top_140/vpd[2] rowReadOFF[9] rowReadON[9]
+ rowReadON[8] RefrBp PrBp PrSFBp col_periphery_1x2_12/COL_LINE0 pixRst[24] OffBn
+ rowReadOFF[8] pixRst[25] openDVS_pixel2x2_top_159/GndD DiffBn col_periphery_1x2_12/COL_LINE1
+ GndD VddA18 OnBn openDVS_pixel2x2_top
XopenDVS_pixel2x2_top_162 openDVS_pixel2x2_top_162/vpd[0] openDVS_pixel2x2_top_162/vpd[1]
+ openDVS_pixel2x2_top_162/vpd[3] openDVS_pixel2x2_top_162/vpd[2] rowReadOFF[11] rowReadON[11]
+ rowReadON[10] RefrBp PrBp PrSFBp col_periphery_1x2_2/COL_LINE0 pixRst[4] OffBn rowReadOFF[10]
+ pixRst[5] openDVS_pixel2x2_top_191/GndD DiffBn col_periphery_1x2_2/COL_LINE1 GndD
+ VddA18 OnBn openDVS_pixel2x2_top
XopenDVS_pixel2x2_top_195 openDVS_pixel2x2_top_195/vpd[0] openDVS_pixel2x2_top_195/vpd[1]
+ openDVS_pixel2x2_top_195/vpd[3] openDVS_pixel2x2_top_195/vpd[2] rowReadOFF[13] rowReadON[13]
+ rowReadON[12] RefrBp PrBp PrSFBp col_periphery_1x2_3/COL_LINE0 pixRst[6] OffBn rowReadOFF[12]
+ pixRst[7] openDVS_pixel2x2_top_223/GndD DiffBn col_periphery_1x2_3/COL_LINE1 GndD
+ VddA18 OnBn openDVS_pixel2x2_top
XopenDVS_pixel2x2_top_24 openDVS_pixel2x2_top_24/vpd[0] openDVS_pixel2x2_top_24/vpd[1]
+ openDVS_pixel2x2_top_24/vpd[3] openDVS_pixel2x2_top_24/vpd[2] rowReadOFF[1] rowReadON[1]
+ rowReadON[0] RefrBp PrBp PrSFBp col_periphery_1x2_24/COL_LINE0 pixRst[48] OffBn
+ rowReadOFF[0] pixRst[49] openDVS_pixel2x2_top_9/GndD DiffBn col_periphery_1x2_24/COL_LINE1
+ GndD VddA18 OnBn openDVS_pixel2x2_top
XopenDVS_pixel2x2_top_13 openDVS_pixel2x2_top_13/vpd[0] openDVS_pixel2x2_top_13/vpd[1]
+ openDVS_pixel2x2_top_13/vpd[3] openDVS_pixel2x2_top_13/vpd[2] rowReadOFF[1] rowReadON[1]
+ rowReadON[0] RefrBp PrBp PrSFBp col_periphery_1x2_13/COL_LINE0 pixRst[26] OffBn
+ rowReadOFF[0] pixRst[27] openDVS_pixel2x2_top_9/GndD DiffBn col_periphery_1x2_13/COL_LINE1
+ GndD VddA18 OnBn openDVS_pixel2x2_top
Xcol_periphery_1x2_4 pixRst[9] col_periphery_1x2_4/COL_LINE0 col_periphery_1x2_4/COL_LINE1
+ nDETECT col_periphery_1x2_9/VDD DETECT VTHRESH voutn[8] GndD NCHARGE voutn[9] pixRst[8]
+ col_periphery_1x2
XopenDVS_pixel2x2_top_57 openDVS_pixel2x2_top_57/vpd[0] openDVS_pixel2x2_top_57/vpd[1]
+ openDVS_pixel2x2_top_57/vpd[3] openDVS_pixel2x2_top_57/vpd[2] rowReadOFF[3] rowReadON[3]
+ rowReadON[2] RefrBp PrBp PrSFBp col_periphery_1x2_25/COL_LINE0 pixRst[50] OffBn
+ rowReadOFF[2] pixRst[51] openDVS_pixel2x2_top_63/GndD DiffBn col_periphery_1x2_25/COL_LINE1
+ GndD VddA18 OnBn openDVS_pixel2x2_top
XopenDVS_pixel2x2_top_79 openDVS_pixel2x2_top_79/vpd[0] openDVS_pixel2x2_top_79/vpd[1]
+ openDVS_pixel2x2_top_79/vpd[3] openDVS_pixel2x2_top_79/vpd[2] rowReadOFF[5] rowReadON[5]
+ rowReadON[4] RefrBp PrBp PrSFBp col_periphery_1x2_15/COL_LINE0 pixRst[30] OffBn
+ rowReadOFF[4] pixRst[31] openDVS_pixel2x2_top_95/GndD DiffBn col_periphery_1x2_15/COL_LINE1
+ GndD VddA18 OnBn openDVS_pixel2x2_top
XopenDVS_pixel2x2_top_46 openDVS_pixel2x2_top_46/vpd[0] openDVS_pixel2x2_top_46/vpd[1]
+ openDVS_pixel2x2_top_46/vpd[3] openDVS_pixel2x2_top_46/vpd[2] rowReadOFF[3] rowReadON[3]
+ rowReadON[2] RefrBp PrBp PrSFBp col_periphery_1x2_14/COL_LINE0 pixRst[28] OffBn
+ rowReadOFF[2] pixRst[29] openDVS_pixel2x2_top_63/GndD DiffBn col_periphery_1x2_14/COL_LINE1
+ GndD VddA18 OnBn openDVS_pixel2x2_top
XopenDVS_pixel2x2_top_68 openDVS_pixel2x2_top_68/vpd[0] openDVS_pixel2x2_top_68/vpd[1]
+ openDVS_pixel2x2_top_68/vpd[3] openDVS_pixel2x2_top_68/vpd[2] rowReadOFF[5] rowReadON[5]
+ rowReadON[4] RefrBp PrBp PrSFBp col_periphery_1x2_4/COL_LINE0 pixRst[8] OffBn rowReadOFF[4]
+ pixRst[9] openDVS_pixel2x2_top_95/GndD DiffBn col_periphery_1x2_4/COL_LINE1 GndD
+ VddA18 OnBn openDVS_pixel2x2_top
XopenDVS_pixel2x2_top_35 openDVS_pixel2x2_top_35/vpd[0] openDVS_pixel2x2_top_35/vpd[1]
+ openDVS_pixel2x2_top_35/vpd[3] openDVS_pixel2x2_top_35/vpd[2] rowReadOFF[3] rowReadON[3]
+ rowReadON[2] RefrBp PrBp PrSFBp col_periphery_1x2_3/COL_LINE0 pixRst[6] OffBn rowReadOFF[2]
+ pixRst[7] openDVS_pixel2x2_top_63/GndD DiffBn col_periphery_1x2_3/COL_LINE1 GndD
+ VddA18 OnBn openDVS_pixel2x2_top
XopenDVS_pixel2x2_top_909 openDVS_pixel2x2_top_909/vpd[0] openDVS_pixel2x2_top_909/vpd[1]
+ openDVS_pixel2x2_top_909/vpd[3] openDVS_pixel2x2_top_909/vpd[2] rowReadOFF[57] rowReadON[57]
+ rowReadON[56] RefrBp PrBp PrSFBp col_periphery_1x2_13/COL_LINE0 pixRst[26] OffBn
+ rowReadOFF[56] pixRst[27] openDVS_pixel2x2_top_927/GndD DiffBn col_periphery_1x2_13/COL_LINE1
+ GndD VddA18 OnBn openDVS_pixel2x2_top
XopenDVS_pixel2x2_top_706 openDVS_pixel2x2_top_706/vpd[0] openDVS_pixel2x2_top_706/vpd[1]
+ openDVS_pixel2x2_top_706/vpd[3] openDVS_pixel2x2_top_706/vpd[2] rowReadOFF[45] rowReadON[45]
+ rowReadON[44] RefrBp PrBp PrSFBp col_periphery_1x2_2/COL_LINE0 pixRst[4] OffBn rowReadOFF[44]
+ pixRst[5] openDVS_pixel2x2_top_735/GndD DiffBn col_periphery_1x2_2/COL_LINE1 GndD
+ VddA18 OnBn openDVS_pixel2x2_top
XopenDVS_pixel2x2_top_739 openDVS_pixel2x2_top_739/vpd[0] openDVS_pixel2x2_top_739/vpd[1]
+ openDVS_pixel2x2_top_739/vpd[3] openDVS_pixel2x2_top_739/vpd[2] rowReadOFF[47] rowReadON[47]
+ rowReadON[46] RefrBp PrBp PrSFBp col_periphery_1x2_3/COL_LINE0 pixRst[6] OffBn rowReadOFF[46]
+ pixRst[7] openDVS_pixel2x2_top_767/GndD DiffBn col_periphery_1x2_3/COL_LINE1 GndD
+ VddA18 OnBn openDVS_pixel2x2_top
XopenDVS_pixel2x2_top_717 openDVS_pixel2x2_top_717/vpd[0] openDVS_pixel2x2_top_717/vpd[1]
+ openDVS_pixel2x2_top_717/vpd[3] openDVS_pixel2x2_top_717/vpd[2] rowReadOFF[45] rowReadON[45]
+ rowReadON[44] RefrBp PrBp PrSFBp col_periphery_1x2_13/COL_LINE0 pixRst[26] OffBn
+ rowReadOFF[44] pixRst[27] openDVS_pixel2x2_top_735/GndD DiffBn col_periphery_1x2_13/COL_LINE1
+ GndD VddA18 OnBn openDVS_pixel2x2_top
XopenDVS_pixel2x2_top_728 openDVS_pixel2x2_top_728/vpd[0] openDVS_pixel2x2_top_728/vpd[1]
+ openDVS_pixel2x2_top_728/vpd[3] openDVS_pixel2x2_top_728/vpd[2] rowReadOFF[45] rowReadON[45]
+ rowReadON[44] RefrBp PrBp PrSFBp col_periphery_1x2_24/COL_LINE0 pixRst[48] OffBn
+ rowReadOFF[44] pixRst[49] openDVS_pixel2x2_top_735/GndD DiffBn col_periphery_1x2_24/COL_LINE1
+ GndD VddA18 OnBn openDVS_pixel2x2_top
XopenDVS_pixel2x2_top_503 openDVS_pixel2x2_top_503/vpd[0] openDVS_pixel2x2_top_503/vpd[1]
+ openDVS_pixel2x2_top_503/vpd[3] openDVS_pixel2x2_top_503/vpd[2] rowReadOFF[31] rowReadON[31]
+ rowReadON[30] RefrBp PrBp PrSFBp col_periphery_1x2_23/COL_LINE0 pixRst[46] OffBn
+ rowReadOFF[30] pixRst[47] openDVS_pixel2x2_top_511/GndD DiffBn col_periphery_1x2_23/COL_LINE1
+ GndD VddA18 OnBn openDVS_pixel2x2_top
XopenDVS_pixel2x2_top_569 openDVS_pixel2x2_top_569/vpd[0] openDVS_pixel2x2_top_569/vpd[1]
+ openDVS_pixel2x2_top_569/vpd[3] openDVS_pixel2x2_top_569/vpd[2] rowReadOFF[35] rowReadON[35]
+ rowReadON[34] RefrBp PrBp PrSFBp col_periphery_1x2_25/COL_LINE0 pixRst[50] OffBn
+ rowReadOFF[34] pixRst[51] openDVS_pixel2x2_top_575/GndD DiffBn col_periphery_1x2_25/COL_LINE1
+ GndD VddA18 OnBn openDVS_pixel2x2_top
XopenDVS_pixel2x2_top_536 openDVS_pixel2x2_top_536/vpd[0] openDVS_pixel2x2_top_536/vpd[1]
+ openDVS_pixel2x2_top_536/vpd[3] openDVS_pixel2x2_top_536/vpd[2] rowReadOFF[33] rowReadON[33]
+ rowReadON[32] RefrBp PrBp PrSFBp col_periphery_1x2_24/COL_LINE0 pixRst[48] OffBn
+ rowReadOFF[32] pixRst[49] openDVS_pixel2x2_top_543/GndD DiffBn col_periphery_1x2_24/COL_LINE1
+ GndD VddA18 OnBn openDVS_pixel2x2_top
XopenDVS_pixel2x2_top_558 openDVS_pixel2x2_top_558/vpd[0] openDVS_pixel2x2_top_558/vpd[1]
+ openDVS_pixel2x2_top_558/vpd[3] openDVS_pixel2x2_top_558/vpd[2] rowReadOFF[35] rowReadON[35]
+ rowReadON[34] RefrBp PrBp PrSFBp col_periphery_1x2_14/COL_LINE0 pixRst[28] OffBn
+ rowReadOFF[34] pixRst[29] openDVS_pixel2x2_top_575/GndD DiffBn col_periphery_1x2_14/COL_LINE1
+ GndD VddA18 OnBn openDVS_pixel2x2_top
XopenDVS_pixel2x2_top_525 openDVS_pixel2x2_top_525/vpd[0] openDVS_pixel2x2_top_525/vpd[1]
+ openDVS_pixel2x2_top_525/vpd[3] openDVS_pixel2x2_top_525/vpd[2] rowReadOFF[33] rowReadON[33]
+ rowReadON[32] RefrBp PrBp PrSFBp col_periphery_1x2_13/COL_LINE0 pixRst[26] OffBn
+ rowReadOFF[32] pixRst[27] openDVS_pixel2x2_top_543/GndD DiffBn col_periphery_1x2_13/COL_LINE1
+ GndD VddA18 OnBn openDVS_pixel2x2_top
XopenDVS_pixel2x2_top_514 openDVS_pixel2x2_top_514/vpd[0] openDVS_pixel2x2_top_514/vpd[1]
+ openDVS_pixel2x2_top_514/vpd[3] openDVS_pixel2x2_top_514/vpd[2] rowReadOFF[33] rowReadON[33]
+ rowReadON[32] RefrBp PrBp PrSFBp col_periphery_1x2_2/COL_LINE0 pixRst[4] OffBn rowReadOFF[32]
+ pixRst[5] openDVS_pixel2x2_top_543/GndD DiffBn col_periphery_1x2_2/COL_LINE1 GndD
+ VddA18 OnBn openDVS_pixel2x2_top
XopenDVS_pixel2x2_top_547 openDVS_pixel2x2_top_547/vpd[0] openDVS_pixel2x2_top_547/vpd[1]
+ openDVS_pixel2x2_top_547/vpd[3] openDVS_pixel2x2_top_547/vpd[2] rowReadOFF[35] rowReadON[35]
+ rowReadON[34] RefrBp PrBp PrSFBp col_periphery_1x2_3/COL_LINE0 pixRst[6] OffBn rowReadOFF[34]
+ pixRst[7] openDVS_pixel2x2_top_575/GndD DiffBn col_periphery_1x2_3/COL_LINE1 GndD
+ VddA18 OnBn openDVS_pixel2x2_top
XopenDVS_pixel2x2_top_344 openDVS_pixel2x2_top_344/vpd[0] openDVS_pixel2x2_top_344/vpd[1]
+ openDVS_pixel2x2_top_344/vpd[3] openDVS_pixel2x2_top_344/vpd[2] rowReadOFF[21] rowReadON[21]
+ rowReadON[20] RefrBp PrBp PrSFBp col_periphery_1x2_24/COL_LINE0 pixRst[48] OffBn
+ rowReadOFF[20] pixRst[49] openDVS_pixel2x2_top_351/GndD DiffBn col_periphery_1x2_24/COL_LINE1
+ GndD VddA18 OnBn openDVS_pixel2x2_top
XopenDVS_pixel2x2_top_311 openDVS_pixel2x2_top_311/vpd[0] openDVS_pixel2x2_top_311/vpd[1]
+ openDVS_pixel2x2_top_311/vpd[3] openDVS_pixel2x2_top_311/vpd[2] rowReadOFF[19] rowReadON[19]
+ rowReadON[18] RefrBp PrBp PrSFBp col_periphery_1x2_23/COL_LINE0 pixRst[46] OffBn
+ rowReadOFF[18] pixRst[47] openDVS_pixel2x2_top_319/GndD DiffBn col_periphery_1x2_23/COL_LINE1
+ GndD VddA18 OnBn openDVS_pixel2x2_top
XopenDVS_pixel2x2_top_333 openDVS_pixel2x2_top_333/vpd[0] openDVS_pixel2x2_top_333/vpd[1]
+ openDVS_pixel2x2_top_333/vpd[3] openDVS_pixel2x2_top_333/vpd[2] rowReadOFF[21] rowReadON[21]
+ rowReadON[20] RefrBp PrBp PrSFBp col_periphery_1x2_13/COL_LINE0 pixRst[26] OffBn
+ rowReadOFF[20] pixRst[27] openDVS_pixel2x2_top_351/GndD DiffBn col_periphery_1x2_13/COL_LINE1
+ GndD VddA18 OnBn openDVS_pixel2x2_top
XopenDVS_pixel2x2_top_300 openDVS_pixel2x2_top_300/vpd[0] openDVS_pixel2x2_top_300/vpd[1]
+ openDVS_pixel2x2_top_300/vpd[3] openDVS_pixel2x2_top_300/vpd[2] rowReadOFF[19] rowReadON[19]
+ rowReadON[18] RefrBp PrBp PrSFBp col_periphery_1x2_12/COL_LINE0 pixRst[24] OffBn
+ rowReadOFF[18] pixRst[25] openDVS_pixel2x2_top_319/GndD DiffBn col_periphery_1x2_12/COL_LINE1
+ GndD VddA18 OnBn openDVS_pixel2x2_top
XopenDVS_pixel2x2_top_322 openDVS_pixel2x2_top_322/vpd[0] openDVS_pixel2x2_top_322/vpd[1]
+ openDVS_pixel2x2_top_322/vpd[3] openDVS_pixel2x2_top_322/vpd[2] rowReadOFF[21] rowReadON[21]
+ rowReadON[20] RefrBp PrBp PrSFBp col_periphery_1x2_2/COL_LINE0 pixRst[4] OffBn rowReadOFF[20]
+ pixRst[5] openDVS_pixel2x2_top_351/GndD DiffBn col_periphery_1x2_2/COL_LINE1 GndD
+ VddA18 OnBn openDVS_pixel2x2_top
XopenDVS_pixel2x2_top_377 openDVS_pixel2x2_top_377/vpd[0] openDVS_pixel2x2_top_377/vpd[1]
+ openDVS_pixel2x2_top_377/vpd[3] openDVS_pixel2x2_top_377/vpd[2] rowReadOFF[23] rowReadON[23]
+ rowReadON[22] RefrBp PrBp PrSFBp col_periphery_1x2_25/COL_LINE0 pixRst[50] OffBn
+ rowReadOFF[22] pixRst[51] openDVS_pixel2x2_top_383/GndD DiffBn col_periphery_1x2_25/COL_LINE1
+ GndD VddA18 OnBn openDVS_pixel2x2_top
XopenDVS_pixel2x2_top_399 openDVS_pixel2x2_top_399/vpd[0] openDVS_pixel2x2_top_399/vpd[1]
+ openDVS_pixel2x2_top_399/vpd[3] openDVS_pixel2x2_top_399/vpd[2] rowReadOFF[25] rowReadON[25]
+ rowReadON[24] RefrBp PrBp PrSFBp col_periphery_1x2_15/COL_LINE0 pixRst[30] OffBn
+ rowReadOFF[24] pixRst[31] openDVS_pixel2x2_top_415/GndD DiffBn col_periphery_1x2_15/COL_LINE1
+ GndD VddA18 OnBn openDVS_pixel2x2_top
XopenDVS_pixel2x2_top_366 openDVS_pixel2x2_top_366/vpd[0] openDVS_pixel2x2_top_366/vpd[1]
+ openDVS_pixel2x2_top_366/vpd[3] openDVS_pixel2x2_top_366/vpd[2] rowReadOFF[23] rowReadON[23]
+ rowReadON[22] RefrBp PrBp PrSFBp col_periphery_1x2_14/COL_LINE0 pixRst[28] OffBn
+ rowReadOFF[22] pixRst[29] openDVS_pixel2x2_top_383/GndD DiffBn col_periphery_1x2_14/COL_LINE1
+ GndD VddA18 OnBn openDVS_pixel2x2_top
XopenDVS_pixel2x2_top_388 openDVS_pixel2x2_top_388/vpd[0] openDVS_pixel2x2_top_388/vpd[1]
+ openDVS_pixel2x2_top_388/vpd[3] openDVS_pixel2x2_top_388/vpd[2] rowReadOFF[25] rowReadON[25]
+ rowReadON[24] RefrBp PrBp PrSFBp col_periphery_1x2_4/COL_LINE0 pixRst[8] OffBn rowReadOFF[24]
+ pixRst[9] openDVS_pixel2x2_top_415/GndD DiffBn col_periphery_1x2_4/COL_LINE1 GndD
+ VddA18 OnBn openDVS_pixel2x2_top
XopenDVS_pixel2x2_top_355 openDVS_pixel2x2_top_355/vpd[0] openDVS_pixel2x2_top_355/vpd[1]
+ openDVS_pixel2x2_top_355/vpd[3] openDVS_pixel2x2_top_355/vpd[2] rowReadOFF[23] rowReadON[23]
+ rowReadON[22] RefrBp PrBp PrSFBp col_periphery_1x2_3/COL_LINE0 pixRst[6] OffBn rowReadOFF[22]
+ pixRst[7] openDVS_pixel2x2_top_383/GndD DiffBn col_periphery_1x2_3/COL_LINE1 GndD
+ VddA18 OnBn openDVS_pixel2x2_top
XopenDVS_pixel2x2_top_185 openDVS_pixel2x2_top_185/vpd[0] openDVS_pixel2x2_top_185/vpd[1]
+ openDVS_pixel2x2_top_185/vpd[3] openDVS_pixel2x2_top_185/vpd[2] rowReadOFF[11] rowReadON[11]
+ rowReadON[10] RefrBp PrBp PrSFBp col_periphery_1x2_25/COL_LINE0 pixRst[50] OffBn
+ rowReadOFF[10] pixRst[51] openDVS_pixel2x2_top_191/GndD DiffBn col_periphery_1x2_25/COL_LINE1
+ GndD VddA18 OnBn openDVS_pixel2x2_top
XopenDVS_pixel2x2_top_152 openDVS_pixel2x2_top_152/vpd[0] openDVS_pixel2x2_top_152/vpd[1]
+ openDVS_pixel2x2_top_152/vpd[3] openDVS_pixel2x2_top_152/vpd[2] rowReadOFF[9] rowReadON[9]
+ rowReadON[8] RefrBp PrBp PrSFBp col_periphery_1x2_24/COL_LINE0 pixRst[48] OffBn
+ rowReadOFF[8] pixRst[49] openDVS_pixel2x2_top_159/GndD DiffBn col_periphery_1x2_24/COL_LINE1
+ GndD VddA18 OnBn openDVS_pixel2x2_top
XopenDVS_pixel2x2_top_174 openDVS_pixel2x2_top_174/vpd[0] openDVS_pixel2x2_top_174/vpd[1]
+ openDVS_pixel2x2_top_174/vpd[3] openDVS_pixel2x2_top_174/vpd[2] rowReadOFF[11] rowReadON[11]
+ rowReadON[10] RefrBp PrBp PrSFBp col_periphery_1x2_14/COL_LINE0 pixRst[28] OffBn
+ rowReadOFF[10] pixRst[29] openDVS_pixel2x2_top_191/GndD DiffBn col_periphery_1x2_14/COL_LINE1
+ GndD VddA18 OnBn openDVS_pixel2x2_top
XopenDVS_pixel2x2_top_141 openDVS_pixel2x2_top_141/vpd[0] openDVS_pixel2x2_top_141/vpd[1]
+ openDVS_pixel2x2_top_141/vpd[3] openDVS_pixel2x2_top_141/vpd[2] rowReadOFF[9] rowReadON[9]
+ rowReadON[8] RefrBp PrBp PrSFBp col_periphery_1x2_13/COL_LINE0 pixRst[26] OffBn
+ rowReadOFF[8] pixRst[27] openDVS_pixel2x2_top_159/GndD DiffBn col_periphery_1x2_13/COL_LINE1
+ GndD VddA18 OnBn openDVS_pixel2x2_top
XopenDVS_pixel2x2_top_163 openDVS_pixel2x2_top_163/vpd[0] openDVS_pixel2x2_top_163/vpd[1]
+ openDVS_pixel2x2_top_163/vpd[3] openDVS_pixel2x2_top_163/vpd[2] rowReadOFF[11] rowReadON[11]
+ rowReadON[10] RefrBp PrBp PrSFBp col_periphery_1x2_3/COL_LINE0 pixRst[6] OffBn rowReadOFF[10]
+ pixRst[7] openDVS_pixel2x2_top_191/GndD DiffBn col_periphery_1x2_3/COL_LINE1 GndD
+ VddA18 OnBn openDVS_pixel2x2_top
XopenDVS_pixel2x2_top_130 openDVS_pixel2x2_top_130/vpd[0] openDVS_pixel2x2_top_130/vpd[1]
+ openDVS_pixel2x2_top_130/vpd[3] openDVS_pixel2x2_top_130/vpd[2] rowReadOFF[9] rowReadON[9]
+ rowReadON[8] RefrBp PrBp PrSFBp col_periphery_1x2_2/COL_LINE0 pixRst[4] OffBn rowReadOFF[8]
+ pixRst[5] openDVS_pixel2x2_top_159/GndD DiffBn col_periphery_1x2_2/COL_LINE1 GndD
+ VddA18 OnBn openDVS_pixel2x2_top
XopenDVS_pixel2x2_top_196 openDVS_pixel2x2_top_196/vpd[0] openDVS_pixel2x2_top_196/vpd[1]
+ openDVS_pixel2x2_top_196/vpd[3] openDVS_pixel2x2_top_196/vpd[2] rowReadOFF[13] rowReadON[13]
+ rowReadON[12] RefrBp PrBp PrSFBp col_periphery_1x2_4/COL_LINE0 pixRst[8] OffBn rowReadOFF[12]
+ pixRst[9] openDVS_pixel2x2_top_223/GndD DiffBn col_periphery_1x2_4/COL_LINE1 GndD
+ VddA18 OnBn openDVS_pixel2x2_top
XopenDVS_pixel2x2_top_25 openDVS_pixel2x2_top_25/vpd[0] openDVS_pixel2x2_top_25/vpd[1]
+ openDVS_pixel2x2_top_25/vpd[3] openDVS_pixel2x2_top_25/vpd[2] rowReadOFF[1] rowReadON[1]
+ rowReadON[0] RefrBp PrBp PrSFBp col_periphery_1x2_25/COL_LINE0 pixRst[50] OffBn
+ rowReadOFF[0] pixRst[51] openDVS_pixel2x2_top_9/GndD DiffBn col_periphery_1x2_25/COL_LINE1
+ GndD VddA18 OnBn openDVS_pixel2x2_top
XopenDVS_pixel2x2_top_14 openDVS_pixel2x2_top_14/vpd[0] openDVS_pixel2x2_top_14/vpd[1]
+ openDVS_pixel2x2_top_14/vpd[3] openDVS_pixel2x2_top_14/vpd[2] rowReadOFF[1] rowReadON[1]
+ rowReadON[0] RefrBp PrBp PrSFBp col_periphery_1x2_14/COL_LINE0 pixRst[28] OffBn
+ rowReadOFF[0] pixRst[29] openDVS_pixel2x2_top_9/GndD DiffBn col_periphery_1x2_14/COL_LINE1
+ GndD VddA18 OnBn openDVS_pixel2x2_top
XopenDVS_pixel2x2_top_58 openDVS_pixel2x2_top_58/vpd[0] openDVS_pixel2x2_top_58/vpd[1]
+ openDVS_pixel2x2_top_58/vpd[3] openDVS_pixel2x2_top_58/vpd[2] rowReadOFF[3] rowReadON[3]
+ rowReadON[2] RefrBp PrBp PrSFBp col_periphery_1x2_26/COL_LINE0 pixRst[52] OffBn
+ rowReadOFF[2] pixRst[53] openDVS_pixel2x2_top_63/GndD DiffBn col_periphery_1x2_26/COL_LINE1
+ GndD VddA18 OnBn openDVS_pixel2x2_top
XopenDVS_pixel2x2_top_47 openDVS_pixel2x2_top_47/vpd[0] openDVS_pixel2x2_top_47/vpd[1]
+ openDVS_pixel2x2_top_47/vpd[3] openDVS_pixel2x2_top_47/vpd[2] rowReadOFF[3] rowReadON[3]
+ rowReadON[2] RefrBp PrBp PrSFBp col_periphery_1x2_15/COL_LINE0 pixRst[30] OffBn
+ rowReadOFF[2] pixRst[31] openDVS_pixel2x2_top_63/GndD DiffBn col_periphery_1x2_15/COL_LINE1
+ GndD VddA18 OnBn openDVS_pixel2x2_top
XopenDVS_pixel2x2_top_69 openDVS_pixel2x2_top_69/vpd[0] openDVS_pixel2x2_top_69/vpd[1]
+ openDVS_pixel2x2_top_69/vpd[3] openDVS_pixel2x2_top_69/vpd[2] rowReadOFF[5] rowReadON[5]
+ rowReadON[4] RefrBp PrBp PrSFBp col_periphery_1x2_5/COL_LINE0 pixRst[10] OffBn rowReadOFF[4]
+ pixRst[11] openDVS_pixel2x2_top_95/GndD DiffBn col_periphery_1x2_5/COL_LINE1 GndD
+ VddA18 OnBn openDVS_pixel2x2_top
XopenDVS_pixel2x2_top_36 openDVS_pixel2x2_top_36/vpd[0] openDVS_pixel2x2_top_36/vpd[1]
+ openDVS_pixel2x2_top_36/vpd[3] openDVS_pixel2x2_top_36/vpd[2] rowReadOFF[3] rowReadON[3]
+ rowReadON[2] RefrBp PrBp PrSFBp col_periphery_1x2_4/COL_LINE0 pixRst[8] OffBn rowReadOFF[2]
+ pixRst[9] openDVS_pixel2x2_top_63/GndD DiffBn col_periphery_1x2_4/COL_LINE1 GndD
+ VddA18 OnBn openDVS_pixel2x2_top
XopenDVS_pixel2x2_top_1020 openDVS_pixel2x2_top_1020/vpd[0] openDVS_pixel2x2_top_1020/vpd[1]
+ openDVS_pixel2x2_top_1020/vpd[3] openDVS_pixel2x2_top_1020/vpd[2] rowReadOFF[63]
+ rowReadON[63] rowReadON[62] RefrBp PrBp PrSFBp col_periphery_1x2_28/COL_LINE0 pixRst[56]
+ OffBn rowReadOFF[62] pixRst[57] openDVS_pixel2x2_top_999/GndD DiffBn col_periphery_1x2_28/COL_LINE1
+ GndD VddA18 OnBn openDVS_pixel2x2_top
Xcol_periphery_1x2_5 pixRst[11] col_periphery_1x2_5/COL_LINE0 col_periphery_1x2_5/COL_LINE1
+ nDETECT col_periphery_1x2_9/VDD DETECT VTHRESH voutn[10] GndD NCHARGE voutn[11]
+ pixRst[10] col_periphery_1x2
XopenDVS_pixel2x2_top_707 openDVS_pixel2x2_top_707/vpd[0] openDVS_pixel2x2_top_707/vpd[1]
+ openDVS_pixel2x2_top_707/vpd[3] openDVS_pixel2x2_top_707/vpd[2] rowReadOFF[45] rowReadON[45]
+ rowReadON[44] RefrBp PrBp PrSFBp col_periphery_1x2_3/COL_LINE0 pixRst[6] OffBn rowReadOFF[44]
+ pixRst[7] openDVS_pixel2x2_top_735/GndD DiffBn col_periphery_1x2_3/COL_LINE1 GndD
+ VddA18 OnBn openDVS_pixel2x2_top
XopenDVS_pixel2x2_top_718 openDVS_pixel2x2_top_718/vpd[0] openDVS_pixel2x2_top_718/vpd[1]
+ openDVS_pixel2x2_top_718/vpd[3] openDVS_pixel2x2_top_718/vpd[2] rowReadOFF[45] rowReadON[45]
+ rowReadON[44] RefrBp PrBp PrSFBp col_periphery_1x2_14/COL_LINE0 pixRst[28] OffBn
+ rowReadOFF[44] pixRst[29] openDVS_pixel2x2_top_735/GndD DiffBn col_periphery_1x2_14/COL_LINE1
+ GndD VddA18 OnBn openDVS_pixel2x2_top
XopenDVS_pixel2x2_top_729 openDVS_pixel2x2_top_729/vpd[0] openDVS_pixel2x2_top_729/vpd[1]
+ openDVS_pixel2x2_top_729/vpd[3] openDVS_pixel2x2_top_729/vpd[2] rowReadOFF[45] rowReadON[45]
+ rowReadON[44] RefrBp PrBp PrSFBp col_periphery_1x2_25/COL_LINE0 pixRst[50] OffBn
+ rowReadOFF[44] pixRst[51] openDVS_pixel2x2_top_735/GndD DiffBn col_periphery_1x2_25/COL_LINE1
+ GndD VddA18 OnBn openDVS_pixel2x2_top
XopenDVS_pixel2x2_top_504 openDVS_pixel2x2_top_504/vpd[0] openDVS_pixel2x2_top_504/vpd[1]
+ openDVS_pixel2x2_top_504/vpd[3] openDVS_pixel2x2_top_504/vpd[2] rowReadOFF[31] rowReadON[31]
+ rowReadON[30] RefrBp PrBp PrSFBp col_periphery_1x2_24/COL_LINE0 pixRst[48] OffBn
+ rowReadOFF[30] pixRst[49] openDVS_pixel2x2_top_511/GndD DiffBn col_periphery_1x2_24/COL_LINE1
+ GndD VddA18 OnBn openDVS_pixel2x2_top
XopenDVS_pixel2x2_top_537 openDVS_pixel2x2_top_537/vpd[0] openDVS_pixel2x2_top_537/vpd[1]
+ openDVS_pixel2x2_top_537/vpd[3] openDVS_pixel2x2_top_537/vpd[2] rowReadOFF[33] rowReadON[33]
+ rowReadON[32] RefrBp PrBp PrSFBp col_periphery_1x2_25/COL_LINE0 pixRst[50] OffBn
+ rowReadOFF[32] pixRst[51] openDVS_pixel2x2_top_543/GndD DiffBn col_periphery_1x2_25/COL_LINE1
+ GndD VddA18 OnBn openDVS_pixel2x2_top
XopenDVS_pixel2x2_top_559 openDVS_pixel2x2_top_559/vpd[0] openDVS_pixel2x2_top_559/vpd[1]
+ openDVS_pixel2x2_top_559/vpd[3] openDVS_pixel2x2_top_559/vpd[2] rowReadOFF[35] rowReadON[35]
+ rowReadON[34] RefrBp PrBp PrSFBp col_periphery_1x2_15/COL_LINE0 pixRst[30] OffBn
+ rowReadOFF[34] pixRst[31] openDVS_pixel2x2_top_575/GndD DiffBn col_periphery_1x2_15/COL_LINE1
+ GndD VddA18 OnBn openDVS_pixel2x2_top
XopenDVS_pixel2x2_top_526 openDVS_pixel2x2_top_526/vpd[0] openDVS_pixel2x2_top_526/vpd[1]
+ openDVS_pixel2x2_top_526/vpd[3] openDVS_pixel2x2_top_526/vpd[2] rowReadOFF[33] rowReadON[33]
+ rowReadON[32] RefrBp PrBp PrSFBp col_periphery_1x2_14/COL_LINE0 pixRst[28] OffBn
+ rowReadOFF[32] pixRst[29] openDVS_pixel2x2_top_543/GndD DiffBn col_periphery_1x2_14/COL_LINE1
+ GndD VddA18 OnBn openDVS_pixel2x2_top
XopenDVS_pixel2x2_top_515 openDVS_pixel2x2_top_515/vpd[0] openDVS_pixel2x2_top_515/vpd[1]
+ openDVS_pixel2x2_top_515/vpd[3] openDVS_pixel2x2_top_515/vpd[2] rowReadOFF[33] rowReadON[33]
+ rowReadON[32] RefrBp PrBp PrSFBp col_periphery_1x2_3/COL_LINE0 pixRst[6] OffBn rowReadOFF[32]
+ pixRst[7] openDVS_pixel2x2_top_543/GndD DiffBn col_periphery_1x2_3/COL_LINE1 GndD
+ VddA18 OnBn openDVS_pixel2x2_top
XopenDVS_pixel2x2_top_548 openDVS_pixel2x2_top_548/vpd[0] openDVS_pixel2x2_top_548/vpd[1]
+ openDVS_pixel2x2_top_548/vpd[3] openDVS_pixel2x2_top_548/vpd[2] rowReadOFF[35] rowReadON[35]
+ rowReadON[34] RefrBp PrBp PrSFBp col_periphery_1x2_4/COL_LINE0 pixRst[8] OffBn rowReadOFF[34]
+ pixRst[9] openDVS_pixel2x2_top_575/GndD DiffBn col_periphery_1x2_4/COL_LINE1 GndD
+ VddA18 OnBn openDVS_pixel2x2_top
XopenDVS_pixel2x2_top_312 openDVS_pixel2x2_top_312/vpd[0] openDVS_pixel2x2_top_312/vpd[1]
+ openDVS_pixel2x2_top_312/vpd[3] openDVS_pixel2x2_top_312/vpd[2] rowReadOFF[19] rowReadON[19]
+ rowReadON[18] RefrBp PrBp PrSFBp col_periphery_1x2_24/COL_LINE0 pixRst[48] OffBn
+ rowReadOFF[18] pixRst[49] openDVS_pixel2x2_top_319/GndD DiffBn col_periphery_1x2_24/COL_LINE1
+ GndD VddA18 OnBn openDVS_pixel2x2_top
XopenDVS_pixel2x2_top_301 openDVS_pixel2x2_top_301/vpd[0] openDVS_pixel2x2_top_301/vpd[1]
+ openDVS_pixel2x2_top_301/vpd[3] openDVS_pixel2x2_top_301/vpd[2] rowReadOFF[19] rowReadON[19]
+ rowReadON[18] RefrBp PrBp PrSFBp col_periphery_1x2_13/COL_LINE0 pixRst[26] OffBn
+ rowReadOFF[18] pixRst[27] openDVS_pixel2x2_top_319/GndD DiffBn col_periphery_1x2_13/COL_LINE1
+ GndD VddA18 OnBn openDVS_pixel2x2_top
XopenDVS_pixel2x2_top_345 openDVS_pixel2x2_top_345/vpd[0] openDVS_pixel2x2_top_345/vpd[1]
+ openDVS_pixel2x2_top_345/vpd[3] openDVS_pixel2x2_top_345/vpd[2] rowReadOFF[21] rowReadON[21]
+ rowReadON[20] RefrBp PrBp PrSFBp col_periphery_1x2_25/COL_LINE0 pixRst[50] OffBn
+ rowReadOFF[20] pixRst[51] openDVS_pixel2x2_top_351/GndD DiffBn col_periphery_1x2_25/COL_LINE1
+ GndD VddA18 OnBn openDVS_pixel2x2_top
XopenDVS_pixel2x2_top_334 openDVS_pixel2x2_top_334/vpd[0] openDVS_pixel2x2_top_334/vpd[1]
+ openDVS_pixel2x2_top_334/vpd[3] openDVS_pixel2x2_top_334/vpd[2] rowReadOFF[21] rowReadON[21]
+ rowReadON[20] RefrBp PrBp PrSFBp col_periphery_1x2_14/COL_LINE0 pixRst[28] OffBn
+ rowReadOFF[20] pixRst[29] openDVS_pixel2x2_top_351/GndD DiffBn col_periphery_1x2_14/COL_LINE1
+ GndD VddA18 OnBn openDVS_pixel2x2_top
XopenDVS_pixel2x2_top_323 openDVS_pixel2x2_top_323/vpd[0] openDVS_pixel2x2_top_323/vpd[1]
+ openDVS_pixel2x2_top_323/vpd[3] openDVS_pixel2x2_top_323/vpd[2] rowReadOFF[21] rowReadON[21]
+ rowReadON[20] RefrBp PrBp PrSFBp col_periphery_1x2_3/COL_LINE0 pixRst[6] OffBn rowReadOFF[20]
+ pixRst[7] openDVS_pixel2x2_top_351/GndD DiffBn col_periphery_1x2_3/COL_LINE1 GndD
+ VddA18 OnBn openDVS_pixel2x2_top
XopenDVS_pixel2x2_top_378 openDVS_pixel2x2_top_378/vpd[0] openDVS_pixel2x2_top_378/vpd[1]
+ openDVS_pixel2x2_top_378/vpd[3] openDVS_pixel2x2_top_378/vpd[2] rowReadOFF[23] rowReadON[23]
+ rowReadON[22] RefrBp PrBp PrSFBp col_periphery_1x2_26/COL_LINE0 pixRst[52] OffBn
+ rowReadOFF[22] pixRst[53] openDVS_pixel2x2_top_383/GndD DiffBn col_periphery_1x2_26/COL_LINE1
+ GndD VddA18 OnBn openDVS_pixel2x2_top
XopenDVS_pixel2x2_top_367 openDVS_pixel2x2_top_367/vpd[0] openDVS_pixel2x2_top_367/vpd[1]
+ openDVS_pixel2x2_top_367/vpd[3] openDVS_pixel2x2_top_367/vpd[2] rowReadOFF[23] rowReadON[23]
+ rowReadON[22] RefrBp PrBp PrSFBp col_periphery_1x2_15/COL_LINE0 pixRst[30] OffBn
+ rowReadOFF[22] pixRst[31] openDVS_pixel2x2_top_383/GndD DiffBn col_periphery_1x2_15/COL_LINE1
+ GndD VddA18 OnBn openDVS_pixel2x2_top
XopenDVS_pixel2x2_top_389 openDVS_pixel2x2_top_389/vpd[0] openDVS_pixel2x2_top_389/vpd[1]
+ openDVS_pixel2x2_top_389/vpd[3] openDVS_pixel2x2_top_389/vpd[2] rowReadOFF[25] rowReadON[25]
+ rowReadON[24] RefrBp PrBp PrSFBp col_periphery_1x2_5/COL_LINE0 pixRst[10] OffBn
+ rowReadOFF[24] pixRst[11] openDVS_pixel2x2_top_415/GndD DiffBn col_periphery_1x2_5/COL_LINE1
+ GndD VddA18 OnBn openDVS_pixel2x2_top
XopenDVS_pixel2x2_top_356 openDVS_pixel2x2_top_356/vpd[0] openDVS_pixel2x2_top_356/vpd[1]
+ openDVS_pixel2x2_top_356/vpd[3] openDVS_pixel2x2_top_356/vpd[2] rowReadOFF[23] rowReadON[23]
+ rowReadON[22] RefrBp PrBp PrSFBp col_periphery_1x2_4/COL_LINE0 pixRst[8] OffBn rowReadOFF[22]
+ pixRst[9] openDVS_pixel2x2_top_383/GndD DiffBn col_periphery_1x2_4/COL_LINE1 GndD
+ VddA18 OnBn openDVS_pixel2x2_top
XopenDVS_pixel2x2_top_890 openDVS_pixel2x2_top_890/vpd[0] openDVS_pixel2x2_top_890/vpd[1]
+ openDVS_pixel2x2_top_890/vpd[3] openDVS_pixel2x2_top_890/vpd[2] rowReadOFF[55] rowReadON[55]
+ rowReadON[54] RefrBp PrBp PrSFBp col_periphery_1x2_26/COL_LINE0 pixRst[52] OffBn
+ rowReadOFF[54] pixRst[53] openDVS_pixel2x2_top_895/GndD DiffBn col_periphery_1x2_26/COL_LINE1
+ GndD VddA18 OnBn openDVS_pixel2x2_top
XopenDVS_pixel2x2_top_186 openDVS_pixel2x2_top_186/vpd[0] openDVS_pixel2x2_top_186/vpd[1]
+ openDVS_pixel2x2_top_186/vpd[3] openDVS_pixel2x2_top_186/vpd[2] rowReadOFF[11] rowReadON[11]
+ rowReadON[10] RefrBp PrBp PrSFBp col_periphery_1x2_26/COL_LINE0 pixRst[52] OffBn
+ rowReadOFF[10] pixRst[53] openDVS_pixel2x2_top_191/GndD DiffBn col_periphery_1x2_26/COL_LINE1
+ GndD VddA18 OnBn openDVS_pixel2x2_top
XopenDVS_pixel2x2_top_153 openDVS_pixel2x2_top_153/vpd[0] openDVS_pixel2x2_top_153/vpd[1]
+ openDVS_pixel2x2_top_153/vpd[3] openDVS_pixel2x2_top_153/vpd[2] rowReadOFF[9] rowReadON[9]
+ rowReadON[8] RefrBp PrBp PrSFBp col_periphery_1x2_25/COL_LINE0 pixRst[50] OffBn
+ rowReadOFF[8] pixRst[51] openDVS_pixel2x2_top_159/GndD DiffBn col_periphery_1x2_25/COL_LINE1
+ GndD VddA18 OnBn openDVS_pixel2x2_top
XopenDVS_pixel2x2_top_120 openDVS_pixel2x2_top_120/vpd[0] openDVS_pixel2x2_top_120/vpd[1]
+ openDVS_pixel2x2_top_120/vpd[3] openDVS_pixel2x2_top_120/vpd[2] rowReadOFF[7] rowReadON[7]
+ rowReadON[6] RefrBp PrBp PrSFBp col_periphery_1x2_24/COL_LINE0 pixRst[48] OffBn
+ rowReadOFF[6] pixRst[49] openDVS_pixel2x2_top_99/GndD DiffBn col_periphery_1x2_24/COL_LINE1
+ GndD VddA18 OnBn openDVS_pixel2x2_top
XopenDVS_pixel2x2_top_175 openDVS_pixel2x2_top_175/vpd[0] openDVS_pixel2x2_top_175/vpd[1]
+ openDVS_pixel2x2_top_175/vpd[3] openDVS_pixel2x2_top_175/vpd[2] rowReadOFF[11] rowReadON[11]
+ rowReadON[10] RefrBp PrBp PrSFBp col_periphery_1x2_15/COL_LINE0 pixRst[30] OffBn
+ rowReadOFF[10] pixRst[31] openDVS_pixel2x2_top_191/GndD DiffBn col_periphery_1x2_15/COL_LINE1
+ GndD VddA18 OnBn openDVS_pixel2x2_top
XopenDVS_pixel2x2_top_142 openDVS_pixel2x2_top_142/vpd[0] openDVS_pixel2x2_top_142/vpd[1]
+ openDVS_pixel2x2_top_142/vpd[3] openDVS_pixel2x2_top_142/vpd[2] rowReadOFF[9] rowReadON[9]
+ rowReadON[8] RefrBp PrBp PrSFBp col_periphery_1x2_14/COL_LINE0 pixRst[28] OffBn
+ rowReadOFF[8] pixRst[29] openDVS_pixel2x2_top_159/GndD DiffBn col_periphery_1x2_14/COL_LINE1
+ GndD VddA18 OnBn openDVS_pixel2x2_top
XopenDVS_pixel2x2_top_164 openDVS_pixel2x2_top_164/vpd[0] openDVS_pixel2x2_top_164/vpd[1]
+ openDVS_pixel2x2_top_164/vpd[3] openDVS_pixel2x2_top_164/vpd[2] rowReadOFF[11] rowReadON[11]
+ rowReadON[10] RefrBp PrBp PrSFBp col_periphery_1x2_4/COL_LINE0 pixRst[8] OffBn rowReadOFF[10]
+ pixRst[9] openDVS_pixel2x2_top_191/GndD DiffBn col_periphery_1x2_4/COL_LINE1 GndD
+ VddA18 OnBn openDVS_pixel2x2_top
XopenDVS_pixel2x2_top_131 openDVS_pixel2x2_top_131/vpd[0] openDVS_pixel2x2_top_131/vpd[1]
+ openDVS_pixel2x2_top_131/vpd[3] openDVS_pixel2x2_top_131/vpd[2] rowReadOFF[9] rowReadON[9]
+ rowReadON[8] RefrBp PrBp PrSFBp col_periphery_1x2_3/COL_LINE0 pixRst[6] OffBn rowReadOFF[8]
+ pixRst[7] openDVS_pixel2x2_top_159/GndD DiffBn col_periphery_1x2_3/COL_LINE1 GndD
+ VddA18 OnBn openDVS_pixel2x2_top
XopenDVS_pixel2x2_top_197 openDVS_pixel2x2_top_197/vpd[0] openDVS_pixel2x2_top_197/vpd[1]
+ openDVS_pixel2x2_top_197/vpd[3] openDVS_pixel2x2_top_197/vpd[2] rowReadOFF[13] rowReadON[13]
+ rowReadON[12] RefrBp PrBp PrSFBp col_periphery_1x2_5/COL_LINE0 pixRst[10] OffBn
+ rowReadOFF[12] pixRst[11] openDVS_pixel2x2_top_223/GndD DiffBn col_periphery_1x2_5/COL_LINE1
+ GndD VddA18 OnBn openDVS_pixel2x2_top
XopenDVS_pixel2x2_top_26 openDVS_pixel2x2_top_26/vpd[0] openDVS_pixel2x2_top_26/vpd[1]
+ openDVS_pixel2x2_top_26/vpd[3] openDVS_pixel2x2_top_26/vpd[2] rowReadOFF[1] rowReadON[1]
+ rowReadON[0] RefrBp PrBp PrSFBp col_periphery_1x2_26/COL_LINE0 pixRst[52] OffBn
+ rowReadOFF[0] pixRst[53] openDVS_pixel2x2_top_9/GndD DiffBn col_periphery_1x2_26/COL_LINE1
+ GndD VddA18 OnBn openDVS_pixel2x2_top
XopenDVS_pixel2x2_top_15 openDVS_pixel2x2_top_15/vpd[0] openDVS_pixel2x2_top_15/vpd[1]
+ openDVS_pixel2x2_top_15/vpd[3] openDVS_pixel2x2_top_15/vpd[2] rowReadOFF[1] rowReadON[1]
+ rowReadON[0] RefrBp PrBp PrSFBp col_periphery_1x2_15/COL_LINE0 pixRst[30] OffBn
+ rowReadOFF[0] pixRst[31] openDVS_pixel2x2_top_9/GndD DiffBn col_periphery_1x2_15/COL_LINE1
+ GndD VddA18 OnBn openDVS_pixel2x2_top
Xcol_periphery_1x2_6 pixRst[13] col_periphery_1x2_6/COL_LINE0 col_periphery_1x2_6/COL_LINE1
+ nDETECT col_periphery_1x2_9/VDD DETECT VTHRESH voutn[12] GndD NCHARGE voutn[13]
+ pixRst[12] col_periphery_1x2
XopenDVS_pixel2x2_top_59 openDVS_pixel2x2_top_59/vpd[0] openDVS_pixel2x2_top_59/vpd[1]
+ openDVS_pixel2x2_top_59/vpd[3] openDVS_pixel2x2_top_59/vpd[2] rowReadOFF[3] rowReadON[3]
+ rowReadON[2] RefrBp PrBp PrSFBp col_periphery_1x2_27/COL_LINE0 pixRst[54] OffBn
+ rowReadOFF[2] pixRst[55] openDVS_pixel2x2_top_63/GndD DiffBn col_periphery_1x2_27/COL_LINE1
+ GndD VddA18 OnBn openDVS_pixel2x2_top
XopenDVS_pixel2x2_top_48 openDVS_pixel2x2_top_48/vpd[0] openDVS_pixel2x2_top_48/vpd[1]
+ openDVS_pixel2x2_top_48/vpd[3] openDVS_pixel2x2_top_48/vpd[2] rowReadOFF[3] rowReadON[3]
+ rowReadON[2] RefrBp PrBp PrSFBp col_periphery_1x2_16/COL_LINE0 pixRst[32] OffBn
+ rowReadOFF[2] pixRst[33] openDVS_pixel2x2_top_63/GndD DiffBn col_periphery_1x2_16/COL_LINE1
+ GndD VddA18 OnBn openDVS_pixel2x2_top
XopenDVS_pixel2x2_top_37 openDVS_pixel2x2_top_37/vpd[0] openDVS_pixel2x2_top_37/vpd[1]
+ openDVS_pixel2x2_top_37/vpd[3] openDVS_pixel2x2_top_37/vpd[2] rowReadOFF[3] rowReadON[3]
+ rowReadON[2] RefrBp PrBp PrSFBp col_periphery_1x2_5/COL_LINE0 pixRst[10] OffBn rowReadOFF[2]
+ pixRst[11] openDVS_pixel2x2_top_63/GndD DiffBn col_periphery_1x2_5/COL_LINE1 GndD
+ VddA18 OnBn openDVS_pixel2x2_top
XopenDVS_pixel2x2_top_1010 openDVS_pixel2x2_top_1010/vpd[0] openDVS_pixel2x2_top_1010/vpd[1]
+ openDVS_pixel2x2_top_1010/vpd[3] openDVS_pixel2x2_top_1010/vpd[2] rowReadOFF[63]
+ rowReadON[63] rowReadON[62] RefrBp PrBp PrSFBp col_periphery_1x2_18/COL_LINE0 pixRst[36]
+ OffBn rowReadOFF[62] pixRst[37] openDVS_pixel2x2_top_999/GndD DiffBn col_periphery_1x2_18/COL_LINE1
+ GndD VddA18 OnBn openDVS_pixel2x2_top
XopenDVS_pixel2x2_top_1021 openDVS_pixel2x2_top_1021/vpd[0] openDVS_pixel2x2_top_1021/vpd[1]
+ openDVS_pixel2x2_top_1021/vpd[3] openDVS_pixel2x2_top_1021/vpd[2] rowReadOFF[63]
+ rowReadON[63] rowReadON[62] RefrBp PrBp PrSFBp col_periphery_1x2_29/COL_LINE0 pixRst[58]
+ OffBn rowReadOFF[62] pixRst[59] openDVS_pixel2x2_top_999/GndD DiffBn col_periphery_1x2_29/COL_LINE1
+ GndD VddA18 OnBn openDVS_pixel2x2_top
XopenDVS_pixel2x2_top_708 openDVS_pixel2x2_top_708/vpd[0] openDVS_pixel2x2_top_708/vpd[1]
+ openDVS_pixel2x2_top_708/vpd[3] openDVS_pixel2x2_top_708/vpd[2] rowReadOFF[45] rowReadON[45]
+ rowReadON[44] RefrBp PrBp PrSFBp col_periphery_1x2_4/COL_LINE0 pixRst[8] OffBn rowReadOFF[44]
+ pixRst[9] openDVS_pixel2x2_top_735/GndD DiffBn col_periphery_1x2_4/COL_LINE1 GndD
+ VddA18 OnBn openDVS_pixel2x2_top
XopenDVS_pixel2x2_top_719 openDVS_pixel2x2_top_719/vpd[0] openDVS_pixel2x2_top_719/vpd[1]
+ openDVS_pixel2x2_top_719/vpd[3] openDVS_pixel2x2_top_719/vpd[2] rowReadOFF[45] rowReadON[45]
+ rowReadON[44] RefrBp PrBp PrSFBp col_periphery_1x2_15/COL_LINE0 pixRst[30] OffBn
+ rowReadOFF[44] pixRst[31] openDVS_pixel2x2_top_735/GndD DiffBn col_periphery_1x2_15/COL_LINE1
+ GndD VddA18 OnBn openDVS_pixel2x2_top
XopenDVS_pixel2x2_top_505 openDVS_pixel2x2_top_505/vpd[0] openDVS_pixel2x2_top_505/vpd[1]
+ openDVS_pixel2x2_top_505/vpd[3] openDVS_pixel2x2_top_505/vpd[2] rowReadOFF[31] rowReadON[31]
+ rowReadON[30] RefrBp PrBp PrSFBp col_periphery_1x2_25/COL_LINE0 pixRst[50] OffBn
+ rowReadOFF[30] pixRst[51] openDVS_pixel2x2_top_511/GndD DiffBn col_periphery_1x2_25/COL_LINE1
+ GndD VddA18 OnBn openDVS_pixel2x2_top
XopenDVS_pixel2x2_top_538 openDVS_pixel2x2_top_538/vpd[0] openDVS_pixel2x2_top_538/vpd[1]
+ openDVS_pixel2x2_top_538/vpd[3] openDVS_pixel2x2_top_538/vpd[2] rowReadOFF[33] rowReadON[33]
+ rowReadON[32] RefrBp PrBp PrSFBp col_periphery_1x2_26/COL_LINE0 pixRst[52] OffBn
+ rowReadOFF[32] pixRst[53] openDVS_pixel2x2_top_543/GndD DiffBn col_periphery_1x2_26/COL_LINE1
+ GndD VddA18 OnBn openDVS_pixel2x2_top
XopenDVS_pixel2x2_top_527 openDVS_pixel2x2_top_527/vpd[0] openDVS_pixel2x2_top_527/vpd[1]
+ openDVS_pixel2x2_top_527/vpd[3] openDVS_pixel2x2_top_527/vpd[2] rowReadOFF[33] rowReadON[33]
+ rowReadON[32] RefrBp PrBp PrSFBp col_periphery_1x2_15/COL_LINE0 pixRst[30] OffBn
+ rowReadOFF[32] pixRst[31] openDVS_pixel2x2_top_543/GndD DiffBn col_periphery_1x2_15/COL_LINE1
+ GndD VddA18 OnBn openDVS_pixel2x2_top
XopenDVS_pixel2x2_top_549 openDVS_pixel2x2_top_549/vpd[0] openDVS_pixel2x2_top_549/vpd[1]
+ openDVS_pixel2x2_top_549/vpd[3] openDVS_pixel2x2_top_549/vpd[2] rowReadOFF[35] rowReadON[35]
+ rowReadON[34] RefrBp PrBp PrSFBp col_periphery_1x2_5/COL_LINE0 pixRst[10] OffBn
+ rowReadOFF[34] pixRst[11] openDVS_pixel2x2_top_575/GndD DiffBn col_periphery_1x2_5/COL_LINE1
+ GndD VddA18 OnBn openDVS_pixel2x2_top
XopenDVS_pixel2x2_top_516 openDVS_pixel2x2_top_516/vpd[0] openDVS_pixel2x2_top_516/vpd[1]
+ openDVS_pixel2x2_top_516/vpd[3] openDVS_pixel2x2_top_516/vpd[2] rowReadOFF[33] rowReadON[33]
+ rowReadON[32] RefrBp PrBp PrSFBp col_periphery_1x2_4/COL_LINE0 pixRst[8] OffBn rowReadOFF[32]
+ pixRst[9] openDVS_pixel2x2_top_543/GndD DiffBn col_periphery_1x2_4/COL_LINE1 GndD
+ VddA18 OnBn openDVS_pixel2x2_top
XopenDVS_pixel2x2_top_346 openDVS_pixel2x2_top_346/vpd[0] openDVS_pixel2x2_top_346/vpd[1]
+ openDVS_pixel2x2_top_346/vpd[3] openDVS_pixel2x2_top_346/vpd[2] rowReadOFF[21] rowReadON[21]
+ rowReadON[20] RefrBp PrBp PrSFBp col_periphery_1x2_26/COL_LINE0 pixRst[52] OffBn
+ rowReadOFF[20] pixRst[53] openDVS_pixel2x2_top_351/GndD DiffBn col_periphery_1x2_26/COL_LINE1
+ GndD VddA18 OnBn openDVS_pixel2x2_top
XopenDVS_pixel2x2_top_313 openDVS_pixel2x2_top_313/vpd[0] openDVS_pixel2x2_top_313/vpd[1]
+ openDVS_pixel2x2_top_313/vpd[3] openDVS_pixel2x2_top_313/vpd[2] rowReadOFF[19] rowReadON[19]
+ rowReadON[18] RefrBp PrBp PrSFBp col_periphery_1x2_25/COL_LINE0 pixRst[50] OffBn
+ rowReadOFF[18] pixRst[51] openDVS_pixel2x2_top_319/GndD DiffBn col_periphery_1x2_25/COL_LINE1
+ GndD VddA18 OnBn openDVS_pixel2x2_top
XopenDVS_pixel2x2_top_335 openDVS_pixel2x2_top_335/vpd[0] openDVS_pixel2x2_top_335/vpd[1]
+ openDVS_pixel2x2_top_335/vpd[3] openDVS_pixel2x2_top_335/vpd[2] rowReadOFF[21] rowReadON[21]
+ rowReadON[20] RefrBp PrBp PrSFBp col_periphery_1x2_15/COL_LINE0 pixRst[30] OffBn
+ rowReadOFF[20] pixRst[31] openDVS_pixel2x2_top_351/GndD DiffBn col_periphery_1x2_15/COL_LINE1
+ GndD VddA18 OnBn openDVS_pixel2x2_top
XopenDVS_pixel2x2_top_302 openDVS_pixel2x2_top_302/vpd[0] openDVS_pixel2x2_top_302/vpd[1]
+ openDVS_pixel2x2_top_302/vpd[3] openDVS_pixel2x2_top_302/vpd[2] rowReadOFF[19] rowReadON[19]
+ rowReadON[18] RefrBp PrBp PrSFBp col_periphery_1x2_14/COL_LINE0 pixRst[28] OffBn
+ rowReadOFF[18] pixRst[29] openDVS_pixel2x2_top_319/GndD DiffBn col_periphery_1x2_14/COL_LINE1
+ GndD VddA18 OnBn openDVS_pixel2x2_top
XopenDVS_pixel2x2_top_324 openDVS_pixel2x2_top_324/vpd[0] openDVS_pixel2x2_top_324/vpd[1]
+ openDVS_pixel2x2_top_324/vpd[3] openDVS_pixel2x2_top_324/vpd[2] rowReadOFF[21] rowReadON[21]
+ rowReadON[20] RefrBp PrBp PrSFBp col_periphery_1x2_4/COL_LINE0 pixRst[8] OffBn rowReadOFF[20]
+ pixRst[9] openDVS_pixel2x2_top_351/GndD DiffBn col_periphery_1x2_4/COL_LINE1 GndD
+ VddA18 OnBn openDVS_pixel2x2_top
XopenDVS_pixel2x2_top_379 openDVS_pixel2x2_top_379/vpd[0] openDVS_pixel2x2_top_379/vpd[1]
+ openDVS_pixel2x2_top_379/vpd[3] openDVS_pixel2x2_top_379/vpd[2] rowReadOFF[23] rowReadON[23]
+ rowReadON[22] RefrBp PrBp PrSFBp col_periphery_1x2_27/COL_LINE0 pixRst[54] OffBn
+ rowReadOFF[22] pixRst[55] openDVS_pixel2x2_top_383/GndD DiffBn col_periphery_1x2_27/COL_LINE1
+ GndD VddA18 OnBn openDVS_pixel2x2_top
XopenDVS_pixel2x2_top_368 openDVS_pixel2x2_top_368/vpd[0] openDVS_pixel2x2_top_368/vpd[1]
+ openDVS_pixel2x2_top_368/vpd[3] openDVS_pixel2x2_top_368/vpd[2] rowReadOFF[23] rowReadON[23]
+ rowReadON[22] RefrBp PrBp PrSFBp col_periphery_1x2_16/COL_LINE0 pixRst[32] OffBn
+ rowReadOFF[22] pixRst[33] openDVS_pixel2x2_top_383/GndD DiffBn col_periphery_1x2_16/COL_LINE1
+ GndD VddA18 OnBn openDVS_pixel2x2_top
XopenDVS_pixel2x2_top_357 openDVS_pixel2x2_top_357/vpd[0] openDVS_pixel2x2_top_357/vpd[1]
+ openDVS_pixel2x2_top_357/vpd[3] openDVS_pixel2x2_top_357/vpd[2] rowReadOFF[23] rowReadON[23]
+ rowReadON[22] RefrBp PrBp PrSFBp col_periphery_1x2_5/COL_LINE0 pixRst[10] OffBn
+ rowReadOFF[22] pixRst[11] openDVS_pixel2x2_top_383/GndD DiffBn col_periphery_1x2_5/COL_LINE1
+ GndD VddA18 OnBn openDVS_pixel2x2_top
XopenDVS_pixel2x2_top_880 openDVS_pixel2x2_top_880/vpd[0] openDVS_pixel2x2_top_880/vpd[1]
+ openDVS_pixel2x2_top_880/vpd[3] openDVS_pixel2x2_top_880/vpd[2] rowReadOFF[55] rowReadON[55]
+ rowReadON[54] RefrBp PrBp PrSFBp col_periphery_1x2_16/COL_LINE0 pixRst[32] OffBn
+ rowReadOFF[54] pixRst[33] openDVS_pixel2x2_top_895/GndD DiffBn col_periphery_1x2_16/COL_LINE1
+ GndD VddA18 OnBn openDVS_pixel2x2_top
XopenDVS_pixel2x2_top_891 openDVS_pixel2x2_top_891/vpd[0] openDVS_pixel2x2_top_891/vpd[1]
+ openDVS_pixel2x2_top_891/vpd[3] openDVS_pixel2x2_top_891/vpd[2] rowReadOFF[55] rowReadON[55]
+ rowReadON[54] RefrBp PrBp PrSFBp col_periphery_1x2_27/COL_LINE0 pixRst[54] OffBn
+ rowReadOFF[54] pixRst[55] openDVS_pixel2x2_top_895/GndD DiffBn col_periphery_1x2_27/COL_LINE1
+ GndD VddA18 OnBn openDVS_pixel2x2_top
XopenDVS_pixel2x2_top_187 openDVS_pixel2x2_top_187/vpd[0] openDVS_pixel2x2_top_187/vpd[1]
+ openDVS_pixel2x2_top_187/vpd[3] openDVS_pixel2x2_top_187/vpd[2] rowReadOFF[11] rowReadON[11]
+ rowReadON[10] RefrBp PrBp PrSFBp col_periphery_1x2_27/COL_LINE0 pixRst[54] OffBn
+ rowReadOFF[10] pixRst[55] openDVS_pixel2x2_top_191/GndD DiffBn col_periphery_1x2_27/COL_LINE1
+ GndD VddA18 OnBn openDVS_pixel2x2_top
XopenDVS_pixel2x2_top_154 openDVS_pixel2x2_top_154/vpd[0] openDVS_pixel2x2_top_154/vpd[1]
+ openDVS_pixel2x2_top_154/vpd[3] openDVS_pixel2x2_top_154/vpd[2] rowReadOFF[9] rowReadON[9]
+ rowReadON[8] RefrBp PrBp PrSFBp col_periphery_1x2_26/COL_LINE0 pixRst[52] OffBn
+ rowReadOFF[8] pixRst[53] openDVS_pixel2x2_top_159/GndD DiffBn col_periphery_1x2_26/COL_LINE1
+ GndD VddA18 OnBn openDVS_pixel2x2_top
XopenDVS_pixel2x2_top_121 openDVS_pixel2x2_top_121/vpd[0] openDVS_pixel2x2_top_121/vpd[1]
+ openDVS_pixel2x2_top_121/vpd[3] openDVS_pixel2x2_top_121/vpd[2] rowReadOFF[7] rowReadON[7]
+ rowReadON[6] RefrBp PrBp PrSFBp col_periphery_1x2_25/COL_LINE0 pixRst[50] OffBn
+ rowReadOFF[6] pixRst[51] openDVS_pixel2x2_top_99/GndD DiffBn col_periphery_1x2_25/COL_LINE1
+ GndD VddA18 OnBn openDVS_pixel2x2_top
XopenDVS_pixel2x2_top_176 openDVS_pixel2x2_top_176/vpd[0] openDVS_pixel2x2_top_176/vpd[1]
+ openDVS_pixel2x2_top_176/vpd[3] openDVS_pixel2x2_top_176/vpd[2] rowReadOFF[11] rowReadON[11]
+ rowReadON[10] RefrBp PrBp PrSFBp col_periphery_1x2_16/COL_LINE0 pixRst[32] OffBn
+ rowReadOFF[10] pixRst[33] openDVS_pixel2x2_top_191/GndD DiffBn col_periphery_1x2_16/COL_LINE1
+ GndD VddA18 OnBn openDVS_pixel2x2_top
XopenDVS_pixel2x2_top_143 openDVS_pixel2x2_top_143/vpd[0] openDVS_pixel2x2_top_143/vpd[1]
+ openDVS_pixel2x2_top_143/vpd[3] openDVS_pixel2x2_top_143/vpd[2] rowReadOFF[9] rowReadON[9]
+ rowReadON[8] RefrBp PrBp PrSFBp col_periphery_1x2_15/COL_LINE0 pixRst[30] OffBn
+ rowReadOFF[8] pixRst[31] openDVS_pixel2x2_top_159/GndD DiffBn col_periphery_1x2_15/COL_LINE1
+ GndD VddA18 OnBn openDVS_pixel2x2_top
XopenDVS_pixel2x2_top_110 openDVS_pixel2x2_top_110/vpd[0] openDVS_pixel2x2_top_110/vpd[1]
+ openDVS_pixel2x2_top_110/vpd[3] openDVS_pixel2x2_top_110/vpd[2] rowReadOFF[7] rowReadON[7]
+ rowReadON[6] RefrBp PrBp PrSFBp col_periphery_1x2_14/COL_LINE0 pixRst[28] OffBn
+ rowReadOFF[6] pixRst[29] openDVS_pixel2x2_top_99/GndD DiffBn col_periphery_1x2_14/COL_LINE1
+ GndD VddA18 OnBn openDVS_pixel2x2_top
XopenDVS_pixel2x2_top_165 openDVS_pixel2x2_top_165/vpd[0] openDVS_pixel2x2_top_165/vpd[1]
+ openDVS_pixel2x2_top_165/vpd[3] openDVS_pixel2x2_top_165/vpd[2] rowReadOFF[11] rowReadON[11]
+ rowReadON[10] RefrBp PrBp PrSFBp col_periphery_1x2_5/COL_LINE0 pixRst[10] OffBn
+ rowReadOFF[10] pixRst[11] openDVS_pixel2x2_top_191/GndD DiffBn col_periphery_1x2_5/COL_LINE1
+ GndD VddA18 OnBn openDVS_pixel2x2_top
XopenDVS_pixel2x2_top_132 openDVS_pixel2x2_top_132/vpd[0] openDVS_pixel2x2_top_132/vpd[1]
+ openDVS_pixel2x2_top_132/vpd[3] openDVS_pixel2x2_top_132/vpd[2] rowReadOFF[9] rowReadON[9]
+ rowReadON[8] RefrBp PrBp PrSFBp col_periphery_1x2_4/COL_LINE0 pixRst[8] OffBn rowReadOFF[8]
+ pixRst[9] openDVS_pixel2x2_top_159/GndD DiffBn col_periphery_1x2_4/COL_LINE1 GndD
+ VddA18 OnBn openDVS_pixel2x2_top
XopenDVS_pixel2x2_top_198 openDVS_pixel2x2_top_198/vpd[0] openDVS_pixel2x2_top_198/vpd[1]
+ openDVS_pixel2x2_top_198/vpd[3] openDVS_pixel2x2_top_198/vpd[2] rowReadOFF[13] rowReadON[13]
+ rowReadON[12] RefrBp PrBp PrSFBp col_periphery_1x2_6/COL_LINE0 pixRst[12] OffBn
+ rowReadOFF[12] pixRst[13] openDVS_pixel2x2_top_223/GndD DiffBn col_periphery_1x2_6/COL_LINE1
+ GndD VddA18 OnBn openDVS_pixel2x2_top
XopenDVS_pixel2x2_top_27 openDVS_pixel2x2_top_27/vpd[0] openDVS_pixel2x2_top_27/vpd[1]
+ openDVS_pixel2x2_top_27/vpd[3] openDVS_pixel2x2_top_27/vpd[2] rowReadOFF[1] rowReadON[1]
+ rowReadON[0] RefrBp PrBp PrSFBp col_periphery_1x2_27/COL_LINE0 pixRst[54] OffBn
+ rowReadOFF[0] pixRst[55] openDVS_pixel2x2_top_9/GndD DiffBn col_periphery_1x2_27/COL_LINE1
+ GndD VddA18 OnBn openDVS_pixel2x2_top
XopenDVS_pixel2x2_top_16 openDVS_pixel2x2_top_16/vpd[0] openDVS_pixel2x2_top_16/vpd[1]
+ openDVS_pixel2x2_top_16/vpd[3] openDVS_pixel2x2_top_16/vpd[2] rowReadOFF[1] rowReadON[1]
+ rowReadON[0] RefrBp PrBp PrSFBp col_periphery_1x2_16/COL_LINE0 pixRst[32] OffBn
+ rowReadOFF[0] pixRst[33] openDVS_pixel2x2_top_9/GndD DiffBn col_periphery_1x2_16/COL_LINE1
+ GndD VddA18 OnBn openDVS_pixel2x2_top
Xcol_periphery_1x2_7 pixRst[15] col_periphery_1x2_7/COL_LINE0 col_periphery_1x2_7/COL_LINE1
+ nDETECT col_periphery_1x2_9/VDD DETECT VTHRESH voutn[14] GndD NCHARGE voutn[15]
+ pixRst[14] col_periphery_1x2
XopenDVS_pixel2x2_top_49 openDVS_pixel2x2_top_49/vpd[0] openDVS_pixel2x2_top_49/vpd[1]
+ openDVS_pixel2x2_top_49/vpd[3] openDVS_pixel2x2_top_49/vpd[2] rowReadOFF[3] rowReadON[3]
+ rowReadON[2] RefrBp PrBp PrSFBp col_periphery_1x2_17/COL_LINE0 pixRst[34] OffBn
+ rowReadOFF[2] pixRst[35] openDVS_pixel2x2_top_63/GndD DiffBn col_periphery_1x2_17/COL_LINE1
+ GndD VddA18 OnBn openDVS_pixel2x2_top
XopenDVS_pixel2x2_top_38 openDVS_pixel2x2_top_38/vpd[0] openDVS_pixel2x2_top_38/vpd[1]
+ openDVS_pixel2x2_top_38/vpd[3] openDVS_pixel2x2_top_38/vpd[2] rowReadOFF[3] rowReadON[3]
+ rowReadON[2] RefrBp PrBp PrSFBp col_periphery_1x2_6/COL_LINE0 pixRst[12] OffBn rowReadOFF[2]
+ pixRst[13] openDVS_pixel2x2_top_63/GndD DiffBn col_periphery_1x2_6/COL_LINE1 GndD
+ VddA18 OnBn openDVS_pixel2x2_top
XopenDVS_pixel2x2_top_1000 openDVS_pixel2x2_top_1000/vpd[0] openDVS_pixel2x2_top_1000/vpd[1]
+ openDVS_pixel2x2_top_1000/vpd[3] openDVS_pixel2x2_top_1000/vpd[2] rowReadOFF[63]
+ rowReadON[63] rowReadON[62] RefrBp PrBp PrSFBp col_periphery_1x2_8/COL_LINE0 pixRst[16]
+ OffBn rowReadOFF[62] pixRst[17] openDVS_pixel2x2_top_999/GndD DiffBn col_periphery_1x2_8/COL_LINE1
+ GndD VddA18 OnBn openDVS_pixel2x2_top
XopenDVS_pixel2x2_top_1011 openDVS_pixel2x2_top_1011/vpd[0] openDVS_pixel2x2_top_1011/vpd[1]
+ openDVS_pixel2x2_top_1011/vpd[3] openDVS_pixel2x2_top_1011/vpd[2] rowReadOFF[63]
+ rowReadON[63] rowReadON[62] RefrBp PrBp PrSFBp col_periphery_1x2_19/COL_LINE0 pixRst[38]
+ OffBn rowReadOFF[62] pixRst[39] openDVS_pixel2x2_top_999/GndD DiffBn col_periphery_1x2_19/COL_LINE1
+ GndD VddA18 OnBn openDVS_pixel2x2_top
XopenDVS_pixel2x2_top_1022 openDVS_pixel2x2_top_1022/vpd[0] openDVS_pixel2x2_top_1022/vpd[1]
+ openDVS_pixel2x2_top_1022/vpd[3] openDVS_pixel2x2_top_1022/vpd[2] rowReadOFF[63]
+ rowReadON[63] rowReadON[62] RefrBp PrBp PrSFBp col_periphery_1x2_30/COL_LINE0 pixRst[60]
+ OffBn rowReadOFF[62] pixRst[61] openDVS_pixel2x2_top_999/GndD DiffBn col_periphery_1x2_30/COL_LINE1
+ GndD VddA18 OnBn openDVS_pixel2x2_top
XopenDVS_pixel2x2_top_709 openDVS_pixel2x2_top_709/vpd[0] openDVS_pixel2x2_top_709/vpd[1]
+ openDVS_pixel2x2_top_709/vpd[3] openDVS_pixel2x2_top_709/vpd[2] rowReadOFF[45] rowReadON[45]
+ rowReadON[44] RefrBp PrBp PrSFBp col_periphery_1x2_5/COL_LINE0 pixRst[10] OffBn
+ rowReadOFF[44] pixRst[11] openDVS_pixel2x2_top_735/GndD DiffBn col_periphery_1x2_5/COL_LINE1
+ GndD VddA18 OnBn openDVS_pixel2x2_top
XopenDVS_pixel2x2_top_506 openDVS_pixel2x2_top_506/vpd[0] openDVS_pixel2x2_top_506/vpd[1]
+ openDVS_pixel2x2_top_506/vpd[3] openDVS_pixel2x2_top_506/vpd[2] rowReadOFF[31] rowReadON[31]
+ rowReadON[30] RefrBp PrBp PrSFBp col_periphery_1x2_26/COL_LINE0 pixRst[52] OffBn
+ rowReadOFF[30] pixRst[53] openDVS_pixel2x2_top_511/GndD DiffBn col_periphery_1x2_26/COL_LINE1
+ GndD VddA18 OnBn openDVS_pixel2x2_top
XopenDVS_pixel2x2_top_539 openDVS_pixel2x2_top_539/vpd[0] openDVS_pixel2x2_top_539/vpd[1]
+ openDVS_pixel2x2_top_539/vpd[3] openDVS_pixel2x2_top_539/vpd[2] rowReadOFF[33] rowReadON[33]
+ rowReadON[32] RefrBp PrBp PrSFBp col_periphery_1x2_27/COL_LINE0 pixRst[54] OffBn
+ rowReadOFF[32] pixRst[55] openDVS_pixel2x2_top_543/GndD DiffBn col_periphery_1x2_27/COL_LINE1
+ GndD VddA18 OnBn openDVS_pixel2x2_top
XopenDVS_pixel2x2_top_528 openDVS_pixel2x2_top_528/vpd[0] openDVS_pixel2x2_top_528/vpd[1]
+ openDVS_pixel2x2_top_528/vpd[3] openDVS_pixel2x2_top_528/vpd[2] rowReadOFF[33] rowReadON[33]
+ rowReadON[32] RefrBp PrBp PrSFBp col_periphery_1x2_16/COL_LINE0 pixRst[32] OffBn
+ rowReadOFF[32] pixRst[33] openDVS_pixel2x2_top_543/GndD DiffBn col_periphery_1x2_16/COL_LINE1
+ GndD VddA18 OnBn openDVS_pixel2x2_top
XopenDVS_pixel2x2_top_517 openDVS_pixel2x2_top_517/vpd[0] openDVS_pixel2x2_top_517/vpd[1]
+ openDVS_pixel2x2_top_517/vpd[3] openDVS_pixel2x2_top_517/vpd[2] rowReadOFF[33] rowReadON[33]
+ rowReadON[32] RefrBp PrBp PrSFBp col_periphery_1x2_5/COL_LINE0 pixRst[10] OffBn
+ rowReadOFF[32] pixRst[11] openDVS_pixel2x2_top_543/GndD DiffBn col_periphery_1x2_5/COL_LINE1
+ GndD VddA18 OnBn openDVS_pixel2x2_top
XopenDVS_pixel2x2_top_347 openDVS_pixel2x2_top_347/vpd[0] openDVS_pixel2x2_top_347/vpd[1]
+ openDVS_pixel2x2_top_347/vpd[3] openDVS_pixel2x2_top_347/vpd[2] rowReadOFF[21] rowReadON[21]
+ rowReadON[20] RefrBp PrBp PrSFBp col_periphery_1x2_27/COL_LINE0 pixRst[54] OffBn
+ rowReadOFF[20] pixRst[55] openDVS_pixel2x2_top_351/GndD DiffBn col_periphery_1x2_27/COL_LINE1
+ GndD VddA18 OnBn openDVS_pixel2x2_top
XopenDVS_pixel2x2_top_314 openDVS_pixel2x2_top_314/vpd[0] openDVS_pixel2x2_top_314/vpd[1]
+ openDVS_pixel2x2_top_314/vpd[3] openDVS_pixel2x2_top_314/vpd[2] rowReadOFF[19] rowReadON[19]
+ rowReadON[18] RefrBp PrBp PrSFBp col_periphery_1x2_26/COL_LINE0 pixRst[52] OffBn
+ rowReadOFF[18] pixRst[53] openDVS_pixel2x2_top_319/GndD DiffBn col_periphery_1x2_26/COL_LINE1
+ GndD VddA18 OnBn openDVS_pixel2x2_top
XopenDVS_pixel2x2_top_336 openDVS_pixel2x2_top_336/vpd[0] openDVS_pixel2x2_top_336/vpd[1]
+ openDVS_pixel2x2_top_336/vpd[3] openDVS_pixel2x2_top_336/vpd[2] rowReadOFF[21] rowReadON[21]
+ rowReadON[20] RefrBp PrBp PrSFBp col_periphery_1x2_16/COL_LINE0 pixRst[32] OffBn
+ rowReadOFF[20] pixRst[33] openDVS_pixel2x2_top_351/GndD DiffBn col_periphery_1x2_16/COL_LINE1
+ GndD VddA18 OnBn openDVS_pixel2x2_top
XopenDVS_pixel2x2_top_303 openDVS_pixel2x2_top_303/vpd[0] openDVS_pixel2x2_top_303/vpd[1]
+ openDVS_pixel2x2_top_303/vpd[3] openDVS_pixel2x2_top_303/vpd[2] rowReadOFF[19] rowReadON[19]
+ rowReadON[18] RefrBp PrBp PrSFBp col_periphery_1x2_15/COL_LINE0 pixRst[30] OffBn
+ rowReadOFF[18] pixRst[31] openDVS_pixel2x2_top_319/GndD DiffBn col_periphery_1x2_15/COL_LINE1
+ GndD VddA18 OnBn openDVS_pixel2x2_top
XopenDVS_pixel2x2_top_325 openDVS_pixel2x2_top_325/vpd[0] openDVS_pixel2x2_top_325/vpd[1]
+ openDVS_pixel2x2_top_325/vpd[3] openDVS_pixel2x2_top_325/vpd[2] rowReadOFF[21] rowReadON[21]
+ rowReadON[20] RefrBp PrBp PrSFBp col_periphery_1x2_5/COL_LINE0 pixRst[10] OffBn
+ rowReadOFF[20] pixRst[11] openDVS_pixel2x2_top_351/GndD DiffBn col_periphery_1x2_5/COL_LINE1
+ GndD VddA18 OnBn openDVS_pixel2x2_top
XopenDVS_pixel2x2_top_369 openDVS_pixel2x2_top_369/vpd[0] openDVS_pixel2x2_top_369/vpd[1]
+ openDVS_pixel2x2_top_369/vpd[3] openDVS_pixel2x2_top_369/vpd[2] rowReadOFF[23] rowReadON[23]
+ rowReadON[22] RefrBp PrBp PrSFBp col_periphery_1x2_17/COL_LINE0 pixRst[34] OffBn
+ rowReadOFF[22] pixRst[35] openDVS_pixel2x2_top_383/GndD DiffBn col_periphery_1x2_17/COL_LINE1
+ GndD VddA18 OnBn openDVS_pixel2x2_top
XopenDVS_pixel2x2_top_358 openDVS_pixel2x2_top_358/vpd[0] openDVS_pixel2x2_top_358/vpd[1]
+ openDVS_pixel2x2_top_358/vpd[3] openDVS_pixel2x2_top_358/vpd[2] rowReadOFF[23] rowReadON[23]
+ rowReadON[22] RefrBp PrBp PrSFBp col_periphery_1x2_6/COL_LINE0 pixRst[12] OffBn
+ rowReadOFF[22] pixRst[13] openDVS_pixel2x2_top_383/GndD DiffBn col_periphery_1x2_6/COL_LINE1
+ GndD VddA18 OnBn openDVS_pixel2x2_top
XopenDVS_pixel2x2_top_870 openDVS_pixel2x2_top_870/vpd[0] openDVS_pixel2x2_top_870/vpd[1]
+ openDVS_pixel2x2_top_870/vpd[3] openDVS_pixel2x2_top_870/vpd[2] rowReadOFF[55] rowReadON[55]
+ rowReadON[54] RefrBp PrBp PrSFBp col_periphery_1x2_6/COL_LINE0 pixRst[12] OffBn
+ rowReadOFF[54] pixRst[13] openDVS_pixel2x2_top_895/GndD DiffBn col_periphery_1x2_6/COL_LINE1
+ GndD VddA18 OnBn openDVS_pixel2x2_top
XopenDVS_pixel2x2_top_881 openDVS_pixel2x2_top_881/vpd[0] openDVS_pixel2x2_top_881/vpd[1]
+ openDVS_pixel2x2_top_881/vpd[3] openDVS_pixel2x2_top_881/vpd[2] rowReadOFF[55] rowReadON[55]
+ rowReadON[54] RefrBp PrBp PrSFBp col_periphery_1x2_17/COL_LINE0 pixRst[34] OffBn
+ rowReadOFF[54] pixRst[35] openDVS_pixel2x2_top_895/GndD DiffBn col_periphery_1x2_17/COL_LINE1
+ GndD VddA18 OnBn openDVS_pixel2x2_top
XopenDVS_pixel2x2_top_892 openDVS_pixel2x2_top_892/vpd[0] openDVS_pixel2x2_top_892/vpd[1]
+ openDVS_pixel2x2_top_892/vpd[3] openDVS_pixel2x2_top_892/vpd[2] rowReadOFF[55] rowReadON[55]
+ rowReadON[54] RefrBp PrBp PrSFBp col_periphery_1x2_28/COL_LINE0 pixRst[56] OffBn
+ rowReadOFF[54] pixRst[57] openDVS_pixel2x2_top_895/GndD DiffBn col_periphery_1x2_28/COL_LINE1
+ GndD VddA18 OnBn openDVS_pixel2x2_top
XopenDVS_pixel2x2_top_155 openDVS_pixel2x2_top_155/vpd[0] openDVS_pixel2x2_top_155/vpd[1]
+ openDVS_pixel2x2_top_155/vpd[3] openDVS_pixel2x2_top_155/vpd[2] rowReadOFF[9] rowReadON[9]
+ rowReadON[8] RefrBp PrBp PrSFBp col_periphery_1x2_27/COL_LINE0 pixRst[54] OffBn
+ rowReadOFF[8] pixRst[55] openDVS_pixel2x2_top_159/GndD DiffBn col_periphery_1x2_27/COL_LINE1
+ GndD VddA18 OnBn openDVS_pixel2x2_top
XopenDVS_pixel2x2_top_188 openDVS_pixel2x2_top_188/vpd[0] openDVS_pixel2x2_top_188/vpd[1]
+ openDVS_pixel2x2_top_188/vpd[3] openDVS_pixel2x2_top_188/vpd[2] rowReadOFF[11] rowReadON[11]
+ rowReadON[10] RefrBp PrBp PrSFBp col_periphery_1x2_28/COL_LINE0 pixRst[56] OffBn
+ rowReadOFF[10] pixRst[57] openDVS_pixel2x2_top_191/GndD DiffBn col_periphery_1x2_28/COL_LINE1
+ GndD VddA18 OnBn openDVS_pixel2x2_top
XopenDVS_pixel2x2_top_122 openDVS_pixel2x2_top_122/vpd[0] openDVS_pixel2x2_top_122/vpd[1]
+ openDVS_pixel2x2_top_122/vpd[3] openDVS_pixel2x2_top_122/vpd[2] rowReadOFF[7] rowReadON[7]
+ rowReadON[6] RefrBp PrBp PrSFBp col_periphery_1x2_26/COL_LINE0 pixRst[52] OffBn
+ rowReadOFF[6] pixRst[53] openDVS_pixel2x2_top_99/GndD DiffBn col_periphery_1x2_26/COL_LINE1
+ GndD VddA18 OnBn openDVS_pixel2x2_top
XopenDVS_pixel2x2_top_144 openDVS_pixel2x2_top_144/vpd[0] openDVS_pixel2x2_top_144/vpd[1]
+ openDVS_pixel2x2_top_144/vpd[3] openDVS_pixel2x2_top_144/vpd[2] rowReadOFF[9] rowReadON[9]
+ rowReadON[8] RefrBp PrBp PrSFBp col_periphery_1x2_16/COL_LINE0 pixRst[32] OffBn
+ rowReadOFF[8] pixRst[33] openDVS_pixel2x2_top_159/GndD DiffBn col_periphery_1x2_16/COL_LINE1
+ GndD VddA18 OnBn openDVS_pixel2x2_top
XopenDVS_pixel2x2_top_177 openDVS_pixel2x2_top_177/vpd[0] openDVS_pixel2x2_top_177/vpd[1]
+ openDVS_pixel2x2_top_177/vpd[3] openDVS_pixel2x2_top_177/vpd[2] rowReadOFF[11] rowReadON[11]
+ rowReadON[10] RefrBp PrBp PrSFBp col_periphery_1x2_17/COL_LINE0 pixRst[34] OffBn
+ rowReadOFF[10] pixRst[35] openDVS_pixel2x2_top_191/GndD DiffBn col_periphery_1x2_17/COL_LINE1
+ GndD VddA18 OnBn openDVS_pixel2x2_top
XopenDVS_pixel2x2_top_111 openDVS_pixel2x2_top_111/vpd[0] openDVS_pixel2x2_top_111/vpd[1]
+ openDVS_pixel2x2_top_111/vpd[3] openDVS_pixel2x2_top_111/vpd[2] rowReadOFF[7] rowReadON[7]
+ rowReadON[6] RefrBp PrBp PrSFBp col_periphery_1x2_15/COL_LINE0 pixRst[30] OffBn
+ rowReadOFF[6] pixRst[31] openDVS_pixel2x2_top_99/GndD DiffBn col_periphery_1x2_15/COL_LINE1
+ GndD VddA18 OnBn openDVS_pixel2x2_top
XopenDVS_pixel2x2_top_133 openDVS_pixel2x2_top_133/vpd[0] openDVS_pixel2x2_top_133/vpd[1]
+ openDVS_pixel2x2_top_133/vpd[3] openDVS_pixel2x2_top_133/vpd[2] rowReadOFF[9] rowReadON[9]
+ rowReadON[8] RefrBp PrBp PrSFBp col_periphery_1x2_5/COL_LINE0 pixRst[10] OffBn rowReadOFF[8]
+ pixRst[11] openDVS_pixel2x2_top_159/GndD DiffBn col_periphery_1x2_5/COL_LINE1 GndD
+ VddA18 OnBn openDVS_pixel2x2_top
XopenDVS_pixel2x2_top_166 openDVS_pixel2x2_top_166/vpd[0] openDVS_pixel2x2_top_166/vpd[1]
+ openDVS_pixel2x2_top_166/vpd[3] openDVS_pixel2x2_top_166/vpd[2] rowReadOFF[11] rowReadON[11]
+ rowReadON[10] RefrBp PrBp PrSFBp col_periphery_1x2_6/COL_LINE0 pixRst[12] OffBn
+ rowReadOFF[10] pixRst[13] openDVS_pixel2x2_top_191/GndD DiffBn col_periphery_1x2_6/COL_LINE1
+ GndD VddA18 OnBn openDVS_pixel2x2_top
XopenDVS_pixel2x2_top_100 openDVS_pixel2x2_top_100/vpd[0] openDVS_pixel2x2_top_100/vpd[1]
+ openDVS_pixel2x2_top_100/vpd[3] openDVS_pixel2x2_top_100/vpd[2] rowReadOFF[7] rowReadON[7]
+ rowReadON[6] RefrBp PrBp PrSFBp col_periphery_1x2_4/COL_LINE0 pixRst[8] OffBn rowReadOFF[6]
+ pixRst[9] openDVS_pixel2x2_top_99/GndD DiffBn col_periphery_1x2_4/COL_LINE1 GndD
+ VddA18 OnBn openDVS_pixel2x2_top
XopenDVS_pixel2x2_top_199 openDVS_pixel2x2_top_199/vpd[0] openDVS_pixel2x2_top_199/vpd[1]
+ openDVS_pixel2x2_top_199/vpd[3] openDVS_pixel2x2_top_199/vpd[2] rowReadOFF[13] rowReadON[13]
+ rowReadON[12] RefrBp PrBp PrSFBp col_periphery_1x2_7/COL_LINE0 pixRst[14] OffBn
+ rowReadOFF[12] pixRst[15] openDVS_pixel2x2_top_223/GndD DiffBn col_periphery_1x2_7/COL_LINE1
+ GndD VddA18 OnBn openDVS_pixel2x2_top
XopenDVS_pixel2x2_top_28 openDVS_pixel2x2_top_28/vpd[0] openDVS_pixel2x2_top_28/vpd[1]
+ openDVS_pixel2x2_top_28/vpd[3] openDVS_pixel2x2_top_28/vpd[2] rowReadOFF[1] rowReadON[1]
+ rowReadON[0] RefrBp PrBp PrSFBp col_periphery_1x2_28/COL_LINE0 pixRst[56] OffBn
+ rowReadOFF[0] pixRst[57] openDVS_pixel2x2_top_9/GndD DiffBn col_periphery_1x2_28/COL_LINE1
+ GndD VddA18 OnBn openDVS_pixel2x2_top
XopenDVS_pixel2x2_top_17 openDVS_pixel2x2_top_17/vpd[0] openDVS_pixel2x2_top_17/vpd[1]
+ openDVS_pixel2x2_top_17/vpd[3] openDVS_pixel2x2_top_17/vpd[2] rowReadOFF[1] rowReadON[1]
+ rowReadON[0] RefrBp PrBp PrSFBp col_periphery_1x2_17/COL_LINE0 pixRst[34] OffBn
+ rowReadOFF[0] pixRst[35] openDVS_pixel2x2_top_9/GndD DiffBn col_periphery_1x2_17/COL_LINE1
+ GndD VddA18 OnBn openDVS_pixel2x2_top
Xcol_periphery_1x2_8 pixRst[17] col_periphery_1x2_8/COL_LINE0 col_periphery_1x2_8/COL_LINE1
+ nDETECT col_periphery_1x2_9/VDD DETECT VTHRESH voutn[16] GndD NCHARGE voutn[17]
+ pixRst[16] col_periphery_1x2
XopenDVS_pixel2x2_top_39 openDVS_pixel2x2_top_39/vpd[0] openDVS_pixel2x2_top_39/vpd[1]
+ openDVS_pixel2x2_top_39/vpd[3] openDVS_pixel2x2_top_39/vpd[2] rowReadOFF[3] rowReadON[3]
+ rowReadON[2] RefrBp PrBp PrSFBp col_periphery_1x2_7/COL_LINE0 pixRst[14] OffBn rowReadOFF[2]
+ pixRst[15] openDVS_pixel2x2_top_63/GndD DiffBn col_periphery_1x2_7/COL_LINE1 GndD
+ VddA18 OnBn openDVS_pixel2x2_top
XopenDVS_pixel2x2_top_1001 openDVS_pixel2x2_top_1001/vpd[0] openDVS_pixel2x2_top_1001/vpd[1]
+ openDVS_pixel2x2_top_1001/vpd[3] openDVS_pixel2x2_top_1001/vpd[2] rowReadOFF[63]
+ rowReadON[63] rowReadON[62] RefrBp PrBp PrSFBp col_periphery_1x2_9/COL_LINE0 pixRst[18]
+ OffBn rowReadOFF[62] pixRst[19] openDVS_pixel2x2_top_999/GndD DiffBn col_periphery_1x2_9/COL_LINE1
+ GndD VddA18 OnBn openDVS_pixel2x2_top
XopenDVS_pixel2x2_top_1012 openDVS_pixel2x2_top_1012/vpd[0] openDVS_pixel2x2_top_1012/vpd[1]
+ openDVS_pixel2x2_top_1012/vpd[3] openDVS_pixel2x2_top_1012/vpd[2] rowReadOFF[63]
+ rowReadON[63] rowReadON[62] RefrBp PrBp PrSFBp col_periphery_1x2_20/COL_LINE0 pixRst[40]
+ OffBn rowReadOFF[62] pixRst[41] openDVS_pixel2x2_top_999/GndD DiffBn col_periphery_1x2_20/COL_LINE1
+ GndD VddA18 OnBn openDVS_pixel2x2_top
XopenDVS_pixel2x2_top_1023 openDVS_pixel2x2_top_1023/vpd[0] openDVS_pixel2x2_top_1023/vpd[1]
+ openDVS_pixel2x2_top_1023/vpd[3] openDVS_pixel2x2_top_1023/vpd[2] rowReadOFF[63]
+ rowReadON[63] rowReadON[62] RefrBp PrBp PrSFBp col_periphery_1x2_31/COL_LINE0 pixRst[62]
+ OffBn rowReadOFF[62] pixRst[63] openDVS_pixel2x2_top_999/GndD DiffBn col_periphery_1x2_31/COL_LINE1
+ GndD VddA18 OnBn openDVS_pixel2x2_top
XopenDVS_pixel2x2_top_507 openDVS_pixel2x2_top_507/vpd[0] openDVS_pixel2x2_top_507/vpd[1]
+ openDVS_pixel2x2_top_507/vpd[3] openDVS_pixel2x2_top_507/vpd[2] rowReadOFF[31] rowReadON[31]
+ rowReadON[30] RefrBp PrBp PrSFBp col_periphery_1x2_27/COL_LINE0 pixRst[54] OffBn
+ rowReadOFF[30] pixRst[55] openDVS_pixel2x2_top_511/GndD DiffBn col_periphery_1x2_27/COL_LINE1
+ GndD VddA18 OnBn openDVS_pixel2x2_top
XopenDVS_pixel2x2_top_529 openDVS_pixel2x2_top_529/vpd[0] openDVS_pixel2x2_top_529/vpd[1]
+ openDVS_pixel2x2_top_529/vpd[3] openDVS_pixel2x2_top_529/vpd[2] rowReadOFF[33] rowReadON[33]
+ rowReadON[32] RefrBp PrBp PrSFBp col_periphery_1x2_17/COL_LINE0 pixRst[34] OffBn
+ rowReadOFF[32] pixRst[35] openDVS_pixel2x2_top_543/GndD DiffBn col_periphery_1x2_17/COL_LINE1
+ GndD VddA18 OnBn openDVS_pixel2x2_top
XopenDVS_pixel2x2_top_518 openDVS_pixel2x2_top_518/vpd[0] openDVS_pixel2x2_top_518/vpd[1]
+ openDVS_pixel2x2_top_518/vpd[3] openDVS_pixel2x2_top_518/vpd[2] rowReadOFF[33] rowReadON[33]
+ rowReadON[32] RefrBp PrBp PrSFBp col_periphery_1x2_6/COL_LINE0 pixRst[12] OffBn
+ rowReadOFF[32] pixRst[13] openDVS_pixel2x2_top_543/GndD DiffBn col_periphery_1x2_6/COL_LINE1
+ GndD VddA18 OnBn openDVS_pixel2x2_top
XopenDVS_pixel2x2_top_315 openDVS_pixel2x2_top_315/vpd[0] openDVS_pixel2x2_top_315/vpd[1]
+ openDVS_pixel2x2_top_315/vpd[3] openDVS_pixel2x2_top_315/vpd[2] rowReadOFF[19] rowReadON[19]
+ rowReadON[18] RefrBp PrBp PrSFBp col_periphery_1x2_27/COL_LINE0 pixRst[54] OffBn
+ rowReadOFF[18] pixRst[55] openDVS_pixel2x2_top_319/GndD DiffBn col_periphery_1x2_27/COL_LINE1
+ GndD VddA18 OnBn openDVS_pixel2x2_top
XopenDVS_pixel2x2_top_348 openDVS_pixel2x2_top_348/vpd[0] openDVS_pixel2x2_top_348/vpd[1]
+ openDVS_pixel2x2_top_348/vpd[3] openDVS_pixel2x2_top_348/vpd[2] rowReadOFF[21] rowReadON[21]
+ rowReadON[20] RefrBp PrBp PrSFBp col_periphery_1x2_28/COL_LINE0 pixRst[56] OffBn
+ rowReadOFF[20] pixRst[57] openDVS_pixel2x2_top_351/GndD DiffBn col_periphery_1x2_28/COL_LINE1
+ GndD VddA18 OnBn openDVS_pixel2x2_top
XopenDVS_pixel2x2_top_304 openDVS_pixel2x2_top_304/vpd[0] openDVS_pixel2x2_top_304/vpd[1]
+ openDVS_pixel2x2_top_304/vpd[3] openDVS_pixel2x2_top_304/vpd[2] rowReadOFF[19] rowReadON[19]
+ rowReadON[18] RefrBp PrBp PrSFBp col_periphery_1x2_16/COL_LINE0 pixRst[32] OffBn
+ rowReadOFF[18] pixRst[33] openDVS_pixel2x2_top_319/GndD DiffBn col_periphery_1x2_16/COL_LINE1
+ GndD VddA18 OnBn openDVS_pixel2x2_top
XopenDVS_pixel2x2_top_337 openDVS_pixel2x2_top_337/vpd[0] openDVS_pixel2x2_top_337/vpd[1]
+ openDVS_pixel2x2_top_337/vpd[3] openDVS_pixel2x2_top_337/vpd[2] rowReadOFF[21] rowReadON[21]
+ rowReadON[20] RefrBp PrBp PrSFBp col_periphery_1x2_17/COL_LINE0 pixRst[34] OffBn
+ rowReadOFF[20] pixRst[35] openDVS_pixel2x2_top_351/GndD DiffBn col_periphery_1x2_17/COL_LINE1
+ GndD VddA18 OnBn openDVS_pixel2x2_top
XopenDVS_pixel2x2_top_326 openDVS_pixel2x2_top_326/vpd[0] openDVS_pixel2x2_top_326/vpd[1]
+ openDVS_pixel2x2_top_326/vpd[3] openDVS_pixel2x2_top_326/vpd[2] rowReadOFF[21] rowReadON[21]
+ rowReadON[20] RefrBp PrBp PrSFBp col_periphery_1x2_6/COL_LINE0 pixRst[12] OffBn
+ rowReadOFF[20] pixRst[13] openDVS_pixel2x2_top_351/GndD DiffBn col_periphery_1x2_6/COL_LINE1
+ GndD VddA18 OnBn openDVS_pixel2x2_top
XopenDVS_pixel2x2_top_359 openDVS_pixel2x2_top_359/vpd[0] openDVS_pixel2x2_top_359/vpd[1]
+ openDVS_pixel2x2_top_359/vpd[3] openDVS_pixel2x2_top_359/vpd[2] rowReadOFF[23] rowReadON[23]
+ rowReadON[22] RefrBp PrBp PrSFBp col_periphery_1x2_7/COL_LINE0 pixRst[14] OffBn
+ rowReadOFF[22] pixRst[15] openDVS_pixel2x2_top_383/GndD DiffBn col_periphery_1x2_7/COL_LINE1
+ GndD VddA18 OnBn openDVS_pixel2x2_top
XopenDVS_pixel2x2_top_871 openDVS_pixel2x2_top_871/vpd[0] openDVS_pixel2x2_top_871/vpd[1]
+ openDVS_pixel2x2_top_871/vpd[3] openDVS_pixel2x2_top_871/vpd[2] rowReadOFF[55] rowReadON[55]
+ rowReadON[54] RefrBp PrBp PrSFBp col_periphery_1x2_7/COL_LINE0 pixRst[14] OffBn
+ rowReadOFF[54] pixRst[15] openDVS_pixel2x2_top_895/GndD DiffBn col_periphery_1x2_7/COL_LINE1
+ GndD VddA18 OnBn openDVS_pixel2x2_top
XopenDVS_pixel2x2_top_882 openDVS_pixel2x2_top_882/vpd[0] openDVS_pixel2x2_top_882/vpd[1]
+ openDVS_pixel2x2_top_882/vpd[3] openDVS_pixel2x2_top_882/vpd[2] rowReadOFF[55] rowReadON[55]
+ rowReadON[54] RefrBp PrBp PrSFBp col_periphery_1x2_18/COL_LINE0 pixRst[36] OffBn
+ rowReadOFF[54] pixRst[37] openDVS_pixel2x2_top_895/GndD DiffBn col_periphery_1x2_18/COL_LINE1
+ GndD VddA18 OnBn openDVS_pixel2x2_top
XopenDVS_pixel2x2_top_860 openDVS_pixel2x2_top_860/vpd[0] openDVS_pixel2x2_top_860/vpd[1]
+ openDVS_pixel2x2_top_860/vpd[3] openDVS_pixel2x2_top_860/vpd[2] rowReadOFF[53] rowReadON[53]
+ rowReadON[52] RefrBp PrBp PrSFBp col_periphery_1x2_28/COL_LINE0 pixRst[56] OffBn
+ rowReadOFF[52] pixRst[57] openDVS_pixel2x2_top_863/GndD DiffBn col_periphery_1x2_28/COL_LINE1
+ GndD VddA18 OnBn openDVS_pixel2x2_top
XopenDVS_pixel2x2_top_893 openDVS_pixel2x2_top_893/vpd[0] openDVS_pixel2x2_top_893/vpd[1]
+ openDVS_pixel2x2_top_893/vpd[3] openDVS_pixel2x2_top_893/vpd[2] rowReadOFF[55] rowReadON[55]
+ rowReadON[54] RefrBp PrBp PrSFBp col_periphery_1x2_29/COL_LINE0 pixRst[58] OffBn
+ rowReadOFF[54] pixRst[59] openDVS_pixel2x2_top_895/GndD DiffBn col_periphery_1x2_29/COL_LINE1
+ GndD VddA18 OnBn openDVS_pixel2x2_top
XopenDVS_pixel2x2_top_189 openDVS_pixel2x2_top_189/vpd[0] openDVS_pixel2x2_top_189/vpd[1]
+ openDVS_pixel2x2_top_189/vpd[3] openDVS_pixel2x2_top_189/vpd[2] rowReadOFF[11] rowReadON[11]
+ rowReadON[10] RefrBp PrBp PrSFBp col_periphery_1x2_29/COL_LINE0 pixRst[58] OffBn
+ rowReadOFF[10] pixRst[59] openDVS_pixel2x2_top_191/GndD DiffBn col_periphery_1x2_29/COL_LINE1
+ GndD VddA18 OnBn openDVS_pixel2x2_top
XopenDVS_pixel2x2_top_123 openDVS_pixel2x2_top_123/vpd[0] openDVS_pixel2x2_top_123/vpd[1]
+ openDVS_pixel2x2_top_123/vpd[3] openDVS_pixel2x2_top_123/vpd[2] rowReadOFF[7] rowReadON[7]
+ rowReadON[6] RefrBp PrBp PrSFBp col_periphery_1x2_27/COL_LINE0 pixRst[54] OffBn
+ rowReadOFF[6] pixRst[55] openDVS_pixel2x2_top_99/GndD DiffBn col_periphery_1x2_27/COL_LINE1
+ GndD VddA18 OnBn openDVS_pixel2x2_top
XopenDVS_pixel2x2_top_156 openDVS_pixel2x2_top_156/vpd[0] openDVS_pixel2x2_top_156/vpd[1]
+ openDVS_pixel2x2_top_156/vpd[3] openDVS_pixel2x2_top_156/vpd[2] rowReadOFF[9] rowReadON[9]
+ rowReadON[8] RefrBp PrBp PrSFBp col_periphery_1x2_28/COL_LINE0 pixRst[56] OffBn
+ rowReadOFF[8] pixRst[57] openDVS_pixel2x2_top_159/GndD DiffBn col_periphery_1x2_28/COL_LINE1
+ GndD VddA18 OnBn openDVS_pixel2x2_top
XopenDVS_pixel2x2_top_178 openDVS_pixel2x2_top_178/vpd[0] openDVS_pixel2x2_top_178/vpd[1]
+ openDVS_pixel2x2_top_178/vpd[3] openDVS_pixel2x2_top_178/vpd[2] rowReadOFF[11] rowReadON[11]
+ rowReadON[10] RefrBp PrBp PrSFBp col_periphery_1x2_18/COL_LINE0 pixRst[36] OffBn
+ rowReadOFF[10] pixRst[37] openDVS_pixel2x2_top_191/GndD DiffBn col_periphery_1x2_18/COL_LINE1
+ GndD VddA18 OnBn openDVS_pixel2x2_top
XopenDVS_pixel2x2_top_112 openDVS_pixel2x2_top_112/vpd[0] openDVS_pixel2x2_top_112/vpd[1]
+ openDVS_pixel2x2_top_112/vpd[3] openDVS_pixel2x2_top_112/vpd[2] rowReadOFF[7] rowReadON[7]
+ rowReadON[6] RefrBp PrBp PrSFBp col_periphery_1x2_16/COL_LINE0 pixRst[32] OffBn
+ rowReadOFF[6] pixRst[33] openDVS_pixel2x2_top_99/GndD DiffBn col_periphery_1x2_16/COL_LINE1
+ GndD VddA18 OnBn openDVS_pixel2x2_top
XopenDVS_pixel2x2_top_145 openDVS_pixel2x2_top_145/vpd[0] openDVS_pixel2x2_top_145/vpd[1]
+ openDVS_pixel2x2_top_145/vpd[3] openDVS_pixel2x2_top_145/vpd[2] rowReadOFF[9] rowReadON[9]
+ rowReadON[8] RefrBp PrBp PrSFBp col_periphery_1x2_17/COL_LINE0 pixRst[34] OffBn
+ rowReadOFF[8] pixRst[35] openDVS_pixel2x2_top_159/GndD DiffBn col_periphery_1x2_17/COL_LINE1
+ GndD VddA18 OnBn openDVS_pixel2x2_top
XopenDVS_pixel2x2_top_167 openDVS_pixel2x2_top_167/vpd[0] openDVS_pixel2x2_top_167/vpd[1]
+ openDVS_pixel2x2_top_167/vpd[3] openDVS_pixel2x2_top_167/vpd[2] rowReadOFF[11] rowReadON[11]
+ rowReadON[10] RefrBp PrBp PrSFBp col_periphery_1x2_7/COL_LINE0 pixRst[14] OffBn
+ rowReadOFF[10] pixRst[15] openDVS_pixel2x2_top_191/GndD DiffBn col_periphery_1x2_7/COL_LINE1
+ GndD VddA18 OnBn openDVS_pixel2x2_top
XopenDVS_pixel2x2_top_101 openDVS_pixel2x2_top_101/vpd[0] openDVS_pixel2x2_top_101/vpd[1]
+ openDVS_pixel2x2_top_101/vpd[3] openDVS_pixel2x2_top_101/vpd[2] rowReadOFF[7] rowReadON[7]
+ rowReadON[6] RefrBp PrBp PrSFBp col_periphery_1x2_5/COL_LINE0 pixRst[10] OffBn rowReadOFF[6]
+ pixRst[11] openDVS_pixel2x2_top_99/GndD DiffBn col_periphery_1x2_5/COL_LINE1 GndD
+ VddA18 OnBn openDVS_pixel2x2_top
XopenDVS_pixel2x2_top_134 openDVS_pixel2x2_top_134/vpd[0] openDVS_pixel2x2_top_134/vpd[1]
+ openDVS_pixel2x2_top_134/vpd[3] openDVS_pixel2x2_top_134/vpd[2] rowReadOFF[9] rowReadON[9]
+ rowReadON[8] RefrBp PrBp PrSFBp col_periphery_1x2_6/COL_LINE0 pixRst[12] OffBn rowReadOFF[8]
+ pixRst[13] openDVS_pixel2x2_top_159/GndD DiffBn col_periphery_1x2_6/COL_LINE1 GndD
+ VddA18 OnBn openDVS_pixel2x2_top
XopenDVS_pixel2x2_top_29 openDVS_pixel2x2_top_29/vpd[0] openDVS_pixel2x2_top_29/vpd[1]
+ openDVS_pixel2x2_top_29/vpd[3] openDVS_pixel2x2_top_29/vpd[2] rowReadOFF[1] rowReadON[1]
+ rowReadON[0] RefrBp PrBp PrSFBp col_periphery_1x2_29/COL_LINE0 pixRst[58] OffBn
+ rowReadOFF[0] pixRst[59] openDVS_pixel2x2_top_9/GndD DiffBn col_periphery_1x2_29/COL_LINE1
+ GndD VddA18 OnBn openDVS_pixel2x2_top
XopenDVS_pixel2x2_top_18 openDVS_pixel2x2_top_18/vpd[0] openDVS_pixel2x2_top_18/vpd[1]
+ openDVS_pixel2x2_top_18/vpd[3] openDVS_pixel2x2_top_18/vpd[2] rowReadOFF[1] rowReadON[1]
+ rowReadON[0] RefrBp PrBp PrSFBp col_periphery_1x2_18/COL_LINE0 pixRst[36] OffBn
+ rowReadOFF[0] pixRst[37] openDVS_pixel2x2_top_9/GndD DiffBn col_periphery_1x2_18/COL_LINE1
+ GndD VddA18 OnBn openDVS_pixel2x2_top
Xcol_periphery_1x2_9 pixRst[19] col_periphery_1x2_9/COL_LINE0 col_periphery_1x2_9/COL_LINE1
+ nDETECT col_periphery_1x2_9/VDD DETECT VTHRESH voutn[18] GndD NCHARGE voutn[19]
+ pixRst[18] col_periphery_1x2
XopenDVS_pixel2x2_top_1002 openDVS_pixel2x2_top_1002/vpd[0] openDVS_pixel2x2_top_1002/vpd[1]
+ openDVS_pixel2x2_top_1002/vpd[3] openDVS_pixel2x2_top_1002/vpd[2] rowReadOFF[63]
+ rowReadON[63] rowReadON[62] RefrBp PrBp PrSFBp col_periphery_1x2_10/COL_LINE0 pixRst[20]
+ OffBn rowReadOFF[62] pixRst[21] openDVS_pixel2x2_top_999/GndD DiffBn col_periphery_1x2_10/COL_LINE1
+ GndD VddA18 OnBn openDVS_pixel2x2_top
XopenDVS_pixel2x2_top_1013 openDVS_pixel2x2_top_1013/vpd[0] openDVS_pixel2x2_top_1013/vpd[1]
+ openDVS_pixel2x2_top_1013/vpd[3] openDVS_pixel2x2_top_1013/vpd[2] rowReadOFF[63]
+ rowReadON[63] rowReadON[62] RefrBp PrBp PrSFBp col_periphery_1x2_21/COL_LINE0 pixRst[42]
+ OffBn rowReadOFF[62] pixRst[43] openDVS_pixel2x2_top_999/GndD DiffBn col_periphery_1x2_21/COL_LINE1
+ GndD VddA18 OnBn openDVS_pixel2x2_top
XopenDVS_pixel2x2_top_690 openDVS_pixel2x2_top_690/vpd[0] openDVS_pixel2x2_top_690/vpd[1]
+ openDVS_pixel2x2_top_690/vpd[3] openDVS_pixel2x2_top_690/vpd[2] rowReadOFF[43] rowReadON[43]
+ rowReadON[42] RefrBp PrBp PrSFBp col_periphery_1x2_18/COL_LINE0 pixRst[36] OffBn
+ rowReadOFF[42] pixRst[37] openDVS_pixel2x2_top_703/GndD DiffBn col_periphery_1x2_18/COL_LINE1
+ GndD VddA18 OnBn openDVS_pixel2x2_top
XopenDVS_pixel2x2_top_508 openDVS_pixel2x2_top_508/vpd[0] openDVS_pixel2x2_top_508/vpd[1]
+ openDVS_pixel2x2_top_508/vpd[3] openDVS_pixel2x2_top_508/vpd[2] rowReadOFF[31] rowReadON[31]
+ rowReadON[30] RefrBp PrBp PrSFBp col_periphery_1x2_28/COL_LINE0 pixRst[56] OffBn
+ rowReadOFF[30] pixRst[57] openDVS_pixel2x2_top_511/GndD DiffBn col_periphery_1x2_28/COL_LINE1
+ GndD VddA18 OnBn openDVS_pixel2x2_top
XopenDVS_pixel2x2_top_519 openDVS_pixel2x2_top_519/vpd[0] openDVS_pixel2x2_top_519/vpd[1]
+ openDVS_pixel2x2_top_519/vpd[3] openDVS_pixel2x2_top_519/vpd[2] rowReadOFF[33] rowReadON[33]
+ rowReadON[32] RefrBp PrBp PrSFBp col_periphery_1x2_7/COL_LINE0 pixRst[14] OffBn
+ rowReadOFF[32] pixRst[15] openDVS_pixel2x2_top_543/GndD DiffBn col_periphery_1x2_7/COL_LINE1
+ GndD VddA18 OnBn openDVS_pixel2x2_top
XopenDVS_pixel2x2_top_349 openDVS_pixel2x2_top_349/vpd[0] openDVS_pixel2x2_top_349/vpd[1]
+ openDVS_pixel2x2_top_349/vpd[3] openDVS_pixel2x2_top_349/vpd[2] rowReadOFF[21] rowReadON[21]
+ rowReadON[20] RefrBp PrBp PrSFBp col_periphery_1x2_29/COL_LINE0 pixRst[58] OffBn
+ rowReadOFF[20] pixRst[59] openDVS_pixel2x2_top_351/GndD DiffBn col_periphery_1x2_29/COL_LINE1
+ GndD VddA18 OnBn openDVS_pixel2x2_top
XopenDVS_pixel2x2_top_316 openDVS_pixel2x2_top_316/vpd[0] openDVS_pixel2x2_top_316/vpd[1]
+ openDVS_pixel2x2_top_316/vpd[3] openDVS_pixel2x2_top_316/vpd[2] rowReadOFF[19] rowReadON[19]
+ rowReadON[18] RefrBp PrBp PrSFBp col_periphery_1x2_28/COL_LINE0 pixRst[56] OffBn
+ rowReadOFF[18] pixRst[57] openDVS_pixel2x2_top_319/GndD DiffBn col_periphery_1x2_28/COL_LINE1
+ GndD VddA18 OnBn openDVS_pixel2x2_top
XopenDVS_pixel2x2_top_338 openDVS_pixel2x2_top_338/vpd[0] openDVS_pixel2x2_top_338/vpd[1]
+ openDVS_pixel2x2_top_338/vpd[3] openDVS_pixel2x2_top_338/vpd[2] rowReadOFF[21] rowReadON[21]
+ rowReadON[20] RefrBp PrBp PrSFBp col_periphery_1x2_18/COL_LINE0 pixRst[36] OffBn
+ rowReadOFF[20] pixRst[37] openDVS_pixel2x2_top_351/GndD DiffBn col_periphery_1x2_18/COL_LINE1
+ GndD VddA18 OnBn openDVS_pixel2x2_top
XopenDVS_pixel2x2_top_305 openDVS_pixel2x2_top_305/vpd[0] openDVS_pixel2x2_top_305/vpd[1]
+ openDVS_pixel2x2_top_305/vpd[3] openDVS_pixel2x2_top_305/vpd[2] rowReadOFF[19] rowReadON[19]
+ rowReadON[18] RefrBp PrBp PrSFBp col_periphery_1x2_17/COL_LINE0 pixRst[34] OffBn
+ rowReadOFF[18] pixRst[35] openDVS_pixel2x2_top_319/GndD DiffBn col_periphery_1x2_17/COL_LINE1
+ GndD VddA18 OnBn openDVS_pixel2x2_top
XopenDVS_pixel2x2_top_327 openDVS_pixel2x2_top_327/vpd[0] openDVS_pixel2x2_top_327/vpd[1]
+ openDVS_pixel2x2_top_327/vpd[3] openDVS_pixel2x2_top_327/vpd[2] rowReadOFF[21] rowReadON[21]
+ rowReadON[20] RefrBp PrBp PrSFBp col_periphery_1x2_7/COL_LINE0 pixRst[14] OffBn
+ rowReadOFF[20] pixRst[15] openDVS_pixel2x2_top_351/GndD DiffBn col_periphery_1x2_7/COL_LINE1
+ GndD VddA18 OnBn openDVS_pixel2x2_top
XopenDVS_pixel2x2_top_872 openDVS_pixel2x2_top_872/vpd[0] openDVS_pixel2x2_top_872/vpd[1]
+ openDVS_pixel2x2_top_872/vpd[3] openDVS_pixel2x2_top_872/vpd[2] rowReadOFF[55] rowReadON[55]
+ rowReadON[54] RefrBp PrBp PrSFBp col_periphery_1x2_8/COL_LINE0 pixRst[16] OffBn
+ rowReadOFF[54] pixRst[17] openDVS_pixel2x2_top_895/GndD DiffBn col_periphery_1x2_8/COL_LINE1
+ GndD VddA18 OnBn openDVS_pixel2x2_top
XopenDVS_pixel2x2_top_850 openDVS_pixel2x2_top_850/vpd[0] openDVS_pixel2x2_top_850/vpd[1]
+ openDVS_pixel2x2_top_850/vpd[3] openDVS_pixel2x2_top_850/vpd[2] rowReadOFF[53] rowReadON[53]
+ rowReadON[52] RefrBp PrBp PrSFBp col_periphery_1x2_18/COL_LINE0 pixRst[36] OffBn
+ rowReadOFF[52] pixRst[37] openDVS_pixel2x2_top_863/GndD DiffBn col_periphery_1x2_18/COL_LINE1
+ GndD VddA18 OnBn openDVS_pixel2x2_top
XopenDVS_pixel2x2_top_883 openDVS_pixel2x2_top_883/vpd[0] openDVS_pixel2x2_top_883/vpd[1]
+ openDVS_pixel2x2_top_883/vpd[3] openDVS_pixel2x2_top_883/vpd[2] rowReadOFF[55] rowReadON[55]
+ rowReadON[54] RefrBp PrBp PrSFBp col_periphery_1x2_19/COL_LINE0 pixRst[38] OffBn
+ rowReadOFF[54] pixRst[39] openDVS_pixel2x2_top_895/GndD DiffBn col_periphery_1x2_19/COL_LINE1
+ GndD VddA18 OnBn openDVS_pixel2x2_top
XopenDVS_pixel2x2_top_861 openDVS_pixel2x2_top_861/vpd[0] openDVS_pixel2x2_top_861/vpd[1]
+ openDVS_pixel2x2_top_861/vpd[3] openDVS_pixel2x2_top_861/vpd[2] rowReadOFF[53] rowReadON[53]
+ rowReadON[52] RefrBp PrBp PrSFBp col_periphery_1x2_29/COL_LINE0 pixRst[58] OffBn
+ rowReadOFF[52] pixRst[59] openDVS_pixel2x2_top_863/GndD DiffBn col_periphery_1x2_29/COL_LINE1
+ GndD VddA18 OnBn openDVS_pixel2x2_top
XopenDVS_pixel2x2_top_894 openDVS_pixel2x2_top_894/vpd[0] openDVS_pixel2x2_top_894/vpd[1]
+ openDVS_pixel2x2_top_894/vpd[3] openDVS_pixel2x2_top_894/vpd[2] rowReadOFF[55] rowReadON[55]
+ rowReadON[54] RefrBp PrBp PrSFBp col_periphery_1x2_30/COL_LINE0 pixRst[60] OffBn
+ rowReadOFF[54] pixRst[61] openDVS_pixel2x2_top_895/GndD DiffBn col_periphery_1x2_30/COL_LINE1
+ GndD VddA18 OnBn openDVS_pixel2x2_top
XopenDVS_pixel2x2_top_157 openDVS_pixel2x2_top_157/vpd[0] openDVS_pixel2x2_top_157/vpd[1]
+ openDVS_pixel2x2_top_157/vpd[3] openDVS_pixel2x2_top_157/vpd[2] rowReadOFF[9] rowReadON[9]
+ rowReadON[8] RefrBp PrBp PrSFBp col_periphery_1x2_29/COL_LINE0 pixRst[58] OffBn
+ rowReadOFF[8] pixRst[59] openDVS_pixel2x2_top_159/GndD DiffBn col_periphery_1x2_29/COL_LINE1
+ GndD VddA18 OnBn openDVS_pixel2x2_top
XopenDVS_pixel2x2_top_124 openDVS_pixel2x2_top_124/vpd[0] openDVS_pixel2x2_top_124/vpd[1]
+ openDVS_pixel2x2_top_124/vpd[3] openDVS_pixel2x2_top_124/vpd[2] rowReadOFF[7] rowReadON[7]
+ rowReadON[6] RefrBp PrBp PrSFBp col_periphery_1x2_28/COL_LINE0 pixRst[56] OffBn
+ rowReadOFF[6] pixRst[57] openDVS_pixel2x2_top_99/GndD DiffBn col_periphery_1x2_28/COL_LINE1
+ GndD VddA18 OnBn openDVS_pixel2x2_top
XopenDVS_pixel2x2_top_179 openDVS_pixel2x2_top_179/vpd[0] openDVS_pixel2x2_top_179/vpd[1]
+ openDVS_pixel2x2_top_179/vpd[3] openDVS_pixel2x2_top_179/vpd[2] rowReadOFF[11] rowReadON[11]
+ rowReadON[10] RefrBp PrBp PrSFBp col_periphery_1x2_19/COL_LINE0 pixRst[38] OffBn
+ rowReadOFF[10] pixRst[39] openDVS_pixel2x2_top_191/GndD DiffBn col_periphery_1x2_19/COL_LINE1
+ GndD VddA18 OnBn openDVS_pixel2x2_top
XopenDVS_pixel2x2_top_146 openDVS_pixel2x2_top_146/vpd[0] openDVS_pixel2x2_top_146/vpd[1]
+ openDVS_pixel2x2_top_146/vpd[3] openDVS_pixel2x2_top_146/vpd[2] rowReadOFF[9] rowReadON[9]
+ rowReadON[8] RefrBp PrBp PrSFBp col_periphery_1x2_18/COL_LINE0 pixRst[36] OffBn
+ rowReadOFF[8] pixRst[37] openDVS_pixel2x2_top_159/GndD DiffBn col_periphery_1x2_18/COL_LINE1
+ GndD VddA18 OnBn openDVS_pixel2x2_top
XopenDVS_pixel2x2_top_113 openDVS_pixel2x2_top_113/vpd[0] openDVS_pixel2x2_top_113/vpd[1]
+ openDVS_pixel2x2_top_113/vpd[3] openDVS_pixel2x2_top_113/vpd[2] rowReadOFF[7] rowReadON[7]
+ rowReadON[6] RefrBp PrBp PrSFBp col_periphery_1x2_17/COL_LINE0 pixRst[34] OffBn
+ rowReadOFF[6] pixRst[35] openDVS_pixel2x2_top_99/GndD DiffBn col_periphery_1x2_17/COL_LINE1
+ GndD VddA18 OnBn openDVS_pixel2x2_top
XopenDVS_pixel2x2_top_168 openDVS_pixel2x2_top_168/vpd[0] openDVS_pixel2x2_top_168/vpd[1]
+ openDVS_pixel2x2_top_168/vpd[3] openDVS_pixel2x2_top_168/vpd[2] rowReadOFF[11] rowReadON[11]
+ rowReadON[10] RefrBp PrBp PrSFBp col_periphery_1x2_8/COL_LINE0 pixRst[16] OffBn
+ rowReadOFF[10] pixRst[17] openDVS_pixel2x2_top_191/GndD DiffBn col_periphery_1x2_8/COL_LINE1
+ GndD VddA18 OnBn openDVS_pixel2x2_top
XopenDVS_pixel2x2_top_135 openDVS_pixel2x2_top_135/vpd[0] openDVS_pixel2x2_top_135/vpd[1]
+ openDVS_pixel2x2_top_135/vpd[3] openDVS_pixel2x2_top_135/vpd[2] rowReadOFF[9] rowReadON[9]
+ rowReadON[8] RefrBp PrBp PrSFBp col_periphery_1x2_7/COL_LINE0 pixRst[14] OffBn rowReadOFF[8]
+ pixRst[15] openDVS_pixel2x2_top_159/GndD DiffBn col_periphery_1x2_7/COL_LINE1 GndD
+ VddA18 OnBn openDVS_pixel2x2_top
XopenDVS_pixel2x2_top_102 openDVS_pixel2x2_top_102/vpd[0] openDVS_pixel2x2_top_102/vpd[1]
+ openDVS_pixel2x2_top_102/vpd[3] openDVS_pixel2x2_top_102/vpd[2] rowReadOFF[7] rowReadON[7]
+ rowReadON[6] RefrBp PrBp PrSFBp col_periphery_1x2_6/COL_LINE0 pixRst[12] OffBn rowReadOFF[6]
+ pixRst[13] openDVS_pixel2x2_top_99/GndD DiffBn col_periphery_1x2_6/COL_LINE1 GndD
+ VddA18 OnBn openDVS_pixel2x2_top
XopenDVS_pixel2x2_top_19 openDVS_pixel2x2_top_19/vpd[0] openDVS_pixel2x2_top_19/vpd[1]
+ openDVS_pixel2x2_top_19/vpd[3] openDVS_pixel2x2_top_19/vpd[2] rowReadOFF[1] rowReadON[1]
+ rowReadON[0] RefrBp PrBp PrSFBp col_periphery_1x2_19/COL_LINE0 pixRst[38] OffBn
+ rowReadOFF[0] pixRst[39] openDVS_pixel2x2_top_9/GndD DiffBn col_periphery_1x2_19/COL_LINE1
+ GndD VddA18 OnBn openDVS_pixel2x2_top
XopenDVS_pixel2x2_top_1003 openDVS_pixel2x2_top_1003/vpd[0] openDVS_pixel2x2_top_1003/vpd[1]
+ openDVS_pixel2x2_top_1003/vpd[3] openDVS_pixel2x2_top_1003/vpd[2] rowReadOFF[63]
+ rowReadON[63] rowReadON[62] RefrBp PrBp PrSFBp col_periphery_1x2_11/COL_LINE0 pixRst[22]
+ OffBn rowReadOFF[62] pixRst[23] openDVS_pixel2x2_top_999/GndD DiffBn col_periphery_1x2_11/COL_LINE1
+ GndD VddA18 OnBn openDVS_pixel2x2_top
XopenDVS_pixel2x2_top_1014 openDVS_pixel2x2_top_1014/vpd[0] openDVS_pixel2x2_top_1014/vpd[1]
+ openDVS_pixel2x2_top_1014/vpd[3] openDVS_pixel2x2_top_1014/vpd[2] rowReadOFF[63]
+ rowReadON[63] rowReadON[62] RefrBp PrBp PrSFBp col_periphery_1x2_22/COL_LINE0 pixRst[44]
+ OffBn rowReadOFF[62] pixRst[45] openDVS_pixel2x2_top_999/GndD DiffBn col_periphery_1x2_22/COL_LINE1
+ GndD VddA18 OnBn openDVS_pixel2x2_top
XopenDVS_pixel2x2_top_680 openDVS_pixel2x2_top_680/vpd[0] openDVS_pixel2x2_top_680/vpd[1]
+ openDVS_pixel2x2_top_680/vpd[3] openDVS_pixel2x2_top_680/vpd[2] rowReadOFF[43] rowReadON[43]
+ rowReadON[42] RefrBp PrBp PrSFBp col_periphery_1x2_8/COL_LINE0 pixRst[16] OffBn
+ rowReadOFF[42] pixRst[17] openDVS_pixel2x2_top_703/GndD DiffBn col_periphery_1x2_8/COL_LINE1
+ GndD VddA18 OnBn openDVS_pixel2x2_top
XopenDVS_pixel2x2_top_691 openDVS_pixel2x2_top_691/vpd[0] openDVS_pixel2x2_top_691/vpd[1]
+ openDVS_pixel2x2_top_691/vpd[3] openDVS_pixel2x2_top_691/vpd[2] rowReadOFF[43] rowReadON[43]
+ rowReadON[42] RefrBp PrBp PrSFBp col_periphery_1x2_19/COL_LINE0 pixRst[38] OffBn
+ rowReadOFF[42] pixRst[39] openDVS_pixel2x2_top_703/GndD DiffBn col_periphery_1x2_19/COL_LINE1
+ GndD VddA18 OnBn openDVS_pixel2x2_top
XopenDVS_pixel2x2_top_509 openDVS_pixel2x2_top_509/vpd[0] openDVS_pixel2x2_top_509/vpd[1]
+ openDVS_pixel2x2_top_509/vpd[3] openDVS_pixel2x2_top_509/vpd[2] rowReadOFF[31] rowReadON[31]
+ rowReadON[30] RefrBp PrBp PrSFBp col_periphery_1x2_29/COL_LINE0 pixRst[58] OffBn
+ rowReadOFF[30] pixRst[59] openDVS_pixel2x2_top_511/GndD DiffBn col_periphery_1x2_29/COL_LINE1
+ GndD VddA18 OnBn openDVS_pixel2x2_top
XopenDVS_pixel2x2_top_317 openDVS_pixel2x2_top_317/vpd[0] openDVS_pixel2x2_top_317/vpd[1]
+ openDVS_pixel2x2_top_317/vpd[3] openDVS_pixel2x2_top_317/vpd[2] rowReadOFF[19] rowReadON[19]
+ rowReadON[18] RefrBp PrBp PrSFBp col_periphery_1x2_29/COL_LINE0 pixRst[58] OffBn
+ rowReadOFF[18] pixRst[59] openDVS_pixel2x2_top_319/GndD DiffBn col_periphery_1x2_29/COL_LINE1
+ GndD VddA18 OnBn openDVS_pixel2x2_top
XopenDVS_pixel2x2_top_306 openDVS_pixel2x2_top_306/vpd[0] openDVS_pixel2x2_top_306/vpd[1]
+ openDVS_pixel2x2_top_306/vpd[3] openDVS_pixel2x2_top_306/vpd[2] rowReadOFF[19] rowReadON[19]
+ rowReadON[18] RefrBp PrBp PrSFBp col_periphery_1x2_18/COL_LINE0 pixRst[36] OffBn
+ rowReadOFF[18] pixRst[37] openDVS_pixel2x2_top_319/GndD DiffBn col_periphery_1x2_18/COL_LINE1
+ GndD VddA18 OnBn openDVS_pixel2x2_top
XopenDVS_pixel2x2_top_339 openDVS_pixel2x2_top_339/vpd[0] openDVS_pixel2x2_top_339/vpd[1]
+ openDVS_pixel2x2_top_339/vpd[3] openDVS_pixel2x2_top_339/vpd[2] rowReadOFF[21] rowReadON[21]
+ rowReadON[20] RefrBp PrBp PrSFBp col_periphery_1x2_19/COL_LINE0 pixRst[38] OffBn
+ rowReadOFF[20] pixRst[39] openDVS_pixel2x2_top_351/GndD DiffBn col_periphery_1x2_19/COL_LINE1
+ GndD VddA18 OnBn openDVS_pixel2x2_top
XopenDVS_pixel2x2_top_328 openDVS_pixel2x2_top_328/vpd[0] openDVS_pixel2x2_top_328/vpd[1]
+ openDVS_pixel2x2_top_328/vpd[3] openDVS_pixel2x2_top_328/vpd[2] rowReadOFF[21] rowReadON[21]
+ rowReadON[20] RefrBp PrBp PrSFBp col_periphery_1x2_8/COL_LINE0 pixRst[16] OffBn
+ rowReadOFF[20] pixRst[17] openDVS_pixel2x2_top_351/GndD DiffBn col_periphery_1x2_8/COL_LINE1
+ GndD VddA18 OnBn openDVS_pixel2x2_top
XopenDVS_pixel2x2_top_873 openDVS_pixel2x2_top_873/vpd[0] openDVS_pixel2x2_top_873/vpd[1]
+ openDVS_pixel2x2_top_873/vpd[3] openDVS_pixel2x2_top_873/vpd[2] rowReadOFF[55] rowReadON[55]
+ rowReadON[54] RefrBp PrBp PrSFBp col_periphery_1x2_9/COL_LINE0 pixRst[18] OffBn
+ rowReadOFF[54] pixRst[19] openDVS_pixel2x2_top_895/GndD DiffBn col_periphery_1x2_9/COL_LINE1
+ GndD VddA18 OnBn openDVS_pixel2x2_top
XopenDVS_pixel2x2_top_840 openDVS_pixel2x2_top_840/vpd[0] openDVS_pixel2x2_top_840/vpd[1]
+ openDVS_pixel2x2_top_840/vpd[3] openDVS_pixel2x2_top_840/vpd[2] rowReadOFF[53] rowReadON[53]
+ rowReadON[52] RefrBp PrBp PrSFBp col_periphery_1x2_8/COL_LINE0 pixRst[16] OffBn
+ rowReadOFF[52] pixRst[17] openDVS_pixel2x2_top_863/GndD DiffBn col_periphery_1x2_8/COL_LINE1
+ GndD VddA18 OnBn openDVS_pixel2x2_top
XopenDVS_pixel2x2_top_851 openDVS_pixel2x2_top_851/vpd[0] openDVS_pixel2x2_top_851/vpd[1]
+ openDVS_pixel2x2_top_851/vpd[3] openDVS_pixel2x2_top_851/vpd[2] rowReadOFF[53] rowReadON[53]
+ rowReadON[52] RefrBp PrBp PrSFBp col_periphery_1x2_19/COL_LINE0 pixRst[38] OffBn
+ rowReadOFF[52] pixRst[39] openDVS_pixel2x2_top_863/GndD DiffBn col_periphery_1x2_19/COL_LINE1
+ GndD VddA18 OnBn openDVS_pixel2x2_top
XopenDVS_pixel2x2_top_862 openDVS_pixel2x2_top_862/vpd[0] openDVS_pixel2x2_top_862/vpd[1]
+ openDVS_pixel2x2_top_862/vpd[3] openDVS_pixel2x2_top_862/vpd[2] rowReadOFF[53] rowReadON[53]
+ rowReadON[52] RefrBp PrBp PrSFBp col_periphery_1x2_30/COL_LINE0 pixRst[60] OffBn
+ rowReadOFF[52] pixRst[61] openDVS_pixel2x2_top_863/GndD DiffBn col_periphery_1x2_30/COL_LINE1
+ GndD VddA18 OnBn openDVS_pixel2x2_top
XopenDVS_pixel2x2_top_884 openDVS_pixel2x2_top_884/vpd[0] openDVS_pixel2x2_top_884/vpd[1]
+ openDVS_pixel2x2_top_884/vpd[3] openDVS_pixel2x2_top_884/vpd[2] rowReadOFF[55] rowReadON[55]
+ rowReadON[54] RefrBp PrBp PrSFBp col_periphery_1x2_20/COL_LINE0 pixRst[40] OffBn
+ rowReadOFF[54] pixRst[41] openDVS_pixel2x2_top_895/GndD DiffBn col_periphery_1x2_20/COL_LINE1
+ GndD VddA18 OnBn openDVS_pixel2x2_top
XopenDVS_pixel2x2_top_895 openDVS_pixel2x2_top_895/vpd[0] openDVS_pixel2x2_top_895/vpd[1]
+ openDVS_pixel2x2_top_895/vpd[3] openDVS_pixel2x2_top_895/vpd[2] rowReadOFF[55] rowReadON[55]
+ rowReadON[54] RefrBp PrBp PrSFBp col_periphery_1x2_31/COL_LINE0 pixRst[62] OffBn
+ rowReadOFF[54] pixRst[63] openDVS_pixel2x2_top_895/GndD DiffBn col_periphery_1x2_31/COL_LINE1
+ GndD VddA18 OnBn openDVS_pixel2x2_top
XopenDVS_pixel2x2_top_158 openDVS_pixel2x2_top_158/vpd[0] openDVS_pixel2x2_top_158/vpd[1]
+ openDVS_pixel2x2_top_158/vpd[3] openDVS_pixel2x2_top_158/vpd[2] rowReadOFF[9] rowReadON[9]
+ rowReadON[8] RefrBp PrBp PrSFBp col_periphery_1x2_30/COL_LINE0 pixRst[60] OffBn
+ rowReadOFF[8] pixRst[61] openDVS_pixel2x2_top_159/GndD DiffBn col_periphery_1x2_30/COL_LINE1
+ GndD VddA18 OnBn openDVS_pixel2x2_top
XopenDVS_pixel2x2_top_125 openDVS_pixel2x2_top_125/vpd[0] openDVS_pixel2x2_top_125/vpd[1]
+ openDVS_pixel2x2_top_125/vpd[3] openDVS_pixel2x2_top_125/vpd[2] rowReadOFF[7] rowReadON[7]
+ rowReadON[6] RefrBp PrBp PrSFBp col_periphery_1x2_29/COL_LINE0 pixRst[58] OffBn
+ rowReadOFF[6] pixRst[59] openDVS_pixel2x2_top_99/GndD DiffBn col_periphery_1x2_29/COL_LINE1
+ GndD VddA18 OnBn openDVS_pixel2x2_top
XopenDVS_pixel2x2_top_147 openDVS_pixel2x2_top_147/vpd[0] openDVS_pixel2x2_top_147/vpd[1]
+ openDVS_pixel2x2_top_147/vpd[3] openDVS_pixel2x2_top_147/vpd[2] rowReadOFF[9] rowReadON[9]
+ rowReadON[8] RefrBp PrBp PrSFBp col_periphery_1x2_19/COL_LINE0 pixRst[38] OffBn
+ rowReadOFF[8] pixRst[39] openDVS_pixel2x2_top_159/GndD DiffBn col_periphery_1x2_19/COL_LINE1
+ GndD VddA18 OnBn openDVS_pixel2x2_top
XopenDVS_pixel2x2_top_114 openDVS_pixel2x2_top_114/vpd[0] openDVS_pixel2x2_top_114/vpd[1]
+ openDVS_pixel2x2_top_114/vpd[3] openDVS_pixel2x2_top_114/vpd[2] rowReadOFF[7] rowReadON[7]
+ rowReadON[6] RefrBp PrBp PrSFBp col_periphery_1x2_18/COL_LINE0 pixRst[36] OffBn
+ rowReadOFF[6] pixRst[37] openDVS_pixel2x2_top_99/GndD DiffBn col_periphery_1x2_18/COL_LINE1
+ GndD VddA18 OnBn openDVS_pixel2x2_top
XopenDVS_pixel2x2_top_169 openDVS_pixel2x2_top_169/vpd[0] openDVS_pixel2x2_top_169/vpd[1]
+ openDVS_pixel2x2_top_169/vpd[3] openDVS_pixel2x2_top_169/vpd[2] rowReadOFF[11] rowReadON[11]
+ rowReadON[10] RefrBp PrBp PrSFBp col_periphery_1x2_9/COL_LINE0 pixRst[18] OffBn
+ rowReadOFF[10] pixRst[19] openDVS_pixel2x2_top_191/GndD DiffBn col_periphery_1x2_9/COL_LINE1
+ GndD VddA18 OnBn openDVS_pixel2x2_top
XopenDVS_pixel2x2_top_136 openDVS_pixel2x2_top_136/vpd[0] openDVS_pixel2x2_top_136/vpd[1]
+ openDVS_pixel2x2_top_136/vpd[3] openDVS_pixel2x2_top_136/vpd[2] rowReadOFF[9] rowReadON[9]
+ rowReadON[8] RefrBp PrBp PrSFBp col_periphery_1x2_8/COL_LINE0 pixRst[16] OffBn rowReadOFF[8]
+ pixRst[17] openDVS_pixel2x2_top_159/GndD DiffBn col_periphery_1x2_8/COL_LINE1 GndD
+ VddA18 OnBn openDVS_pixel2x2_top
XopenDVS_pixel2x2_top_103 openDVS_pixel2x2_top_103/vpd[0] openDVS_pixel2x2_top_103/vpd[1]
+ openDVS_pixel2x2_top_103/vpd[3] openDVS_pixel2x2_top_103/vpd[2] rowReadOFF[7] rowReadON[7]
+ rowReadON[6] RefrBp PrBp PrSFBp col_periphery_1x2_7/COL_LINE0 pixRst[14] OffBn rowReadOFF[6]
+ pixRst[15] openDVS_pixel2x2_top_99/GndD DiffBn col_periphery_1x2_7/COL_LINE1 GndD
+ VddA18 OnBn openDVS_pixel2x2_top
XopenDVS_pixel2x2_top_670 openDVS_pixel2x2_top_670/vpd[0] openDVS_pixel2x2_top_670/vpd[1]
+ openDVS_pixel2x2_top_670/vpd[3] openDVS_pixel2x2_top_670/vpd[2] rowReadOFF[41] rowReadON[41]
+ rowReadON[40] RefrBp PrBp PrSFBp col_periphery_1x2_30/COL_LINE0 pixRst[60] OffBn
+ rowReadOFF[40] pixRst[61] openDVS_pixel2x2_top_671/GndD DiffBn col_periphery_1x2_30/COL_LINE1
+ GndD VddA18 OnBn openDVS_pixel2x2_top
XopenDVS_pixel2x2_top_681 openDVS_pixel2x2_top_681/vpd[0] openDVS_pixel2x2_top_681/vpd[1]
+ openDVS_pixel2x2_top_681/vpd[3] openDVS_pixel2x2_top_681/vpd[2] rowReadOFF[43] rowReadON[43]
+ rowReadON[42] RefrBp PrBp PrSFBp col_periphery_1x2_9/COL_LINE0 pixRst[18] OffBn
+ rowReadOFF[42] pixRst[19] openDVS_pixel2x2_top_703/GndD DiffBn col_periphery_1x2_9/COL_LINE1
+ GndD VddA18 OnBn openDVS_pixel2x2_top
XopenDVS_pixel2x2_top_692 openDVS_pixel2x2_top_692/vpd[0] openDVS_pixel2x2_top_692/vpd[1]
+ openDVS_pixel2x2_top_692/vpd[3] openDVS_pixel2x2_top_692/vpd[2] rowReadOFF[43] rowReadON[43]
+ rowReadON[42] RefrBp PrBp PrSFBp col_periphery_1x2_20/COL_LINE0 pixRst[40] OffBn
+ rowReadOFF[42] pixRst[41] openDVS_pixel2x2_top_703/GndD DiffBn col_periphery_1x2_20/COL_LINE1
+ GndD VddA18 OnBn openDVS_pixel2x2_top
XopenDVS_pixel2x2_top_1004 openDVS_pixel2x2_top_1004/vpd[0] openDVS_pixel2x2_top_1004/vpd[1]
+ openDVS_pixel2x2_top_1004/vpd[3] openDVS_pixel2x2_top_1004/vpd[2] rowReadOFF[63]
+ rowReadON[63] rowReadON[62] RefrBp PrBp PrSFBp col_periphery_1x2_12/COL_LINE0 pixRst[24]
+ OffBn rowReadOFF[62] pixRst[25] openDVS_pixel2x2_top_999/GndD DiffBn col_periphery_1x2_12/COL_LINE1
+ GndD VddA18 OnBn openDVS_pixel2x2_top
XopenDVS_pixel2x2_top_1015 openDVS_pixel2x2_top_1015/vpd[0] openDVS_pixel2x2_top_1015/vpd[1]
+ openDVS_pixel2x2_top_1015/vpd[3] openDVS_pixel2x2_top_1015/vpd[2] rowReadOFF[63]
+ rowReadON[63] rowReadON[62] RefrBp PrBp PrSFBp col_periphery_1x2_23/COL_LINE0 pixRst[46]
+ OffBn rowReadOFF[62] pixRst[47] openDVS_pixel2x2_top_999/GndD DiffBn col_periphery_1x2_23/COL_LINE1
+ GndD VddA18 OnBn openDVS_pixel2x2_top
XopenDVS_pixel2x2_top_318 openDVS_pixel2x2_top_318/vpd[0] openDVS_pixel2x2_top_318/vpd[1]
+ openDVS_pixel2x2_top_318/vpd[3] openDVS_pixel2x2_top_318/vpd[2] rowReadOFF[19] rowReadON[19]
+ rowReadON[18] RefrBp PrBp PrSFBp col_periphery_1x2_30/COL_LINE0 pixRst[60] OffBn
+ rowReadOFF[18] pixRst[61] openDVS_pixel2x2_top_319/GndD DiffBn col_periphery_1x2_30/COL_LINE1
+ GndD VddA18 OnBn openDVS_pixel2x2_top
XopenDVS_pixel2x2_top_307 openDVS_pixel2x2_top_307/vpd[0] openDVS_pixel2x2_top_307/vpd[1]
+ openDVS_pixel2x2_top_307/vpd[3] openDVS_pixel2x2_top_307/vpd[2] rowReadOFF[19] rowReadON[19]
+ rowReadON[18] RefrBp PrBp PrSFBp col_periphery_1x2_19/COL_LINE0 pixRst[38] OffBn
+ rowReadOFF[18] pixRst[39] openDVS_pixel2x2_top_319/GndD DiffBn col_periphery_1x2_19/COL_LINE1
+ GndD VddA18 OnBn openDVS_pixel2x2_top
XopenDVS_pixel2x2_top_329 openDVS_pixel2x2_top_329/vpd[0] openDVS_pixel2x2_top_329/vpd[1]
+ openDVS_pixel2x2_top_329/vpd[3] openDVS_pixel2x2_top_329/vpd[2] rowReadOFF[21] rowReadON[21]
+ rowReadON[20] RefrBp PrBp PrSFBp col_periphery_1x2_9/COL_LINE0 pixRst[18] OffBn
+ rowReadOFF[20] pixRst[19] openDVS_pixel2x2_top_351/GndD DiffBn col_periphery_1x2_9/COL_LINE1
+ GndD VddA18 OnBn openDVS_pixel2x2_top
XopenDVS_pixel2x2_top_874 openDVS_pixel2x2_top_874/vpd[0] openDVS_pixel2x2_top_874/vpd[1]
+ openDVS_pixel2x2_top_874/vpd[3] openDVS_pixel2x2_top_874/vpd[2] rowReadOFF[55] rowReadON[55]
+ rowReadON[54] RefrBp PrBp PrSFBp col_periphery_1x2_10/COL_LINE0 pixRst[20] OffBn
+ rowReadOFF[54] pixRst[21] openDVS_pixel2x2_top_895/GndD DiffBn col_periphery_1x2_10/COL_LINE1
+ GndD VddA18 OnBn openDVS_pixel2x2_top
XopenDVS_pixel2x2_top_841 openDVS_pixel2x2_top_841/vpd[0] openDVS_pixel2x2_top_841/vpd[1]
+ openDVS_pixel2x2_top_841/vpd[3] openDVS_pixel2x2_top_841/vpd[2] rowReadOFF[53] rowReadON[53]
+ rowReadON[52] RefrBp PrBp PrSFBp col_periphery_1x2_9/COL_LINE0 pixRst[18] OffBn
+ rowReadOFF[52] pixRst[19] openDVS_pixel2x2_top_863/GndD DiffBn col_periphery_1x2_9/COL_LINE1
+ GndD VddA18 OnBn openDVS_pixel2x2_top
XopenDVS_pixel2x2_top_896 openDVS_pixel2x2_top_896/vpd[0] openDVS_pixel2x2_top_896/vpd[1]
+ openDVS_pixel2x2_top_896/vpd[3] openDVS_pixel2x2_top_896/vpd[2] rowReadOFF[57] rowReadON[57]
+ rowReadON[56] RefrBp PrBp PrSFBp col_periphery_1x2_0/COL_LINE0 pixRst[0] OffBn rowReadOFF[56]
+ pixRst[1] openDVS_pixel2x2_top_927/GndD DiffBn col_periphery_1x2_0/COL_LINE1 GndD
+ VddA18 OnBn openDVS_pixel2x2_top
XopenDVS_pixel2x2_top_852 openDVS_pixel2x2_top_852/vpd[0] openDVS_pixel2x2_top_852/vpd[1]
+ openDVS_pixel2x2_top_852/vpd[3] openDVS_pixel2x2_top_852/vpd[2] rowReadOFF[53] rowReadON[53]
+ rowReadON[52] RefrBp PrBp PrSFBp col_periphery_1x2_20/COL_LINE0 pixRst[40] OffBn
+ rowReadOFF[52] pixRst[41] openDVS_pixel2x2_top_863/GndD DiffBn col_periphery_1x2_20/COL_LINE1
+ GndD VddA18 OnBn openDVS_pixel2x2_top
XopenDVS_pixel2x2_top_885 openDVS_pixel2x2_top_885/vpd[0] openDVS_pixel2x2_top_885/vpd[1]
+ openDVS_pixel2x2_top_885/vpd[3] openDVS_pixel2x2_top_885/vpd[2] rowReadOFF[55] rowReadON[55]
+ rowReadON[54] RefrBp PrBp PrSFBp col_periphery_1x2_21/COL_LINE0 pixRst[42] OffBn
+ rowReadOFF[54] pixRst[43] openDVS_pixel2x2_top_895/GndD DiffBn col_periphery_1x2_21/COL_LINE1
+ GndD VddA18 OnBn openDVS_pixel2x2_top
XopenDVS_pixel2x2_top_863 openDVS_pixel2x2_top_863/vpd[0] openDVS_pixel2x2_top_863/vpd[1]
+ openDVS_pixel2x2_top_863/vpd[3] openDVS_pixel2x2_top_863/vpd[2] rowReadOFF[53] rowReadON[53]
+ rowReadON[52] RefrBp PrBp PrSFBp col_periphery_1x2_31/COL_LINE0 pixRst[62] OffBn
+ rowReadOFF[52] pixRst[63] openDVS_pixel2x2_top_863/GndD DiffBn col_periphery_1x2_31/COL_LINE1
+ GndD VddA18 OnBn openDVS_pixel2x2_top
XopenDVS_pixel2x2_top_830 openDVS_pixel2x2_top_830/vpd[0] openDVS_pixel2x2_top_830/vpd[1]
+ openDVS_pixel2x2_top_830/vpd[3] openDVS_pixel2x2_top_830/vpd[2] rowReadOFF[51] rowReadON[51]
+ rowReadON[50] RefrBp PrBp PrSFBp col_periphery_1x2_30/COL_LINE0 pixRst[60] OffBn
+ rowReadOFF[50] pixRst[61] openDVS_pixel2x2_top_831/GndD DiffBn col_periphery_1x2_30/COL_LINE1
+ GndD VddA18 OnBn openDVS_pixel2x2_top
XopenDVS_pixel2x2_top_159 openDVS_pixel2x2_top_159/vpd[0] openDVS_pixel2x2_top_159/vpd[1]
+ openDVS_pixel2x2_top_159/vpd[3] openDVS_pixel2x2_top_159/vpd[2] rowReadOFF[9] rowReadON[9]
+ rowReadON[8] RefrBp PrBp PrSFBp col_periphery_1x2_31/COL_LINE0 pixRst[62] OffBn
+ rowReadOFF[8] pixRst[63] openDVS_pixel2x2_top_159/GndD DiffBn col_periphery_1x2_31/COL_LINE1
+ GndD VddA18 OnBn openDVS_pixel2x2_top
XopenDVS_pixel2x2_top_126 openDVS_pixel2x2_top_126/vpd[0] openDVS_pixel2x2_top_126/vpd[1]
+ openDVS_pixel2x2_top_126/vpd[3] openDVS_pixel2x2_top_126/vpd[2] rowReadOFF[7] rowReadON[7]
+ rowReadON[6] RefrBp PrBp PrSFBp col_periphery_1x2_30/COL_LINE0 pixRst[60] OffBn
+ rowReadOFF[6] pixRst[61] openDVS_pixel2x2_top_99/GndD DiffBn col_periphery_1x2_30/COL_LINE1
+ GndD VddA18 OnBn openDVS_pixel2x2_top
XopenDVS_pixel2x2_top_148 openDVS_pixel2x2_top_148/vpd[0] openDVS_pixel2x2_top_148/vpd[1]
+ openDVS_pixel2x2_top_148/vpd[3] openDVS_pixel2x2_top_148/vpd[2] rowReadOFF[9] rowReadON[9]
+ rowReadON[8] RefrBp PrBp PrSFBp col_periphery_1x2_20/COL_LINE0 pixRst[40] OffBn
+ rowReadOFF[8] pixRst[41] openDVS_pixel2x2_top_159/GndD DiffBn col_periphery_1x2_20/COL_LINE1
+ GndD VddA18 OnBn openDVS_pixel2x2_top
XopenDVS_pixel2x2_top_115 openDVS_pixel2x2_top_115/vpd[0] openDVS_pixel2x2_top_115/vpd[1]
+ openDVS_pixel2x2_top_115/vpd[3] openDVS_pixel2x2_top_115/vpd[2] rowReadOFF[7] rowReadON[7]
+ rowReadON[6] RefrBp PrBp PrSFBp col_periphery_1x2_19/COL_LINE0 pixRst[38] OffBn
+ rowReadOFF[6] pixRst[39] openDVS_pixel2x2_top_99/GndD DiffBn col_periphery_1x2_19/COL_LINE1
+ GndD VddA18 OnBn openDVS_pixel2x2_top
XopenDVS_pixel2x2_top_137 openDVS_pixel2x2_top_137/vpd[0] openDVS_pixel2x2_top_137/vpd[1]
+ openDVS_pixel2x2_top_137/vpd[3] openDVS_pixel2x2_top_137/vpd[2] rowReadOFF[9] rowReadON[9]
+ rowReadON[8] RefrBp PrBp PrSFBp col_periphery_1x2_9/COL_LINE0 pixRst[18] OffBn rowReadOFF[8]
+ pixRst[19] openDVS_pixel2x2_top_159/GndD DiffBn col_periphery_1x2_9/COL_LINE1 GndD
+ VddA18 OnBn openDVS_pixel2x2_top
XopenDVS_pixel2x2_top_104 openDVS_pixel2x2_top_104/vpd[0] openDVS_pixel2x2_top_104/vpd[1]
+ openDVS_pixel2x2_top_104/vpd[3] openDVS_pixel2x2_top_104/vpd[2] rowReadOFF[7] rowReadON[7]
+ rowReadON[6] RefrBp PrBp PrSFBp col_periphery_1x2_8/COL_LINE0 pixRst[16] OffBn rowReadOFF[6]
+ pixRst[17] openDVS_pixel2x2_top_99/GndD DiffBn col_periphery_1x2_8/COL_LINE1 GndD
+ VddA18 OnBn openDVS_pixel2x2_top
XopenDVS_pixel2x2_top_671 openDVS_pixel2x2_top_671/vpd[0] openDVS_pixel2x2_top_671/vpd[1]
+ openDVS_pixel2x2_top_671/vpd[3] openDVS_pixel2x2_top_671/vpd[2] rowReadOFF[41] rowReadON[41]
+ rowReadON[40] RefrBp PrBp PrSFBp col_periphery_1x2_31/COL_LINE0 pixRst[62] OffBn
+ rowReadOFF[40] pixRst[63] openDVS_pixel2x2_top_671/GndD DiffBn col_periphery_1x2_31/COL_LINE1
+ GndD VddA18 OnBn openDVS_pixel2x2_top
XopenDVS_pixel2x2_top_660 openDVS_pixel2x2_top_660/vpd[0] openDVS_pixel2x2_top_660/vpd[1]
+ openDVS_pixel2x2_top_660/vpd[3] openDVS_pixel2x2_top_660/vpd[2] rowReadOFF[41] rowReadON[41]
+ rowReadON[40] RefrBp PrBp PrSFBp col_periphery_1x2_20/COL_LINE0 pixRst[40] OffBn
+ rowReadOFF[40] pixRst[41] openDVS_pixel2x2_top_671/GndD DiffBn col_periphery_1x2_20/COL_LINE1
+ GndD VddA18 OnBn openDVS_pixel2x2_top
XopenDVS_pixel2x2_top_682 openDVS_pixel2x2_top_682/vpd[0] openDVS_pixel2x2_top_682/vpd[1]
+ openDVS_pixel2x2_top_682/vpd[3] openDVS_pixel2x2_top_682/vpd[2] rowReadOFF[43] rowReadON[43]
+ rowReadON[42] RefrBp PrBp PrSFBp col_periphery_1x2_10/COL_LINE0 pixRst[20] OffBn
+ rowReadOFF[42] pixRst[21] openDVS_pixel2x2_top_703/GndD DiffBn col_periphery_1x2_10/COL_LINE1
+ GndD VddA18 OnBn openDVS_pixel2x2_top
XopenDVS_pixel2x2_top_693 openDVS_pixel2x2_top_693/vpd[0] openDVS_pixel2x2_top_693/vpd[1]
+ openDVS_pixel2x2_top_693/vpd[3] openDVS_pixel2x2_top_693/vpd[2] rowReadOFF[43] rowReadON[43]
+ rowReadON[42] RefrBp PrBp PrSFBp col_periphery_1x2_21/COL_LINE0 pixRst[42] OffBn
+ rowReadOFF[42] pixRst[43] openDVS_pixel2x2_top_703/GndD DiffBn col_periphery_1x2_21/COL_LINE1
+ GndD VddA18 OnBn openDVS_pixel2x2_top
XopenDVS_pixel2x2_top_1005 openDVS_pixel2x2_top_1005/vpd[0] openDVS_pixel2x2_top_1005/vpd[1]
+ openDVS_pixel2x2_top_1005/vpd[3] openDVS_pixel2x2_top_1005/vpd[2] rowReadOFF[63]
+ rowReadON[63] rowReadON[62] RefrBp PrBp PrSFBp col_periphery_1x2_13/COL_LINE0 pixRst[26]
+ OffBn rowReadOFF[62] pixRst[27] openDVS_pixel2x2_top_999/GndD DiffBn col_periphery_1x2_13/COL_LINE1
+ GndD VddA18 OnBn openDVS_pixel2x2_top
XopenDVS_pixel2x2_top_1016 openDVS_pixel2x2_top_1016/vpd[0] openDVS_pixel2x2_top_1016/vpd[1]
+ openDVS_pixel2x2_top_1016/vpd[3] openDVS_pixel2x2_top_1016/vpd[2] rowReadOFF[63]
+ rowReadON[63] rowReadON[62] RefrBp PrBp PrSFBp col_periphery_1x2_24/COL_LINE0 pixRst[48]
+ OffBn rowReadOFF[62] pixRst[49] openDVS_pixel2x2_top_999/GndD DiffBn col_periphery_1x2_24/COL_LINE1
+ GndD VddA18 OnBn openDVS_pixel2x2_top
XopenDVS_pixel2x2_top_490 openDVS_pixel2x2_top_490/vpd[0] openDVS_pixel2x2_top_490/vpd[1]
+ openDVS_pixel2x2_top_490/vpd[3] openDVS_pixel2x2_top_490/vpd[2] rowReadOFF[31] rowReadON[31]
+ rowReadON[30] RefrBp PrBp PrSFBp col_periphery_1x2_10/COL_LINE0 pixRst[20] OffBn
+ rowReadOFF[30] pixRst[21] openDVS_pixel2x2_top_511/GndD DiffBn col_periphery_1x2_10/COL_LINE1
+ GndD VddA18 OnBn openDVS_pixel2x2_top
XopenDVS_pixel2x2_top_319 openDVS_pixel2x2_top_319/vpd[0] openDVS_pixel2x2_top_319/vpd[1]
+ openDVS_pixel2x2_top_319/vpd[3] openDVS_pixel2x2_top_319/vpd[2] rowReadOFF[19] rowReadON[19]
+ rowReadON[18] RefrBp PrBp PrSFBp col_periphery_1x2_31/COL_LINE0 pixRst[62] OffBn
+ rowReadOFF[18] pixRst[63] openDVS_pixel2x2_top_319/GndD DiffBn col_periphery_1x2_31/COL_LINE1
+ GndD VddA18 OnBn openDVS_pixel2x2_top
XopenDVS_pixel2x2_top_308 openDVS_pixel2x2_top_308/vpd[0] openDVS_pixel2x2_top_308/vpd[1]
+ openDVS_pixel2x2_top_308/vpd[3] openDVS_pixel2x2_top_308/vpd[2] rowReadOFF[19] rowReadON[19]
+ rowReadON[18] RefrBp PrBp PrSFBp col_periphery_1x2_20/COL_LINE0 pixRst[40] OffBn
+ rowReadOFF[18] pixRst[41] openDVS_pixel2x2_top_319/GndD DiffBn col_periphery_1x2_20/COL_LINE1
+ GndD VddA18 OnBn openDVS_pixel2x2_top
XopenDVS_pixel2x2_top_842 openDVS_pixel2x2_top_842/vpd[0] openDVS_pixel2x2_top_842/vpd[1]
+ openDVS_pixel2x2_top_842/vpd[3] openDVS_pixel2x2_top_842/vpd[2] rowReadOFF[53] rowReadON[53]
+ rowReadON[52] RefrBp PrBp PrSFBp col_periphery_1x2_10/COL_LINE0 pixRst[20] OffBn
+ rowReadOFF[52] pixRst[21] openDVS_pixel2x2_top_863/GndD DiffBn col_periphery_1x2_10/COL_LINE1
+ GndD VddA18 OnBn openDVS_pixel2x2_top
XopenDVS_pixel2x2_top_875 openDVS_pixel2x2_top_875/vpd[0] openDVS_pixel2x2_top_875/vpd[1]
+ openDVS_pixel2x2_top_875/vpd[3] openDVS_pixel2x2_top_875/vpd[2] rowReadOFF[55] rowReadON[55]
+ rowReadON[54] RefrBp PrBp PrSFBp col_periphery_1x2_11/COL_LINE0 pixRst[22] OffBn
+ rowReadOFF[54] pixRst[23] openDVS_pixel2x2_top_895/GndD DiffBn col_periphery_1x2_11/COL_LINE1
+ GndD VddA18 OnBn openDVS_pixel2x2_top
XopenDVS_pixel2x2_top_864 openDVS_pixel2x2_top_864/vpd[0] openDVS_pixel2x2_top_864/vpd[1]
+ openDVS_pixel2x2_top_864/vpd[3] openDVS_pixel2x2_top_864/vpd[2] rowReadOFF[55] rowReadON[55]
+ rowReadON[54] RefrBp PrBp PrSFBp col_periphery_1x2_0/COL_LINE0 pixRst[0] OffBn rowReadOFF[54]
+ pixRst[1] openDVS_pixel2x2_top_895/GndD DiffBn col_periphery_1x2_0/COL_LINE1 GndD
+ VddA18 OnBn openDVS_pixel2x2_top
XopenDVS_pixel2x2_top_897 openDVS_pixel2x2_top_897/vpd[0] openDVS_pixel2x2_top_897/vpd[1]
+ openDVS_pixel2x2_top_897/vpd[3] openDVS_pixel2x2_top_897/vpd[2] rowReadOFF[57] rowReadON[57]
+ rowReadON[56] RefrBp PrBp PrSFBp col_periphery_1x2_1/COL_LINE0 pixRst[2] OffBn rowReadOFF[56]
+ pixRst[3] openDVS_pixel2x2_top_927/GndD DiffBn col_periphery_1x2_1/COL_LINE1 GndD
+ VddA18 OnBn openDVS_pixel2x2_top
XopenDVS_pixel2x2_top_886 openDVS_pixel2x2_top_886/vpd[0] openDVS_pixel2x2_top_886/vpd[1]
+ openDVS_pixel2x2_top_886/vpd[3] openDVS_pixel2x2_top_886/vpd[2] rowReadOFF[55] rowReadON[55]
+ rowReadON[54] RefrBp PrBp PrSFBp col_periphery_1x2_22/COL_LINE0 pixRst[44] OffBn
+ rowReadOFF[54] pixRst[45] openDVS_pixel2x2_top_895/GndD DiffBn col_periphery_1x2_22/COL_LINE1
+ GndD VddA18 OnBn openDVS_pixel2x2_top
XopenDVS_pixel2x2_top_853 openDVS_pixel2x2_top_853/vpd[0] openDVS_pixel2x2_top_853/vpd[1]
+ openDVS_pixel2x2_top_853/vpd[3] openDVS_pixel2x2_top_853/vpd[2] rowReadOFF[53] rowReadON[53]
+ rowReadON[52] RefrBp PrBp PrSFBp col_periphery_1x2_21/COL_LINE0 pixRst[42] OffBn
+ rowReadOFF[52] pixRst[43] openDVS_pixel2x2_top_863/GndD DiffBn col_periphery_1x2_21/COL_LINE1
+ GndD VddA18 OnBn openDVS_pixel2x2_top
XopenDVS_pixel2x2_top_820 openDVS_pixel2x2_top_820/vpd[0] openDVS_pixel2x2_top_820/vpd[1]
+ openDVS_pixel2x2_top_820/vpd[3] openDVS_pixel2x2_top_820/vpd[2] rowReadOFF[51] rowReadON[51]
+ rowReadON[50] RefrBp PrBp PrSFBp col_periphery_1x2_20/COL_LINE0 pixRst[40] OffBn
+ rowReadOFF[50] pixRst[41] openDVS_pixel2x2_top_831/GndD DiffBn col_periphery_1x2_20/COL_LINE1
+ GndD VddA18 OnBn openDVS_pixel2x2_top
XopenDVS_pixel2x2_top_831 openDVS_pixel2x2_top_831/vpd[0] openDVS_pixel2x2_top_831/vpd[1]
+ openDVS_pixel2x2_top_831/vpd[3] openDVS_pixel2x2_top_831/vpd[2] rowReadOFF[51] rowReadON[51]
+ rowReadON[50] RefrBp PrBp PrSFBp col_periphery_1x2_31/COL_LINE0 pixRst[62] OffBn
+ rowReadOFF[50] pixRst[63] openDVS_pixel2x2_top_831/GndD DiffBn col_periphery_1x2_31/COL_LINE1
+ GndD VddA18 OnBn openDVS_pixel2x2_top
XopenDVS_pixel2x2_top_127 openDVS_pixel2x2_top_127/vpd[0] openDVS_pixel2x2_top_127/vpd[1]
+ openDVS_pixel2x2_top_127/vpd[3] openDVS_pixel2x2_top_127/vpd[2] rowReadOFF[7] rowReadON[7]
+ rowReadON[6] RefrBp PrBp PrSFBp col_periphery_1x2_31/COL_LINE0 pixRst[62] OffBn
+ rowReadOFF[6] pixRst[63] openDVS_pixel2x2_top_99/GndD DiffBn col_periphery_1x2_31/COL_LINE1
+ GndD VddA18 OnBn openDVS_pixel2x2_top
XopenDVS_pixel2x2_top_149 openDVS_pixel2x2_top_149/vpd[0] openDVS_pixel2x2_top_149/vpd[1]
+ openDVS_pixel2x2_top_149/vpd[3] openDVS_pixel2x2_top_149/vpd[2] rowReadOFF[9] rowReadON[9]
+ rowReadON[8] RefrBp PrBp PrSFBp col_periphery_1x2_21/COL_LINE0 pixRst[42] OffBn
+ rowReadOFF[8] pixRst[43] openDVS_pixel2x2_top_159/GndD DiffBn col_periphery_1x2_21/COL_LINE1
+ GndD VddA18 OnBn openDVS_pixel2x2_top
XopenDVS_pixel2x2_top_116 openDVS_pixel2x2_top_116/vpd[0] openDVS_pixel2x2_top_116/vpd[1]
+ openDVS_pixel2x2_top_116/vpd[3] openDVS_pixel2x2_top_116/vpd[2] rowReadOFF[7] rowReadON[7]
+ rowReadON[6] RefrBp PrBp PrSFBp col_periphery_1x2_20/COL_LINE0 pixRst[40] OffBn
+ rowReadOFF[6] pixRst[41] openDVS_pixel2x2_top_99/GndD DiffBn col_periphery_1x2_20/COL_LINE1
+ GndD VddA18 OnBn openDVS_pixel2x2_top
XopenDVS_pixel2x2_top_138 openDVS_pixel2x2_top_138/vpd[0] openDVS_pixel2x2_top_138/vpd[1]
+ openDVS_pixel2x2_top_138/vpd[3] openDVS_pixel2x2_top_138/vpd[2] rowReadOFF[9] rowReadON[9]
+ rowReadON[8] RefrBp PrBp PrSFBp col_periphery_1x2_10/COL_LINE0 pixRst[20] OffBn
+ rowReadOFF[8] pixRst[21] openDVS_pixel2x2_top_159/GndD DiffBn col_periphery_1x2_10/COL_LINE1
+ GndD VddA18 OnBn openDVS_pixel2x2_top
XopenDVS_pixel2x2_top_105 openDVS_pixel2x2_top_105/vpd[0] openDVS_pixel2x2_top_105/vpd[1]
+ openDVS_pixel2x2_top_105/vpd[3] openDVS_pixel2x2_top_105/vpd[2] rowReadOFF[7] rowReadON[7]
+ rowReadON[6] RefrBp PrBp PrSFBp col_periphery_1x2_9/COL_LINE0 pixRst[18] OffBn rowReadOFF[6]
+ pixRst[19] openDVS_pixel2x2_top_99/GndD DiffBn col_periphery_1x2_9/COL_LINE1 GndD
+ VddA18 OnBn openDVS_pixel2x2_top
XopenDVS_pixel2x2_top_661 openDVS_pixel2x2_top_661/vpd[0] openDVS_pixel2x2_top_661/vpd[1]
+ openDVS_pixel2x2_top_661/vpd[3] openDVS_pixel2x2_top_661/vpd[2] rowReadOFF[41] rowReadON[41]
+ rowReadON[40] RefrBp PrBp PrSFBp col_periphery_1x2_21/COL_LINE0 pixRst[42] OffBn
+ rowReadOFF[40] pixRst[43] openDVS_pixel2x2_top_671/GndD DiffBn col_periphery_1x2_21/COL_LINE1
+ GndD VddA18 OnBn openDVS_pixel2x2_top
XopenDVS_pixel2x2_top_650 openDVS_pixel2x2_top_650/vpd[0] openDVS_pixel2x2_top_650/vpd[1]
+ openDVS_pixel2x2_top_650/vpd[3] openDVS_pixel2x2_top_650/vpd[2] rowReadOFF[41] rowReadON[41]
+ rowReadON[40] RefrBp PrBp PrSFBp col_periphery_1x2_10/COL_LINE0 pixRst[20] OffBn
+ rowReadOFF[40] pixRst[21] openDVS_pixel2x2_top_671/GndD DiffBn col_periphery_1x2_10/COL_LINE1
+ GndD VddA18 OnBn openDVS_pixel2x2_top
XopenDVS_pixel2x2_top_1006 openDVS_pixel2x2_top_1006/vpd[0] openDVS_pixel2x2_top_1006/vpd[1]
+ openDVS_pixel2x2_top_1006/vpd[3] openDVS_pixel2x2_top_1006/vpd[2] rowReadOFF[63]
+ rowReadON[63] rowReadON[62] RefrBp PrBp PrSFBp col_periphery_1x2_14/COL_LINE0 pixRst[28]
+ OffBn rowReadOFF[62] pixRst[29] openDVS_pixel2x2_top_999/GndD DiffBn col_periphery_1x2_14/COL_LINE1
+ GndD VddA18 OnBn openDVS_pixel2x2_top
XopenDVS_pixel2x2_top_1017 openDVS_pixel2x2_top_1017/vpd[0] openDVS_pixel2x2_top_1017/vpd[1]
+ openDVS_pixel2x2_top_1017/vpd[3] openDVS_pixel2x2_top_1017/vpd[2] rowReadOFF[63]
+ rowReadON[63] rowReadON[62] RefrBp PrBp PrSFBp col_periphery_1x2_25/COL_LINE0 pixRst[50]
+ OffBn rowReadOFF[62] pixRst[51] openDVS_pixel2x2_top_999/GndD DiffBn col_periphery_1x2_25/COL_LINE1
+ GndD VddA18 OnBn openDVS_pixel2x2_top
XopenDVS_pixel2x2_top_672 openDVS_pixel2x2_top_672/vpd[0] openDVS_pixel2x2_top_672/vpd[1]
+ openDVS_pixel2x2_top_672/vpd[3] openDVS_pixel2x2_top_672/vpd[2] rowReadOFF[43] rowReadON[43]
+ rowReadON[42] RefrBp PrBp PrSFBp col_periphery_1x2_0/COL_LINE0 pixRst[0] OffBn rowReadOFF[42]
+ pixRst[1] openDVS_pixel2x2_top_703/GndD DiffBn col_periphery_1x2_0/COL_LINE1 GndD
+ VddA18 OnBn openDVS_pixel2x2_top
XopenDVS_pixel2x2_top_683 openDVS_pixel2x2_top_683/vpd[0] openDVS_pixel2x2_top_683/vpd[1]
+ openDVS_pixel2x2_top_683/vpd[3] openDVS_pixel2x2_top_683/vpd[2] rowReadOFF[43] rowReadON[43]
+ rowReadON[42] RefrBp PrBp PrSFBp col_periphery_1x2_11/COL_LINE0 pixRst[22] OffBn
+ rowReadOFF[42] pixRst[23] openDVS_pixel2x2_top_703/GndD DiffBn col_periphery_1x2_11/COL_LINE1
+ GndD VddA18 OnBn openDVS_pixel2x2_top
XopenDVS_pixel2x2_top_694 openDVS_pixel2x2_top_694/vpd[0] openDVS_pixel2x2_top_694/vpd[1]
+ openDVS_pixel2x2_top_694/vpd[3] openDVS_pixel2x2_top_694/vpd[2] rowReadOFF[43] rowReadON[43]
+ rowReadON[42] RefrBp PrBp PrSFBp col_periphery_1x2_22/COL_LINE0 pixRst[44] OffBn
+ rowReadOFF[42] pixRst[45] openDVS_pixel2x2_top_703/GndD DiffBn col_periphery_1x2_22/COL_LINE1
+ GndD VddA18 OnBn openDVS_pixel2x2_top
XopenDVS_pixel2x2_top_491 openDVS_pixel2x2_top_491/vpd[0] openDVS_pixel2x2_top_491/vpd[1]
+ openDVS_pixel2x2_top_491/vpd[3] openDVS_pixel2x2_top_491/vpd[2] rowReadOFF[31] rowReadON[31]
+ rowReadON[30] RefrBp PrBp PrSFBp col_periphery_1x2_11/COL_LINE0 pixRst[22] OffBn
+ rowReadOFF[30] pixRst[23] openDVS_pixel2x2_top_511/GndD DiffBn col_periphery_1x2_11/COL_LINE1
+ GndD VddA18 OnBn openDVS_pixel2x2_top
XopenDVS_pixel2x2_top_480 openDVS_pixel2x2_top_480/vpd[0] openDVS_pixel2x2_top_480/vpd[1]
+ openDVS_pixel2x2_top_480/vpd[3] openDVS_pixel2x2_top_480/vpd[2] rowReadOFF[31] rowReadON[31]
+ rowReadON[30] RefrBp PrBp PrSFBp col_periphery_1x2_0/COL_LINE0 pixRst[0] OffBn rowReadOFF[30]
+ pixRst[1] openDVS_pixel2x2_top_511/GndD DiffBn col_periphery_1x2_0/COL_LINE1 GndD
+ VddA18 OnBn openDVS_pixel2x2_top
.ends

.subckt pixel_4tile col_event_rst_bot_right[63] col_event_rst_bot_right[62] col_event_rst_bot_right[61]
+ col_event_rst_bot_right[60] col_event_rst_bot_right[59] col_event_rst_bot_right[58]
+ col_event_rst_bot_right[57] col_event_rst_bot_right[56] col_event_rst_bot_right[55]
+ col_event_rst_bot_right[54] col_event_rst_bot_right[53] col_event_rst_bot_right[52]
+ col_event_rst_bot_right[51] col_event_rst_bot_right[50] col_event_rst_bot_right[49]
+ col_event_rst_bot_right[48] col_event_rst_bot_right[47] col_event_rst_bot_right[46]
+ col_event_rst_bot_right[45] col_event_rst_bot_right[44] col_event_rst_bot_right[43]
+ col_event_rst_bot_right[42] col_event_rst_bot_right[41] col_event_rst_bot_right[40]
+ col_event_rst_bot_right[39] col_event_rst_bot_right[38] col_event_rst_bot_right[37]
+ col_event_rst_bot_right[36] col_event_rst_bot_right[35] col_event_rst_bot_right[34]
+ col_event_rst_bot_right[33] col_event_rst_bot_right[32] col_event_rst_bot_right[31]
+ col_event_rst_bot_right[30] col_event_rst_bot_right[29] col_event_rst_bot_right[28]
+ col_event_rst_bot_right[27] col_event_rst_bot_right[26] col_event_rst_bot_right[25]
+ col_event_rst_bot_right[24] col_event_rst_bot_right[23] col_event_rst_bot_right[22]
+ col_event_rst_bot_right[21] col_event_rst_bot_right[20] col_event_rst_bot_right[19]
+ col_event_rst_bot_right[18] col_event_rst_bot_right[17] col_event_rst_bot_right[16]
+ col_event_rst_bot_right[15] col_event_rst_bot_right[14] col_event_rst_bot_right[13]
+ col_event_rst_bot_right[12] col_event_rst_bot_right[11] col_event_rst_bot_right[10]
+ col_event_rst_bot_right[9] col_event_rst_bot_right[8] col_event_rst_bot_right[7]
+ col_event_rst_bot_right[6] col_event_rst_bot_right[5] col_event_rst_bot_right[4]
+ col_event_rst_bot_right[3] col_event_rst_bot_right[2] col_event_rst_bot_right[1]
+ col_event_rst_bot_right[0] col_event_rst_bot_left[63] col_event_rst_bot_left[62]
+ col_event_rst_bot_left[61] col_event_rst_bot_left[60] col_event_rst_bot_left[59]
+ col_event_rst_bot_left[58] col_event_rst_bot_left[57] col_event_rst_bot_left[56]
+ col_event_rst_bot_left[55] col_event_rst_bot_left[54] col_event_rst_bot_left[53]
+ col_event_rst_bot_left[52] col_event_rst_bot_left[51] col_event_rst_bot_left[50]
+ col_event_rst_bot_left[49] col_event_rst_bot_left[48] col_event_rst_bot_left[47]
+ col_event_rst_bot_left[46] col_event_rst_bot_left[45] col_event_rst_bot_left[44]
+ col_event_rst_bot_left[43] col_event_rst_bot_left[42] col_event_rst_bot_left[41]
+ col_event_rst_bot_left[40] col_event_rst_bot_left[39] col_event_rst_bot_left[38]
+ col_event_rst_bot_left[37] col_event_rst_bot_left[36] col_event_rst_bot_left[35]
+ col_event_rst_bot_left[34] col_event_rst_bot_left[33] col_event_rst_bot_left[32]
+ col_event_rst_bot_left[31] col_event_rst_bot_left[30] col_event_rst_bot_left[29]
+ col_event_rst_bot_left[28] col_event_rst_bot_left[27] col_event_rst_bot_left[26]
+ col_event_rst_bot_left[25] col_event_rst_bot_left[24] col_event_rst_bot_left[23]
+ col_event_rst_bot_left[22] col_event_rst_bot_left[21] col_event_rst_bot_left[20]
+ col_event_rst_bot_left[19] col_event_rst_bot_left[18] col_event_rst_bot_left[17]
+ col_event_rst_bot_left[16] col_event_rst_bot_left[15] col_event_rst_bot_left[14]
+ col_event_rst_bot_left[13] col_event_rst_bot_left[12] col_event_rst_bot_left[11]
+ col_event_rst_bot_left[10] col_event_rst_bot_left[9] col_event_rst_bot_left[8] col_event_rst_bot_left[7]
+ col_event_rst_bot_left[6] col_event_rst_bot_left[5] col_event_rst_bot_left[4] col_event_rst_bot_left[3]
+ col_event_rst_bot_left[2] col_event_rst_bot_left[1] col_event_rst_bot_left[0] vssc1
+ array_col_bot_left[55] array_col_bot_left[42] array_col_bot_right[14] array_col_bot_left[41]
+ array_col_bot_left[40] array_col_bot_left[20] array_col_bot_left[23] array_col_bot_right[3]
+ array_col_bot_right[15] array_col_bot_right[17] array_col_bot_right[9] array_col_bot_left[31]
+ array_col_bot_right[23] array_col_bot_left[43] array_col_bot_left[60] array_col_bot_left[21]
+ array_col_bot_left[22] array_col_bot_left[16] array_col_bot_left[45] array_col_bot_right[16]
+ array_col_bot_left[32] array_col_bot_left[7] array_col_bot_right[27] array_col_bot_right[26]
+ array_col_bot_right[11] array_col_bot_left[0] array_col_bot_right[2] array_col_bot_right[18]
+ array_col_bot_left[44] array_col_bot_right[4] array_col_bot_right[6] array_col_bot_right[22]
+ array_col_bot_right[55] array_col_bot_right[10] array_col_bot_right[19] array_col_bot_right[1]
+ array_col_bot_right[62] array_col_bot_right[59] array_col_bot_right[0] array_col_bot_right[58]
+ array_col_bot_right[54] array_col_bot_left[62] array_col_bot_left[15] array_col_bot_left[14]
+ array_col_bot_left[5] array_col_bot_left[4] array_col_bot_right[13] array_col_bot_right[61]
+ array_col_bot_left[30] array_col_bot_left[33] array_col_bot_left[26] array_col_bot_left[58]
+ array_col_bot_left[2] array_col_bot_left[3] array_col_bot_right[29] array_col_bot_right[28]
+ array_col_bot_right[25] array_col_bot_left[54] array_col_bot_right[24] array_col_bot_right[21]
+ array_col_bot_right[20] array_col_bot_right[7] array_col_bot_right[12] array_col_bot_left[53]
+ array_col_bot_left[50] array_col_bot_left[49] array_col_bot_right[60] array_col_bot_right[57]
+ array_col_bot_right[56] array_col_bot_right[53] array_col_bot_right[52] array_col_bot_right[49]
+ array_col_bot_right[48] array_col_bot_right[45] array_col_bot_right[44] array_col_bot_right[41]
+ array_col_bot_right[40] array_col_bot_right[37] array_col_bot_right[36] array_col_bot_right[33]
+ array_col_bot_right[32] array_col_bot_left[10] array_col_bot_left[11] array_col_bot_left[6]
+ array_col_bot_left[37] array_col_bot_left[36] array_col_bot_left[29] array_col_bot_left[28]
+ array_col_bot_left[24] array_col_bot_left[19] array_col_bot_left[61] array_col_bot_left[57]
+ array_col_bot_left[56] array_col_bot_left[52] array_col_bot_left[51] array_col_bot_left[48]
+ array_col_bot_left[47] array_col_bot_left[46] array_col_bot_left[63] array_col_bot_right[51]
+ array_col_bot_right[50] array_col_bot_right[47] array_col_bot_right[46] array_col_bot_right[43]
+ array_col_bot_right[42] array_col_bot_right[39] array_col_bot_right[38] array_col_bot_right[35]
+ array_col_bot_right[8] array_col_bot_right[34] array_col_bot_right[31] array_col_bot_left[1]
+ array_col_bot_right[30] array_col_bot_left[12] array_col_bot_left[13] array_col_bot_left[39]
+ array_col_bot_left[38] array_col_bot_left[35] array_col_bot_right[5] array_col_bot_left[34]
+ array_col_bot_left[27] array_col_bot_left[25] array_col_bot_left[18] array_col_bot_left[17]
+ array_col_bot_left[9] array_col_bot_right[63] array_col_bot_left[8] array_col_bot_left[59]
+ row_off_detect_top[44] row_off_detect_top[43] row_on_detect_bot[46] row_on_detect_bot[45]
+ detect_pulse_global_top_left row_on_detect_bot[43] row_on_detect_bot[28] row_on_detect_bot[29]
+ row_on_detect_bot[27] row_on_detect_bot[30] row_on_detect_bot[20] row_on_detect_bot[19]
+ row_off_detect_bot[53] row_on_detect_bot[32] row_off_detect_bot[54] row_on_detect_bot[34]
+ row_on_detect_bot[31] row_on_detect_bot[36] row_on_detect_bot[33] row_on_detect_bot[35]
+ row_on_detect_bot[38] row_off_detect_bot[52] row_on_detect_bot[40] row_on_detect_bot[37]
+ row_on_detect_bot[42] row_on_detect_bot[39] row_on_detect_bot[44] row_on_detect_bot[41]
+ row_on_detect_bot[63] dac_config_1 row_off_detect_bot[36] row_off_detect_bot[34]
+ row_off_detect_bot[35] row_on_detect_bot[21] row_on_detect_top[21] row_on_detect_top[22]
+ pre_charge_global_top_left row_on_detect_top[3] row_on_detect_top[4] pre_charge_global_bot_left
+ row_off_detect_top[33] row_off_detect_top[34] row_off_detect_top[36] row_off_detect_top[0]
+ row_off_detect_top[31] row_off_detect_top[32] row_off_detect_top[40] row_off_detect_top[41]
+ row_off_detect_top[42] row_off_detect_top[47] row_on_detect_top[27] row_off_detect_top[61]
+ row_on_detect_bot[25] row_on_detect_bot[53] row_off_detect_top[59] row_off_detect_bot[37]
+ dac_config_2 row_off_detect_top[11] row_off_detect_top[25] row_on_detect_bot[49]
+ row_on_detect_bot[50] row_on_detect_bot[11] row_off_detect_bot[38] row_off_detect_bot[39]
+ row_off_detect_bot[40] row_off_detect_bot[26] dac_config_3 row_on_detect_bot[22]
+ dac_config_4 row_on_detect_bot[7] row_on_detect_bot[8] row_off_detect_bot[41] row_on_detect_bot[3]
+ row_on_detect_bot[4] row_off_detect_top[35] row_off_detect_top[37] row_off_detect_top[38]
+ row_on_detect_top[63] row_on_detect_top[43] row_on_detect_top[44] row_off_detect_top[39]
+ row_off_detect_top[48] row_off_detect_top[49] row_off_detect_top[50] row_on_detect_top[28]
+ row_off_detect_bot[42] row_off_detect_top[58] row_off_detect_top[62] row_on_detect_bot[26]
+ row_on_detect_bot[54] row_on_detect_top[19] row_on_detect_top[20] row_off_detect_top[60]
+ row_off_detect_bot[43] row_off_detect_top[12] row_on_detect_top[0] row_off_detect_top[26]
+ ndetect_pulse_global_bot_left row_on_detect_bot[12] dac_config_0 row_on_detect_top[1]
+ row_on_detect_top[2] row_on_detect_top[23] row_off_detect_top[9] row_off_detect_top[10]
+ row_on_detect_bot[1] row_on_detect_top[33] row_on_detect_top[31] row_on_detect_top[32]
+ row_off_detect_top[57] row_on_detect_top[47] row_off_detect_top[3] row_off_detect_top[4]
+ row_off_detect_top[24] row_off_detect_top[21] row_off_detect_top[22] row_off_detect_top[17]
+ row_off_detect_top[18] row_off_detect_top[16] row_off_detect_top[51] row_on_detect_top[51]
+ row_on_detect_top[52] row_off_detect_top[30] row_on_detect_top[41] row_on_detect_bot[23]
+ row_on_detect_bot[24] row_on_detect_bot[60] row_off_detect_bot[2] row_off_detect_bot[3]
+ row_off_detect_bot[4] row_off_detect_bot[21] row_off_detect_bot[20] row_off_detect_bot[17]
+ row_off_detect_bot[12] row_off_detect_bot[11] row_off_detect_bot[10] row_off_detect_bot[6]
+ row_off_detect_bot[5] row_off_detect_bot[63] row_off_detect_bot[61] row_off_detect_bot[57]
+ row_on_detect_bot[9] row_on_detect_bot[10] row_on_detect_bot[62] row_on_detect_top[58]
+ row_on_detect_top[55] row_on_detect_top[17] row_on_detect_top[18] row_on_detect_top[39]
+ row_on_detect_top[15] row_on_detect_bot[51] row_on_detect_bot[52] row_on_detect_top[25]
+ row_on_detect_top[24] row_off_detect_bot[29] row_off_detect_bot[28] row_on_detect_bot[2]
+ row_on_detect_top[37] row_on_detect_top[38] row_on_detect_top[34] row_off_detect_top[19]
+ row_off_detect_top[20] row_on_detect_top[26] row_on_detect_top[48] row_on_detect_top[59]
+ row_on_detect_top[60] row_on_detect_top[13] row_on_detect_top[14] row_off_detect_top[53]
+ row_off_detect_top[54] row_off_detect_top[23] row_on_detect_top[9] row_on_detect_top[10]
+ row_off_detect_top[15] row_off_detect_bot[44] row_off_detect_bot[45] row_off_detect_top[52]
+ detect_pulse_global_bot_left ndetect_pulse_global_top_left row_off_detect_top[29]
+ row_on_detect_top[42] row_on_detect_top[11] row_on_detect_top[12] row_on_detect_bot[59]
+ row_off_detect_bot[0] row_off_detect_bot[23] row_off_detect_bot[22] row_off_detect_bot[16]
+ row_off_detect_bot[30] row_off_detect_bot[13] row_off_detect_bot[7] row_off_detect_bot[58]
+ row_off_detect_bot[59] row_on_detect_bot[17] row_on_detect_bot[18] row_on_detect_top[57]
+ row_on_detect_top[56] dac_config_6 row_on_detect_top[40] row_on_detect_top[16] row_on_detect_bot[61]
+ row_off_detect_bot[1] row_on_detect_top[35] row_on_detect_top[36] row_on_detect_bot[13]
+ row_on_detect_bot[14] row_off_detect_bot[25] row_off_detect_bot[24] row_off_detect_bot[19]
+ row_off_detect_bot[18] row_off_detect_bot[15] row_off_detect_bot[14] row_off_detect_bot[9]
+ row_off_detect_bot[8] row_on_detect_bot[15] row_on_detect_bot[16] row_off_detect_bot[62]
+ row_off_detect_bot[60] row_off_detect_top[1] row_off_detect_top[2] row_off_detect_bot[56]
+ row_off_detect_bot[55] row_on_detect_top[5] row_on_detect_top[6] row_off_detect_top[5]
+ row_off_detect_top[6] row_off_detect_top[7] row_off_detect_top[8] row_off_detect_top[55]
+ row_off_detect_top[56] row_off_detect_top[13] row_off_detect_top[14] row_on_detect_top[49]
+ row_on_detect_top[50] row_on_detect_bot[5] row_on_detect_bot[6] row_off_detect_bot[32]
+ row_off_detect_bot[46] row_off_detect_bot[47] row_off_detect_bot[33] row_on_detect_top[53]
+ row_on_detect_top[54] row_on_detect_top[7] row_on_detect_top[8] row_on_detect_bot[47]
+ row_on_detect_bot[48] row_off_detect_top[45] row_off_detect_top[46] row_on_detect_top[45]
+ row_on_detect_top[46] row_off_detect_top[63] row_on_detect_bot[0] row_off_detect_top[27]
+ row_off_detect_top[28] row_on_detect_top[61] row_on_detect_top[62] row_on_detect_top[29]
+ row_on_detect_top[30] row_off_detect_bot[27] row_off_detect_bot[48] row_off_detect_bot[49]
+ dac_config_5 row_off_detect_bot[50] row_off_detect_bot[51] row_on_detect_bot[58]
+ row_off_detect_bot[31] row_on_detect_bot[55] row_on_detect_bot[56] row_on_detect_bot[57]
Xpixel_layout_tile_bot_0 array_col_bot_right[12] array_col_bot_right[11] array_col_bot_right[10]
+ array_col_bot_right[9] array_col_bot_right[8] array_col_bot_right[7] array_col_bot_right[6]
+ col_event_rst_bot_right[0] col_event_rst_bot_right[4] col_event_rst_bot_right[5]
+ col_event_rst_bot_right[6] col_event_rst_bot_right[7] col_event_rst_bot_right[8]
+ col_event_rst_bot_right[11] array_col_bot_right[32] array_col_bot_right[31] array_col_bot_right[30]
+ array_col_bot_right[27] array_col_bot_right[26] array_col_bot_right[25] array_col_bot_right[24]
+ col_event_rst_bot_right[24] col_event_rst_bot_right[25] col_event_rst_bot_right[26]
+ col_event_rst_bot_right[27] col_event_rst_bot_right[32] col_event_rst_bot_right[33]
+ col_event_rst_bot_right[34] array_col_bot_right[52] array_col_bot_right[51] array_col_bot_right[50]
+ array_col_bot_right[44] array_col_bot_right[56] array_col_bot_right[57] array_col_bot_right[60]
+ col_event_rst_bot_right[53] col_event_rst_bot_right[48] col_event_rst_bot_right[45]
+ col_event_rst_bot_right[44] col_event_rst_bot_right[63] col_event_rst_bot_right[58]
+ col_event_rst_bot_right[57] col_event_rst_bot_right[56] col_event_rst_bot_right[55]
+ col_event_rst_bot_right[54] row_on_detect_bot[0] row_on_detect_bot[1] row_on_detect_bot[10]
+ row_on_detect_bot[11] row_on_detect_bot[14] row_on_detect_bot[15] row_on_detect_bot[16]
+ row_on_detect_bot[17] row_on_detect_bot[18] row_on_detect_bot[19] row_on_detect_bot[20]
+ row_on_detect_bot[21] row_on_detect_bot[22] row_on_detect_bot[23] row_on_detect_bot[24]
+ row_on_detect_bot[34] row_on_detect_bot[35] row_on_detect_bot[36] row_on_detect_bot[37]
+ row_on_detect_bot[40] row_on_detect_bot[62] row_off_detect_bot[2] row_off_detect_bot[3]
+ row_off_detect_bot[7] row_off_detect_bot[8] row_off_detect_bot[9] row_off_detect_bot[10]
+ row_off_detect_bot[11] row_off_detect_bot[12] row_off_detect_bot[13] row_off_detect_bot[14]
+ row_off_detect_bot[23] row_off_detect_bot[24] row_off_detect_bot[26] row_off_detect_bot[27]
+ row_off_detect_bot[30] row_off_detect_bot[31] row_off_detect_bot[44] row_off_detect_bot[45]
+ row_off_detect_bot[46] row_off_detect_bot[47] row_off_detect_bot[51] row_off_detect_bot[54]
+ row_off_detect_bot[55] row_off_detect_bot[56] row_off_detect_bot[57] row_off_detect_bot[60]
+ row_off_detect_bot[61] vssc1 vssc1 vssc1 vssc1 vssc1 vssc1 col_event_rst_bot_right[42]
+ vssc1 vssc1 vssc1 pixel_layout_tile_bot_1/openDVS_pixel2x2_bot_927/GndD row_off_detect_bot[42]
+ pixel_layout_tile_bot_1/openDVS_pixel2x2_bot_223/GndD row_on_detect_bot[63] col_event_rst_bot_right[43]
+ vssc1 row_off_detect_bot[43] vssc1 pixel_layout_tile_bot_1/openDVS_pixel2x2_bot_703/GndD
+ col_event_rst_bot_right[1] vssc1 row_on_detect_bot[28] vssc1 row_on_detect_bot[25]
+ row_on_detect_bot[29] vssc1 array_col_bot_right[18] col_event_rst_bot_right[35]
+ col_event_rst_bot_right[41] row_off_detect_bot[18] vssc1 pixel_layout_tile_bot_1/openDVS_pixel2x2_bot_351/GndD
+ col_event_rst_bot_right[22] row_off_detect_bot[19] vssc1 col_event_rst_bot_right[14]
+ row_off_detect_bot[38] col_event_rst_bot_right[23] pixel_layout_tile_bot_1/openDVS_pixel2x2_bot_415/GndD
+ array_col_bot_right[23] vssc1 array_col_bot_right[40] row_on_detect_bot[12] row_off_detect_bot[39]
+ array_col_bot_right[35] row_on_detect_bot[13] pixel_layout_tile_bot_1/openDVS_pixel2x2_bot_991/GndD
+ row_on_detect_bot[46] row_off_detect_bot[6] row_off_detect_bot[15] row_on_detect_bot[26]
+ row_off_detect_bot[34] col_event_rst_bot_right[15] row_on_detect_bot[50] row_on_detect_bot[47]
+ col_event_rst_bot_right[16] row_on_detect_bot[27] row_off_detect_bot[35] row_off_detect_bot[0]
+ row_on_detect_bot[51] vssc1 pixel_layout_tile_bot_1/openDVS_pixel2x2_bot_287/GndD
+ row_on_detect_bot[6] row_off_detect_bot[1] array_col_bot_right[19] array_col_bot_right[20]
+ array_col_bot_right[61] pixel_layout_tile_bot_1/openDVS_pixel2x2_bot_767/GndD row_on_detect_bot[7]
+ array_col_bot_right[62] row_on_detect_bot[41] vssc1 row_on_detect_bot[30] vssc1
+ col_event_rst_bot_right[38] array_col_bot_right[36] pixel_layout_tile_bot_1/openDVS_pixel2x2_bot_447/GndD
+ ndetect_pulse_global_bot_left pixel_layout_tile_bot_1/openDVS_pixel2x2_bot_543/GndD
+ pixel_layout_tile_bot_1/openDVS_pixel2x2_bot_63/GndD vssc1 row_on_detect_bot[31]
+ array_col_bot_right[41] row_off_detect_bot[52] array_col_bot_right[37] array_col_bot_right[42]
+ row_on_detect_bot[44] pixel_layout_tile_bot_1/openDVS_pixel2x2_bot_607/GndD pixel_layout_tile_bot_1/openDVS_pixel2x2_bot_99/GndD
+ col_event_rst_bot_right[31] row_off_detect_bot[53] col_event_rst_bot_right[49] col_event_rst_bot_right[50]
+ row_on_detect_bot[45] col_event_rst_bot_right[12] row_on_detect_bot[58] col_event_rst_bot_right[21]
+ col_event_rst_bot_right[46] array_col_bot_right[3] vssc1 row_on_detect_bot[54] array_col_bot_right[0]
+ col_event_rst_bot_right[2] pixel_layout_tile_bot_1/openDVS_pixel2x2_bot_383/GndD
+ col_event_rst_bot_right[13] vssc1 row_on_detect_bot[59] col_event_rst_bot_right[17]
+ col_event_rst_bot_right[47] array_col_bot_right[15] row_on_detect_bot[55] col_event_rst_bot_right[59]
+ array_col_bot_right[47] col_event_rst_bot_right[3] array_col_bot_right[53] row_on_detect_bot[38]
+ pre_charge_global_bot_left row_off_detect_bot[40] array_col_bot_right[54] row_off_detect_bot[62]
+ pixel_layout_tile_bot_1/openDVS_pixel2x2_bot_863/GndD col_event_rst_bot_right[30]
+ row_off_detect_bot[32] row_on_detect_bot[39] pixel_layout_tile_bot_1/openDVS_pixel2x2_bot_479/GndD
+ row_off_detect_bot[41] array_col_bot_right[58] row_off_detect_bot[63] array_col_bot_right[21]
+ row_on_detect_bot[48] vssc1 array_col_bot_right[22] pixel_layout_tile_bot_1/openDVS_pixel2x2_bot_999/GndD
+ array_col_bot_right[63] row_off_detect_bot[17] row_off_detect_bot[33] col_event_rst_bot_right[39]
+ array_col_bot_right[38] array_col_bot_right[59] pixel_layout_tile_bot_1/openDVS_pixel2x2_bot_959/GndD
+ col_event_rst_bot_right[40] array_col_bot_right[33] row_on_detect_bot[52] row_on_detect_bot[49]
+ array_col_bot_right[34] pixel_layout_tile_bot_1/openDVS_pixel2x2_bot_159/GndD row_on_detect_bot[32]
+ pixel_layout_tile_bot_1/openDVS_pixel2x2_bot_255/GndD vssc1 row_on_detect_bot[4]
+ array_col_bot_right[39] row_off_detect_bot[37] row_off_detect_bot[28] row_on_detect_bot[53]
+ array_col_bot_right[5] vssc1 vssc1 row_on_detect_bot[33] pixel_layout_tile_bot_1/openDVS_pixel2x2_bot_319/GndD
+ row_on_detect_bot[8] detect_pulse_global_bot_left row_on_detect_bot[5] pixel_layout_tile_bot_1/openDVS_pixel2x2_bot_639/GndD
+ vssc1 row_off_detect_bot[4] pixel_layout_tile_bot_1/openDVS_pixel2x2_bot_735/GndD
+ row_off_detect_bot[20] array_col_bot_right[43] row_off_detect_bot[58] row_on_detect_bot[42]
+ row_off_detect_bot[29] row_on_detect_bot[3] pixel_layout_tile_bot_1/openDVS_pixel2x2_bot_831/GndD
+ row_off_detect_bot[48] col_event_rst_bot_right[36] col_event_rst_bot_right[9] array_col_bot_right[16]
+ row_on_detect_bot[9] array_col_bot_right[48] row_off_detect_bot[5] row_off_detect_bot[22]
+ row_off_detect_bot[21] row_off_detect_bot[59] pixel_layout_tile_bot_1/openDVS_pixel2x2_bot_799/GndD
+ row_on_detect_bot[43] col_event_rst_bot_right[51] array_col_bot_right[4] pixel_layout_tile_bot_1/openDVS_pixel2x2_bot_895/GndD
+ row_on_detect_bot[60] row_off_detect_bot[36] array_col_bot_right[45] vssc1 col_event_rst_bot_right[28]
+ row_off_detect_bot[49] array_col_bot_right[46] col_event_rst_bot_right[37] vssc1
+ row_on_detect_bot[56] pixel_layout_tile_bot_1/openDVS_pixel2x2_bot_191/GndD col_event_rst_bot_right[60]
+ array_col_bot_right[17] array_col_bot_right[1] pixel_layout_tile_bot_1/openDVS_pixel2x2_bot_511/GndD
+ pixel_layout_tile_bot_1/GND array_col_bot_right[28] array_col_bot_right[49] dac_config_3
+ array_col_bot_right[2] row_on_detect_bot[61] vssc1 col_event_rst_bot_right[18] vssc1
+ row_off_detect_bot[25] col_event_rst_bot_right[29] row_off_detect_bot[16] col_event_rst_bot_right[52]
+ row_on_detect_bot[2] dac_config_6 row_on_detect_bot[57] dac_config_5 col_event_rst_bot_right[20]
+ vssc1 array_col_bot_right[13] array_col_bot_right[29] pixel_layout_tile_bot_1/openDVS_pixel2x2_bot_575/GndD
+ pixel_layout_tile_bot_1/openDVS_pixel2x2_bot_95/GndD col_event_rst_bot_right[61]
+ pixel_layout_tile_bot_1/openDVS_pixel2x2_bot_671/GndD array_col_bot_right[14] dac_config_0
+ dac_config_4 col_event_rst_bot_right[10] row_off_detect_bot[50] dac_config_2 dac_config_1
+ col_event_rst_bot_right[19] vssc1 col_event_rst_bot_right[62] array_col_bot_right[55]
+ vssc1 pixel_layout_tile_bot
Xpixel_layout_tile_bot_1 array_col_bot_left[12] array_col_bot_left[11] array_col_bot_left[10]
+ array_col_bot_left[9] array_col_bot_left[8] array_col_bot_left[7] array_col_bot_left[6]
+ col_event_rst_bot_left[0] col_event_rst_bot_left[4] col_event_rst_bot_left[5] col_event_rst_bot_left[6]
+ col_event_rst_bot_left[7] col_event_rst_bot_left[8] col_event_rst_bot_left[11] array_col_bot_left[32]
+ array_col_bot_left[31] array_col_bot_left[30] array_col_bot_left[27] array_col_bot_left[26]
+ array_col_bot_left[25] array_col_bot_left[24] col_event_rst_bot_left[24] col_event_rst_bot_left[25]
+ col_event_rst_bot_left[26] col_event_rst_bot_left[27] col_event_rst_bot_left[32]
+ col_event_rst_bot_left[33] col_event_rst_bot_left[34] array_col_bot_left[52] array_col_bot_left[51]
+ array_col_bot_left[50] array_col_bot_left[44] array_col_bot_left[56] array_col_bot_left[57]
+ array_col_bot_left[60] col_event_rst_bot_left[53] col_event_rst_bot_left[48] col_event_rst_bot_left[45]
+ col_event_rst_bot_left[44] col_event_rst_bot_left[63] col_event_rst_bot_left[58]
+ col_event_rst_bot_left[57] col_event_rst_bot_left[56] col_event_rst_bot_left[55]
+ col_event_rst_bot_left[54] row_on_detect_bot[0] row_on_detect_bot[1] row_on_detect_bot[10]
+ row_on_detect_bot[11] row_on_detect_bot[14] row_on_detect_bot[15] row_on_detect_bot[16]
+ row_on_detect_bot[17] row_on_detect_bot[18] row_on_detect_bot[19] row_on_detect_bot[20]
+ row_on_detect_bot[21] row_on_detect_bot[22] row_on_detect_bot[23] row_on_detect_bot[24]
+ row_on_detect_bot[34] row_on_detect_bot[35] row_on_detect_bot[36] row_on_detect_bot[37]
+ row_on_detect_bot[40] row_on_detect_bot[62] row_off_detect_bot[2] row_off_detect_bot[3]
+ row_off_detect_bot[7] row_off_detect_bot[8] row_off_detect_bot[9] row_off_detect_bot[10]
+ row_off_detect_bot[11] row_off_detect_bot[12] row_off_detect_bot[13] row_off_detect_bot[14]
+ row_off_detect_bot[23] row_off_detect_bot[24] row_off_detect_bot[26] row_off_detect_bot[27]
+ row_off_detect_bot[30] row_off_detect_bot[31] row_off_detect_bot[44] row_off_detect_bot[45]
+ row_off_detect_bot[46] row_off_detect_bot[47] row_off_detect_bot[51] row_off_detect_bot[54]
+ row_off_detect_bot[55] row_off_detect_bot[56] row_off_detect_bot[57] row_off_detect_bot[60]
+ row_off_detect_bot[61] vssc1 vssc1 vssc1 vssc1 vssc1 vssc1 col_event_rst_bot_left[42]
+ vssc1 vssc1 vssc1 pixel_layout_tile_bot_1/openDVS_pixel2x2_bot_927/GndD row_off_detect_bot[42]
+ pixel_layout_tile_bot_1/openDVS_pixel2x2_bot_223/GndD row_on_detect_bot[63] col_event_rst_bot_left[43]
+ vssc1 row_off_detect_bot[43] vssc1 pixel_layout_tile_bot_1/openDVS_pixel2x2_bot_703/GndD
+ col_event_rst_bot_left[1] vssc1 row_on_detect_bot[28] vssc1 row_on_detect_bot[25]
+ row_on_detect_bot[29] vssc1 array_col_bot_left[18] col_event_rst_bot_left[35] col_event_rst_bot_left[41]
+ row_off_detect_bot[18] vssc1 pixel_layout_tile_bot_1/openDVS_pixel2x2_bot_351/GndD
+ col_event_rst_bot_left[22] row_off_detect_bot[19] vssc1 col_event_rst_bot_left[14]
+ row_off_detect_bot[38] col_event_rst_bot_left[23] pixel_layout_tile_bot_1/openDVS_pixel2x2_bot_415/GndD
+ array_col_bot_left[23] vssc1 array_col_bot_left[40] row_on_detect_bot[12] row_off_detect_bot[39]
+ array_col_bot_left[35] row_on_detect_bot[13] pixel_layout_tile_bot_1/openDVS_pixel2x2_bot_991/GndD
+ row_on_detect_bot[46] row_off_detect_bot[6] row_off_detect_bot[15] row_on_detect_bot[26]
+ row_off_detect_bot[34] col_event_rst_bot_left[15] row_on_detect_bot[50] row_on_detect_bot[47]
+ col_event_rst_bot_left[16] row_on_detect_bot[27] row_off_detect_bot[35] row_off_detect_bot[0]
+ row_on_detect_bot[51] vssc1 pixel_layout_tile_bot_1/openDVS_pixel2x2_bot_287/GndD
+ row_on_detect_bot[6] row_off_detect_bot[1] array_col_bot_left[19] array_col_bot_left[20]
+ array_col_bot_left[61] pixel_layout_tile_bot_1/openDVS_pixel2x2_bot_767/GndD row_on_detect_bot[7]
+ array_col_bot_left[62] row_on_detect_bot[41] vssc1 row_on_detect_bot[30] vssc1 col_event_rst_bot_left[38]
+ array_col_bot_left[36] pixel_layout_tile_bot_1/openDVS_pixel2x2_bot_447/GndD ndetect_pulse_global_bot_left
+ pixel_layout_tile_bot_1/openDVS_pixel2x2_bot_543/GndD pixel_layout_tile_bot_1/openDVS_pixel2x2_bot_63/GndD
+ vssc1 row_on_detect_bot[31] array_col_bot_left[41] row_off_detect_bot[52] array_col_bot_left[37]
+ array_col_bot_left[42] row_on_detect_bot[44] pixel_layout_tile_bot_1/openDVS_pixel2x2_bot_607/GndD
+ pixel_layout_tile_bot_1/openDVS_pixel2x2_bot_99/GndD col_event_rst_bot_left[31]
+ row_off_detect_bot[53] col_event_rst_bot_left[49] col_event_rst_bot_left[50] row_on_detect_bot[45]
+ col_event_rst_bot_left[12] row_on_detect_bot[58] col_event_rst_bot_left[21] col_event_rst_bot_left[46]
+ array_col_bot_left[3] vssc1 row_on_detect_bot[54] array_col_bot_left[0] col_event_rst_bot_left[2]
+ pixel_layout_tile_bot_1/openDVS_pixel2x2_bot_383/GndD col_event_rst_bot_left[13]
+ vssc1 row_on_detect_bot[59] col_event_rst_bot_left[17] col_event_rst_bot_left[47]
+ array_col_bot_left[15] row_on_detect_bot[55] col_event_rst_bot_left[59] array_col_bot_left[47]
+ col_event_rst_bot_left[3] array_col_bot_left[53] row_on_detect_bot[38] pre_charge_global_bot_left
+ row_off_detect_bot[40] array_col_bot_left[54] row_off_detect_bot[62] pixel_layout_tile_bot_1/openDVS_pixel2x2_bot_863/GndD
+ col_event_rst_bot_left[30] row_off_detect_bot[32] row_on_detect_bot[39] pixel_layout_tile_bot_1/openDVS_pixel2x2_bot_479/GndD
+ row_off_detect_bot[41] array_col_bot_left[58] row_off_detect_bot[63] array_col_bot_left[21]
+ row_on_detect_bot[48] vssc1 array_col_bot_left[22] pixel_layout_tile_bot_1/openDVS_pixel2x2_bot_999/GndD
+ array_col_bot_left[63] row_off_detect_bot[17] row_off_detect_bot[33] col_event_rst_bot_left[39]
+ array_col_bot_left[38] array_col_bot_left[59] pixel_layout_tile_bot_1/openDVS_pixel2x2_bot_959/GndD
+ col_event_rst_bot_left[40] array_col_bot_left[33] row_on_detect_bot[52] row_on_detect_bot[49]
+ array_col_bot_left[34] pixel_layout_tile_bot_1/openDVS_pixel2x2_bot_159/GndD row_on_detect_bot[32]
+ pixel_layout_tile_bot_1/openDVS_pixel2x2_bot_255/GndD vssc1 row_on_detect_bot[4]
+ array_col_bot_left[39] row_off_detect_bot[37] row_off_detect_bot[28] row_on_detect_bot[53]
+ array_col_bot_left[5] vssc1 vssc1 row_on_detect_bot[33] pixel_layout_tile_bot_1/openDVS_pixel2x2_bot_319/GndD
+ row_on_detect_bot[8] detect_pulse_global_bot_left row_on_detect_bot[5] pixel_layout_tile_bot_1/openDVS_pixel2x2_bot_639/GndD
+ vssc1 row_off_detect_bot[4] pixel_layout_tile_bot_1/openDVS_pixel2x2_bot_735/GndD
+ row_off_detect_bot[20] array_col_bot_left[43] row_off_detect_bot[58] row_on_detect_bot[42]
+ row_off_detect_bot[29] row_on_detect_bot[3] pixel_layout_tile_bot_1/openDVS_pixel2x2_bot_831/GndD
+ row_off_detect_bot[48] col_event_rst_bot_left[36] col_event_rst_bot_left[9] array_col_bot_left[16]
+ row_on_detect_bot[9] array_col_bot_left[48] row_off_detect_bot[5] row_off_detect_bot[22]
+ row_off_detect_bot[21] row_off_detect_bot[59] pixel_layout_tile_bot_1/openDVS_pixel2x2_bot_799/GndD
+ row_on_detect_bot[43] col_event_rst_bot_left[51] array_col_bot_left[4] pixel_layout_tile_bot_1/openDVS_pixel2x2_bot_895/GndD
+ row_on_detect_bot[60] row_off_detect_bot[36] array_col_bot_left[45] vssc1 col_event_rst_bot_left[28]
+ row_off_detect_bot[49] array_col_bot_left[46] col_event_rst_bot_left[37] vssc1 row_on_detect_bot[56]
+ pixel_layout_tile_bot_1/openDVS_pixel2x2_bot_191/GndD col_event_rst_bot_left[60]
+ array_col_bot_left[17] array_col_bot_left[1] pixel_layout_tile_bot_1/openDVS_pixel2x2_bot_511/GndD
+ pixel_layout_tile_bot_1/GND array_col_bot_left[28] array_col_bot_left[49] dac_config_3
+ array_col_bot_left[2] row_on_detect_bot[61] vssc1 col_event_rst_bot_left[18] vssc1
+ row_off_detect_bot[25] col_event_rst_bot_left[29] row_off_detect_bot[16] col_event_rst_bot_left[52]
+ row_on_detect_bot[2] dac_config_6 row_on_detect_bot[57] dac_config_5 col_event_rst_bot_left[20]
+ vssc1 array_col_bot_left[13] array_col_bot_left[29] pixel_layout_tile_bot_1/openDVS_pixel2x2_bot_575/GndD
+ pixel_layout_tile_bot_1/openDVS_pixel2x2_bot_95/GndD col_event_rst_bot_left[61]
+ pixel_layout_tile_bot_1/openDVS_pixel2x2_bot_671/GndD array_col_bot_left[14] dac_config_0
+ dac_config_4 col_event_rst_bot_left[10] row_off_detect_bot[50] dac_config_2 dac_config_1
+ col_event_rst_bot_left[19] vssc1 col_event_rst_bot_left[62] array_col_bot_left[55]
+ vssc1 pixel_layout_tile_bot
Xpixel_layout_tile_0 row_off_detect_top[0] row_off_detect_top[1] row_off_detect_top[4]
+ row_off_detect_top[5] row_off_detect_top[6] row_off_detect_top[7] row_off_detect_top[10]
+ row_off_detect_top[11] row_off_detect_top[12] row_off_detect_top[13] row_off_detect_top[14]
+ row_off_detect_top[15] row_off_detect_top[16] row_off_detect_top[17] row_off_detect_top[18]
+ row_off_detect_top[19] row_off_detect_top[22] row_off_detect_top[23] row_off_detect_top[26]
+ row_off_detect_top[27] row_off_detect_top[31] row_off_detect_top[32] row_off_detect_top[33]
+ row_off_detect_top[34] row_off_detect_top[35] row_off_detect_top[36] row_off_detect_top[37]
+ row_off_detect_top[38] row_off_detect_top[39] row_off_detect_top[42] row_off_detect_top[43]
+ row_off_detect_top[46] row_off_detect_top[47] row_off_detect_top[50] row_off_detect_top[51]
+ row_off_detect_top[52] row_off_detect_top[53] row_off_detect_top[54] row_off_detect_top[55]
+ row_off_detect_top[56] row_off_detect_top[63] row_on_detect_top[0] row_on_detect_top[1]
+ row_on_detect_top[6] row_on_detect_top[7] row_on_detect_top[21] row_on_detect_top[26]
+ row_on_detect_top[27] row_on_detect_top[28] row_on_detect_top[29] row_on_detect_top[30]
+ row_on_detect_top[31] row_on_detect_top[40] row_on_detect_top[41] row_on_detect_top[44]
+ row_on_detect_top[45] row_on_detect_top[46] row_on_detect_top[47] row_on_detect_top[56]
+ row_on_detect_top[57] row_on_detect_top[60] row_on_detect_top[61] ndetect_pulse_global_top_left
+ array_col_top_left[60] array_col_top_left[57] array_col_top_left[56] col_event_rst_top_left[54]
+ col_event_rst_top_left[55] col_event_rst_top_left[56] col_event_rst_top_left[57]
+ col_event_rst_top_left[58] col_event_rst_top_left[63] array_col_top_left[6] array_col_top_left[7]
+ array_col_top_left[8] array_col_top_left[9] array_col_top_left[10] array_col_top_left[11]
+ array_col_top_left[12] array_col_top_left[24] array_col_top_left[25] array_col_top_left[26]
+ array_col_top_left[27] array_col_top_left[30] array_col_top_left[31] array_col_top_left[32]
+ array_col_top_left[44] array_col_top_left[50] array_col_top_left[51] array_col_top_left[52]
+ col_event_rst_top_left[34] col_event_rst_top_left[33] col_event_rst_top_left[32]
+ col_event_rst_top_left[27] col_event_rst_top_left[26] col_event_rst_top_left[25]
+ col_event_rst_top_left[24] col_event_rst_top_left[11] col_event_rst_top_left[8]
+ col_event_rst_top_left[7] col_event_rst_top_left[6] col_event_rst_top_left[5] col_event_rst_top_left[4]
+ col_event_rst_top_left[0] col_event_rst_top_left[44] col_event_rst_top_left[45]
+ col_event_rst_top_left[48] col_event_rst_top_left[53] pixel_layout_tile_1/openDVS_pixel2x2_top_607/GndD
+ col_event_rst_top_left[42] row_on_detect_top[12] row_on_detect_top[13] row_on_detect_top[52]
+ col_event_rst_top_left[43] row_on_detect_top[53] col_event_rst_top_left[1] pixel_layout_tile_1/openDVS_pixel2x2_top_319/GndD
+ row_off_detect_top[59] row_on_detect_top[38] array_col_top_left[18] col_event_rst_top_left[35]
+ pixel_layout_tile_1/openDVS_pixel2x2_top_671/GndD row_on_detect_top[34] row_on_detect_top[39]
+ col_event_rst_top_left[41] col_event_rst_top_left[22] row_on_detect_top[35] row_off_detect_top[60]
+ col_event_rst_top_left[14] col_event_rst_top_left[23] array_col_top_left[23] array_col_top_left[40]
+ row_off_detect_top[61] pixel_layout_tile_1/openDVS_pixel2x2_top_511/GndD row_off_detect_top[40]
+ array_col_top_left[35] row_on_detect_top[4] pixel_layout_tile_1/openDVS_pixel2x2_top_447/GndD
+ row_off_detect_top[41] row_off_detect_top[20] col_event_rst_top_left[15] row_on_detect_top[5]
+ col_event_rst_top_left[16] row_on_detect_top[50] row_off_detect_top[21] row_on_detect_top[51]
+ row_on_detect_top[16] array_col_top_left[19] pixel_layout_tile_1/openDVS_pixel2x2_top_63/GndD
+ pixel_layout_tile_1/openDVS_pixel2x2_top_287/GndD pixel_layout_tile_1/openDVS_pixel2x2_top_383/GndD
+ array_col_top_left[20] array_col_top_left[61] row_on_detect_top[17] array_col_top_left[62]
+ pixel_layout_tile_1/openDVS_pixel2x2_top_767/GndD pixel_layout_tile_1/openDVS_pixel2x2_top_863/GndD
+ col_event_rst_top_left[38] array_col_top_left[36] row_on_detect_top[22] pixel_layout_tile_1/openDVS_pixel2x2_top_927/GndD
+ array_col_top_left[41] array_col_top_left[37] row_off_detect_top[2] array_col_top_left[42]
+ pixel_layout_tile_1/openDVS_pixel2x2_top_223/GndD pixel_layout_tile_1/openDVS_pixel2x2_top_543/GndD
+ row_on_detect_top[36] row_on_detect_top[23] row_off_detect_top[58] col_event_rst_top_left[31]
+ pixel_layout_tile_1/openDVS_pixel2x2_top_159/GndD dac_config_6 col_event_rst_top_left[49]
+ row_off_detect_top[3] row_on_detect_top[32] row_on_detect_top[37] col_event_rst_top_left[50]
+ col_event_rst_top_left[12] pixel_layout_tile_1/openDVS_pixel2x2_top_703/GndD col_event_rst_top_left[21]
+ pixel_layout_tile_1/openDVS_pixel2x2_top_999/GndD row_off_detect_top[44] col_event_rst_top_left[46]
+ array_col_top_left[3] array_col_top_left[0] pixel_layout_tile_1/openDVS_pixel2x2_top_95/GndD
+ col_event_rst_top_left[2] pixel_layout_tile_1/openDVS_pixel2x2_top_639/GndD row_on_detect_top[33]
+ col_event_rst_top_left[13] col_event_rst_top_left[17] row_off_detect_top[45] col_event_rst_top_left[47]
+ row_off_detect_top[30] array_col_top_left[15] col_event_rst_top_left[59] array_col_top_left[47]
+ row_off_detect_top[24] col_event_rst_top_left[3] row_on_detect_top[42] array_col_top_left[53]
+ pre_charge_global_top_left pixel_layout_tile_1/openDVS_pixel2x2_top_799/GndD array_col_top_left[54]
+ col_event_rst_top_left[30] row_off_detect_top[25] row_off_detect_top[48] row_on_detect_top[43]
+ row_on_detect_top[8] array_col_top_left[58] array_col_top_left[21] row_on_detect_top[2]
+ array_col_top_left[22] array_col_top_left[63] row_off_detect_top[49] pixel_layout_tile_1/openDVS_pixel2x2_top_479/GndD
+ pixel_layout_tile_1/openDVS_pixel2x2_top_575/GndD row_on_detect_top[9] col_event_rst_top_left[39]
+ array_col_top_left[38] array_col_top_left[59] row_off_detect_top[28] col_event_rst_top_left[40]
+ array_col_top_left[33] row_on_detect_top[3] array_col_top_left[34] row_off_detect_top[57]
+ row_on_detect_top[18] array_col_top_left[39] pixel_layout_tile_1/openDVS_pixel2x2_top_959/GndD
+ row_off_detect_top[29] array_col_top_left[5] row_on_detect_top[48] pixel_layout_tile_1/openDVS_pixel2x2_top_255/GndD
+ row_off_detect_top[8] row_on_detect_top[14] row_on_detect_top[19] detect_pulse_global_top_left
+ row_on_detect_top[62] array_col_top_left[43] row_on_detect_top[49] pixel_layout_tile_1/openDVS_pixel2x2_top_351/GndD
+ row_off_detect_top[9] col_event_rst_top_left[36] row_on_detect_top[10] col_event_rst_top_left[9]
+ row_on_detect_top[15] array_col_top_left[16] pixel_layout_tile_1/openDVS_pixel2x2_top_415/GndD
+ pixel_layout_tile_1/openDVS_pixel2x2_top_735/GndD array_col_top_left[48] pixel_layout_tile_1/openDVS_pixel2x2_top_831/GndD
+ row_on_detect_top[63] col_event_rst_top_left[51] array_col_top_left[4] row_on_detect_top[58]
+ array_col_top_left[45] vssc1 col_event_rst_top_left[28] row_on_detect_top[24] array_col_top_left[46]
+ col_event_rst_top_left[37] row_on_detect_top[11] array_col_top_left[17] col_event_rst_top_left[60]
+ array_col_top_left[1] array_col_top_left[28] array_col_top_left[49] array_col_top_left[2]
+ dac_config_5 pixel_layout_tile_1/openDVS_pixel2x2_top_895/GndD pixel_layout_tile_1/openDVS_pixel2x2_top_991/GndD
+ col_event_rst_top_left[18] row_on_detect_top[54] row_on_detect_top[59] dac_config_3
+ pixel_layout_tile_1/openDVS_pixel2x2_top_9/GndD col_event_rst_top_left[29] row_on_detect_top[20]
+ col_event_rst_top_left[52] pixel_layout_tile_1/openDVS_pixel2x2_top_191/GndD row_on_detect_top[25]
+ col_event_rst_top_left[20] array_col_top_left[13] array_col_top_left[29] dac_config_4
+ col_event_rst_top_left[61] row_off_detect_top[62] array_col_top_left[14] col_event_rst_top_left[10]
+ dac_config_1 dac_config_0 col_event_rst_top_left[19] dac_config_2 pixel_layout_tile_1/openDVS_pixel2x2_top_99/GndD
+ col_event_rst_top_left[62] array_col_top_left[55] row_on_detect_top[55] vssc1 vssc1
+ pixel_layout_tile
Xpixel_layout_tile_1 row_off_detect_top[0] row_off_detect_top[1] row_off_detect_top[4]
+ row_off_detect_top[5] row_off_detect_top[6] row_off_detect_top[7] row_off_detect_top[10]
+ row_off_detect_top[11] row_off_detect_top[12] row_off_detect_top[13] row_off_detect_top[14]
+ row_off_detect_top[15] row_off_detect_top[16] row_off_detect_top[17] row_off_detect_top[18]
+ row_off_detect_top[19] row_off_detect_top[22] row_off_detect_top[23] row_off_detect_top[26]
+ row_off_detect_top[27] row_off_detect_top[31] row_off_detect_top[32] row_off_detect_top[33]
+ row_off_detect_top[34] row_off_detect_top[35] row_off_detect_top[36] row_off_detect_top[37]
+ row_off_detect_top[38] row_off_detect_top[39] row_off_detect_top[42] row_off_detect_top[43]
+ row_off_detect_top[46] row_off_detect_top[47] row_off_detect_top[50] row_off_detect_top[51]
+ row_off_detect_top[52] row_off_detect_top[53] row_off_detect_top[54] row_off_detect_top[55]
+ row_off_detect_top[56] row_off_detect_top[63] row_on_detect_top[0] row_on_detect_top[1]
+ row_on_detect_top[6] row_on_detect_top[7] row_on_detect_top[21] row_on_detect_top[26]
+ row_on_detect_top[27] row_on_detect_top[28] row_on_detect_top[29] row_on_detect_top[30]
+ row_on_detect_top[31] row_on_detect_top[40] row_on_detect_top[41] row_on_detect_top[44]
+ row_on_detect_top[45] row_on_detect_top[46] row_on_detect_top[47] row_on_detect_top[56]
+ row_on_detect_top[57] row_on_detect_top[60] row_on_detect_top[61] ndetect_pulse_global_top_left
+ array_col_top_right[60] array_col_top_right[57] array_col_top_right[56] col_event_rst_top_right[54]
+ col_event_rst_top_right[55] col_event_rst_top_right[56] col_event_rst_top_right[57]
+ col_event_rst_top_right[58] col_event_rst_top_right[63] array_col_top_right[6] array_col_top_right[7]
+ array_col_top_right[8] array_col_top_right[9] array_col_top_right[10] array_col_top_right[11]
+ array_col_top_right[12] array_col_top_right[24] array_col_top_right[25] array_col_top_right[26]
+ array_col_top_right[27] array_col_top_right[30] array_col_top_right[31] array_col_top_right[32]
+ array_col_top_right[44] array_col_top_right[50] array_col_top_right[51] array_col_top_right[52]
+ col_event_rst_top_right[34] col_event_rst_top_right[33] col_event_rst_top_right[32]
+ col_event_rst_top_right[27] col_event_rst_top_right[26] col_event_rst_top_right[25]
+ col_event_rst_top_right[24] col_event_rst_top_right[11] col_event_rst_top_right[8]
+ col_event_rst_top_right[7] col_event_rst_top_right[6] col_event_rst_top_right[5]
+ col_event_rst_top_right[4] col_event_rst_top_right[0] col_event_rst_top_right[44]
+ col_event_rst_top_right[45] col_event_rst_top_right[48] col_event_rst_top_right[53]
+ pixel_layout_tile_1/openDVS_pixel2x2_top_607/GndD col_event_rst_top_right[42] row_on_detect_top[12]
+ row_on_detect_top[13] row_on_detect_top[52] col_event_rst_top_right[43] row_on_detect_top[53]
+ col_event_rst_top_right[1] pixel_layout_tile_1/openDVS_pixel2x2_top_319/GndD row_off_detect_top[59]
+ row_on_detect_top[38] array_col_top_right[18] col_event_rst_top_right[35] pixel_layout_tile_1/openDVS_pixel2x2_top_671/GndD
+ row_on_detect_top[34] row_on_detect_top[39] col_event_rst_top_right[41] col_event_rst_top_right[22]
+ row_on_detect_top[35] row_off_detect_top[60] col_event_rst_top_right[14] col_event_rst_top_right[23]
+ array_col_top_right[23] array_col_top_right[40] row_off_detect_top[61] pixel_layout_tile_1/openDVS_pixel2x2_top_511/GndD
+ row_off_detect_top[40] array_col_top_right[35] row_on_detect_top[4] pixel_layout_tile_1/openDVS_pixel2x2_top_447/GndD
+ row_off_detect_top[41] row_off_detect_top[20] col_event_rst_top_right[15] row_on_detect_top[5]
+ col_event_rst_top_right[16] row_on_detect_top[50] row_off_detect_top[21] row_on_detect_top[51]
+ row_on_detect_top[16] array_col_top_right[19] pixel_layout_tile_1/openDVS_pixel2x2_top_63/GndD
+ pixel_layout_tile_1/openDVS_pixel2x2_top_287/GndD pixel_layout_tile_1/openDVS_pixel2x2_top_383/GndD
+ array_col_top_right[20] array_col_top_right[61] row_on_detect_top[17] array_col_top_right[62]
+ pixel_layout_tile_1/openDVS_pixel2x2_top_767/GndD pixel_layout_tile_1/openDVS_pixel2x2_top_863/GndD
+ col_event_rst_top_right[38] array_col_top_right[36] row_on_detect_top[22] pixel_layout_tile_1/openDVS_pixel2x2_top_927/GndD
+ array_col_top_right[41] array_col_top_right[37] row_off_detect_top[2] array_col_top_right[42]
+ pixel_layout_tile_1/openDVS_pixel2x2_top_223/GndD pixel_layout_tile_1/openDVS_pixel2x2_top_543/GndD
+ row_on_detect_top[36] row_on_detect_top[23] row_off_detect_top[58] col_event_rst_top_right[31]
+ pixel_layout_tile_1/openDVS_pixel2x2_top_159/GndD dac_config_6 col_event_rst_top_right[49]
+ row_off_detect_top[3] row_on_detect_top[32] row_on_detect_top[37] col_event_rst_top_right[50]
+ col_event_rst_top_right[12] pixel_layout_tile_1/openDVS_pixel2x2_top_703/GndD col_event_rst_top_right[21]
+ pixel_layout_tile_1/openDVS_pixel2x2_top_999/GndD row_off_detect_top[44] col_event_rst_top_right[46]
+ array_col_top_right[3] array_col_top_right[0] pixel_layout_tile_1/openDVS_pixel2x2_top_95/GndD
+ col_event_rst_top_right[2] pixel_layout_tile_1/openDVS_pixel2x2_top_639/GndD row_on_detect_top[33]
+ col_event_rst_top_right[13] col_event_rst_top_right[17] row_off_detect_top[45] col_event_rst_top_right[47]
+ row_off_detect_top[30] array_col_top_right[15] col_event_rst_top_right[59] array_col_top_right[47]
+ row_off_detect_top[24] col_event_rst_top_right[3] row_on_detect_top[42] array_col_top_right[53]
+ pre_charge_global_top_left pixel_layout_tile_1/openDVS_pixel2x2_top_799/GndD array_col_top_right[54]
+ col_event_rst_top_right[30] row_off_detect_top[25] row_off_detect_top[48] row_on_detect_top[43]
+ row_on_detect_top[8] array_col_top_right[58] array_col_top_right[21] row_on_detect_top[2]
+ array_col_top_right[22] array_col_top_right[63] row_off_detect_top[49] pixel_layout_tile_1/openDVS_pixel2x2_top_479/GndD
+ pixel_layout_tile_1/openDVS_pixel2x2_top_575/GndD row_on_detect_top[9] col_event_rst_top_right[39]
+ array_col_top_right[38] array_col_top_right[59] row_off_detect_top[28] col_event_rst_top_right[40]
+ array_col_top_right[33] row_on_detect_top[3] array_col_top_right[34] row_off_detect_top[57]
+ row_on_detect_top[18] array_col_top_right[39] pixel_layout_tile_1/openDVS_pixel2x2_top_959/GndD
+ row_off_detect_top[29] array_col_top_right[5] row_on_detect_top[48] pixel_layout_tile_1/openDVS_pixel2x2_top_255/GndD
+ row_off_detect_top[8] row_on_detect_top[14] row_on_detect_top[19] detect_pulse_global_top_left
+ row_on_detect_top[62] array_col_top_right[43] row_on_detect_top[49] pixel_layout_tile_1/openDVS_pixel2x2_top_351/GndD
+ row_off_detect_top[9] col_event_rst_top_right[36] row_on_detect_top[10] col_event_rst_top_right[9]
+ row_on_detect_top[15] array_col_top_right[16] pixel_layout_tile_1/openDVS_pixel2x2_top_415/GndD
+ pixel_layout_tile_1/openDVS_pixel2x2_top_735/GndD array_col_top_right[48] pixel_layout_tile_1/openDVS_pixel2x2_top_831/GndD
+ row_on_detect_top[63] col_event_rst_top_right[51] array_col_top_right[4] row_on_detect_top[58]
+ array_col_top_right[45] vssc1 col_event_rst_top_right[28] row_on_detect_top[24]
+ array_col_top_right[46] col_event_rst_top_right[37] row_on_detect_top[11] array_col_top_right[17]
+ col_event_rst_top_right[60] array_col_top_right[1] array_col_top_right[28] array_col_top_right[49]
+ array_col_top_right[2] dac_config_5 pixel_layout_tile_1/openDVS_pixel2x2_top_895/GndD
+ pixel_layout_tile_1/openDVS_pixel2x2_top_991/GndD col_event_rst_top_right[18] row_on_detect_top[54]
+ row_on_detect_top[59] dac_config_3 pixel_layout_tile_1/openDVS_pixel2x2_top_9/GndD
+ col_event_rst_top_right[29] row_on_detect_top[20] col_event_rst_top_right[52] pixel_layout_tile_1/openDVS_pixel2x2_top_191/GndD
+ row_on_detect_top[25] col_event_rst_top_right[20] array_col_top_right[13] array_col_top_right[29]
+ dac_config_4 col_event_rst_top_right[61] row_off_detect_top[62] array_col_top_right[14]
+ col_event_rst_top_right[10] dac_config_1 dac_config_0 col_event_rst_top_right[19]
+ dac_config_2 pixel_layout_tile_1/openDVS_pixel2x2_top_99/GndD col_event_rst_top_right[62]
+ array_col_top_right[55] row_on_detect_top[55] vssc1 vssc1 pixel_layout_tile
.ends
