.subckt PixelPhotoreceptor VddA18 PrBp GndA vpd vpr
*.iopin PrBp
*.iopin VddA18
*.iopin vpd
*.iopin GndA
*.iopin vpr
XMpd VddA18 vpr vpd GndA sky130_fd_pr__nfet_01v8 L=0.3 W=0.5 nf=1 mult=1
XMpr_amp vpr vpd GndA GndA sky130_fd_pr__nfet_01v8 L=0.3 W=0.42 nf=1 mult=1
XMprBias vpr PrBp VddA18 VddA18 sky130_fd_pr__pfet_01v8 L=0.15 W=0.5 nf=1 mult=1
XD1 GndA vpd sky130_fd_pr__model__parasitic__diode_ps2dn area=1e12 perim=4e6
.ends

.subckt PixelSourceFollower VddA18 PrSFBp GndA vpr vsf
*.iopin GndA
*.iopin PrSFBp
*.iopin vpr
*.iopin vsf
*.iopin VddA18
XMsf GndA vpr vsf VddA18 sky130_fd_pr__pfet_01v8 L=0.25 W=0.42 nf=1 mult=1
XMsfBias vsf PrSFBp VddA18 VddA18 sky130_fd_pr__pfet_01v8_hvt L=1.5 W=0.42 nf=1 mult=1
.ends

.subckt PixelChangeAmplifier VddA18 DiffBn GndA vsf vdiff nRst
*.iopin DiffBn
*.iopin vsf
*.iopin VddA18
*.iopin GndA
*.iopin vdiff
*.iopin nRst
XC1b vd vsf sky130_fd_pr__cap_mim_m3_1 W=6.47 L=1.05 MF=1
XC2 vd vdiff sky130_fd_pr__cap_mim_m3_1 W=1 L=1 MF=1
XMchAmpBias vdiff DiffBn GndA GndA sky130_fd_pr__nfet_01v8 L=1.5 W=1.5 nf=1 mult=1
XMrst vdiff nRst vd VddA18 sky130_fd_pr__pfet_01v8_hvt L=0.42 W=0.42 nf=1 mult=1
XMchAmp vdiff vd VddA18 VddA18 sky130_fd_pr__pfet_01v8 L=1.5 W=1.5 nf=1 mult=1
XC1a vd vsf sky130_fd_pr__cap_mim_m3_1 W=3.985 L=2.27 MF=1
.ends

.subckt PixelComparators VddA18 OnBn GndA vdiff ON OffBn nOFF
*.iopin OnBn
*.iopin OffBn
*.iopin VddA18
*.iopin vdiff
*.iopin GndA
*.iopin ON
*.iopin nOFF
XMonBias ON OnBn GndA GndA sky130_fd_pr__nfet_01v8 L=1.5 W=1.5 nf=1 mult=1
XMoffBias nOFF OffBn GndA GndA sky130_fd_pr__nfet_01v8 L=1.5 W=1.5 nf=1 mult=1
XMon ON vdiff VddA18 VddA18 sky130_fd_pr__pfet_01v8 L=1.5 W=1.5 nf=1 mult=1
XMoff nOFF vdiff VddA18 VddA18 sky130_fd_pr__pfet_01v8 L=1.5 W=1.5 nf=1 mult=1
.ends

.subckt PixelHandshake rowReadOFF GndA rowReadON readLine ON nOFF GndD
*.ipin rowReadON
*.ipin rowReadOFF
*.iopin readLine
*.iopin ON
*.iopin nOFF
*.iopin GndD
*.iopin GndA
XMswON readLine rowReadON readLineONpd GndA sky130_fd_pr__nfet_01v8 L=0.15 W=0.42 nf=1 mult=1
XMoutON readLineONpd ON GndD GndA sky130_fd_pr__nfet_01v8 L=0.15 W=0.42 nf=1 mult=1
XMswOFF readLine rowReadOFF readLineOFFpd GndA sky130_fd_pr__nfet_01v8 L=0.15 W=0.42 nf=1 mult=1
XMoutOFF readLineOFFpd nOFF GndD GndA sky130_fd_pr__nfet_01v8 L=0.15 W=0.42 nf=1 mult=1
.ends

.subckt PixelResetGen rowRst GndA colRst nRst RefrBp VddA18
*.ipin rowRst
*.ipin colRst
*.iopin RefrBp
*.iopin GndA
*.iopin VddA18
*.iopin nRst
XMPDrefrCol nRst colRst net1 GndA sky130_fd_pr__nfet_01v8 L=0.15 W=0.42 nf=1 mult=1
XMrefrBias nRst RefrBp VddA18 VddA18 sky130_fd_pr__pfet_01v8 L=1.5 W=0.42 nf=1 mult=1
XMcapRefr VddA18 nRst VddA18 VddA18 sky130_fd_pr__pfet_01v8 L=1.5 W=1.5 nf=1 mult=1
XMPDRefrRow net1 rowRst GndA GndA sky130_fd_pr__nfet_01v8 L=0.15 W=0.42 nf=1 mult=1
.ends

.subckt openDVS_pixel2x2 DiffBn Vdd18A RefrBp GndD GndA PrSFBp OffBn PrBp OnBn pixRst<0> readLine<0> readLine<1> pixRst<1> rowReadON<0> rowReadON<1> rowReadOFF<0> rowReadOFF<1>
*.iopin GndD
*.iopin Vdd18A
*.iopin GndA
*.iopin OffBn
*.iopin OnBn
*.iopin DiffBn
*.iopin RefrBp
*.iopin PrSFBp
*.iopin PrBp
*.iopin readLine<0>
*.iopin readLine<1>
*.iopin pixRst<0>
*.iopin rowReadON<1>
*.iopin rowReadOFF<1>
*.iopin rowReadON<0>
*.iopin rowReadOFF<0>
*.iopin pixRst<1>
x1 rowReadON<0> Vdd18A PrBp GndA vpd00 rowReadOFF<0> pixRst<0> PrSFBp DiffBn OnBn OffBn RefrBp
+ readLine<0> GndD openDVS_pixel
x2 rowReadON<0> Vdd18A PrBp GndA vpd01 rowReadOFF<0> pixRst<1> PrSFBp DiffBn OnBn OffBn RefrBp
+ readLine<1> GndD openDVS_pixel
x3 rowReadON<1> Vdd18A PrBp GndA vpd10 rowReadOFF<1> pixRst<0> PrSFBp DiffBn OnBn OffBn RefrBp
+ readLine<0> GndD openDVS_pixel
x4 rowReadON<1> Vdd18A PrBp GndA vpd11 rowReadOFF<1> pixRst<1> PrSFBp DiffBn OnBn OffBn RefrBp
+ readLine<1> GndD openDVS_pixel
.ends
