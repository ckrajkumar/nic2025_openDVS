.subckt openDVS_pixel2x2 DiffBn Vdd18A RefrBp GndD GndA PrSFBp OffBn PrBp OnBn pixRst<0> readLine<0> readLine<1> pixRst<1> rowReadON<0> rowReadON<1> rowReadOFF<0> rowReadOFF<1>
*.iopin GndD
*.iopin Vdd18A
*.iopin GndA
*.iopin OffBn
*.iopin OnBn
*.iopin DiffBn
*.iopin RefrBp
*.iopin PrSFBp
*.iopin PrBp
*.iopin readLine<0>
*.iopin readLine<1>
*.iopin pixRst<0>
*.iopin rowReadON<1>
*.iopin rowReadOFF<1>
*.iopin rowReadON<0>
*.iopin rowReadOFF<0>
*.iopin pixRst<1>
x1 rowReadON<0> Vdd18A PrBp GndA vpd00 rowReadOFF<0> pixRst<0> PrSFBp DiffBn OnBn OffBn RefrBp
+ readLine<0> GndD openDVS_pixel
x2 rowReadON<0> Vdd18A PrBp GndA vpd01 rowReadOFF<0> pixRst<1> PrSFBp DiffBn OnBn OffBn RefrBp
+ readLine<1> GndD openDVS_pixel
x3 rowReadON<1> Vdd18A PrBp GndA vpd10 rowReadOFF<1> pixRst<0> PrSFBp DiffBn OnBn OffBn RefrBp
+ readLine<0> GndD openDVS_pixel
x4 rowReadON<1> Vdd18A PrBp GndA vpd11 rowReadOFF<1> pixRst<1> PrSFBp DiffBn OnBn OffBn RefrBp
+ readLine<1> GndD openDVS_pixel
.ends
