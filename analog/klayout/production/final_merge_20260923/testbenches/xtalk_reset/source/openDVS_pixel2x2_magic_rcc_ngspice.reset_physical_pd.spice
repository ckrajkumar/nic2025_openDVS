* RESET_APPARATUS exact-cace-reset-physical-photodiode-v2
* RESET_BASE_PATH magic_rcc_ngspice
* RESET_BASE_SHA256 c93cd8b0cad09088f8448eb687377f822f0a15cf6b7ef68c2344391f65330e9c
* Physical photodiodes retained; no artificial photodiode or vd DC paths
* NGSPICE file created from openDVS_pixel2x2_top.ext - technology: sky130A

.subckt openDVS_pixel2x2__diffbn_physical_core pixRst[1] pixRst[0] rowReadON[1] rowReadON[0]
+ rowReadOFF[1] rowReadOFF[0] readLine[1] readLine[0] vpd[3] vpd[2] vpd[1] vpd[0] VddA18 GndA
+ GndD OnBn OffBn DiffBn_uq1 DiffBn openDVS_pixel_1.DiffBn PrSFBp RefrBp PrBp
X0 GndA.t20 vpd[2].t1 openDVS_pixel_3.vpr.t1 GndA.t19 sky130_fd_pr__nfet_01v8 ad=0.126 pd=1.44 as=0.126 ps=1.44 w=0.42 l=0.3
X1 openDVS_pixel_2.nOFF.t0 OffBn.t1 GndA.t1 GndA.t0 sky130_fd_pr__nfet_01v8 ad=0.45 pd=3.6 as=0.45 ps=3.6 w=1.5 l=1.5
X2 GndA.t41 vpd[3].t1 openDVS_pixel_1.vpr.t1 GndA.t40 sky130_fd_pr__nfet_01v8 ad=0.126 pd=1.44 as=0.126 ps=1.44 w=0.42 l=0.3
X3 openDVS_pixel_1.vd.t0 openDVS_pixel_1.nRst.t2 openDVS_pixel_1.vdiff VddA18.t18 sky130_fd_pr__pfet_01v8_hvt ad=0.126 pd=1.44 as=0.126 ps=1.44 w=0.42 l=0.42
X4 openDVS_pixel_2.vd.t1 openDVS_pixel_2.vsf.t2 sky130_fd_pr__cap_mim_m3_1 l=1.505 w=6.47
X5 GndA.t44 OnBn.t2 openDVS_pixel_3.ON.t1 GndA.t4 sky130_fd_pr__nfet_01v8 ad=0.45 pd=3.6 as=0.45 ps=3.6 w=1.5 l=1.5
X6 a_n3254_125.t0 openDVS_pixel_0.ON.t2 GndD.t2 GndA.t12 sky130_fd_pr__nfet_01v8 ad=0.105 pd=0.92 as=0.126 ps=1.44 w=0.42 l=0.15
X7 openDVS_pixel_3.vd.t0 openDVS_pixel_3.nRst.t3 openDVS_pixel_3.vdiff VddA18.t18 sky130_fd_pr__pfet_01v8_hvt ad=0.126 pd=1.44 as=0.126 ps=1.44 w=0.42 l=0.42
X8 VddA18.t42 openDVS_pixel_2.vd.t4 openDVS_pixel_2.vdiff.t1 VddA18.t2 sky130_fd_pr__pfet_01v8 ad=0.225 pd=1.8 as=0.45 ps=3.6 w=1.5 l=1.5
X9 openDVS_pixel_2.ON.t0 OnBn.t1 GndA.t43 GndA.t42 sky130_fd_pr__nfet_01v8 ad=0.45 pd=3.6 as=0.45 ps=3.6 w=1.5 l=1.5
X10 openDVS_pixel_1.vd.t3 openDVS_pixel_1.vdiff.t0 sky130_fd_pr__cap_mim_m3_1 l=1 w=1
X11 readLine[0].t2 rowReadON[0].t1 a_n3254_125# GndA.t12 sky130_fd_pr__nfet_01v8 ad=0.105 pd=0.92 as=0.105 ps=0.92 w=0.42 l=0.15
X12 openDVS_pixel_3.vdiff.t0 openDVS_pixel_3.vd.t4 VddA18.t22 VddA18.t0 sky130_fd_pr__pfet_01v8 ad=0.45 pd=3.6 as=0.225 ps=1.8 w=1.5 l=1.5
X13 openDVS_pixel_1.vsf PrSFBp.t0 VddA18.t1 VddA18.t0 sky130_fd_pr__pfet_01v8_hvt ad=0.126 pd=1.44 as=0.063 ps=0.72 w=0.42 l=1.5
X14 VddA18.t35 openDVS_pixel_2.vpr vpd[1].t0 GndA.t36 sky130_fd_pr__nfet_01v8 ad=0.15 pd=1.6 as=0.15 ps=1.6 w=0.5 l=0.3
X15 vpd[3].t0 openDVS_pixel_1.vpr.t2 VddA18.t19 GndA.t30 sky130_fd_pr__nfet_01v8 ad=0.15 pd=1.6 as=0.15 ps=1.6 w=0.5 l=0.3
X16 openDVS_pixel_0.vd.t1 openDVS_pixel_0.vdiff.t0 sky130_fd_pr__cap_mim_m3_1 l=1 w=1
X17 GndA.t53 DiffBn.t0 openDVS_pixel_3.vdiff.t0 GndA.t52 sky130_fd_pr__nfet_01v8 ad=0.45 pd=3.6 as=0.45 ps=3.6 w=1.5 l=1.5
X18 VddA18.t12 RefrBp.t3 openDVS_pixel_0.nRst.t0 VddA18.t2 sky130_fd_pr__pfet_01v8 ad=0.063 pd=0.72 as=0.126 ps=1.44 w=0.42 l=1.5
X19 VddA18.t20 openDVS_pixel_0.nRst.t2 VddA18.t20 VddA18.t2 sky130_fd_pr__pfet_01v8 ad=0.45 pd=3.6 as=0 ps=0 w=1.5 l=1.5
X20 VddA18.t30 openDVS_pixel_0.vdiff.t5 openDVS_pixel_0.ON.t0 VddA18.t24 sky130_fd_pr__pfet_01v8 ad=0.225 pd=1.8 as=0.45 ps=3.6 w=1.5 l=1.5
X21 VddA18.t16 openDVS_pixel_2.nRst.t3 VddA18.t16 VddA18.t2 sky130_fd_pr__pfet_01v8 ad=0.45 pd=3.6 as=0 ps=0 w=1.5 l=1.5
X22 openDVS_pixel_3.vd.t2 openDVS_pixel_3.vsf.t1 sky130_fd_pr__cap_mim_m3_1 l=2.27 w=3.985
X23 openDVS_pixel_1.vd.t2 openDVS_pixel_1.vsf.t1 sky130_fd_pr__cap_mim_m3_1 l=2.27 w=3.985
D0 GndA.t39 vpd[3] sky130_fd_pr__model__parasitic__diode_ps2dn area=32.49 pj=22.8 m=1
X24 a_n2994_125.t0 rowReadOFF[0].t1 readLine[0].t1 GndA.t12 sky130_fd_pr__nfet_01v8 ad=0.105 pd=0.92 as=0.105 ps=0.92 w=0.42 l=0.15
X25 openDVS_pixel_3.vsf PrSFBp.t2 VddA18.t5 VddA18.t0 sky130_fd_pr__pfet_01v8_hvt ad=0.126 pd=1.44 as=0.063 ps=0.72 w=0.42 l=1.5
X26 GndD.t1 openDVS_pixel_0.nOFF.t2 a_n2994_125# GndA.t12 sky130_fd_pr__nfet_01v8 ad=0.126 pd=1.44 as=0.105 ps=0.92 w=0.42 l=0.15
X27 openDVS_pixel_1.ON.t0 openDVS_pixel_1.vdiff.t0 VddA18.t33 VddA18.t28 sky130_fd_pr__pfet_01v8 ad=0.45 pd=3.6 as=0.225 ps=1.8 w=1.5 l=1.5
X28 openDVS_pixel_1.nRst.t0 RefrBp.t0 VddA18.t15 VddA18.t0 sky130_fd_pr__pfet_01v8 ad=0.126 pd=1.44 as=0.063 ps=0.72 w=0.42 l=1.5
X29 openDVS_pixel_2.vd.t3 openDVS_pixel_2.vsf.t1 sky130_fd_pr__cap_mim_m3_1 l=2.27 w=3.985
X30 VddA18.t36 openDVS_pixel_0.vpr vpd[0].t0 GndA.t37 sky130_fd_pr__nfet_01v8 ad=0.15 pd=1.6 as=0.15 ps=1.6 w=0.5 l=0.3
X31 GndD.t7 openDVS_pixel_1.ON.t2 a_788_n281.t0 GndA.t17 sky130_fd_pr__nfet_01v8 ad=0.126 pd=1.44 as=0.105 ps=0.92 w=0.42 l=0.15
X32 openDVS_pixel_1.vsf.t2 openDVS_pixel_1.vpr.t3 GndA.t31 VddA18.t31 sky130_fd_pr__pfet_01v8 ad=0.126 pd=1.44 as=0.126 ps=1.44 w=0.42 l=0.25
X33 openDVS_pixel_0.ON.t1 OnBn.t3 GndA.t46 GndA.t45 sky130_fd_pr__nfet_01v8 ad=0.45 pd=3.6 as=0.45 ps=3.6 w=1.5 l=1.5
X34 VddA18.t21 openDVS_pixel_3.nRst.t2 VddA18.t21 VddA18.t0 sky130_fd_pr__pfet_01v8 ad=0.225 pd=1.8 as=0 ps=0 w=1.5 l=1.5
X35 a_n3254_n281# openDVS_pixel_2.ON.t2 GndD.t5 GndA.t16 sky130_fd_pr__nfet_01v8 ad=0.105 pd=0.92 as=0.126 ps=1.44 w=0.42 l=0.15
D1 GndA.t18 vpd[2] sky130_fd_pr__model__parasitic__diode_ps2dn area=32.49 pj=22.8 m=1
X36 openDVS_pixel_0.vdiff.t3 DiffBn_uq1.t1 GndA.t57 GndA.t56 sky130_fd_pr__nfet_01v8 ad=0.45 pd=3.6 as=0.45 ps=3.6 w=1.5 l=1.5
X37 GndA.t5 OffBn.t2 openDVS_pixel_3.nOFF.t0 GndA.t4 sky130_fd_pr__nfet_01v8 ad=0.45 pd=3.6 as=0.45 ps=3.6 w=1.5 l=1.5
X38 VddA18.t23 openDVS_pixel_0.vd.t4 openDVS_pixel_0.vdiff.t1 VddA18.t2 sky130_fd_pr__pfet_01v8 ad=0.225 pd=1.8 as=0.45 ps=3.6 w=1.5 l=1.5
X39 GndA.t22 openDVS_pixel_1.DiffBn.t0 openDVS_pixel_1.vdiff.t0 GndA.t21 sky130_fd_pr__nfet_01v8 ad=0.45 pd=3.6 as=0.45 ps=3.6 w=1.5 l=1.5
X40 openDVS_pixel_0.vdiff.t2 openDVS_pixel_0.nRst.t3 openDVS_pixel_0.vd.t0 VddA18.t38 sky130_fd_pr__pfet_01v8_hvt ad=0.126 pd=1.44 as=0.126 ps=1.44 w=0.42 l=0.42
X41 GndA.t11 rowReadON[0].t2 a_1070_435# GndA.t10 sky130_fd_pr__nfet_01v8 ad=0.126 pd=1.44 as=0.105 ps=0.92 w=0.42 l=0.15
X42 a_788_n281# rowReadON[1].t2 readLine[1].t2 GndA.t17 sky130_fd_pr__nfet_01v8 ad=0.105 pd=0.92 as=0.105 ps=0.92 w=0.42 l=0.15
X43 openDVS_pixel_2.vpr vpd[1].t1 GndA.t29 GndA.t28 sky130_fd_pr__nfet_01v8 ad=0.126 pd=1.44 as=0.126 ps=1.44 w=0.42 l=0.3
X44 openDVS_pixel_2.vdiff.t2 openDVS_pixel_2.nRst.t2 openDVS_pixel_2.vd.t0 VddA18.t38 sky130_fd_pr__pfet_01v8_hvt ad=0.126 pd=1.44 as=0.126 ps=1.44 w=0.42 l=0.42
X45 openDVS_pixel_2.nOFF.t1 openDVS_pixel_2.vdiff.t4 VddA18.t40 VddA18.t39 sky130_fd_pr__pfet_01v8 ad=0.45 pd=3.6 as=0.225 ps=1.8 w=1.5 l=1.5
X46 a_1070_n607.t0 rowReadON[1].t0 GndA.t51 GndA.t50 sky130_fd_pr__nfet_01v8 ad=0.105 pd=0.92 as=0.126 ps=1.44 w=0.42 l=0.15
X47 openDVS_pixel_2.vd.t2 openDVS_pixel_2.vdiff.t0 sky130_fd_pr__cap_mim_m3_1 l=1 w=1
X48 VddA18.t4 PrSFBp.t3 openDVS_pixel_0.vsf VddA18.t2 sky130_fd_pr__pfet_01v8_hvt ad=0.063 pd=0.72 as=0.126 ps=1.44 w=0.42 l=1.5
X49 GndA.t9 rowReadON[0].t3 a_n3520_435# GndA.t8 sky130_fd_pr__nfet_01v8 ad=0.126 pd=1.44 as=0.105 ps=0.92 w=0.42 l=0.15
X50 readLine[0].t3 rowReadON[1].t3 a_n3254_n281.t0 GndA.t16 sky130_fd_pr__nfet_01v8 ad=0.105 pd=0.92 as=0.105 ps=0.92 w=0.42 l=0.15
X51 VddA18.t32 openDVS_pixel_1.vdiff.t0 openDVS_pixel_1.nOFF.t1 VddA18.t26 sky130_fd_pr__pfet_01v8 ad=0.225 pd=1.8 as=0.45 ps=3.6 w=1.5 l=1.5
X52 GndA.t7 OffBn.t0 openDVS_pixel_1.nOFF.t0 GndA.t6 sky130_fd_pr__nfet_01v8 ad=0.45 pd=3.6 as=0.45 ps=3.6 w=1.5 l=1.5
X53 a_n3520_n607.t0 rowReadON[1].t1 GndA.t49 GndA.t48 sky130_fd_pr__nfet_01v8 ad=0.105 pd=0.92 as=0.126 ps=1.44 w=0.42 l=0.15
X54 readLine[1].t0 rowReadOFF[1].t0 a_528_n281# GndA.t17 sky130_fd_pr__nfet_01v8 ad=0.105 pd=0.92 as=0.105 ps=0.92 w=0.42 l=0.15
X55 openDVS_pixel_0.vd.t3 openDVS_pixel_0.vsf.t1 sky130_fd_pr__cap_mim_m3_1 l=1.505 w=6.47
X56 a_528_125# openDVS_pixel_3.nOFF.t2 GndD.t6 GndA.t13 sky130_fd_pr__nfet_01v8 ad=0.105 pd=0.92 as=0.126 ps=1.44 w=0.42 l=0.15
X57 GndA.t47 OnBn.t0 openDVS_pixel_1.ON.t1 GndA.t6 sky130_fd_pr__nfet_01v8 ad=0.45 pd=3.6 as=0.45 ps=3.6 w=1.5 l=1.5
X58 openDVS_pixel_3.vd.t3 openDVS_pixel_3.vsf.t2 sky130_fd_pr__cap_mim_m3_1 l=1.505 w=6.47
X59 openDVS_pixel_1.vd.t1 openDVS_pixel_1.vsf.t0 sky130_fd_pr__cap_mim_m3_1 l=1.505 w=6.47
X60 a_1070_435.t0 pixRst[1].t1 openDVS_pixel_3.nRst.t1 GndA.t33 sky130_fd_pr__nfet_01v8 ad=0.105 pd=0.92 as=0.126 ps=1.44 w=0.42 l=0.15
X61 GndD.t4 openDVS_pixel_3.ON.t2 a_788_125.t0 GndA.t13 sky130_fd_pr__nfet_01v8 ad=0.126 pd=1.44 as=0.105 ps=0.92 w=0.42 l=0.15
X62 a_n2994_n281# rowReadOFF[1].t1 readLine[0].t0 GndA.t16 sky130_fd_pr__nfet_01v8 ad=0.105 pd=0.92 as=0.105 ps=0.92 w=0.42 l=0.15
X63 GndA.t32 openDVS_pixel_3.vpr.t2 openDVS_pixel_3.vsf.t0 VddA18.t31 sky130_fd_pr__pfet_01v8 ad=0.126 pd=1.44 as=0.126 ps=1.44 w=0.42 l=0.25
X64 openDVS_pixel_3.ON.t0 openDVS_pixel_3.vdiff.t0 VddA18.t29 VddA18.t28 sky130_fd_pr__pfet_01v8 ad=0.45 pd=3.6 as=0.225 ps=1.8 w=1.5 l=1.5
X65 VddA18.t25 openDVS_pixel_2.vdiff.t5 openDVS_pixel_2.ON.t1 VddA18.t24 sky130_fd_pr__pfet_01v8 ad=0.225 pd=1.8 as=0.45 ps=3.6 w=1.5 l=1.5
X66 openDVS_pixel_1.nRst.t1 pixRst[1].t0 a_1070_n607# GndA.t34 sky130_fd_pr__nfet_01v8 ad=0.126 pd=1.44 as=0.105 ps=0.92 w=0.42 l=0.15
X67 openDVS_pixel_0.vd.t2 openDVS_pixel_0.vsf.t2 sky130_fd_pr__cap_mim_m3_1 l=2.27 w=3.985
X68 openDVS_pixel_0.nOFF.t0 OffBn.t3 GndA.t3 GndA.t2 sky130_fd_pr__nfet_01v8 ad=0.45 pd=3.6 as=0.45 ps=3.6 w=1.5 l=1.5
X69 a_n3520_435.t0 pixRst[0].t1 openDVS_pixel_0.nRst.t1 GndA.t14 sky130_fd_pr__nfet_01v8 ad=0.105 pd=0.92 as=0.126 ps=1.44 w=0.42 l=0.15
X70 a_788_125# rowReadON[0].t0 readLine[1].t1 GndA.t13 sky130_fd_pr__nfet_01v8 ad=0.105 pd=0.92 as=0.105 ps=0.92 w=0.42 l=0.15
X71 GndD.t3 openDVS_pixel_2.nOFF.t2 a_n2994_n281.t0 GndA.t16 sky130_fd_pr__nfet_01v8 ad=0.126 pd=1.44 as=0.105 ps=0.92 w=0.42 l=0.15
X72 VddA18.t3 PrSFBp.t1 openDVS_pixel_2.vsf VddA18.t2 sky130_fd_pr__pfet_01v8_hvt ad=0.063 pd=0.72 as=0.126 ps=1.44 w=0.42 l=1.5
X73 openDVS_pixel_2.vpr.t0 PrBp.t1 VddA18.t7 VddA18.t6 sky130_fd_pr__pfet_01v8 ad=0.15 pd=1.6 as=0.15 ps=1.6 w=0.5 l=0.15
X74 VddA18.t9 PrBp.t2 openDVS_pixel_3.vpr.t0 VddA18.t8 sky130_fd_pr__pfet_01v8 ad=0.15 pd=1.6 as=0.15 ps=1.6 w=0.5 l=0.15
X75 readLine[1].t3 rowReadOFF[0].t0 a_528_125.t0 GndA.t13 sky130_fd_pr__nfet_01v8 ad=0.105 pd=0.92 as=0.105 ps=0.92 w=0.42 l=0.15
X76 openDVS_pixel_2.nRst.t1 pixRst[0].t0 a_n3520_n607# GndA.t15 sky130_fd_pr__nfet_01v8 ad=0.126 pd=1.44 as=0.105 ps=0.92 w=0.42 l=0.15
X77 openDVS_pixel_0.vpr vpd[0].t1 GndA.t25 GndA.t24 sky130_fd_pr__nfet_01v8 ad=0.126 pd=1.44 as=0.126 ps=1.44 w=0.42 l=0.3
X78 VddA18.t10 PrBp.t3 openDVS_pixel_0.vpr.t0 VddA18.t6 sky130_fd_pr__pfet_01v8 ad=0.15 pd=1.6 as=0.15 ps=1.6 w=0.5 l=0.15
X79 openDVS_pixel_1.vdiff.t0 openDVS_pixel_1.vd.t4 VddA18.t43 VddA18.t0 sky130_fd_pr__pfet_01v8 ad=0.45 pd=3.6 as=0.225 ps=1.8 w=1.5 l=1.5
D2 GndA.t27 vpd[1] sky130_fd_pr__model__parasitic__diode_ps2dn area=32.49 pj=22.8 m=1
X80 openDVS_pixel_0.nOFF.t1 openDVS_pixel_0.vdiff.t4 VddA18.t41 VddA18.t39 sky130_fd_pr__pfet_01v8 ad=0.45 pd=3.6 as=0.225 ps=1.8 w=1.5 l=1.5
X81 VddA18.t13 RefrBp.t1 openDVS_pixel_2.nRst.t0 VddA18.t2 sky130_fd_pr__pfet_01v8 ad=0.063 pd=0.72 as=0.126 ps=1.44 w=0.42 l=1.5
X82 openDVS_pixel_2.vsf.t0 openDVS_pixel_2.vpr GndA.t35 VddA18.t34 sky130_fd_pr__pfet_01v8 ad=0.126 pd=1.44 as=0.126 ps=1.44 w=0.42 l=0.25
D3 GndA.t23 vpd[0] sky130_fd_pr__model__parasitic__diode_ps2dn area=32.49 pj=22.8 m=1
X83 vpd[2].t0 openDVS_pixel_3.vpr.t3 VddA18.t17 GndA.t26 sky130_fd_pr__nfet_01v8 ad=0.15 pd=1.6 as=0.15 ps=1.6 w=0.5 l=0.3
X84 GndA.t38 openDVS_pixel_0.vpr openDVS_pixel_0.vsf.t0 VddA18.t34 sky130_fd_pr__pfet_01v8 ad=0.126 pd=1.44 as=0.126 ps=1.44 w=0.42 l=0.25
X85 openDVS_pixel_3.vd.t1 openDVS_pixel_3.vdiff.t0 sky130_fd_pr__cap_mim_m3_1 l=1 w=1
X86 openDVS_pixel_3.nRst.t0 RefrBp.t2 VddA18.t14 VddA18.t0 sky130_fd_pr__pfet_01v8 ad=0.126 pd=1.44 as=0.063 ps=0.72 w=0.42 l=1.5
X87 VddA18.t37 openDVS_pixel_1.nRst.t3 VddA18.t37 VddA18.t0 sky130_fd_pr__pfet_01v8 ad=0.225 pd=1.8 as=0 ps=0 w=1.5 l=1.5
X88 openDVS_pixel_2.vdiff.t3 DiffBn_uq1.t0 GndA.t55 GndA.t54 sky130_fd_pr__nfet_01v8 ad=0.45 pd=3.6 as=0.45 ps=3.6 w=1.5 l=1.5
X89 openDVS_pixel_1.vpr.t0 PrBp.t0 VddA18.t11 VddA18.t8 sky130_fd_pr__pfet_01v8 ad=0.15 pd=1.6 as=0.15 ps=1.6 w=0.5 l=0.15
X90 VddA18.t27 openDVS_pixel_3.vdiff.t0 openDVS_pixel_3.nOFF.t1 VddA18.t26 sky130_fd_pr__pfet_01v8 ad=0.225 pd=1.8 as=0.45 ps=3.6 w=1.5 l=1.5
X91 a_528_n281.t0 openDVS_pixel_1.nOFF.t2 GndD.t0 GndA.t17 sky130_fd_pr__nfet_01v8 ad=0.105 pd=0.92 as=0.126 ps=1.44 w=0.42 l=0.15
C0 rowReadON[1] openDVS_pixel_2.vsf 0.18263f
C1 vpd[2] openDVS_pixel_3.vpr 0.22393f
C2 openDVS_pixel_2.vd DiffBn_uq1 0.32938f
C3 VddA18 openDVS_pixel_2.vpr 1.30303f
C4 openDVS_pixel_3.vdiff openDVS_pixel_3.vsf 0.45438f
C5 rowReadON[1] GndD 3.05076f
C6 readLine[1] openDVS_pixel_3.nOFF 0.0087f
C7 openDVS_pixel_1.ON pixRst[1] 0.17114f
C8 openDVS_pixel_3.vdiff openDVS_pixel_0.vpr 0.00108f
C9 OffBn openDVS_pixel_1.vd 0.03201f
C10 openDVS_pixel_3.vsf OnBn 0.74515f
C11 openDVS_pixel_0.nOFF DiffBn_uq1 0.00314f
C12 rowReadON[1] openDVS_pixel_2.nOFF 0.06777f
C13 openDVS_pixel_3.vd PrBp 0.00417f
C14 openDVS_pixel_0.vpr OnBn 0.07638f
C15 pixRst[0] openDVS_pixel_2.nRst 0.11213f
C16 a_n2994_125# readLine[0] 0.00568f
C17 vpd[0] openDVS_pixel_0.vdiff 0.013f
C18 openDVS_pixel_1.vd openDVS_pixel_1.vsf 2.5355f
C19 a_n2994_n281# rowReadOFF[1] 0.00474f
C20 openDVS_pixel_2.nRst PrBp 0.00274f
C21 OffBn readLine[1] 0.02861f
C22 openDVS_pixel_3.nRst GndD 0.00147f
C23 VddA18 openDVS_pixel_1.nRst 1.81406f
C24 openDVS_pixel_1.vdiff GndD 0.10338f
C25 openDVS_pixel_1.vd openDVS_pixel_1.nOFF 0.03252f
C26 vpd[2] openDVS_pixel_3.nRst 0.01107f
C27 rowReadOFF[1] DiffBn_uq1 0.03332f
C28 openDVS_pixel_2.nRst openDVS_pixel_0.nRst 0.00215f
C29 readLine[1] openDVS_pixel_1.vsf 0.05261f
C30 VddA18 rowReadOFF[0] 0.8509f
C31 openDVS_pixel_0.ON openDVS_pixel_0.vd 0.04789f
C32 openDVS_pixel_3.vpr RefrBp 0.04246f
C33 readLine[1] openDVS_pixel_1.nOFF 0.0087f
C34 openDVS_pixel_2.vpr openDVS_pixel_1.vpr 0.04798f
C35 readLine[1] rowReadON[0] 0.17546f
C36 openDVS_pixel_0.ON openDVS_pixel_2.ON 0.01841f
C37 OffBn DiffBn 0.63458f
C38 rowReadON[1] RefrBp 0.02285f
C39 openDVS_pixel_0.vd readLine[0] 0.01062f
C40 a_n2994_125# rowReadON[0] 0.00288f
C41 openDVS_pixel_1.nRst openDVS_pixel_1.vpr 0.29659f
C42 openDVS_pixel_2.nRst openDVS_pixel_2.vd 0.74657f
C43 readLine[1] a_528_n281# 0.00568f
C44 openDVS_pixel_3.nRst a_1070_435# 0.0102f
C45 openDVS_pixel_3.nRst RefrBp 0.29036f
C46 readLine[1] openDVS_pixel_3.ON 0.09499f
C47 openDVS_pixel_1.vdiff RefrBp 0.29532f
C48 OffBn openDVS_pixel_1.DiffBn 0.63458f
C49 openDVS_pixel_3.vpr PrBp 0.04152f
C50 openDVS_pixel_2.ON readLine[0] 0.09499f
C51 pixRst[0] rowReadON[1] 0.12139f
C52 VddA18 PrSFBp 3.58346f
C53 vpd[0] openDVS_pixel_0.vpr 0.22393f
C54 OffBn openDVS_pixel_0.vd 0.09215f
C55 rowReadOFF[1] pixRst[1] 0.08479f
C56 openDVS_pixel_0.ON readLine[0] 0.09499f
C57 rowReadON[1] openDVS_pixel_1.ON 0.26989f
C58 openDVS_pixel_1.nRst a_1070_n607# 0.0102f
C59 openDVS_pixel_1.vsf openDVS_pixel_1.DiffBn 0.15326f
C60 rowReadON[1] PrBp 0.02285f
C61 openDVS_pixel_2.nRst rowReadOFF[1] 0.19202f
C62 openDVS_pixel_2.vpr DiffBn_uq1 0.73278f
C63 vpd[3] VddA18 0.26641f
C64 OffBn openDVS_pixel_2.ON 0.06368f
C65 openDVS_pixel_2.vsf GndD 0.23889f
C66 openDVS_pixel_1.vdiff openDVS_pixel_1.ON 0.72993f
C67 openDVS_pixel_0.vd rowReadON[0] 0.02536f
C68 OffBn openDVS_pixel_0.ON 0.06368f
C69 openDVS_pixel_3.nRst PrBp 0.00939f
C70 openDVS_pixel_1.vdiff PrBp 0.40444f
C71 openDVS_pixel_2.nOFF openDVS_pixel_2.vsf 0.09278f
C72 VddA18 openDVS_pixel_3.vdiff 2.61784f
C73 VddA18 OnBn 3.83852f
C74 openDVS_pixel_0.vd openDVS_pixel_0.vdiff 0.74931f
C75 vpd[1] openDVS_pixel_2.ON 0.00255f
C76 openDVS_pixel_3.nRst openDVS_pixel_0.nRst 0.08244f
C77 readLine[1] openDVS_pixel_3.vsf 0.05261f
C78 openDVS_pixel_2.nOFF GndD 0.06696f
C79 openDVS_pixel_1.vpr PrSFBp 0.03096f
C80 rowReadOFF[0] DiffBn_uq1 0.03332f
C81 openDVS_pixel_0.ON rowReadON[0] 0.26989f
C82 OffBn readLine[0] 0.02861f
C83 rowReadON[1] openDVS_pixel_2.vd 0.02536f
C84 vpd[3] openDVS_pixel_1.vpr 0.22393f
C85 openDVS_pixel_0.ON openDVS_pixel_0.vdiff 0.72993f
C86 OffBn openDVS_pixel_3.nOFF 0.09117f
C87 DiffBn openDVS_pixel_3.vsf 0.15326f
C88 openDVS_pixel_2.vdiff openDVS_pixel_0.vd 0.002f
C89 openDVS_pixel_1.vpr OnBn 0.11356f
C90 a_528_125# GndD 0.01008f
C91 openDVS_pixel_2.nRst openDVS_pixel_2.vpr 0.29638f
C92 rowReadON[0] readLine[0] 0.17546f
C93 openDVS_pixel_1.nOFF openDVS_pixel_3.nOFF 0.01432f
C94 RefrBp GndD 0.08523f
C95 rowReadON[1] rowReadOFF[1] 2.88289f
C96 OffBn openDVS_pixel_1.vsf 0.24901f
C97 readLine[0] openDVS_pixel_0.vdiff 0.00718f
C98 rowReadON[0] openDVS_pixel_3.nOFF 0.06777f
C99 vpd[2] RefrBp 0.00269f
C100 readLine[1] a_788_n281# 0.0037f
C101 openDVS_pixel_2.ON openDVS_pixel_2.vdiff 0.72993f
C102 openDVS_pixel_1.nRst pixRst[1] 0.11213f
C103 vpd[1] OffBn 0.04029f
C104 PrSFBp DiffBn_uq1 0.03161f
C105 OffBn openDVS_pixel_1.nOFF 0.09117f
C106 rowReadOFF[0] pixRst[1] 0.08479f
C107 openDVS_pixel_3.vd rowReadOFF[0] 0.03626f
C108 pixRst[0] openDVS_pixel_2.vsf 0.46584f
C109 openDVS_pixel_2.nRst openDVS_pixel_1.nRst 0.08244f
C110 OffBn rowReadON[0] 0.03674f
C111 openDVS_pixel_0.vpr openDVS_pixel_0.vd 0.02592f
C112 openDVS_pixel_1.vdiff rowReadOFF[1] 0.40904f
C113 openDVS_pixel_2.vsf openDVS_pixel_0.vsf 0.19726f
C114 vpd[0] VddA18 0.20663f
C115 openDVS_pixel_1.nOFF openDVS_pixel_1.vsf 0.09278f
C116 pixRst[0] GndD 0.15529f
C117 OffBn openDVS_pixel_0.vdiff 0.57932f
C118 openDVS_pixel_2.vsf PrBp 0.00966f
C119 openDVS_pixel_0.vsf GndD 0.23889f
C120 openDVS_pixel_3.ON openDVS_pixel_3.nOFF 0.80535f
C121 pixRst[0] openDVS_pixel_2.nOFF 0.02293f
C122 openDVS_pixel_1.ON GndD 0.10581f
C123 PrBp GndD 0.08523f
C124 openDVS_pixel_2.vdiff readLine[0] 0.0071f
C125 openDVS_pixel_0.nRst GndD 0.00147f
C126 DiffBn_uq1 OnBn 0.52286f
C127 OffBn openDVS_pixel_3.ON 0.06368f
C128 VddA18 openDVS_pixel_1.vd 3.77372f
C129 rowReadON[0] openDVS_pixel_0.vdiff 0.13918f
C130 pixRst[0] a_n3520_435# 0.00158f
C131 openDVS_pixel_1.nOFF a_528_n281# 0.00168f
C132 OffBn openDVS_pixel_2.vdiff 0.58232f
C133 VddA18 readLine[1] 1.80231f
C134 openDVS_pixel_3.vd PrSFBp 0.00668f
C135 rowReadOFF[0] a_n3254_125# 0.0015f
C136 openDVS_pixel_3.ON rowReadON[0] 0.26989f
C137 openDVS_pixel_2.vsf openDVS_pixel_2.vd 2.5355f
C138 openDVS_pixel_3.vsf openDVS_pixel_3.nOFF 0.09278f
C139 openDVS_pixel_2.nRst PrSFBp 0.01613f
C140 vpd[1] openDVS_pixel_2.vdiff 0.013f
C141 a_n3520_435# openDVS_pixel_0.nRst 0.0102f
C142 openDVS_pixel_2.vd GndD 0.01083f
C143 openDVS_pixel_2.nOFF openDVS_pixel_2.vd 0.03252f
C144 PrBp RefrBp 2.55764f
C145 openDVS_pixel_1.vd openDVS_pixel_1.vpr 0.02589f
C146 openDVS_pixel_1.vdiff openDVS_pixel_2.vpr 0.00108f
C147 rowReadON[1] openDVS_pixel_1.nRst 0.01501f
C148 openDVS_pixel_0.nOFF GndD 0.06696f
C149 OffBn openDVS_pixel_3.vsf 0.24901f
C150 a_788_125# GndD 0.00829f
C151 OffBn openDVS_pixel_0.vpr 0.18401f
C152 openDVS_pixel_0.nRst RefrBp 0.25357f
C153 openDVS_pixel_0.nOFF openDVS_pixel_2.nOFF 0.01432f
C154 VddA18 DiffBn 0.27205f
C155 openDVS_pixel_3.vdiff pixRst[1] 0.16516f
C156 openDVS_pixel_3.vdiff openDVS_pixel_3.vd 0.7493f
C157 openDVS_pixel_2.vdiff openDVS_pixel_0.vdiff 0.31374f
C158 openDVS_pixel_3.vd OnBn 0.37373f
C159 OnBn pixRst[1] 0.09713f
C160 openDVS_pixel_1.vsf openDVS_pixel_3.vsf 0.19726f
C161 openDVS_pixel_2.vsf rowReadOFF[1] 0.27878f
C162 pixRst[0] openDVS_pixel_0.vsf 0.46584f
C163 openDVS_pixel_1.nRst openDVS_pixel_3.nRst 0.00215f
C164 openDVS_pixel_1.vdiff openDVS_pixel_1.nRst 1.35959f
C165 openDVS_pixel_2.nRst OnBn 0.02198f
C166 rowReadOFF[1] GndD 0.11618f
C167 rowReadON[1] a_n3254_n281# 0.00986f
C168 openDVS_pixel_2.nOFF rowReadOFF[1] 0.17006f
C169 rowReadOFF[0] openDVS_pixel_3.nRst 0.19202f
C170 openDVS_pixel_3.vsf rowReadON[0] 0.18263f
C171 openDVS_pixel_0.vsf PrBp 0.00966f
C172 vpd[0] DiffBn_uq1 0.06718f
C173 VddA18 openDVS_pixel_1.DiffBn 0.96616f
C174 pixRst[0] openDVS_pixel_0.nRst 0.11213f
C175 readLine[1] a_1070_n607# 0.00158f
*C176 openDVS_pixel_0.vsf openDVS_pixel_0.nRst 0.47069f
C177 VddA18 openDVS_pixel_0.vd 3.63675f
C178 openDVS_pixel_0.vpr openDVS_pixel_0.vdiff 0.03772f
C179 openDVS_pixel_2.vd RefrBp 0.00311f
C180 openDVS_pixel_0.nRst PrBp 0.00279f
C181 openDVS_pixel_3.vpr PrSFBp 0.03548f
C182 openDVS_pixel_3.vsf openDVS_pixel_3.ON 0.13402f
C183 VddA18 openDVS_pixel_2.ON 0.34141f
C184 rowReadON[1] PrSFBp 0.02285f
C185 VddA18 openDVS_pixel_0.ON 0.34139f
C186 openDVS_pixel_1.DiffBn openDVS_pixel_1.vpr 0.69294f
C187 pixRst[0] openDVS_pixel_2.vd 0.0876f
C188 rowReadOFF[1] RefrBp 0.02645f
C189 openDVS_pixel_3.vpr openDVS_pixel_3.vdiff 0.03772f
C190 PrSFBp openDVS_pixel_3.nRst 0.00961f
C191 pixRst[0] openDVS_pixel_0.nOFF 0.02293f
C192 openDVS_pixel_1.vdiff PrSFBp 0.14114f
C193 openDVS_pixel_3.vpr OnBn 0.11368f
C194 openDVS_pixel_2.vsf openDVS_pixel_2.vpr 0.12353f
C195 openDVS_pixel_0.nOFF openDVS_pixel_0.vsf 0.09278f
C196 VddA18 readLine[0] 1.80329f
C197 rowReadON[1] OnBn 0.03047f
C198 openDVS_pixel_0.nOFF openDVS_pixel_0.nRst 0.11129f
C199 VddA18 openDVS_pixel_3.nOFF 0.77685f
C200 vpd[3] openDVS_pixel_1.vdiff 0.013f
C201 pixRst[0] rowReadOFF[1] 0.08479f
C202 openDVS_pixel_1.ON rowReadOFF[1] 0.15632f
C203 openDVS_pixel_3.vdiff openDVS_pixel_3.nRst 1.35959f
C204 openDVS_pixel_3.vdiff openDVS_pixel_1.vdiff 0.31374f
C205 openDVS_pixel_2.nRst a_n3520_n607# 0.0102f
C206 openDVS_pixel_3.vd openDVS_pixel_1.vd 0.12906f
C207 openDVS_pixel_1.vd pixRst[1] 0.0876f
C208 rowReadOFF[1] PrBp 0.03327f
C209 OnBn openDVS_pixel_3.nRst 0.06616f
C210 openDVS_pixel_1.vdiff OnBn 0.79067f
C211 openDVS_pixel_1.nRst GndD 0.00147f
C212 VddA18 OffBn 2.77931f
C213 rowReadOFF[0] GndD 0.11618f
C214 VddA18 openDVS_pixel_1.vsf 0.91301f
C215 readLine[1] pixRst[1] 2.93639f
C216 openDVS_pixel_3.vd readLine[1] 0.01062f
C217 vpd[1] VddA18 0.26642f
C218 DiffBn_uq1 openDVS_pixel_0.vd 0.33039f
C219 VddA18 openDVS_pixel_1.nOFF 0.77685f
C220 a_n3254_n281# GndD 0.00829f
C221 VddA18 rowReadON[0] 0.77776f
C222 openDVS_pixel_2.ON a_n2994_n281# 0.00137f
C223 VddA18 openDVS_pixel_0.vdiff 2.63357f
C224 OffBn openDVS_pixel_1.vpr 0.14185f
C225 openDVS_pixel_2.vd rowReadOFF[1] 0.03626f
C226 DiffBn pixRst[1] 0.05082f
C227 DiffBn openDVS_pixel_3.vd 0.02565f
C228 openDVS_pixel_1.vsf openDVS_pixel_1.vpr 0.12353f
C229 openDVS_pixel_2.vsf PrSFBp 0.23861f
C230 a_528_125# rowReadOFF[0] 0.00474f
C231 openDVS_pixel_1.nRst RefrBp 0.28954f
C232 VddA18 openDVS_pixel_3.ON 0.34139f
C233 PrSFBp GndD 0.08523f
C234 rowReadOFF[0] RefrBp 0.02645f
C235 a_n2994_n281# readLine[0] 0.00568f
C236 openDVS_pixel_2.vpr PrBp 0.03652f
C237 vpd[2] PrSFBp 0.00271f
C238 rowReadON[1] a_n3520_n607# 0.00336f
C239 openDVS_pixel_1.DiffBn pixRst[1] 0.0434f
C240 VddA18 openDVS_pixel_2.vdiff 2.7172f
C241 DiffBn_uq1 readLine[0] 0.06264f
C242 openDVS_pixel_3.vd openDVS_pixel_0.vd 0.04776f
C243 rowReadON[1] openDVS_pixel_1.vd 0.02536f
C244 openDVS_pixel_1.ON openDVS_pixel_1.nRst 0.05396f
C245 openDVS_pixel_2.vsf OnBn 0.503f
C246 pixRst[0] rowReadOFF[0] 0.08479f
C247 openDVS_pixel_3.vdiff GndD 0.10338f
C248 openDVS_pixel_1.nRst PrBp 0.0091f
C249 openDVS_pixel_0.vsf rowReadOFF[0] 0.27878f
C250 OnBn GndD 0.13701f
C251 rowReadON[1] readLine[1] 0.17546f
C252 vpd[2] openDVS_pixel_3.vdiff 0.013f
C253 OffBn DiffBn_uq1 3.8566f
C254 rowReadOFF[0] PrBp 0.03327f
C255 vpd[2] OnBn 0.03834f
C256 VddA18 openDVS_pixel_3.vsf 0.79998f
C257 openDVS_pixel_1.vd openDVS_pixel_1.vdiff 0.7493f
C258 VddA18 openDVS_pixel_0.vpr 0.55513f
C259 openDVS_pixel_2.ON openDVS_pixel_2.nRst 0.05396f
C260 rowReadOFF[0] openDVS_pixel_0.nRst 0.19202f
C261 PrSFBp RefrBp 0.53208f
C262 openDVS_pixel_2.vdiff openDVS_pixel_1.vpr 0.00108f
C263 openDVS_pixel_2.vd openDVS_pixel_2.vpr 0.02589f
C264 readLine[1] openDVS_pixel_3.nRst 0.28148f
C265 vpd[1] DiffBn_uq1 0.06725f
C266 openDVS_pixel_3.vpr DiffBn 0.69294f
C267 readLine[1] openDVS_pixel_1.vdiff 0.0071f
C268 DiffBn_uq1 rowReadON[0] 0.03031f
C269 vpd[3] RefrBp 0.00269f
C270 DiffBn_uq1 openDVS_pixel_0.vdiff 0.33724f
C271 pixRst[1] openDVS_pixel_3.nOFF 0.02293f
C272 openDVS_pixel_3.vd openDVS_pixel_3.nOFF 0.03252f
C273 openDVS_pixel_3.vdiff RefrBp 0.29532f
C274 openDVS_pixel_2.nRst readLine[0] 0.28148f
C275 openDVS_pixel_0.vsf PrSFBp 0.23861f
C276 OnBn RefrBp 2.77227f
C277 DiffBn openDVS_pixel_3.nRst 0.01954f
C278 PrSFBp PrBp 2.70909f
C279 openDVS_pixel_0.nOFF rowReadOFF[0] 0.17006f
C280 openDVS_pixel_0.ON a_n3254_125# 0.00314f
C281 OffBn pixRst[1] 0.29184f
C282 OffBn openDVS_pixel_3.vd 0.03201f
C283 a_788_125# rowReadOFF[0] 0.0015f
C284 PrSFBp openDVS_pixel_0.nRst 0.01642f
C285 vpd[3] openDVS_pixel_1.ON 0.00255f
C286 openDVS_pixel_1.vsf pixRst[1] 0.46584f
C287 OffBn openDVS_pixel_2.nRst 0.07157f
C288 openDVS_pixel_1.nRst rowReadOFF[1] 0.19202f
C289 openDVS_pixel_2.vdiff DiffBn_uq1 0.3371f
C290 pixRst[0] OnBn 0.09708f
C291 openDVS_pixel_1.vdiff openDVS_pixel_1.DiffBn 0.13834f
C292 openDVS_pixel_1.nOFF pixRst[1] 0.02293f
C293 rowReadOFF[0] rowReadOFF[1] 0.00965f
C294 openDVS_pixel_0.vsf OnBn 0.503f
C295 rowReadON[1] openDVS_pixel_2.ON 0.26989f
C296 openDVS_pixel_3.vdiff PrBp 0.40517f
C297 rowReadON[0] pixRst[1] 0.12139f
C298 openDVS_pixel_3.vd rowReadON[0] 0.02536f
C299 openDVS_pixel_1.ON OnBn 0.09492f
C300 a_n3254_125# readLine[0] 0.0037f
C301 vpd[1] openDVS_pixel_2.nRst 0.01107f
C302 OnBn PrBp 0.12593f
C303 openDVS_pixel_3.vdiff openDVS_pixel_0.nRst 0.00112f
C304 a_n3254_n281# rowReadOFF[1] 0.0015f
C305 OnBn openDVS_pixel_0.nRst 0.02198f
C306 openDVS_pixel_2.vd PrSFBp 0.01035f
C307 openDVS_pixel_1.vd GndD 0.01083f
C308 openDVS_pixel_0.vpr DiffBn_uq1 0.73027f
C309 openDVS_pixel_3.ON pixRst[1] 0.17114f
C310 openDVS_pixel_3.vd openDVS_pixel_3.ON 0.04789f
C311 readLine[1] GndD 0.1584f
C312 rowReadON[1] readLine[0] 0.17546f
C313 vpd[0] RefrBp 0.00269f
C314 OffBn openDVS_pixel_3.vpr 0.14185f
C315 a_n2994_125# GndD 0.01008f
C316 PrSFBp rowReadOFF[1] 0.03327f
C317 openDVS_pixel_2.vd OnBn 0.06899f
C318 a_n3254_125# rowReadON[0] 0.00986f
C319 openDVS_pixel_2.nRst openDVS_pixel_2.vdiff 1.36019f
C320 OffBn rowReadON[1] 0.03674f
C321 openDVS_pixel_3.nRst openDVS_pixel_3.nOFF 0.11129f
C322 openDVS_pixel_1.vd RefrBp 0.06494f
C323 rowReadON[1] openDVS_pixel_1.vsf 0.18263f
C324 vpd[2] DiffBn 0.06585f
C325 a_528_125# readLine[1] 0.00568f
C326 vpd[0] openDVS_pixel_0.vsf 0.08916f
C327 VddA18 openDVS_pixel_1.vpr 1.30315f
C328 openDVS_pixel_3.vsf pixRst[1] 0.46584f
C329 openDVS_pixel_3.vd openDVS_pixel_3.vsf 2.5355f
C330 OffBn openDVS_pixel_3.nRst 0.04753f
C331 readLine[1] a_1070_435# 0.00158f
C332 openDVS_pixel_3.vpr openDVS_pixel_0.vdiff 0.00108f
C333 OffBn openDVS_pixel_1.vdiff 0.42925f
C334 rowReadON[1] openDVS_pixel_1.nOFF 0.06777f
C335 rowReadOFF[1] OnBn 0.03333f
C336 pixRst[0] a_n3520_n607# 0.00158f
C337 rowReadON[1] rowReadON[0] 0.01633f
C338 vpd[0] openDVS_pixel_0.nRst 0.01107f
C339 openDVS_pixel_1.vdiff openDVS_pixel_1.vsf 0.45438f
C340 openDVS_pixel_0.vd GndD 0.01083f
C341 openDVS_pixel_1.vdiff openDVS_pixel_1.nOFF 0.66062f
C342 openDVS_pixel_1.vd openDVS_pixel_1.ON 0.04789f
C343 openDVS_pixel_3.nRst rowReadON[0] 0.01501f
C344 openDVS_pixel_2.ON openDVS_pixel_2.vsf 0.13402f
C345 openDVS_pixel_1.vd PrBp 0.00417f
C346 rowReadON[1] a_528_n281# 0.00288f
C347 openDVS_pixel_3.nRst openDVS_pixel_0.vdiff 0.00108f
C348 openDVS_pixel_2.ON GndD 0.10581f
C349 openDVS_pixel_2.vpr PrSFBp 0.0403f
C350 readLine[1] openDVS_pixel_1.ON 0.09499f
C351 openDVS_pixel_2.ON openDVS_pixel_2.nOFF 0.80535f
C352 openDVS_pixel_0.ON GndD 0.10581f
C353 openDVS_pixel_3.ON openDVS_pixel_3.nRst 0.05396f
C354 rowReadON[1] openDVS_pixel_2.vdiff 0.13918f
C355 VddA18 DiffBn_uq1 3.25909f
C356 openDVS_pixel_1.nRst PrSFBp 0.00956f
C357 openDVS_pixel_2.vsf readLine[0] 0.05261f
C358 openDVS_pixel_3.vpr openDVS_pixel_3.vsf 0.12376f
C359 openDVS_pixel_0.vd RefrBp 0.00311f
C360 PrSFBp rowReadOFF[0] 0.03327f
C361 readLine[0] GndD 0.1584f
C362 openDVS_pixel_3.vpr openDVS_pixel_0.vpr 0.04798f
C363 openDVS_pixel_2.vpr OnBn 0.0761f
C364 openDVS_pixel_1.vd openDVS_pixel_2.vd 0.04776f
C365 openDVS_pixel_1.vdiff openDVS_pixel_2.vdiff 0.14513f
C366 openDVS_pixel_2.nOFF readLine[0] 0.0087f
C367 openDVS_pixel_3.nOFF GndD 0.06696f
C368 vpd[3] openDVS_pixel_1.nRst 0.01107f
C369 OffBn openDVS_pixel_2.vsf 0.25893f
C370 OffBn GndD 0.08638f
C371 openDVS_pixel_1.nRst OnBn 0.06606f
C372 pixRst[0] openDVS_pixel_0.vd 0.0876f
C373 openDVS_pixel_2.vsf openDVS_pixel_1.vsf 0.03085f
C374 openDVS_pixel_3.vsf openDVS_pixel_3.nRst 0.47069f
*C375 openDVS_pixel_0.vsf openDVS_pixel_0.vd 2.5355f
C376 openDVS_pixel_3.vdiff rowReadOFF[0] 0.40904f
C377 vpd[2] OffBn 0.04029f
C378 OffBn openDVS_pixel_2.nOFF 0.0912f
C379 a_788_125# readLine[1] 0.0037f
C380 vpd[1] openDVS_pixel_2.vsf 0.08938f
C381 openDVS_pixel_1.vd rowReadOFF[1] 0.03626f
C382 rowReadOFF[0] OnBn 0.03333f
C383 openDVS_pixel_1.vsf GndD 0.23889f
C384 a_n3520_435# readLine[0] 0.00158f
C385 VddA18 pixRst[1] 1.1409f
C386 VddA18 openDVS_pixel_3.vd 3.6346f
C387 openDVS_pixel_0.nOFF a_n2994_125# 0.00168f
*C388 openDVS_pixel_0.vd openDVS_pixel_0.nRst 0.74657f
C389 pixRst[0] openDVS_pixel_2.ON 0.17114f
C390 openDVS_pixel_1.nOFF GndD 0.06696f
C391 readLine[1] rowReadOFF[1] 0.32935f
C392 a_528_125# openDVS_pixel_3.nOFF 0.00168f
C393 VddA18 openDVS_pixel_2.nRst 1.81769f
C394 rowReadON[0] GndD 3.05076f
C395 pixRst[0] openDVS_pixel_0.ON 0.17114f
C396 openDVS_pixel_0.ON openDVS_pixel_0.vsf 0.13402f
C397 openDVS_pixel_0.vdiff GndD 0.10338f
C398 rowReadON[1] a_788_n281# 0.00986f
C399 vpd[3] PrSFBp 0.00271f
C400 openDVS_pixel_0.ON openDVS_pixel_0.nRst 0.05396f
C401 a_528_n281# GndD 0.01008f
C402 OffBn RefrBp 0.11345f
C403 openDVS_pixel_3.ON GndD 0.10581f
C404 pixRst[0] readLine[0] 2.93639f
C405 openDVS_pixel_3.vdiff PrSFBp 0.14114f
C406 openDVS_pixel_0.vsf readLine[0] 0.05261f
C407 openDVS_pixel_2.vd openDVS_pixel_0.vd 0.12906f
C408 vpd[2] openDVS_pixel_3.ON 0.00255f
C409 openDVS_pixel_1.vsf RefrBp 0.01063f
C410 PrSFBp OnBn 0.33006f
C411 a_n3520_435# rowReadON[0] 0.00336f
C412 openDVS_pixel_2.vsf openDVS_pixel_2.vdiff 0.45679f
C413 vpd[1] RefrBp 0.00269f
C414 openDVS_pixel_0.nOFF openDVS_pixel_0.vd 0.03252f
C415 a_528_125# rowReadON[0] 0.00288f
C416 openDVS_pixel_2.vdiff GndD 0.10338f
C417 readLine[0] openDVS_pixel_0.nRst 0.28148f
C418 rowReadON[0] a_1070_435# 0.00336f
C419 openDVS_pixel_2.ON openDVS_pixel_2.vd 0.04789f
C420 openDVS_pixel_2.nOFF openDVS_pixel_2.vdiff 0.66062f
C421 rowReadON[0] RefrBp 0.02285f
C422 a_1070_n607# pixRst[1] 0.00158f
C423 OffBn pixRst[0] 0.29184f
C424 vpd[3] OnBn 0.0384f
C425 OffBn openDVS_pixel_0.vsf 0.25893f
C426 OffBn openDVS_pixel_1.ON 0.06368f
C427 openDVS_pixel_0.vdiff RefrBp 0.11526f
C428 VddA18 openDVS_pixel_3.vpr 0.55512f
C429 OffBn PrBp 0.08543f
C430 openDVS_pixel_3.vdiff OnBn 0.79067f
C431 openDVS_pixel_0.ON openDVS_pixel_0.nOFF 0.80535f
C432 openDVS_pixel_1.ON openDVS_pixel_1.vsf 0.13402f
C433 a_528_125# openDVS_pixel_3.ON 0.00137f
C434 OffBn openDVS_pixel_0.nRst 0.07269f
C435 openDVS_pixel_1.vsf PrBp 0.0231f
C436 VddA18 rowReadON[1] 0.77776f
C437 openDVS_pixel_1.vd openDVS_pixel_1.nRst 0.74657f
C438 openDVS_pixel_3.vsf GndD 0.23889f
C439 pixRst[0] rowReadON[0] 0.12139f
C440 openDVS_pixel_1.nOFF openDVS_pixel_1.ON 0.80535f
C441 vpd[2] openDVS_pixel_3.vsf 0.08916f
C442 openDVS_pixel_2.ON rowReadOFF[1] 0.15632f
C443 openDVS_pixel_0.vsf rowReadON[0] 0.18263f
C444 openDVS_pixel_2.vd readLine[0] 0.01062f
C445 pixRst[0] openDVS_pixel_0.vdiff 0.16513f
C446 rowReadON[0] PrBp 0.02285f
C447 readLine[1] openDVS_pixel_1.nRst 0.28148f
C448 openDVS_pixel_0.vsf openDVS_pixel_0.vdiff 0.45679f
C449 VddA18 openDVS_pixel_3.nRst 1.77061f
C450 openDVS_pixel_0.nOFF readLine[0] 0.0087f
C451 VddA18 openDVS_pixel_1.vdiff 2.70181f
C452 openDVS_pixel_2.vdiff RefrBp 0.11526f
C453 openDVS_pixel_2.nRst DiffBn_uq1 0.06455f
C454 openDVS_pixel_0.vdiff PrBp 0.18695f
C455 rowReadON[0] openDVS_pixel_0.nRst 0.01501f
C456 readLine[1] rowReadOFF[0] 0.32935f
C457 openDVS_pixel_0.vdiff openDVS_pixel_0.nRst 1.36025f
C458 openDVS_pixel_1.ON a_528_n281# 0.00137f
C459 vpd[0] PrSFBp 0.00271f
C460 OffBn openDVS_pixel_2.vd 0.09178f
C461 openDVS_pixel_1.ON openDVS_pixel_3.ON 0.01841f
C462 rowReadOFF[0] a_n2994_125# 0.00474f
C463 rowReadOFF[1] readLine[0] 0.32935f
C464 OffBn openDVS_pixel_0.nOFF 0.0912f
C465 pixRst[0] openDVS_pixel_2.vdiff 0.16504f
C466 openDVS_pixel_3.vsf RefrBp 0.01063f
C467 vpd[1] openDVS_pixel_2.vd 0.03975f
C468 a_788_n281# GndD 0.00829f
C469 openDVS_pixel_2.vdiff PrBp 0.18695f
C470 openDVS_pixel_1.vdiff openDVS_pixel_1.vpr 0.03772f
C471 openDVS_pixel_1.vd PrSFBp 0.00668f
C472 rowReadON[1] a_1070_n607# 0.00336f
C473 OffBn rowReadOFF[1] 0.02601f
C474 openDVS_pixel_3.vd pixRst[1] 0.0876f
C475 openDVS_pixel_2.vd openDVS_pixel_0.vdiff 0.002f
C476 vpd[0] OnBn 0.037f
C477 openDVS_pixel_0.nOFF rowReadON[0] 0.06777f
C478 openDVS_pixel_1.DiffBn openDVS_pixel_1.nRst 0.01954f
C479 a_788_125# rowReadON[0] 0.00986f
C480 openDVS_pixel_1.vsf rowReadOFF[1] 0.27878f
C481 openDVS_pixel_0.nOFF openDVS_pixel_0.vdiff 0.66062f
C482 vpd[3] openDVS_pixel_1.vd 0.03975f
C483 openDVS_pixel_0.vsf openDVS_pixel_3.vsf 0.03085f
C484 openDVS_pixel_0.vsf openDVS_pixel_0.vpr 0.12376f
C485 rowReadON[1] a_n2994_n281# 0.00288f
C486 openDVS_pixel_1.nOFF rowReadOFF[1] 0.17006f
C487 openDVS_pixel_3.vdiff openDVS_pixel_1.vd 0.002f
C488 openDVS_pixel_3.vsf PrBp 0.0231f
C489 rowReadOFF[0] openDVS_pixel_0.vd 0.03626f
C490 openDVS_pixel_0.vpr PrBp 0.03652f
C491 openDVS_pixel_1.vd OnBn 0.37272f
C492 rowReadON[1] DiffBn_uq1 0.03031f
C493 openDVS_pixel_0.vpr openDVS_pixel_0.nRst 0.29659f
C494 a_788_125# openDVS_pixel_3.ON 0.00314f
C495 VddA18 openDVS_pixel_2.vsf 0.91292f
C496 openDVS_pixel_3.vdiff readLine[1] 0.00718f
C497 openDVS_pixel_2.vdiff openDVS_pixel_2.vd 0.74927f
C498 readLine[1] OnBn 0.02508f
C499 VddA18 GndD 3.15332f
C500 a_528_n281# rowReadOFF[1] 0.00474f
C501 openDVS_pixel_0.ON rowReadOFF[0] 0.15632f
C502 VddA18 openDVS_pixel_2.nOFF 0.77685f
C503 vpd[2] VddA18 0.2067f
C504 openDVS_pixel_2.ON a_n3254_n281# 0.00314f
C505 OffBn openDVS_pixel_2.vpr 0.18477f
C506 openDVS_pixel_2.vdiff rowReadOFF[1] 0.40904f
C507 DiffBn openDVS_pixel_3.vdiff 0.13834f
C508 openDVS_pixel_3.vpr openDVS_pixel_3.vd 0.02592f
C509 openDVS_pixel_1.ON a_788_n281# 0.00314f
C510 PrSFBp openDVS_pixel_0.vd 0.01035f
C511 rowReadOFF[0] readLine[0] 0.32935f
C512 DiffBn OnBn 0.24509f
C513 rowReadOFF[0] openDVS_pixel_3.nOFF 0.17006f
C514 vpd[1] openDVS_pixel_2.vpr 0.22393f
C515 vpd[3] openDVS_pixel_1.DiffBn 0.06585f
C516 rowReadON[1] pixRst[1] 0.12139f
C517 a_n3254_n281# readLine[0] 0.0037f
C518 OffBn openDVS_pixel_1.nRst 0.04753f
C519 rowReadON[1] openDVS_pixel_2.nRst 0.01501f
C520 VddA18 RefrBp 3.45868f
C521 OffBn rowReadOFF[0] 0.02601f
C522 openDVS_pixel_1.DiffBn OnBn 0.24509f
C523 openDVS_pixel_1.vsf openDVS_pixel_1.nRst 0.47069f
C524 openDVS_pixel_3.nRst pixRst[1] 0.11213f
C525 openDVS_pixel_3.vd openDVS_pixel_3.nRst 0.74657f
C526 openDVS_pixel_3.vd openDVS_pixel_1.vdiff 0.002f
C527 openDVS_pixel_1.vdiff pixRst[1] 0.16507f
C528 OnBn openDVS_pixel_0.vd 0.06899f
C529 openDVS_pixel_1.nOFF openDVS_pixel_1.nRst 0.11129f
C530 openDVS_pixel_1.vdiff openDVS_pixel_2.nRst 0.00112f
C531 VddA18 pixRst[0] 1.14091f
C532 rowReadOFF[0] rowReadON[0] 2.88289f
C533 openDVS_pixel_2.ON OnBn 0.0949f
C534 VddA18 openDVS_pixel_0.vsf 0.79986f
C535 VddA18 openDVS_pixel_1.ON 0.3414f
C536 a_n2994_n281# GndD 0.01008f
C537 openDVS_pixel_0.ON OnBn 0.0949f
C538 openDVS_pixel_2.vsf DiffBn_uq1 0.39556f
C539 rowReadOFF[0] openDVS_pixel_0.vdiff 0.40904f
C540 VddA18 PrBp 2.50521f
C541 openDVS_pixel_1.vpr RefrBp 0.04245f
C542 openDVS_pixel_2.nOFF a_n2994_n281# 0.00168f
C543 openDVS_pixel_2.vdiff openDVS_pixel_2.vpr 0.03756f
C544 readLine[1] openDVS_pixel_1.vd 0.01062f
C545 DiffBn_uq1 GndD 0.13701f
C546 VddA18 openDVS_pixel_0.nRst 1.77418f
C547 openDVS_pixel_2.nOFF DiffBn_uq1 0.00314f
C548 OffBn PrSFBp 2.63372f
C549 a_788_n281# rowReadOFF[1] 0.0015f
C550 openDVS_pixel_3.ON rowReadOFF[0] 0.15632f
C551 openDVS_pixel_1.vsf PrSFBp 0.23037f
C552 OnBn readLine[0] 0.02503f
C553 openDVS_pixel_2.vdiff openDVS_pixel_1.nRst 0.00108f
C554 openDVS_pixel_3.vdiff openDVS_pixel_3.nOFF 0.66062f
C555 vpd[1] PrSFBp 0.00271f
C556 vpd[3] OffBn 0.04029f
C557 OnBn openDVS_pixel_3.nOFF 0.00315f
C558 openDVS_pixel_3.vpr openDVS_pixel_3.nRst 0.29638f
C559 openDVS_pixel_1.vpr PrBp 0.04152f
C560 PrSFBp rowReadON[0] 0.02285f
C561 vpd[3] openDVS_pixel_1.vsf 0.08938f
C562 OffBn openDVS_pixel_3.vdiff 0.42925f
C563 VddA18 openDVS_pixel_2.vd 3.77589f
C564 vpd[0] openDVS_pixel_0.vd 0.03975f
C565 OffBn OnBn 6.21161f
C566 PrSFBp openDVS_pixel_0.vdiff 0.35387f
C567 VddA18 openDVS_pixel_0.nOFF 0.77685f
C568 rowReadON[1] openDVS_pixel_1.vdiff 0.13918f
C569 DiffBn readLine[1] 0.03437f
C570 DiffBn_uq1 RefrBp 0.02534f
C571 openDVS_pixel_1.vsf OnBn 0.74514f
C572 pixRst[1] GndD 0.15529f
C573 openDVS_pixel_3.vd GndD 0.01083f
C574 openDVS_pixel_3.vsf rowReadOFF[0] 0.27878f
C575 openDVS_pixel_2.nRst openDVS_pixel_2.vsf 0.47069f
C576 openDVS_pixel_1.vd openDVS_pixel_1.DiffBn 0.02565f
C577 vpd[1] OnBn 0.037f
C578 vpd[2] openDVS_pixel_3.vd 0.03975f
C579 openDVS_pixel_3.vdiff rowReadON[0] 0.13918f
C580 openDVS_pixel_1.nOFF OnBn 0.00315f
C581 vpd[0] openDVS_pixel_0.ON 0.00255f
C582 openDVS_pixel_2.nRst GndD 0.00147f
C583 OnBn rowReadON[0] 0.03047f
C584 VddA18 rowReadOFF[1] 0.8509f
C585 openDVS_pixel_3.vdiff openDVS_pixel_0.vdiff 0.14513f
C586 openDVS_pixel_2.nOFF openDVS_pixel_2.nRst 0.11129f
C587 readLine[1] openDVS_pixel_1.DiffBn 0.02845f
C588 OnBn openDVS_pixel_0.vdiff 0.59355f
C589 openDVS_pixel_2.vdiff PrSFBp 0.35313f
C590 pixRst[0] DiffBn_uq1 0.09398f
C591 openDVS_pixel_0.vsf DiffBn_uq1 0.39556f
C592 openDVS_pixel_3.vdiff openDVS_pixel_3.ON 0.72993f
C593 openDVS_pixel_3.ON OnBn 0.09492f
C594 DiffBn_uq1 openDVS_pixel_0.nRst 0.06414f
C595 pixRst[1] a_1070_435# 0.00158f
C596 a_n3520_n607# readLine[0] 0.00158f
C597 openDVS_pixel_3.vd RefrBp 0.06544f
C598 openDVS_pixel_3.vsf PrSFBp 0.23037f
C599 a_n3254_125# GndD 0.00829f
C600 openDVS_pixel_0.vpr PrSFBp 0.03578f
C601 openDVS_pixel_2.vdiff OnBn 0.5926f
C602 openDVS_pixel_2.nRst RefrBp 0.25357f
C603 vpd[0] OffBn 0.04029f
C604 openDVS_pixel_0.ON a_n2994_125# 0.00137f
R0 readLine[1].n3 readLine[1].n2 204.788
R1 readLine[1].n1 readLine[1].n0 204.788
R2 readLine[1].n2 readLine[1].t1 71.4291
R3 readLine[1].n2 readLine[1].t3 71.4291
R4 readLine[1].n0 readLine[1].t2 71.4291
R5 readLine[1].n0 readLine[1].t0 71.4291
R6 readLine[1].n4 readLine[1].n3 1.54652
R7 readLine[1].n1 readLine[1] 1.34855
R8 readLine[1].n3 readLine[1].n1 0.483318
R9 rowReadOFF[1].n2 rowReadOFF[1].t1 322.502
R10 rowReadOFF[1].n0 rowReadOFF[1].t0 322.502
R11 rowReadOFF[1].n3 rowReadOFF[1].n1 8.66396
R12 rowReadOFF[1].n3 rowReadOFF[1].n2 4.67085
R13 rowReadOFF[1].n1 rowReadOFF[1].n0 4.67085
R14 rowReadOFF[1].n4 rowReadOFF[1].n3 1.438
R15 rowReadOFF[1].n1 rowReadOFF[1] 1.313
R16 rowReadOFF[1].n2 rowReadOFF[1] 0.0575652
R17 rowReadOFF[1].n0 rowReadOFF[1] 0.0575652
R18 rowReadON[1].n0 rowReadON[1].t0 468.889
R19 rowReadON[1].n3 rowReadON[1].t1 468.889
R20 rowReadON[1].n0 rowReadON[1].t2 313.202
R21 rowReadON[1].n3 rowReadON[1].t3 313.202
R22 rowReadON[1].n5 rowReadON[1].n2 9.51973
R23 rowReadON[1].n1 rowReadON[1].n0 9.3005
R24 rowReadON[1].n4 rowReadON[1].n3 9.3005
R25 rowReadON[1].n2 rowReadON[1].n1 4.89191
R26 rowReadON[1].n5 rowReadON[1].n4 4.89191
R27 rowReadON[1].n6 rowReadON[1].n5 1.01012
R28 rowReadON[1].n2 rowReadON[1] 0.885115
R29 rowReadON[1].n1 rowReadON[1] 0.0575652
R30 rowReadON[1].n4 rowReadON[1] 0.0575652
R31 readLine[0].n1 readLine[0].n0 194.3
R32 readLine[0].n4 readLine[0].n3 194.3
R33 readLine[0].n0 readLine[0].t2 71.4291
R34 readLine[0].n0 readLine[0].t1 71.4291
R35 readLine[0].n3 readLine[0].t3 71.4291
R36 readLine[0].n3 readLine[0].t0 71.4291
R37 readLine[0].n2 readLine[0].n1 10.4258
R38 readLine[0].n5 readLine[0].n4 10.4258
R39 readLine[0].n2 readLine[0] 1.54652
R40 readLine[0].n6 readLine[0].n5 1.34855
R41 readLine[0].n5 readLine[0].n2 0.483318
R42 readLine[0].n1 readLine[0] 0.063
R43 readLine[0].n4 readLine[0] 0.063
R44 GndD.n10 GndD.t7 237.356
R45 GndD.n1 GndD.t5 237.356
R46 GndD.n9 GndD.t4 237.356
R47 GndD.n30 GndD.t2 237.356
R48 GndD.n6 GndD.t0 237.157
R49 GndD.n21 GndD.t3 237.157
R50 GndD.n18 GndD.t6 237.157
R51 GndD.n3 GndD.t1 237.157
R52 GndD.n14 GndD.n13 4.6255
R53 GndD.n17 GndD.n16 4.6255
R54 GndD.n26 GndD.n25 4.6255
R55 GndD.n29 GndD.n28 4.6255
R56 GndD.n29 GndD.n0 4.5005
R57 GndD.n31 GndD.n30 4.5005
R58 GndD.n23 GndD.n4 4.5005
R59 GndD.n25 GndD.n24 4.5005
R60 GndD.n17 GndD.n5 4.5005
R61 GndD.n20 GndD.n19 4.5005
R62 GndD.n11 GndD.n9 4.5005
R63 GndD.n13 GndD.n12 4.5005
R64 GndD.n31 GndD.n1 4.5005
R65 GndD.n23 GndD.n22 4.5005
R66 GndD.n20 GndD.n7 4.5005
R67 GndD.n11 GndD.n10 4.5005
R68 GndD.n10 GndD.n8 2.39809
R69 GndD.n15 GndD.n7 2.39809
R70 GndD.n22 GndD.n2 2.39809
R71 GndD.n27 GndD.n1 2.39809
R72 GndD.n23 GndD.n20 1.8141
R73 GndD.n7 GndD.n6 0.19817
R74 GndD.n22 GndD.n21 0.19817
R75 GndD.n19 GndD.n18 0.19817
R76 GndD.n4 GndD.n3 0.19817
R77 GndD.n32 GndD.n31 0.149623
R78 GndD.n13 GndD.n9 0.1255
R79 GndD.n19 GndD.n17 0.1255
R80 GndD.n25 GndD.n4 0.1255
R81 GndD.n30 GndD.n29 0.1255
R82 GndD.n11 GndD 0.121114
R83 GndD.n28 GndD.n26 0.120018
R84 GndD.n16 GndD.n14 0.120018
R85 GndD.n31 GndD.n0 0.0355877
R86 GndD.n24 GndD.n23 0.0355877
R87 GndD.n20 GndD.n5 0.0355877
R88 GndD.n12 GndD.n11 0.0355877
R89 GndD.n6 GndD 0.0198966
R90 GndD.n21 GndD 0.0198966
R91 GndD.n18 GndD 0.0198966
R92 GndD.n3 GndD 0.0198966
R93 GndD.n28 GndD.n27 0.0187161
R94 GndD.n26 GndD.n2 0.0187161
R95 GndD.n16 GndD.n15 0.0187161
R96 GndD.n14 GndD.n8 0.0187161
R97 GndD.n27 GndD.n0 0.0182373
R98 GndD.n24 GndD.n2 0.0182373
R99 GndD.n15 GndD.n5 0.0182373
R100 GndD.n12 GndD.n8 0.0182373
R101 rowReadOFF[0].n2 rowReadOFF[0].t1 322.502
R102 rowReadOFF[0].n0 rowReadOFF[0].t0 322.502
R103 rowReadOFF[0].n3 rowReadOFF[0].n1 8.66396
R104 rowReadOFF[0].n3 rowReadOFF[0].n2 4.67085
R105 rowReadOFF[0].n1 rowReadOFF[0].n0 4.67085
R106 rowReadOFF[0].n4 rowReadOFF[0].n3 1.438
R107 rowReadOFF[0].n1 rowReadOFF[0] 1.313
R108 rowReadOFF[0].n2 rowReadOFF[0] 0.0575652
R109 rowReadOFF[0].n0 rowReadOFF[0] 0.0575652
R110 pixRst[1] pixRst[1].t1 322.741
R111 pixRst[1] pixRst[1].t0 322.741
R112 pixRst[1].n1 pixRst[1] 8.04197
R113 pixRst[1].n0 pixRst[1] 8.04197
R114 pixRst[1].n2 pixRst[1].n1 1.54652
R115 pixRst[1].n0 pixRst[1] 1.34855
R116 pixRst[1].n1 pixRst[1].n0 0.483318
R117 pixRst[0] pixRst[0].t0 322.741
R118 pixRst[0] pixRst[0].t1 322.741
R119 pixRst[0].n1 pixRst[0] 8.04197
R120 pixRst[0].n0 pixRst[0] 8.04197
R121 pixRst[0].n0 pixRst[0] 1.54652
R122 pixRst[0].n2 pixRst[0].n1 1.34855
R123 pixRst[0].n1 pixRst[0].n0 0.483318
R124 rowReadON[0].n0 rowReadON[0].t2 468.889
R125 rowReadON[0].n3 rowReadON[0].t3 468.889
R126 rowReadON[0].n0 rowReadON[0].t0 313.202
R127 rowReadON[0].n3 rowReadON[0].t1 313.202
R128 rowReadON[0].n5 rowReadON[0].n2 9.51973
R129 rowReadON[0].n1 rowReadON[0].n0 9.3005
R130 rowReadON[0].n4 rowReadON[0].n3 9.3005
R131 rowReadON[0].n2 rowReadON[0].n1 4.89191
R132 rowReadON[0].n5 rowReadON[0].n4 4.89191
R133 rowReadON[0].n6 rowReadON[0].n5 1.01012
R134 rowReadON[0].n2 rowReadON[0] 0.885115
R135 rowReadON[0].n1 rowReadON[0] 0.0575652
R136 rowReadON[0].n4 rowReadON[0] 0.0575652
R137 RefrBp.n2 RefrBp.n0 99.5497
R138 RefrBp.n10 RefrBp.n8 99.5497
R139 RefrBp.n3 RefrBp.n2 93.5476
R140 RefrBp.n11 RefrBp.n10 93.5476
R141 RefrBp.n1 RefrBp.t1 59.5326
R142 RefrBp.n9 RefrBp.t3 59.5326
R143 RefrBp.n4 RefrBp.n0 29.507
R144 RefrBp.n12 RefrBp.n8 29.507
R145 RefrBp.n3 RefrBp.n1 23.0638
R146 RefrBp.n11 RefrBp.n9 23.0638
R147 RefrBp.n4 RefrBp.n3 11.3247
R148 RefrBp.n12 RefrBp.n11 11.3247
R149 RefrBp.n5 RefrBp.n4 9.3005
R150 RefrBp.n13 RefrBp.n12 9.3005
R151 RefrBp.n7 RefrBp.n6 7.91219
R152 RefrBp.n15 RefrBp.n14 7.91219
R153 RefrBp.n2 RefrBp.t0 6.7485
R154 RefrBp.n10 RefrBp.t2 6.7485
R155 RefrBp.n6 RefrBp.n0 4.97707
R156 RefrBp.n14 RefrBp.n8 4.97707
R157 RefrBp.n15 RefrBp.n7 1.48456
R158 RefrBp.n7 RefrBp 0.967561
R159 RefrBp.n16 RefrBp.n15 0.926258
R160 RefrBp.n5 RefrBp.n1 0.196152
R161 RefrBp.n13 RefrBp.n9 0.196152
R162 RefrBp.n6 RefrBp.n5 0.0871627
R163 RefrBp.n14 RefrBp.n13 0.0871627
R164 PrSFBp.n1 PrSFBp.t1 59.1003
R165 PrSFBp.n5 PrSFBp.t3 59.1003
R166 PrSFBp.n0 PrSFBp.t0 59.0996
R167 PrSFBp.n4 PrSFBp.t2 59.0996
R168 PrSFBp.n3 PrSFBp.n2 7.91388
R169 PrSFBp.n7 PrSFBp.n6 7.91388
R170 PrSFBp.n7 PrSFBp.n3 2.16677
R171 PrSFBp.n3 PrSFBp 0.626455
R172 PrSFBp.n8 PrSFBp.n7 0.585151
R173 PrSFBp.n2 PrSFBp.n0 0.396375
R174 PrSFBp.n6 PrSFBp.n4 0.396375
R175 PrSFBp.n2 PrSFBp.n1 0.0615595
R176 PrSFBp.n6 PrSFBp.n5 0.0615595
R177 PrSFBp.n0 PrSFBp 0.0139972
R178 PrSFBp.n4 PrSFBp 0.0139972
R179 PrSFBp.n1 PrSFBp 0.0124987
R180 PrSFBp.n5 PrSFBp 0.0124987
R181 OffBn.n2 OffBn.t1 76.373
R182 OffBn.n7 OffBn.t3 76.373
R183 OffBn.n0 OffBn.t0 67.0007
R184 OffBn.n5 OffBn.t2 67.0007
R185 OffBn OffBn.n0 18.7964
R186 OffBn OffBn.n5 18.7964
R187 OffBn.n8 OffBn.n6 18.7335
R188 OffBn.n3 OffBn.n1 18.7232
R189 OffBn.n1 OffBn.n0 18.7186
R190 OffBn.n6 OffBn.n5 18.7186
R191 OffBn.n8 OffBn.n7 16.0909
R192 OffBn.n3 OffBn.n2 16.0806
R193 OffBn.n9 OffBn.n8 3.4105
R194 OffBn.n4 OffBn.n3 3.4105
R195 OffBn.n9 OffBn.n4 2.8732
R196 OffBn.n4 OffBn 0.276091
R197 OffBn.n10 OffBn.n9 0.229091
R198 OffBn.n1 OffBn 0.0269423
R199 OffBn.n6 OffBn 0.0269423
R200 OffBn.n2 OffBn 0.0142392
R201 OffBn.n7 OffBn 0.0142392
R202 PrBp.n2 PrBp.t3 174.056
R203 PrBp.n2 PrBp.t2 174.056
R204 PrBp.n0 PrBp.t1 174.056
R205 PrBp.n0 PrBp.t0 174.056
R206 PrBp.n3 PrBp.n2 170.696
R207 PrBp.n1 PrBp.n0 170.696
R208 PrBp.n3 PrBp.n1 2.25792
R209 PrBp.n1 PrBp 0.580879
R210 PrBp.n4 PrBp.n3 0.539576
R211 OnBn.n2 OnBn.t3 97.5819
R212 OnBn.n0 OnBn.t1 97.5819
R213 OnBn.n2 OnBn.t2 89.256
R214 OnBn.n0 OnBn.t0 89.256
R215 OnBn.n1 OnBn.n0 3.4105
R216 OnBn.n3 OnBn.n2 3.4105
R217 OnBn.n3 OnBn.n1 2.78774
R218 OnBn.n1 OnBn 0.31597
R219 OnBn.n4 OnBn.n3 0.274667
R220 DiffBn_uq1.n0 DiffBn_uq1.t1 94.4876
R221 DiffBn_uq1.n0 DiffBn_uq1.t0 91.4881
R222 DiffBn_uq1 DiffBn_uq1.n0 0.209864
R223 VddA18.n21 VddA18.t9 653.41
R224 VddA18.n22 VddA18.t10 653.41
R225 VddA18.n169 VddA18.t11 653.41
R226 VddA18 VddA18.t7 653.41
R227 VddA18.n244 VddA18.n243 594.534
R228 VddA18.n131 VddA18.n130 594.534
R229 VddA18.n133 VddA18.n132 594.301
R230 VddA18.n242 VddA18.n38 594.301
R231 VddA18.t26 VddA18.t28 394.92
R232 VddA18.t24 VddA18.t39 394.92
R233 VddA18.n150 VddA18.n149 348.623
R234 VddA18.n247 VddA18.n35 348.623
R235 VddA18.n250 VddA18.n247 348.623
R236 VddA18.n149 VddA18.n71 348.623
R237 VddA18.t28 VddA18.n148 343.361
R238 VddA18.n87 VddA18.t24 343.361
R239 VddA18.n149 VddA18.t26 301.675
R240 VddA18.n247 VddA18.t39 301.675
R241 VddA18.n86 VddA18.n81 265.926
R242 VddA18.n89 VddA18.n88 265.926
R243 VddA18.n245 VddA18.n37 261.224
R244 VddA18.n246 VddA18.n245 261.224
R245 VddA18.n75 VddA18.n72 260.327
R246 VddA18.n147 VddA18.n146 260.327
R247 VddA18.n85 VddA18.n83 254.119
R248 VddA18.n76 VddA18.n73 254.119
R249 VddA18.t21 VddA18 235.076
R250 VddA18 VddA18.t20 235.076
R251 VddA18.t37 VddA18.n39 235.076
R252 VddA18.n41 VddA18.t16 235.076
R253 VddA18.n70 VddA18.t17 231.351
R254 VddA18.n249 VddA18.t36 231.351
R255 VddA18.n68 VddA18.t19 231.213
R256 VddA18.n34 VddA18.t35 231.213
R257 VddA18.n131 VddA18.n36 186.309
R258 VddA18.n77 VddA18.n76 185
R259 VddA18.n74 VddA18.n73 185
R260 VddA18.n83 VddA18.n82 185
R261 VddA18.n85 VddA18.n84 185
R262 VddA18.n138 VddA18.n137 157.042
R263 VddA18.n141 VddA18.n140 157.042
R264 VddA18.n135 VddA18.n93 151.696
R265 VddA18.n42 VddA18.n40 151.696
R266 VddA18.n92 VddA18.n91 151.649
R267 VddA18.n144 VddA18.n143 151.649
R268 VddA18.n92 VddA18.n80 151.649
R269 VddA18.n144 VddA18.n79 151.649
R270 VddA18.n147 VddA18.n73 75.3262
R271 VddA18.n88 VddA18.n83 75.3262
R272 VddA18.n86 VddA18.n85 75.3262
R273 VddA18.n76 VddA18.n72 75.3262
R274 VddA18.n243 VddA18.t3 70.3576
R275 VddA18.n243 VddA18.t1 70.3576
R276 VddA18.n130 VddA18.t4 70.3576
R277 VddA18.n130 VddA18.t5 70.3576
R278 VddA18.n132 VddA18.t12 70.3576
R279 VddA18.n132 VddA18.t14 70.3576
R280 VddA18.n38 VddA18.t13 70.3576
R281 VddA18.n38 VddA18.t15 70.3576
R282 VddA18.n245 VddA18.n244 59.0399
R283 VddA18.n148 VddA18.n72 54.8384
R284 VddA18.n148 VddA18.n147 54.8384
R285 VddA18.n88 VddA18.n87 54.8384
R286 VddA18.n87 VddA18.n86 54.8384
R287 VddA18.n247 VddA18.t2 51.6765
R288 VddA18.n149 VddA18.t0 51.6765
R289 VddA18.n84 VddA18.n82 27.1064
R290 VddA18.n146 VddA18.n74 27.1064
R291 VddA18.n77 VddA18.n75 27.1064
R292 VddA18.t20 VddA18.n93 19.7005
R293 VddA18.n93 VddA18.t21 19.7005
R294 VddA18.t16 VddA18.n40 19.7005
R295 VddA18.n40 VddA18.t37 19.7005
R296 VddA18.n80 VddA18.t30 19.7005
R297 VddA18.n80 VddA18.t41 19.7005
R298 VddA18.n91 VddA18.t25 19.7005
R299 VddA18.n91 VddA18.t40 19.7005
R300 VddA18.n79 VddA18.t27 19.7005
R301 VddA18.n79 VddA18.t29 19.7005
R302 VddA18.n143 VddA18.t32 19.7005
R303 VddA18.n143 VddA18.t33 19.7005
R304 VddA18.n137 VddA18.t23 19.7005
R305 VddA18.n137 VddA18.t22 19.7005
R306 VddA18.n140 VddA18.t42 19.7005
R307 VddA18.n140 VddA18.t43 19.7005
R308 VddA18.t34 VddA18.n246 13.1579
R309 VddA18.t31 VddA18.n37 13.1579
R310 VddA18.n146 VddA18.n145 9.47985
R311 VddA18.n145 VddA18.n75 9.47985
R312 VddA18.t2 VddA18.t38 7.0559
R313 VddA18.t0 VddA18.t18 7.0559
R314 VddA18.n37 VddA18.n36 6.68993
R315 VddA18.n246 VddA18.n36 6.68993
R316 VddA18.n78 VddA18.n77 5.51637
R317 VddA18.n78 VddA18.n74 5.51637
R318 VddA18.n84 VddA18.n81 5.49481
R319 VddA18.n89 VddA18.n82 5.49481
R320 VddA18.n46 VddA18.n45 4.5005
R321 VddA18.n233 VddA18.n232 4.5005
R322 VddA18.n231 VddA18.n48 4.5005
R323 VddA18.n117 VddA18.n114 4.5005
R324 VddA18.n124 VddA18.n113 4.5005
R325 VddA18.n126 VddA18.n125 4.5005
R326 VddA18.n99 VddA18.n98 4.5005
R327 VddA18.n101 VddA18.n100 4.5005
R328 VddA18.n103 VddA18.n102 4.5005
R329 VddA18.n211 VddA18.n210 4.5005
R330 VddA18.n218 VddA18.n217 4.5005
R331 VddA18.n219 VddA18.n209 4.5005
R332 VddA18.t38 VddA18.t6 3.81423
R333 VddA18.t18 VddA18.t8 3.81423
R334 VddA18.n259 VddA18.n258 3.45252
R335 VddA18.n297 VddA18.n296 3.45252
R336 VddA18.n188 VddA18.n187 3.45252
R337 VddA18.n64 VddA18.n63 3.45252
R338 VddA18.n105 VddA18.n104 3.44701
R339 VddA18.n212 VddA18.n208 3.44701
R340 VddA18.t6 VddA18.t34 3.43286
R341 VddA18.t8 VddA18.t31 3.43286
R342 VddA18.n119 VddA18.n118 3.43222
R343 VddA18.n230 VddA18.n227 3.43222
R344 VddA18.n296 VddA18.n295 3.42607
R345 VddA18.n64 VddA18.n59 3.42607
R346 VddA18.n275 VddA18.n25 3.41121
R347 VddA18.n281 VddA18.n13 3.41121
R348 VddA18.n204 VddA18.n172 3.41121
R349 VddA18.n168 VddA18.n167 3.41121
R350 VddA18.n24 VddA18.n23 3.41101
R351 VddA18.n227 VddA18.n226 3.4105
R352 VddA18.n237 VddA18.n236 3.4105
R353 VddA18.n235 VddA18.n234 3.4105
R354 VddA18.n229 VddA18.n228 3.4105
R355 VddA18.n1 VddA18.n0 3.4105
R356 VddA18.n5 VddA18.n3 3.4105
R357 VddA18.n293 VddA18.n292 3.4105
R358 VddA18.n291 VddA18.n290 3.4105
R359 VddA18.n11 VddA18.n7 3.4105
R360 VddA18.n12 VddA18.n9 3.4105
R361 VddA18.n285 VddA18.n284 3.4105
R362 VddA18.n283 VddA18.n282 3.4105
R363 VddA18.n274 VddA18.n273 3.4105
R364 VddA18.n272 VddA18.n271 3.4105
R365 VddA18.n28 VddA18.n27 3.4105
R366 VddA18.n32 VddA18.n30 3.4105
R367 VddA18.n266 VddA18.n265 3.4105
R368 VddA18.n264 VddA18.n263 3.4105
R369 VddA18.n253 VddA18.n252 3.4105
R370 VddA18.n256 VddA18.n255 3.4105
R371 VddA18.n276 VddA18.n275 3.4105
R372 VddA18.n260 VddA18.n259 3.4105
R373 VddA18.n262 VddA18.n261 3.4105
R374 VddA18.n31 VddA18.n29 3.4105
R375 VddA18.n268 VddA18.n267 3.4105
R376 VddA18.n270 VddA18.n269 3.4105
R377 VddA18.n26 VddA18.n20 3.4105
R378 VddA18.n107 VddA18.n15 3.4105
R379 VddA18.n119 VddA18.n18 3.4105
R380 VddA18.n120 VddA18.n116 3.4105
R381 VddA18.n123 VddA18.n122 3.4105
R382 VddA18.n115 VddA18.n112 3.4105
R383 VddA18.n108 VddA18.n95 3.4105
R384 VddA18.n107 VddA18.n96 3.4105
R385 VddA18.n106 VddA18.n97 3.4105
R386 VddA18.n281 VddA18.n280 3.4105
R387 VddA18.n10 VddA18.n8 3.4105
R388 VddA18.n287 VddA18.n286 3.4105
R389 VddA18.n289 VddA18.n288 3.4105
R390 VddA18.n4 VddA18.n2 3.4105
R391 VddA18.n295 VddA18.n294 3.4105
R392 VddA18.n65 VddA18.n61 3.4105
R393 VddA18.n67 VddA18.n66 3.4105
R394 VddA18.n154 VddA18.n153 3.4105
R395 VddA18.n152 VddA18.n58 3.4105
R396 VddA18.n159 VddA18.n57 3.4105
R397 VddA18.n161 VddA18.n160 3.4105
R398 VddA18.n163 VddA18.n162 3.4105
R399 VddA18.n54 VddA18.n53 3.4105
R400 VddA18.n203 VddA18.n202 3.4105
R401 VddA18.n201 VddA18.n200 3.4105
R402 VddA18.n175 VddA18.n174 3.4105
R403 VddA18.n179 VddA18.n177 3.4105
R404 VddA18.n195 VddA18.n194 3.4105
R405 VddA18.n193 VddA18.n192 3.4105
R406 VddA18.n182 VddA18.n181 3.4105
R407 VddA18.n185 VddA18.n184 3.4105
R408 VddA18.n205 VddA18.n204 3.4105
R409 VddA18.n189 VddA18.n188 3.4105
R410 VddA18.n191 VddA18.n190 3.4105
R411 VddA18.n178 VddA18.n176 3.4105
R412 VddA18.n197 VddA18.n196 3.4105
R413 VddA18.n199 VddA18.n198 3.4105
R414 VddA18.n173 VddA18.n52 3.4105
R415 VddA18.n167 VddA18.n166 3.4105
R416 VddA18.n165 VddA18.n164 3.4105
R417 VddA18.n56 VddA18.n55 3.4105
R418 VddA18.n158 VddA18.n157 3.4105
R419 VddA18.n156 VddA18.n155 3.4105
R420 VddA18.n60 VddA18.n59 3.4105
R421 VddA18.n214 VddA18.n213 3.4105
R422 VddA18.n216 VddA18.n215 3.4105
R423 VddA18.n222 VddA18.n221 3.4105
R424 VddA18.n171 VddA18.n170 3.2847
R425 VddA18.n118 VddA18.n117 2.3963
R426 VddA18.n212 VddA18.n210 2.3963
R427 VddA18.n104 VddA18.n103 2.3963
R428 VddA18.n231 VddA18.n230 2.3963
R429 VddA18.n90 VddA18.n89 1.92227
R430 VddA18.n90 VddA18.n81 1.92227
R431 VddA18.n145 VddA18.n78 1.89332
R432 VddA18.n239 VddA18.n44 1.71902
R433 VddA18.n128 VddA18.n111 1.71902
R434 VddA18.n110 VddA18.n109 1.71902
R435 VddA18.n223 VddA18.n43 1.70675
R436 VddA18.n224 VddA18.n223 1.706
R437 VddA18.n224 VddA18.n207 1.69885
R438 VddA18.n224 VddA18.n208 1.69885
R439 VddA18.n226 VddA18.n47 1.69885
R440 VddA18.n105 VddA18.n15 1.69885
R441 VddA18.n121 VddA18.n18 1.69885
R442 VddA18.n241 VddA18.n42 1.57765
R443 VddA18.n135 VddA18.n134 1.57765
R444 VddA18.n220 VddA18.n219 1.35955
R445 VddA18.n98 VddA18.n94 1.35955
R446 VddA18.n127 VddA18.n126 1.35933
R447 VddA18.n238 VddA18.n45 1.35881
R448 VddA18.n187 VddA18.n186 1.31457
R449 VddA18.n258 VddA18.n257 1.31367
R450 VddA18.n63 VddA18.n62 1.25854
R451 VddA18.n298 VddA18.n297 1.25718
R452 VddA18.n226 VddA18.n44 1.12982
R453 VddA18.n111 VddA18.n18 1.12982
R454 VddA18.n109 VddA18.n15 1.12982
R455 VddA18.n242 VddA18.n241 1.1255
R456 VddA18.n134 VddA18.n133 1.1255
R457 VddA18.n17 VddA18.n16 0.668316
R458 VddA18.n17 VddA18 0.667758
R459 VddA18.n142 VddA18.n92 0.573026
R460 VddA18.n144 VddA18.n142 0.573026
R461 VddA18.n23 VddA18.n21 0.460073
R462 VddA18.n23 VddA18.n22 0.460073
R463 VddA18.n170 VddA18.n169 0.460073
R464 VddA18.n170 VddA18 0.460073
R465 VddA18.n68 VddA18 0.434875
R466 VddA18.n34 VddA18.n33 0.434875
R467 VddA18.n240 VddA18.n239 0.411592
R468 VddA18.n240 VddA18.n43 0.411592
R469 VddA18.n129 VddA18.n128 0.411592
R470 VddA18.n129 VddA18.n110 0.411592
R471 VddA18.n171 VddA18.n168 0.39606
R472 VddA18.n172 VddA18.n171 0.39606
R473 VddA18.n24 VddA18.n13 0.394263
R474 VddA18.n25 VddA18.n24 0.394263
R475 VddA18.n92 VddA18.n90 0.373832
R476 VddA18.n145 VddA18.n144 0.373832
R477 VddA18.n249 VddA18.n248 0.297375
R478 VddA18.n70 VddA18.n69 0.297375
R479 VddA18.n71 VddA18.n6 0.256637
R480 VddA18.n251 VddA18.n250 0.256637
R481 VddA18.n151 VddA18.n150 0.2505
R482 VddA18.n180 VddA18.n35 0.2505
R483 VddA18.n279 VddA18.n14 0.199259
R484 VddA18.n50 VddA18.n49 0.199259
R485 VddA18.n135 VddA18 0.141379
R486 VddA18.n135 VddA18 0.141379
R487 VddA18.n42 VddA18.n41 0.141379
R488 VddA18.n42 VddA18.n39 0.141379
R489 VddA18.n117 VddA18.n113 0.121712
R490 VddA18.n126 VddA18.n113 0.121712
R491 VddA18.n103 VddA18.n101 0.121712
R492 VddA18.n101 VddA18.n98 0.121712
R493 VddA18.n219 VddA18.n218 0.121712
R494 VddA18.n218 VddA18.n210 0.121712
R495 VddA18.n232 VddA18.n45 0.121712
R496 VddA18.n232 VddA18.n231 0.121712
R497 VddA18.n244 VddA18.n242 0.112805
R498 VddA18.n133 VddA18.n131 0.112805
R499 VddA18.n136 VddA18.n135 0.0862552
R500 VddA18.n139 VddA18.n42 0.0862552
R501 VddA18.n225 VddA18.n17 0.0854133
R502 VddA18.n278 VddA18.n17 0.0854133
R503 VddA18.n238 VddA18.n237 0.0630886
R504 VddA18.n127 VddA18.n112 0.0630878
R505 VddA18.n95 VddA18.n94 0.0630875
R506 VddA18.n221 VddA18.n220 0.0630875
R507 VddA18.n233 VddA18.n46 0.0615687
R508 VddA18.n125 VddA18.n124 0.0615687
R509 VddA18.n100 VddA18.n99 0.0615687
R510 VddA18.n217 VddA18.n209 0.0615687
R511 VddA18.n71 VddA18.n70 0.0576777
R512 VddA18.n250 VddA18.n249 0.0576777
R513 VddA18.n150 VddA18.n68 0.0576546
R514 VddA18.n35 VddA18.n34 0.0576546
R515 VddA18.n255 VddA18.n253 0.0574697
R516 VddA18.n30 VddA18.n28 0.0574697
R517 VddA18.n9 VddA18.n7 0.0574697
R518 VddA18.n3 VddA18.n1 0.0574697
R519 VddA18.n184 VddA18.n182 0.0574697
R520 VddA18.n177 VddA18.n175 0.0574697
R521 VddA18.n160 VddA18.n159 0.0574697
R522 VddA18.n66 VddA18.n65 0.0574697
R523 VddA18.n275 VddA18.n274 0.0567576
R524 VddA18.n282 VddA18.n281 0.0567576
R525 VddA18.n204 VddA18.n203 0.0567576
R526 VddA18.n167 VddA18.n54 0.0567576
R527 VddA18.n118 VddA18.n116 0.0559268
R528 VddA18.n213 VddA18.n212 0.0559268
R529 VddA18.n230 VddA18.n229 0.0559268
R530 VddA18.n104 VddA18.n97 0.0559268
R531 VddA18.n142 VddA18.n141 0.0549041
R532 VddA18.n142 VddA18.n138 0.0549039
R533 VddA18.n263 VddA18.n262 0.0510606
R534 VddA18.n294 VddA18.n293 0.0510606
R535 VddA18.n192 VddA18.n191 0.0510606
R536 VddA18.n154 VddA18.n60 0.0510606
R537 VddA18.n283 VddA18.n13 0.0505
R538 VddA18.n284 VddA18.n283 0.0505
R539 VddA18.n284 VddA18.n12 0.0505
R540 VddA18.n12 VddA18.n11 0.0505
R541 VddA18.n292 VddA18.n291 0.0505
R542 VddA18.n292 VddA18.n5 0.0505
R543 VddA18.n5 VddA18.n0 0.0505
R544 VddA18.n297 VddA18.n0 0.0505
R545 VddA18.n258 VddA18.n256 0.0505
R546 VddA18.n256 VddA18.n252 0.0505
R547 VddA18.n264 VddA18.n252 0.0505
R548 VddA18.n265 VddA18.n264 0.0505
R549 VddA18.n32 VddA18.n27 0.0505
R550 VddA18.n272 VddA18.n27 0.0505
R551 VddA18.n273 VddA18.n272 0.0505
R552 VddA18.n273 VddA18.n25 0.0505
R553 VddA18.n168 VddA18.n53 0.0505
R554 VddA18.n162 VddA18.n53 0.0505
R555 VddA18.n162 VddA18.n161 0.0505
R556 VddA18.n161 VddA18.n57 0.0505
R557 VddA18.n153 VddA18.n152 0.0505
R558 VddA18.n153 VddA18.n67 0.0505
R559 VddA18.n67 VddA18.n61 0.0505
R560 VddA18.n63 VddA18.n61 0.0505
R561 VddA18.n187 VddA18.n185 0.0505
R562 VddA18.n185 VddA18.n181 0.0505
R563 VddA18.n193 VddA18.n181 0.0505
R564 VddA18.n194 VddA18.n193 0.0505
R565 VddA18.n179 VddA18.n174 0.0505
R566 VddA18.n201 VddA18.n174 0.0505
R567 VddA18.n202 VddA18.n201 0.0505
R568 VddA18.n202 VddA18.n172 0.0505
R569 VddA18.n234 VddA18.n48 0.0501183
R570 VddA18.n123 VddA18.n114 0.0501183
R571 VddA18.n102 VddA18.n96 0.0501183
R572 VddA18.n216 VddA18.n211 0.0501183
R573 VddA18.n267 VddA18.n266 0.0496364
R574 VddA18.n290 VddA18.n289 0.0496364
R575 VddA18.n196 VddA18.n195 0.0496364
R576 VddA18.n158 VddA18.n58 0.0496364
R577 VddA18.n271 VddA18.n270 0.0439394
R578 VddA18.n286 VddA18.n285 0.0439394
R579 VddA18.n200 VddA18.n199 0.0439394
R580 VddA18.n163 VddA18.n56 0.0439394
R581 VddA18.n226 VddA18.n225 0.0398351
R582 VddA18.n225 VddA18.n224 0.0398351
R583 VddA18.n278 VddA18.n18 0.0398351
R584 VddA18.n278 VddA18.n15 0.0398351
R585 VddA18.n277 VddA18.n19 0.0380213
R586 VddA18.n206 VddA18.n51 0.0380213
R587 VddA18.n223 VddA18.n222 0.0370658
R588 VddA18.n271 VddA18.n26 0.0353939
R589 VddA18.n285 VddA18.n10 0.0353939
R590 VddA18.n200 VddA18.n173 0.0353939
R591 VddA18.n164 VddA18.n163 0.0353939
R592 VddA18.n11 VddA18.n6 0.033
R593 VddA18.n251 VddA18.n32 0.033
R594 VddA18.n151 VddA18.n57 0.033
R595 VddA18.n180 VddA18.n179 0.033
R596 VddA18.n277 VddA18.n276 0.0317861
R597 VddA18.n280 VddA18.n279 0.0317861
R598 VddA18.n206 VddA18.n205 0.0317861
R599 VddA18.n166 VddA18.n50 0.0317861
R600 VddA18.n266 VddA18.n31 0.029697
R601 VddA18.n290 VddA18.n4 0.029697
R602 VddA18.n195 VddA18.n178 0.029697
R603 VddA18.n155 VddA18.n58 0.029697
R604 VddA18.n236 VddA18.n235 0.0292023
R605 VddA18.n228 VddA18.n227 0.0292023
R606 VddA18.n120 VddA18.n119 0.0292023
R607 VddA18.n122 VddA18.n115 0.0292023
R608 VddA18.n107 VddA18.n106 0.0292023
R609 VddA18.n108 VddA18.n107 0.0292023
R610 VddA18.n215 VddA18.n214 0.0292023
R611 VddA18.n263 VddA18.n31 0.0282727
R612 VddA18.n293 VddA18.n4 0.0282727
R613 VddA18.n192 VddA18.n178 0.0282727
R614 VddA18.n155 VddA18.n154 0.0282727
R615 VddA18.n229 VddA18.n48 0.0272176
R616 VddA18.n116 VddA18.n114 0.0272176
R617 VddA18.n102 VddA18.n97 0.0272176
R618 VddA18.n213 VddA18.n211 0.0272176
R619 VddA18.n236 VddA18.n44 0.0255413
R620 VddA18.n109 VddA18.n108 0.0255413
R621 VddA18.n115 VddA18.n111 0.0255413
R622 VddA18.n138 VddA18.n136 0.0249921
R623 VddA18.n141 VddA18.n139 0.024992
R624 VddA18.n274 VddA18.n26 0.0225758
R625 VddA18.n282 VddA18.n10 0.0225758
R626 VddA18.n203 VddA18.n173 0.0225758
R627 VddA18.n164 VddA18.n54 0.0225758
R628 VddA18.n291 VddA18.n6 0.018
R629 VddA18.n265 VddA18.n251 0.018
R630 VddA18.n152 VddA18.n151 0.018
R631 VddA18.n194 VddA18.n180 0.018
R632 VddA18.n241 VddA18.n240 0.016125
R633 VddA18.n134 VddA18.n129 0.016125
R634 VddA18.n261 VddA18.n260 0.0160723
R635 VddA18.n261 VddA18.n29 0.0160723
R636 VddA18.n268 VddA18.n29 0.0160723
R637 VddA18.n269 VddA18.n268 0.0160723
R638 VddA18.n269 VddA18.n20 0.0160723
R639 VddA18.n276 VddA18.n20 0.0160723
R640 VddA18.n280 VddA18.n8 0.0160723
R641 VddA18.n287 VddA18.n8 0.0160723
R642 VddA18.n288 VddA18.n287 0.0160723
R643 VddA18.n288 VddA18.n2 0.0160723
R644 VddA18.n295 VddA18.n2 0.0160723
R645 VddA18.n190 VddA18.n189 0.0160723
R646 VddA18.n190 VddA18.n176 0.0160723
R647 VddA18.n197 VddA18.n176 0.0160723
R648 VddA18.n198 VddA18.n197 0.0160723
R649 VddA18.n198 VddA18.n52 0.0160723
R650 VddA18.n205 VddA18.n52 0.0160723
R651 VddA18.n166 VddA18.n165 0.0160723
R652 VddA18.n165 VddA18.n55 0.0160723
R653 VddA18.n157 VddA18.n55 0.0160723
R654 VddA18.n157 VddA18.n156 0.0160723
R655 VddA18.n156 VddA18.n59 0.0160723
R656 VddA18.n259 VddA18.n255 0.0154545
R657 VddA18.n296 VddA18.n1 0.0154545
R658 VddA18.n188 VddA18.n184 0.0154545
R659 VddA18.n65 VddA18.n64 0.0154545
R660 VddA18.n215 VddA18.n207 0.015291
R661 VddA18.n228 VddA18.n47 0.015291
R662 VddA18.n235 VddA18.n47 0.015291
R663 VddA18.n106 VddA18.n105 0.015291
R664 VddA18.n122 VddA18.n121 0.015291
R665 VddA18.n121 VddA18.n120 0.015291
R666 VddA18.n222 VddA18.n207 0.015291
R667 VddA18.n214 VddA18.n208 0.015291
R668 VddA18.n270 VddA18.n28 0.0140303
R669 VddA18.n286 VddA18.n9 0.0140303
R670 VddA18.n199 VddA18.n175 0.0140303
R671 VddA18.n160 VddA18.n56 0.0140303
R672 VddA18.n234 VddA18.n233 0.0119504
R673 VddA18.n124 VddA18.n123 0.0119504
R674 VddA18.n100 VddA18.n96 0.0119504
R675 VddA18.n217 VddA18.n216 0.0119504
R676 VddA18.n260 VddA18.n254 0.0108343
R677 VddA18.n189 VddA18.n183 0.0108343
R678 VddA18.n278 VddA18.n277 0.00934937
R679 VddA18.n279 VddA18.n278 0.00934937
R680 VddA18.n225 VddA18.n206 0.00934937
R681 VddA18.n225 VddA18.n50 0.00934937
R682 VddA18.n128 VddA18.n127 0.00899824
R683 VddA18.n239 VddA18.n238 0.00899746
R684 VddA18.n267 VddA18.n30 0.00833333
R685 VddA18.n289 VddA18.n7 0.00833333
R686 VddA18.n196 VddA18.n177 0.00833333
R687 VddA18.n159 VddA18.n158 0.00833333
R688 VddA18.n220 VddA18.n43 0.00811828
R689 VddA18.n110 VddA18.n94 0.00811828
R690 VddA18.n262 VddA18.n253 0.00690909
R691 VddA18.n294 VddA18.n3 0.00690909
R692 VddA18.n191 VddA18.n182 0.00690909
R693 VddA18.n66 VddA18.n60 0.00690909
R694 VddA18.n237 VddA18.n46 0.00431679
R695 VddA18.n125 VddA18.n112 0.00431679
R696 VddA18.n99 VddA18.n95 0.00431679
R697 VddA18.n221 VddA18.n209 0.00431679
R698 vpd[3].n0 vpd[3].t1 254.778
R699 vpd[3].n0 vpd[3].t0 230.966
R700 vpd[3] vpd[3].n1 3.79514
R701 vpd[3].n1 vpd[3].n0 0.0496071
R702 vpd[1].n0 vpd[1].t1 254.778
R703 vpd[1].n0 vpd[1].t0 230.966
R704 vpd[1].n2 vpd[1].n1 3.79514
R705 vpd[1].n2 vpd[1] 0.063
R706 vpd[1] vpd[1].n2 0.050069
R707 vpd[1].n1 vpd[1].n0 0.0496071
R708 vpd[2].n0 vpd[2].t1 254.778
R709 vpd[2].n0 vpd[2].t0 230.966
R710 vpd[2].n1 vpd[2] 3.90721
R711 vpd[2] vpd[2].n0 0.0496071
R712 vpd[2].n1 vpd[2] 0.013431
R713 vpd[0].n0 vpd[0].t1 254.778
R714 vpd[0].n0 vpd[0].t0 230.966
R715 vpd[0].n1 vpd[0] 3.90721
R716 vpd[0] vpd[0].n0 0.0496071
R717 vpd[0].n1 vpd[0] 0.013431
R718 GndA.n1349 GndA.n1348 17208.3
R719 GndA.n909 GndA.n908 17204.2
R720 GndA.t18 GndA.n1161 4592.65
R721 GndA.t39 GndA.n144 4592.65
R722 GndA.n443 GndA.n394 1077.71
R723 GndA.n1298 GndA.n59 1077.71
R724 GndA.n613 GndA.n600 1077.71
R725 GndA.n1074 GndA.n1023 1077.71
R726 GndA.n1161 GndA.n166 1075.14
R727 GndA.n144 GndA.n87 1075.14
R728 GndA.t27 GndA.n690 1066.12
R729 GndA.n873 GndA.t23 1066.12
R730 GndA.n181 GndA.n162 1032.46
R731 GndA.n1205 GndA.n1204 1032.46
R732 GndA.n839 GndA.n837 932.854
R733 GndA.n1218 GndA.n78 932.854
R734 GndA.n552 GndA.n544 932.854
R735 GndA.n967 GndA.n966 932.854
R736 GndA.n745 GndA.n683 808.97
R737 GndA.n1247 GndA.n66 808.97
R738 GndA.n522 GndA.n348 802.393
R739 GndA.n1017 GndA.n165 802.393
R740 GndA.t17 GndA.t34 761.944
R741 GndA.t33 GndA.t13 761.944
R742 GndA.t16 GndA.t15 761.944
R743 GndA.t14 GndA.t12 761.944
R744 GndA.n234 GndA.t31 664.658
R745 GndA.n236 GndA.t35 664.658
R746 GndA.n210 GndA.t32 664.658
R747 GndA.n209 GndA.t38 664.658
R748 GndA.n185 GndA.n164 601.348
R749 GndA.n96 GndA.n90 601.348
R750 GndA.n351 GndA.n349 597.657
R751 GndA.n688 GndA.n687 597.657
R752 GndA.n837 GndA.n836 585
R753 GndA.n837 GndA.n378 585
R754 GndA.n377 GndA.n376 585
R755 GndA.n850 GndA.n377 585
R756 GndA.n375 GndA.n342 585
R757 GndA.n851 GndA.n375 585
R758 GndA.n374 GndA.n340 585
R759 GndA.n852 GndA.n374 585
R760 GndA.n373 GndA.n345 585
R761 GndA.n373 GndA.n371 585
R762 GndA.n370 GndA.n369 585
R763 GndA.n856 GndA.n370 585
R764 GndA.n368 GndA.n366 585
R765 GndA.n857 GndA.n366 585
R766 GndA.n367 GndA.n365 585
R767 GndA.n858 GndA.n365 585
R768 GndA.n364 GndA.n347 585
R769 GndA.n364 GndA.n362 585
R770 GndA.n361 GndA.n346 585
R771 GndA.n862 GndA.n361 585
R772 GndA.n360 GndA.n359 585
R773 GndA.n863 GndA.n360 585
R774 GndA.n358 GndA.n357 585
R775 GndA.n864 GndA.n357 585
R776 GndA.n352 GndA.n350 585
R777 GndA.n354 GndA.n352 585
R778 GndA.n870 GndA.n869 585
R779 GndA.n869 GndA.n868 585
R780 GndA.n353 GndA.n351 585
R781 GndA.n465 GndA.n464 585
R782 GndA.n464 GndA.n463 585
R783 GndA.n466 GndA.n457 585
R784 GndA.n459 GndA.n457 585
R785 GndA.n468 GndA.n467 585
R786 GndA.n468 GndA.n458 585
R787 GndA.n470 GndA.n469 585
R788 GndA.n469 GndA.n318 585
R789 GndA.n446 GndA.n394 585
R790 GndA.n394 GndA.n393 585
R791 GndA.n504 GndA.n503 585
R792 GndA.n505 GndA.n504 585
R793 GndA.n396 GndA.n391 585
R794 GndA.n506 GndA.n391 585
R795 GndA.n522 GndA.n521 585
R796 GndA.n521 GndA.n520 585
R797 GndA.n519 GndA.n392 585
R798 GndA.n518 GndA.n517 585
R799 GndA.n516 GndA.n515 585
R800 GndA.n514 GndA.n513 585
R801 GndA.n512 GndA.n511 585
R802 GndA.n508 GndA.n387 585
R803 GndA.n525 GndA.n524 585
R804 GndA.n384 GndA.n383 585
R805 GndA.n532 GndA.n531 585
R806 GndA.n382 GndA.n380 585
R807 GndA.n845 GndA.n844 585
R808 GndA.n842 GndA.n381 585
R809 GndA.n841 GndA.n835 585
R810 GndA.n839 GndA.n838 585
R811 GndA.n401 GndA.n400 585
R812 GndA.n412 GndA.n411 585
R813 GndA.n414 GndA.n413 585
R814 GndA.n416 GndA.n415 585
R815 GndA.n418 GndA.n417 585
R816 GndA.n420 GndA.n419 585
R817 GndA.n422 GndA.n421 585
R818 GndA.n424 GndA.n423 585
R819 GndA.n426 GndA.n425 585
R820 GndA.n428 GndA.n427 585
R821 GndA.n430 GndA.n429 585
R822 GndA.n432 GndA.n431 585
R823 GndA.n434 GndA.n433 585
R824 GndA.n436 GndA.n435 585
R825 GndA.n438 GndA.n437 585
R826 GndA.n440 GndA.n439 585
R827 GndA.n441 GndA.n410 585
R828 GndA.n443 GndA.n442 585
R829 GndA.n472 GndA.n319 585
R830 GndA.n495 GndA.n473 585
R831 GndA.n482 GndA.n473 585
R832 GndA.n483 GndA.n481 585
R833 GndA.n479 GndA.n478 585
R834 GndA.n486 GndA.n477 585
R835 GndA.n488 GndA.n487 585
R836 GndA.n490 GndA.n489 585
R837 GndA.n491 GndA.n475 585
R838 GndA.n493 GndA.n492 585
R839 GndA.n476 GndA.n474 585
R840 GndA.n452 GndA.n451 585
R841 GndA.n498 GndA.n497 585
R842 GndA.n399 GndA.n398 585
R843 GndA.n499 GndA.n399 585
R844 GndA.n502 GndA.n501 585
R845 GndA.n501 GndA.n500 585
R846 GndA.n397 GndA.n395 585
R847 GndA.n450 GndA.n397 585
R848 GndA.n448 GndA.n447 585
R849 GndA.n449 GndA.n448 585
R850 GndA.n1111 GndA.n1110 585
R851 GndA.n1111 GndA.n188 585
R852 GndA.n1113 GndA.n1112 585
R853 GndA.n1114 GndA.n1113 585
R854 GndA.n184 GndA.n183 585
R855 GndA.n186 GndA.n184 585
R856 GndA.n1147 GndA.n1146 585
R857 GndA.n1146 GndA.n1145 585
R858 GndA.n1144 GndA.n185 585
R859 GndA.n1109 GndA.n194 585
R860 GndA.n1083 GndA.n194 585
R861 GndA.n1085 GndA.n1084 585
R862 GndA.n1087 GndA.n1086 585
R863 GndA.n1089 GndA.n1088 585
R864 GndA.n1091 GndA.n1090 585
R865 GndA.n1093 GndA.n1092 585
R866 GndA.n1095 GndA.n1094 585
R867 GndA.n1097 GndA.n1096 585
R868 GndA.n1100 GndA.n1099 585
R869 GndA.n1102 GndA.n1101 585
R870 GndA.n1104 GndA.n1103 585
R871 GndA.n1105 GndA.n197 585
R872 GndA.n1143 GndA.n1142 585
R873 GndA.n1141 GndA.n1140 585
R874 GndA.n1139 GndA.n1138 585
R875 GndA.n1137 GndA.n1136 585
R876 GndA.n1135 GndA.n1134 585
R877 GndA.n1133 GndA.n1132 585
R878 GndA.n1131 GndA.n1130 585
R879 GndA.n1129 GndA.n1128 585
R880 GndA.n173 GndA.n171 585
R881 GndA.n1159 GndA.n1158 585
R882 GndA.n180 GndA.n162 585
R883 GndA.n1165 GndA.n1164 585
R884 GndA.n1149 GndA.n1148 585
R885 GndA.n1151 GndA.n166 585
R886 GndA.n1152 GndA.n1151 585
R887 GndA.n181 GndA.n163 585
R888 GndA.n1204 GndA.n1203 585
R889 GndA.n1202 GndA.n1201 585
R890 GndA.n131 GndA.n89 585
R891 GndA.n1206 GndA.n1205 585
R892 GndA.n1206 GndA.n89 585
R893 GndA.n1207 GndA.n87 585
R894 GndA.n1207 GndA.n1206 585
R895 GndA.n1208 GndA.n1207 585
R896 GndA.n179 GndA.n172 585
R897 GndA.n1157 GndA.n172 585
R898 GndA.n1155 GndA.n1154 585
R899 GndA.n1156 GndA.n1155 585
R900 GndA.n1153 GndA.n178 585
R901 GndA.n178 GndA.n177 585
R902 GndA.n966 GndA.n965 585
R903 GndA.n966 GndA.n964 585
R904 GndA.n968 GndA.n967 585
R905 GndA.n969 GndA.n961 585
R906 GndA.n972 GndA.n971 585
R907 GndA.n970 GndA.n959 585
R908 GndA.n995 GndA.n994 585
R909 GndA.n996 GndA.n953 585
R910 GndA.n991 GndA.n990 585
R911 GndA.n990 GndA.n989 585
R912 GndA.n975 GndA.n974 585
R913 GndA.n988 GndA.n975 585
R914 GndA.n986 GndA.n985 585
R915 GndA.n987 GndA.n986 585
R916 GndA.n984 GndA.n983 585
R917 GndA.n983 GndA.n982 585
R918 GndA.n1220 GndA.n69 585
R919 GndA.n1224 GndA.n69 585
R920 GndA.n1223 GndA.n1222 585
R921 GndA.n1214 GndA.n74 585
R922 GndA.n1220 GndA.n75 585
R923 GndA.n1215 GndA.n75 585
R924 GndA.n1216 GndA.n76 585
R925 GndA.n1218 GndA.n1217 585
R926 GndA.n78 GndA.n77 585
R927 GndA.n1213 GndA.n78 585
R928 GndA.n1211 GndA.n1210 585
R929 GndA.n1212 GndA.n1211 585
R930 GndA.n1209 GndA.n82 585
R931 GndA.n82 GndA.n81 585
R932 GndA.n104 GndA.n85 585
R933 GndA.n105 GndA.n104 585
R934 GndA.n103 GndA.n101 585
R935 GndA.n110 GndA.n109 585
R936 GndA.n112 GndA.n111 585
R937 GndA.n115 GndA.n114 585
R938 GndA.n113 GndA.n99 585
R939 GndA.n120 GndA.n119 585
R940 GndA.n122 GndA.n121 585
R941 GndA.n124 GndA.n123 585
R942 GndA.n97 GndA.n95 585
R943 GndA.n142 GndA.n141 585
R944 GndA.n140 GndA.n96 585
R945 GndA.n132 GndA.n129 585
R946 GndA.n129 GndA.n128 585
R947 GndA.n135 GndA.n134 585
R948 GndA.n136 GndA.n135 585
R949 GndA.n133 GndA.n130 585
R950 GndA.n130 GndA.n37 585
R951 GndA.n65 GndA.n38 585
R952 GndA.n1336 GndA.n38 585
R953 GndA.n1254 GndA.n59 585
R954 GndA.n1300 GndA.n59 585
R955 GndA.n1303 GndA.n1302 585
R956 GndA.n1302 GndA.n1301 585
R957 GndA.n58 GndA.n56 585
R958 GndA.n1251 GndA.n58 585
R959 GndA.n1250 GndA.n1249 585
R960 GndA.n61 GndA.n60 585
R961 GndA.n1230 GndA.n1229 585
R962 GndA.n1232 GndA.n1231 585
R963 GndA.n1234 GndA.n1233 585
R964 GndA.n1237 GndA.n1236 585
R965 GndA.n1247 GndA.n67 585
R966 GndA.n1239 GndA.n67 585
R967 GndA.n71 GndA.n68 585
R968 GndA.n1245 GndA.n1244 585
R969 GndA.n1296 GndA.n1260 585
R970 GndA.n1268 GndA.n1260 585
R971 GndA.n1270 GndA.n1269 585
R972 GndA.n1272 GndA.n1271 585
R973 GndA.n1274 GndA.n1273 585
R974 GndA.n1276 GndA.n1275 585
R975 GndA.n1296 GndA.n1262 585
R976 GndA.n1277 GndA.n1262 585
R977 GndA.n1279 GndA.n1278 585
R978 GndA.n1281 GndA.n1280 585
R979 GndA.n1283 GndA.n1282 585
R980 GndA.n1285 GndA.n1284 585
R981 GndA.n1296 GndA.n1256 585
R982 GndA.n1286 GndA.n1256 585
R983 GndA.n1288 GndA.n1287 585
R984 GndA.n1290 GndA.n1289 585
R985 GndA.n1292 GndA.n1291 585
R986 GndA.n1293 GndA.n1265 585
R987 GndA.n1296 GndA.n1295 585
R988 GndA.n1295 GndA.n1294 585
R989 GndA.n1253 GndA.n1252 585
R990 GndA.n1299 GndA.n1298 585
R991 GndA.n1331 GndA.n1330 585
R992 GndA.n1328 GndA.n42 585
R993 GndA.n1327 GndA.n46 585
R994 GndA.n1325 GndA.n1324 585
R995 GndA.n1321 GndA.n47 585
R996 GndA.n1320 GndA.n1319 585
R997 GndA.n1318 GndA.n48 585
R998 GndA.n1316 GndA.n1315 585
R999 GndA.n1314 GndA.n50 585
R1000 GndA.n1313 GndA.n1312 585
R1001 GndA.n1311 GndA.n51 585
R1002 GndA.n1309 GndA.n1308 585
R1003 GndA.n64 GndA.n53 585
R1004 GndA.n1307 GndA.n53 585
R1005 GndA.n1305 GndA.n1304 585
R1006 GndA.n1306 GndA.n1305 585
R1007 GndA.n57 GndA.n55 585
R1008 GndA.n55 GndA.n54 585
R1009 GndA.n1266 GndA.n1255 585
R1010 GndA.n1267 GndA.n1266 585
R1011 GndA.n769 GndA.n580 585
R1012 GndA.n769 GndA.n574 585
R1013 GndA.n684 GndA.n573 585
R1014 GndA.n786 GndA.n573 585
R1015 GndA.n685 GndA.n572 585
R1016 GndA.n787 GndA.n572 585
R1017 GndA.n686 GndA.n571 585
R1018 GndA.n788 GndA.n571 585
R1019 GndA.n687 GndA.n569 585
R1020 GndA.n738 GndA.n568 585
R1021 GndA.n792 GndA.n568 585
R1022 GndA.n739 GndA.n567 585
R1023 GndA.n793 GndA.n567 585
R1024 GndA.n740 GndA.n566 585
R1025 GndA.n794 GndA.n566 585
R1026 GndA.n742 GndA.n741 585
R1027 GndA.n741 GndA.n564 585
R1028 GndA.n743 GndA.n563 585
R1029 GndA.n798 GndA.n563 585
R1030 GndA.n737 GndA.n562 585
R1031 GndA.n799 GndA.n562 585
R1032 GndA.n736 GndA.n561 585
R1033 GndA.n800 GndA.n561 585
R1034 GndA.n735 GndA.n734 585
R1035 GndA.n734 GndA.n559 585
R1036 GndA.n733 GndA.n558 585
R1037 GndA.n804 GndA.n558 585
R1038 GndA.n691 GndA.n557 585
R1039 GndA.n805 GndA.n557 585
R1040 GndA.n701 GndA.n556 585
R1041 GndA.n806 GndA.n556 585
R1042 GndA.n697 GndA.n696 585
R1043 GndA.n696 GndA.n554 585
R1044 GndA.n592 GndA.n553 585
R1045 GndA.n810 GndA.n553 585
R1046 GndA.n591 GndA.n552 585
R1047 GndA.n811 GndA.n552 585
R1048 GndA.n825 GndA.n544 585
R1049 GndA.n812 GndA.n544 585
R1050 GndA.n814 GndA.n813 585
R1051 GndA.n816 GndA.n815 585
R1052 GndA.n825 GndA.n545 585
R1053 GndA.n817 GndA.n545 585
R1054 GndA.n549 GndA.n546 585
R1055 GndA.n823 GndA.n822 585
R1056 GndA.n663 GndA.n547 585
R1057 GndA.n667 GndA.n666 585
R1058 GndA.n665 GndA.n661 585
R1059 GndA.n673 GndA.n672 585
R1060 GndA.n675 GndA.n674 585
R1061 GndA.n677 GndA.n676 585
R1062 GndA.n683 GndA.n596 585
R1063 GndA.n678 GndA.n596 585
R1064 GndA.n679 GndA.n597 585
R1065 GndA.n681 GndA.n680 585
R1066 GndA.n598 GndA.n590 585
R1067 GndA.n659 GndA.n598 585
R1068 GndA.n657 GndA.n656 585
R1069 GndA.n658 GndA.n657 585
R1070 GndA.n601 GndA.n600 585
R1071 GndA.n600 GndA.n599 585
R1072 GndA.n614 GndA.n613 585
R1073 GndA.n616 GndA.n615 585
R1074 GndA.n618 GndA.n617 585
R1075 GndA.n620 GndA.n619 585
R1076 GndA.n622 GndA.n621 585
R1077 GndA.n624 GndA.n623 585
R1078 GndA.n626 GndA.n625 585
R1079 GndA.n628 GndA.n627 585
R1080 GndA.n630 GndA.n629 585
R1081 GndA.n632 GndA.n631 585
R1082 GndA.n634 GndA.n633 585
R1083 GndA.n636 GndA.n635 585
R1084 GndA.n638 GndA.n637 585
R1085 GndA.n640 GndA.n639 585
R1086 GndA.n641 GndA.n612 585
R1087 GndA.n643 GndA.n642 585
R1088 GndA.n604 GndA.n603 585
R1089 GndA.n649 GndA.n648 585
R1090 GndA.n645 GndA.n602 585
R1091 GndA.n650 GndA.n602 585
R1092 GndA.n654 GndA.n653 585
R1093 GndA.n653 GndA.n652 585
R1094 GndA.n655 GndA.n589 585
R1095 GndA.n651 GndA.n589 585
R1096 GndA.n747 GndA.n746 585
R1097 GndA.n747 GndA.n588 585
R1098 GndA.n749 GndA.n748 585
R1099 GndA.n751 GndA.n750 585
R1100 GndA.n753 GndA.n752 585
R1101 GndA.n755 GndA.n754 585
R1102 GndA.n777 GndA.n583 585
R1103 GndA.n756 GndA.n583 585
R1104 GndA.n758 GndA.n757 585
R1105 GndA.n760 GndA.n759 585
R1106 GndA.n762 GndA.n761 585
R1107 GndA.n587 GndA.n586 585
R1108 GndA.n766 GndA.n765 585
R1109 GndA.n578 GndA.n577 585
R1110 GndA.n780 GndA.n779 585
R1111 GndA.n732 GndA.n731 585
R1112 GndA.n732 GndA.n692 585
R1113 GndA.n732 GndA.n694 585
R1114 GndA.n878 GndA.n877 585
R1115 GndA.n878 GndA.n341 585
R1116 GndA.n878 GndA.n344 585
R1117 GndA.n874 GndA.n337 585
R1118 GndA.n833 GndA.n832 585
R1119 GndA.n832 GndA.n831 585
R1120 GndA.n535 GndA.n534 585
R1121 GndA.n830 GndA.n535 585
R1122 GndA.n828 GndA.n827 585
R1123 GndA.n829 GndA.n828 585
R1124 GndA.n826 GndA.n542 585
R1125 GndA.n542 GndA.n541 585
R1126 GndA.n702 GndA.n700 585
R1127 GndA.n731 GndA.n699 585
R1128 GndA.n704 GndA.n699 585
R1129 GndA.n700 GndA.n699 585
R1130 GndA.n877 GndA.n339 585
R1131 GndA.n880 GndA.n339 585
R1132 GndA.n339 GndA.n337 585
R1133 GndA.n1017 GndA.n1016 585
R1134 GndA.n1016 GndA.n1015 585
R1135 GndA.n956 GndA.n954 585
R1136 GndA.n1010 GndA.n1009 585
R1137 GndA.n1008 GndA.n1007 585
R1138 GndA.n1005 GndA.n1004 585
R1139 GndA.n1003 GndA.n1002 585
R1140 GndA.n949 GndA.n948 585
R1141 GndA.n1020 GndA.n1019 585
R1142 GndA.n1021 GndA.n946 585
R1143 GndA.n1079 GndA.n1078 585
R1144 GndA.n1078 GndA.n1077 585
R1145 GndA.n1024 GndA.n947 585
R1146 GndA.n1076 GndA.n947 585
R1147 GndA.n1074 GndA.n1073 585
R1148 GndA.n1075 GndA.n1074 585
R1149 GndA.n1026 GndA.n1023 585
R1150 GndA.n1023 GndA.n1022 585
R1151 GndA.n1040 GndA.n1039 585
R1152 GndA.n1042 GndA.n1038 585
R1153 GndA.n1043 GndA.n1037 585
R1154 GndA.n1046 GndA.n1045 585
R1155 GndA.n1036 GndA.n1026 585
R1156 GndA.n1047 GndA.n1036 585
R1157 GndA.n1049 GndA.n1048 585
R1158 GndA.n1051 GndA.n1035 585
R1159 GndA.n1052 GndA.n1026 585
R1160 GndA.n1052 GndA.n1034 585
R1161 GndA.n1054 GndA.n1053 585
R1162 GndA.n1056 GndA.n1055 585
R1163 GndA.n1057 GndA.n1032 585
R1164 GndA.n1060 GndA.n1059 585
R1165 GndA.n1031 GndA.n1026 585
R1166 GndA.n1061 GndA.n1031 585
R1167 GndA.n1063 GndA.n1062 585
R1168 GndA.n1065 GndA.n1030 585
R1169 GndA.n1068 GndA.n1067 585
R1170 GndA.n1069 GndA.n1028 585
R1171 GndA.n1072 GndA.n1071 585
R1172 GndA.n1071 GndA.n1070 585
R1173 GndA.n1027 GndA.n1025 585
R1174 GndA.n1029 GndA.n1027 585
R1175 GndA.n945 GndA.n944 585
R1176 GndA.n944 GndA.n943 585
R1177 GndA.n1081 GndA.n1080 585
R1178 GndA.n1082 GndA.n1081 585
R1179 GndA.n469 GndA.n456 502.93
R1180 GndA.n43 GndA.n38 502.93
R1181 GndA.n770 GndA.n769 502.93
R1182 GndA.n1111 GndA.n189 502.93
R1183 GndA.n448 GndA.n401 486.707
R1184 GndA.n1266 GndA.n1260 486.707
R1185 GndA.n648 GndA.n602 486.707
R1186 GndA.n1071 GndA.n1028 486.707
R1187 GndA.n1148 GndA.n166 447.459
R1188 GndA.n1164 GndA.n162 447.459
R1189 GndA.n131 GndA.n87 447.459
R1190 GndA.n1204 GndA.n1202 447.459
R1191 GndA.n501 GndA.n399 422.971
R1192 GndA.n448 GndA.n397 422.971
R1193 GndA.n521 GndA.n391 422.971
R1194 GndA.n504 GndA.n394 422.971
R1195 GndA.n1302 GndA.n59 422.971
R1196 GndA.n1249 GndA.n58 422.971
R1197 GndA.n1229 GndA.n61 422.971
R1198 GndA.n1233 GndA.n1232 422.971
R1199 GndA.n1236 GndA.n67 422.971
R1200 GndA.n1222 GndA.n69 422.971
R1201 GndA.n1269 GndA.n1260 422.971
R1202 GndA.n1275 GndA.n1262 422.971
R1203 GndA.n1287 GndA.n1256 422.971
R1204 GndA.n1291 GndA.n1290 422.971
R1205 GndA.n1295 GndA.n1265 422.971
R1206 GndA.n1266 GndA.n55 422.971
R1207 GndA.n1305 GndA.n53 422.971
R1208 GndA.n766 GndA.n586 422.971
R1209 GndA.n761 GndA.n760 422.971
R1210 GndA.n757 GndA.n583 422.971
R1211 GndA.n747 GndA.n589 422.971
R1212 GndA.n653 GndA.n602 422.971
R1213 GndA.n813 GndA.n544 422.971
R1214 GndA.n597 GndA.n596 422.971
R1215 GndA.n681 GndA.n598 422.971
R1216 GndA.n657 GndA.n600 422.971
R1217 GndA.n1071 GndA.n1027 422.971
R1218 GndA.n1081 GndA.n944 422.971
R1219 GndA.n1084 GndA.n194 422.971
R1220 GndA.n1088 GndA.n1087 422.971
R1221 GndA.n1092 GndA.n1091 422.971
R1222 GndA.n1096 GndA.n1095 422.971
R1223 GndA.n1101 GndA.n1100 422.971
R1224 GndA.n1040 GndA.n1023 422.971
R1225 GndA.n1043 GndA.n1042 422.971
R1226 GndA.n1045 GndA.n1036 422.971
R1227 GndA.n1053 GndA.n1052 422.971
R1228 GndA.n1057 GndA.n1056 422.971
R1229 GndA.n1059 GndA.n1031 422.971
R1230 GndA.n1074 GndA.n947 422.971
R1231 GndA.n1078 GndA.n946 422.971
R1232 GndA.n1019 GndA.n949 422.971
R1233 GndA.n1004 GndA.n1003 422.971
R1234 GndA.n1009 GndA.n1008 422.971
R1235 GndA.n1016 GndA.n954 422.971
R1236 GndA.n473 GndA.n472 417.176
R1237 GndA.n481 GndA.n473 417.176
R1238 GndA.n478 GndA.n477 417.176
R1239 GndA.n489 GndA.n488 417.176
R1240 GndA.n493 GndA.n475 417.176
R1241 GndA.n474 GndA.n452 417.176
R1242 GndA.n497 GndA.n399 417.176
R1243 GndA.n501 GndA.n397 417.176
R1244 GndA.n439 GndA.n410 417.176
R1245 GndA.n437 GndA.n436 417.176
R1246 GndA.n433 GndA.n432 417.176
R1247 GndA.n429 GndA.n428 417.176
R1248 GndA.n425 GndA.n424 417.176
R1249 GndA.n421 GndA.n420 417.176
R1250 GndA.n417 GndA.n416 417.176
R1251 GndA.n413 GndA.n412 417.176
R1252 GndA.n842 GndA.n841 417.176
R1253 GndA.n844 GndA.n382 417.176
R1254 GndA.n532 GndA.n383 417.176
R1255 GndA.n524 GndA.n387 417.176
R1256 GndA.n513 GndA.n512 417.176
R1257 GndA.n517 GndA.n516 417.176
R1258 GndA.n521 GndA.n392 417.176
R1259 GndA.n504 GndA.n391 417.176
R1260 GndA.n837 GndA.n377 417.176
R1261 GndA.n377 GndA.n375 417.176
R1262 GndA.n375 GndA.n374 417.176
R1263 GndA.n374 GndA.n373 417.176
R1264 GndA.n373 GndA.n370 417.176
R1265 GndA.n370 GndA.n366 417.176
R1266 GndA.n366 GndA.n365 417.176
R1267 GndA.n365 GndA.n364 417.176
R1268 GndA.n364 GndA.n361 417.176
R1269 GndA.n361 GndA.n360 417.176
R1270 GndA.n360 GndA.n357 417.176
R1271 GndA.n357 GndA.n352 417.176
R1272 GndA.n869 GndA.n352 417.176
R1273 GndA.n869 GndA.n351 417.176
R1274 GndA.n464 GndA.n351 417.176
R1275 GndA.n464 GndA.n457 417.176
R1276 GndA.n468 GndA.n457 417.176
R1277 GndA.n469 GndA.n468 417.176
R1278 GndA.n130 GndA.n38 417.176
R1279 GndA.n135 GndA.n130 417.176
R1280 GndA.n135 GndA.n129 417.176
R1281 GndA.n129 GndA.n96 417.176
R1282 GndA.n142 GndA.n96 417.176
R1283 GndA.n123 GndA.n95 417.176
R1284 GndA.n121 GndA.n120 417.176
R1285 GndA.n114 GndA.n113 417.176
R1286 GndA.n111 GndA.n110 417.176
R1287 GndA.n104 GndA.n103 417.176
R1288 GndA.n104 GndA.n82 417.176
R1289 GndA.n1211 GndA.n82 417.176
R1290 GndA.n1211 GndA.n78 417.176
R1291 GndA.n1302 GndA.n58 417.176
R1292 GndA.n68 GndA.n67 417.176
R1293 GndA.n1245 GndA.n69 417.176
R1294 GndA.n75 GndA.n74 417.176
R1295 GndA.n76 GndA.n75 417.176
R1296 GndA.n1273 GndA.n1272 417.176
R1297 GndA.n1278 GndA.n1262 417.176
R1298 GndA.n1282 GndA.n1281 417.176
R1299 GndA.n1284 GndA.n1256 417.176
R1300 GndA.n1295 GndA.n1253 417.176
R1301 GndA.n1305 GndA.n55 417.176
R1302 GndA.n1309 GndA.n53 417.176
R1303 GndA.n1312 GndA.n1311 417.176
R1304 GndA.n1316 GndA.n50 417.176
R1305 GndA.n1319 GndA.n1318 417.176
R1306 GndA.n1325 GndA.n47 417.176
R1307 GndA.n1328 GndA.n1327 417.176
R1308 GndA.n779 GndA.n578 417.176
R1309 GndA.n754 GndA.n583 417.176
R1310 GndA.n752 GndA.n751 417.176
R1311 GndA.n748 GndA.n747 417.176
R1312 GndA.n653 GndA.n589 417.176
R1313 GndA.n643 GndA.n604 417.176
R1314 GndA.n639 GndA.n612 417.176
R1315 GndA.n637 GndA.n636 417.176
R1316 GndA.n633 GndA.n632 417.176
R1317 GndA.n629 GndA.n628 417.176
R1318 GndA.n625 GndA.n624 417.176
R1319 GndA.n621 GndA.n620 417.176
R1320 GndA.n617 GndA.n616 417.176
R1321 GndA.n815 GndA.n545 417.176
R1322 GndA.n546 GndA.n545 417.176
R1323 GndA.n823 GndA.n547 417.176
R1324 GndA.n666 GndA.n665 417.176
R1325 GndA.n674 GndA.n673 417.176
R1326 GndA.n676 GndA.n596 417.176
R1327 GndA.n657 GndA.n598 417.176
R1328 GndA.n769 GndA.n573 417.176
R1329 GndA.n573 GndA.n572 417.176
R1330 GndA.n572 GndA.n571 417.176
R1331 GndA.n687 GndA.n571 417.176
R1332 GndA.n687 GndA.n568 417.176
R1333 GndA.n568 GndA.n567 417.176
R1334 GndA.n567 GndA.n566 417.176
R1335 GndA.n741 GndA.n566 417.176
R1336 GndA.n741 GndA.n563 417.176
R1337 GndA.n563 GndA.n562 417.176
R1338 GndA.n562 GndA.n561 417.176
R1339 GndA.n734 GndA.n561 417.176
R1340 GndA.n734 GndA.n558 417.176
R1341 GndA.n558 GndA.n557 417.176
R1342 GndA.n557 GndA.n556 417.176
R1343 GndA.n696 GndA.n556 417.176
R1344 GndA.n696 GndA.n553 417.176
R1345 GndA.n553 GndA.n552 417.176
R1346 GndA.n828 GndA.n542 417.176
R1347 GndA.n828 GndA.n535 417.176
R1348 GndA.n832 GndA.n535 417.176
R1349 GndA.n1027 GndA.n944 417.176
R1350 GndA.n1081 GndA.n194 417.176
R1351 GndA.n1103 GndA.n197 417.176
R1352 GndA.n1049 GndA.n1036 417.176
R1353 GndA.n1052 GndA.n1051 417.176
R1354 GndA.n1063 GndA.n1031 417.176
R1355 GndA.n1067 GndA.n1065 417.176
R1356 GndA.n1078 GndA.n947 417.176
R1357 GndA.n1016 GndA.n953 417.176
R1358 GndA.n994 GndA.n959 417.176
R1359 GndA.n972 GndA.n961 417.176
R1360 GndA.n966 GndA.n178 417.176
R1361 GndA.n1155 GndA.n178 417.176
R1362 GndA.n1155 GndA.n172 417.176
R1363 GndA.n1159 GndA.n172 417.176
R1364 GndA.n1128 GndA.n171 417.176
R1365 GndA.n1132 GndA.n1131 417.176
R1366 GndA.n1136 GndA.n1135 417.176
R1367 GndA.n1140 GndA.n1139 417.176
R1368 GndA.n1142 GndA.n185 417.176
R1369 GndA.n1146 GndA.n185 417.176
R1370 GndA.n1146 GndA.n184 417.176
R1371 GndA.n1113 GndA.n184 417.176
R1372 GndA.n1113 GndA.n1111 417.176
R1373 GndA.n986 GndA.n983 417.176
R1374 GndA.n986 GndA.n975 417.176
R1375 GndA.n990 GndA.n975 417.176
R1376 GndA.n744 GndA.t27 288.798
R1377 GndA.t23 GndA.n872 288.791
R1378 GndA.n984 GndA.t17 286.106
R1379 GndA.t13 GndA.n991 286.106
R1380 GndA.n826 GndA.t16 286.106
R1381 GndA.t12 GndA.n833 286.106
R1382 GndA.n1152 GndA.n182 277.61
R1383 GndA.n1152 GndA.n160 277.61
R1384 GndA.n163 GndA.n161 277.61
R1385 GndA.n1150 GndA.n163 277.61
R1386 GndA.n1206 GndA.n88 277.61
R1387 GndA.n1208 GndA.n83 277.61
R1388 GndA.n1208 GndA.n84 277.61
R1389 GndA.n732 GndA.n693 277.61
R1390 GndA.n879 GndA.n878 277.61
R1391 GndA.n875 GndA.n874 277.61
R1392 GndA.n874 GndA.n338 277.61
R1393 GndA.n702 GndA.n695 277.61
R1394 GndA.n703 GndA.n702 277.61
R1395 GndA.n699 GndA.n698 277.61
R1396 GndA.n343 GndA.n339 277.61
R1397 GndA.n1330 GndA.n44 237.56
R1398 GndA.n323 GndA.t25 237.516
R1399 GndA GndA.t29 237.512
R1400 GndA.n1171 GndA.t51 237.178
R1401 GndA.n708 GndA.t49 237.178
R1402 GndA.n335 GndA.t9 237.178
R1403 GndA.n1169 GndA.t11 237.178
R1404 GndA.n199 GndA.t20 237.171
R1405 GndA GndA.t41 237.167
R1406 GndA.n739 GndA.n738 228.903
R1407 GndA.n740 GndA.n739 228.903
R1408 GndA.n742 GndA.n740 228.903
R1409 GndA.n743 GndA.n742 228.903
R1410 GndA.n736 GndA.n735 228.903
R1411 GndA.n735 GndA.n733 228.903
R1412 GndA.n369 GndA.n368 228.903
R1413 GndA.n368 GndA.n367 228.903
R1414 GndA.n359 GndA.n346 228.903
R1415 GndA.n359 GndA.n358 228.903
R1416 GndA.n358 GndA.n350 228.903
R1417 GndA.n870 GndA.n350 228.903
R1418 GndA.n495 GndA.n315 225.165
R1419 GndA.n1109 GndA.n190 225.165
R1420 GndA.n777 GndA.n776 225.165
R1421 GndA.n45 GndA.n34 225.165
R1422 GndA.n1148 GndA.t4 223.73
R1423 GndA.t6 GndA.n131 223.73
R1424 GndA.n910 GndA.n909 222.375
R1425 GndA.n908 GndA.n907 222.375
R1426 GndA.n1348 GndA.n1347 222.375
R1427 GndA.n1349 GndA.n26 222.375
R1428 GndA.n145 GndA.t39 222.131
R1429 GndA.n1162 GndA.t18 222.125
R1430 GndA.n1210 GndA.n1209 216.839
R1431 GndA.n985 GndA.n984 216.839
R1432 GndA.n985 GndA.n974 216.839
R1433 GndA.n991 GndA.n974 216.839
R1434 GndA.n1154 GndA.n1153 216.839
R1435 GndA.n697 GndA.n592 216.839
R1436 GndA.n827 GndA.n826 216.839
R1437 GndA.n827 GndA.n534 216.839
R1438 GndA.n833 GndA.n534 216.839
R1439 GndA.n376 GndA.n342 216.839
R1440 GndA.n843 GndA.n834 215.619
R1441 GndA.n445 GndA.n403 215.619
R1442 GndA.n1109 GndA.n193 215.619
R1443 GndA.n1109 GndA.n192 215.619
R1444 GndA.n1109 GndA.n191 215.619
R1445 GndA.n1109 GndA.n195 215.619
R1446 GndA.n1109 GndA.n196 215.619
R1447 GndA.n1161 GndA.n167 215.619
R1448 GndA.n1161 GndA.n168 215.619
R1449 GndA.n1161 GndA.n169 215.619
R1450 GndA.n1161 GndA.n170 215.619
R1451 GndA.n1161 GndA.n1160 215.619
R1452 GndA.n992 GndA.n973 215.619
R1453 GndA.n1221 GndA.n1220 215.619
R1454 GndA.n144 GndA.n91 215.619
R1455 GndA.n144 GndA.n92 215.619
R1456 GndA.n144 GndA.n93 215.619
R1457 GndA.n144 GndA.n94 215.619
R1458 GndA.n144 GndA.n143 215.619
R1459 GndA.n1248 GndA.n1247 215.619
R1460 GndA.n1247 GndA.n63 215.619
R1461 GndA.n1247 GndA.n62 215.619
R1462 GndA.n1296 GndA.n1259 215.619
R1463 GndA.n1296 GndA.n1261 215.619
R1464 GndA.n1296 GndA.n1263 215.619
R1465 GndA.n1296 GndA.n1264 215.619
R1466 GndA.n1329 GndA.n45 215.619
R1467 GndA.n825 GndA.n543 215.619
R1468 GndA.n683 GndA.n682 215.619
R1469 GndA.n646 GndA.n644 215.619
R1470 GndA.n777 GndA.n584 215.619
R1471 GndA.n777 GndA.n585 215.619
R1472 GndA.n777 GndA.n767 215.619
R1473 GndA.n1017 GndA.n952 215.619
R1474 GndA.n1017 GndA.n951 215.619
R1475 GndA.n1017 GndA.n950 215.619
R1476 GndA.n1018 GndA.n1017 215.619
R1477 GndA.n1041 GndA.n1026 215.619
R1478 GndA.n1044 GndA.n1026 215.619
R1479 GndA.n1033 GndA.n1026 215.619
R1480 GndA.n1058 GndA.n1026 215.619
R1481 GndA.n1064 GndA.n1026 215.619
R1482 GndA.n522 GndA.n390 214.835
R1483 GndA.n522 GndA.n389 214.835
R1484 GndA.n522 GndA.n388 214.835
R1485 GndA.n523 GndA.n522 214.835
R1486 GndA.n834 GndA.n533 214.835
R1487 GndA.n840 GndA.n834 214.835
R1488 GndA.n445 GndA.n402 214.835
R1489 GndA.n445 GndA.n404 214.835
R1490 GndA.n445 GndA.n405 214.835
R1491 GndA.n445 GndA.n406 214.835
R1492 GndA.n445 GndA.n407 214.835
R1493 GndA.n445 GndA.n408 214.835
R1494 GndA.n445 GndA.n409 214.835
R1495 GndA.n445 GndA.n444 214.835
R1496 GndA.n495 GndA.n455 214.835
R1497 GndA.n495 GndA.n454 214.835
R1498 GndA.n495 GndA.n453 214.835
R1499 GndA.n495 GndA.n494 214.835
R1500 GndA.n496 GndA.n495 214.835
R1501 GndA.n992 GndA.n960 214.835
R1502 GndA.n993 GndA.n992 214.835
R1503 GndA.n1220 GndA.n1219 214.835
R1504 GndA.n1247 GndA.n1246 214.835
R1505 GndA.n1296 GndA.n1258 214.835
R1506 GndA.n1296 GndA.n1257 214.835
R1507 GndA.n1297 GndA.n1296 214.835
R1508 GndA.n1326 GndA.n45 214.835
R1509 GndA.n49 GndA.n45 214.835
R1510 GndA.n1317 GndA.n45 214.835
R1511 GndA.n52 GndA.n45 214.835
R1512 GndA.n1310 GndA.n45 214.835
R1513 GndA.n825 GndA.n824 214.835
R1514 GndA.n683 GndA.n595 214.835
R1515 GndA.n683 GndA.n594 214.835
R1516 GndA.n683 GndA.n593 214.835
R1517 GndA.n646 GndA.n605 214.835
R1518 GndA.n646 GndA.n606 214.835
R1519 GndA.n646 GndA.n607 214.835
R1520 GndA.n646 GndA.n608 214.835
R1521 GndA.n646 GndA.n609 214.835
R1522 GndA.n646 GndA.n610 214.835
R1523 GndA.n646 GndA.n611 214.835
R1524 GndA.n647 GndA.n646 214.835
R1525 GndA.n777 GndA.n581 214.835
R1526 GndA.n777 GndA.n582 214.835
R1527 GndA.n1050 GndA.n1026 214.835
R1528 GndA.n1066 GndA.n1026 214.835
R1529 GndA.n1220 GndA.t50 207.804
R1530 GndA.n992 GndA.t10 207.804
R1531 GndA.n825 GndA.t48 207.804
R1532 GndA.t8 GndA.n834 207.804
R1533 GndA.n733 GndA.n732 206.648
R1534 GndA.n369 GndA.n339 206.648
R1535 GndA.n731 GndA.n730 199.827
R1536 GndA.n877 GndA.n876 199.827
R1537 GndA.n1151 GndA.n159 199.827
R1538 GndA.n181 GndA.n158 199.369
R1539 GndA.n1205 GndA.n147 199.369
R1540 GndA.n881 GndA.n337 199.369
R1541 GndA.n705 GndA.n700 199.369
R1542 GndA.n1208 GndA.n85 195.756
R1543 GndA.n1152 GndA.n179 195.756
R1544 GndA.n701 GndA.n699 195.756
R1545 GndA.n878 GndA.n340 195.756
R1546 GndA.n897 GndA.n320 195
R1547 GndA.n316 GndA.n315 195
R1548 GndA.n899 GndA.n316 195
R1549 GndA.n902 GndA.n901 195
R1550 GndA.n901 GndA.n900 195
R1551 GndA.n903 GndA.n314 195
R1552 GndA.n317 GndA.n314 195
R1553 GndA.n905 GndA.n904 195
R1554 GndA.n906 GndA.n905 195
R1555 GndA.n312 GndA.n311 195
R1556 GndA.n1107 GndA.n1106 195
R1557 GndA.n309 GndA.n190 195
R1558 GndA.n309 GndA.n308 195
R1559 GndA.n914 GndA.n310 195
R1560 GndA.n310 GndA.n306 195
R1561 GndA.n916 GndA.n915 195
R1562 GndA.n917 GndA.n916 195
R1563 GndA.n913 GndA.n307 195
R1564 GndA.n307 GndA.n305 195
R1565 GndA.n912 GndA.n911 195
R1566 GndA.n180 GndA.n158 195
R1567 GndA.n1166 GndA.n1165 195
R1568 GndA.n1149 GndA.n159 195
R1569 GndA.n1203 GndA.n147 195
R1570 GndA.n1201 GndA.n1200 195
R1571 GndA.n31 GndA.n30 195
R1572 GndA.n1345 GndA.n1344 195
R1573 GndA.n1346 GndA.n1345 195
R1574 GndA.n1343 GndA.n33 195
R1575 GndA.n1339 GndA.n33 195
R1576 GndA.n1342 GndA.n1341 195
R1577 GndA.n1341 GndA.n1340 195
R1578 GndA.n35 GndA.n34 195
R1579 GndA.n1338 GndA.n35 195
R1580 GndA.n45 GndA.n44 195
R1581 GndA.n44 GndA.n36 195
R1582 GndA.n1350 GndA.n28 195
R1583 GndA.n1352 GndA.n1351 195
R1584 GndA.n1353 GndA.n1352 195
R1585 GndA.n29 GndA.n27 195
R1586 GndA.n27 GndA.n25 195
R1587 GndA.n771 GndA.n768 195
R1588 GndA.n773 GndA.n771 195
R1589 GndA.n776 GndA.n775 195
R1590 GndA.n775 GndA.n774 195
R1591 GndA.n579 GndA.n575 195
R1592 GndA.n730 GndA.n692 195
R1593 GndA.n729 GndA.n694 195
R1594 GndA.n705 GndA.n704 195
R1595 GndA.n876 GndA.n341 195
R1596 GndA.n344 GndA.n336 195
R1597 GndA.n881 GndA.n880 195
R1598 GndA.t43 GndA.n718 189.877
R1599 GndA.n890 GndA.t46 189.877
R1600 GndA.t47 GndA.n1189 189.877
R1601 GndA.n925 GndA.t44 189.877
R1602 GndA.t1 GndA.n714 184.483
R1603 GndA.n715 GndA.t1 184.483
R1604 GndA.n721 GndA.t43 184.483
R1605 GndA.n333 GndA.t3 184.483
R1606 GndA.t3 GndA.n332 184.483
R1607 GndA.t46 GndA.n889 184.483
R1608 GndA.n1183 GndA.t22 184.483
R1609 GndA.t22 GndA.n1180 184.483
R1610 GndA.n1192 GndA.t47 184.483
R1611 GndA.t44 GndA.n924 184.483
R1612 GndA.n934 GndA.t53 184.483
R1613 GndA.t53 GndA.n933 184.483
R1614 GndA.t7 GndA.n1177 184.483
R1615 GndA.n1178 GndA.t7 184.483
R1616 GndA.n155 GndA.t5 184.483
R1617 GndA.t5 GndA.n154 184.483
R1618 GndA.n1220 GndA.t34 183.71
R1619 GndA.n992 GndA.t33 183.71
R1620 GndA.t15 GndA.n825 183.71
R1621 GndA.n834 GndA.t14 183.71
R1622 GndA.t27 GndA.n743 171.677
R1623 GndA.t23 GndA.n346 171.677
R1624 GndA.n392 GndA.n390 155.333
R1625 GndA.n516 GndA.n389 155.333
R1626 GndA.n512 GndA.n388 155.333
R1627 GndA.n524 GndA.n523 155.333
R1628 GndA.n533 GndA.n532 155.333
R1629 GndA.n841 GndA.n840 155.333
R1630 GndA.n402 GndA.n401 155.333
R1631 GndA.n417 GndA.n404 155.333
R1632 GndA.n421 GndA.n405 155.333
R1633 GndA.n425 GndA.n406 155.333
R1634 GndA.n429 GndA.n407 155.333
R1635 GndA.n433 GndA.n408 155.333
R1636 GndA.n437 GndA.n409 155.333
R1637 GndA.n444 GndA.n410 155.333
R1638 GndA.n478 GndA.n455 155.333
R1639 GndA.n488 GndA.n454 155.333
R1640 GndA.n475 GndA.n453 155.333
R1641 GndA.n494 GndA.n493 155.333
R1642 GndA.n496 GndA.n452 155.333
R1643 GndA.n481 GndA.n455 155.333
R1644 GndA.n477 GndA.n454 155.333
R1645 GndA.n489 GndA.n453 155.333
R1646 GndA.n494 GndA.n474 155.333
R1647 GndA.n497 GndA.n496 155.333
R1648 GndA.n444 GndA.n443 155.333
R1649 GndA.n439 GndA.n409 155.333
R1650 GndA.n436 GndA.n408 155.333
R1651 GndA.n432 GndA.n407 155.333
R1652 GndA.n428 GndA.n406 155.333
R1653 GndA.n424 GndA.n405 155.333
R1654 GndA.n420 GndA.n404 155.333
R1655 GndA.n412 GndA.n402 155.333
R1656 GndA.n840 GndA.n839 155.333
R1657 GndA.n533 GndA.n382 155.333
R1658 GndA.n523 GndA.n383 155.333
R1659 GndA.n388 GndA.n387 155.333
R1660 GndA.n513 GndA.n389 155.333
R1661 GndA.n517 GndA.n390 155.333
R1662 GndA.n967 GndA.n960 155.333
R1663 GndA.n994 GndA.n993 155.333
R1664 GndA.n1219 GndA.n76 155.333
R1665 GndA.n1246 GndA.n68 155.333
R1666 GndA.n1246 GndA.n1245 155.333
R1667 GndA.n1219 GndA.n1218 155.333
R1668 GndA.n1281 GndA.n1258 155.333
R1669 GndA.n1284 GndA.n1257 155.333
R1670 GndA.n1297 GndA.n1253 155.333
R1671 GndA.n1278 GndA.n1258 155.333
R1672 GndA.n1282 GndA.n1257 155.333
R1673 GndA.n1298 GndA.n1297 155.333
R1674 GndA.n1327 GndA.n1326 155.333
R1675 GndA.n49 GndA.n47 155.333
R1676 GndA.n1318 GndA.n1317 155.333
R1677 GndA.n52 GndA.n50 155.333
R1678 GndA.n1311 GndA.n1310 155.333
R1679 GndA.n1310 GndA.n1309 155.333
R1680 GndA.n1312 GndA.n52 155.333
R1681 GndA.n1317 GndA.n1316 155.333
R1682 GndA.n1319 GndA.n49 155.333
R1683 GndA.n1326 GndA.n1325 155.333
R1684 GndA.n824 GndA.n546 155.333
R1685 GndA.n595 GndA.n547 155.333
R1686 GndA.n665 GndA.n594 155.333
R1687 GndA.n674 GndA.n593 155.333
R1688 GndA.n613 GndA.n605 155.333
R1689 GndA.n617 GndA.n606 155.333
R1690 GndA.n621 GndA.n607 155.333
R1691 GndA.n625 GndA.n608 155.333
R1692 GndA.n629 GndA.n609 155.333
R1693 GndA.n633 GndA.n610 155.333
R1694 GndA.n637 GndA.n611 155.333
R1695 GndA.n647 GndA.n604 155.333
R1696 GndA.n748 GndA.n581 155.333
R1697 GndA.n752 GndA.n582 155.333
R1698 GndA.n754 GndA.n582 155.333
R1699 GndA.n751 GndA.n581 155.333
R1700 GndA.n648 GndA.n647 155.333
R1701 GndA.n639 GndA.n611 155.333
R1702 GndA.n636 GndA.n610 155.333
R1703 GndA.n632 GndA.n609 155.333
R1704 GndA.n628 GndA.n608 155.333
R1705 GndA.n624 GndA.n607 155.333
R1706 GndA.n620 GndA.n606 155.333
R1707 GndA.n616 GndA.n605 155.333
R1708 GndA.n824 GndA.n823 155.333
R1709 GndA.n666 GndA.n595 155.333
R1710 GndA.n673 GndA.n594 155.333
R1711 GndA.n676 GndA.n593 155.333
R1712 GndA.n1051 GndA.n1050 155.333
R1713 GndA.n1067 GndA.n1066 155.333
R1714 GndA.n1050 GndA.n1049 155.333
R1715 GndA.n1066 GndA.n1028 155.333
R1716 GndA.n993 GndA.n953 155.333
R1717 GndA.n961 GndA.n960 155.333
R1718 GndA.n844 GndA.n843 153.763
R1719 GndA.n413 GndA.n403 153.763
R1720 GndA.n416 GndA.n403 153.763
R1721 GndA.n843 GndA.n842 153.763
R1722 GndA.n1087 GndA.n193 153.763
R1723 GndA.n1091 GndA.n192 153.763
R1724 GndA.n1095 GndA.n191 153.763
R1725 GndA.n1096 GndA.n195 153.763
R1726 GndA.n1101 GndA.n196 153.763
R1727 GndA.n1142 GndA.n167 153.763
R1728 GndA.n1139 GndA.n168 153.763
R1729 GndA.n1135 GndA.n169 153.763
R1730 GndA.n1131 GndA.n170 153.763
R1731 GndA.n1160 GndA.n171 153.763
R1732 GndA.n973 GndA.n972 153.763
R1733 GndA.n1222 GndA.n1221 153.763
R1734 GndA.n103 GndA.n91 153.763
R1735 GndA.n111 GndA.n92 153.763
R1736 GndA.n113 GndA.n93 153.763
R1737 GndA.n121 GndA.n94 153.763
R1738 GndA.n143 GndA.n95 153.763
R1739 GndA.n143 GndA.n142 153.763
R1740 GndA.n123 GndA.n94 153.763
R1741 GndA.n120 GndA.n93 153.763
R1742 GndA.n114 GndA.n92 153.763
R1743 GndA.n110 GndA.n91 153.763
R1744 GndA.n1249 GndA.n1248 153.763
R1745 GndA.n1229 GndA.n63 153.763
R1746 GndA.n1233 GndA.n62 153.763
R1747 GndA.n1248 GndA.n61 153.763
R1748 GndA.n1232 GndA.n63 153.763
R1749 GndA.n1236 GndA.n62 153.763
R1750 GndA.n1221 GndA.n74 153.763
R1751 GndA.n1269 GndA.n1259 153.763
R1752 GndA.n1275 GndA.n1261 153.763
R1753 GndA.n1290 GndA.n1263 153.763
R1754 GndA.n1265 GndA.n1264 153.763
R1755 GndA.n1272 GndA.n1259 153.763
R1756 GndA.n1273 GndA.n1261 153.763
R1757 GndA.n1287 GndA.n1263 153.763
R1758 GndA.n1291 GndA.n1264 153.763
R1759 GndA.n1330 GndA.n1329 153.763
R1760 GndA.n1329 GndA.n1328 153.763
R1761 GndA.n813 GndA.n543 153.763
R1762 GndA.n682 GndA.n597 153.763
R1763 GndA.n644 GndA.n612 153.763
R1764 GndA.n757 GndA.n584 153.763
R1765 GndA.n761 GndA.n585 153.763
R1766 GndA.n767 GndA.n766 153.763
R1767 GndA.n767 GndA.n578 153.763
R1768 GndA.n586 GndA.n585 153.763
R1769 GndA.n760 GndA.n584 153.763
R1770 GndA.n644 GndA.n643 153.763
R1771 GndA.n815 GndA.n543 153.763
R1772 GndA.n682 GndA.n681 153.763
R1773 GndA.n954 GndA.n952 153.763
R1774 GndA.n1008 GndA.n951 153.763
R1775 GndA.n1003 GndA.n950 153.763
R1776 GndA.n1019 GndA.n1018 153.763
R1777 GndA.n1042 GndA.n1041 153.763
R1778 GndA.n1045 GndA.n1044 153.763
R1779 GndA.n1053 GndA.n1033 153.763
R1780 GndA.n1059 GndA.n1058 153.763
R1781 GndA.n1064 GndA.n1063 153.763
R1782 GndA.n1084 GndA.n193 153.763
R1783 GndA.n1088 GndA.n192 153.763
R1784 GndA.n1092 GndA.n191 153.763
R1785 GndA.n1100 GndA.n195 153.763
R1786 GndA.n1103 GndA.n196 153.763
R1787 GndA.n1041 GndA.n1040 153.763
R1788 GndA.n1044 GndA.n1043 153.763
R1789 GndA.n1056 GndA.n1033 153.763
R1790 GndA.n1058 GndA.n1057 153.763
R1791 GndA.n1065 GndA.n1064 153.763
R1792 GndA.n1018 GndA.n946 153.763
R1793 GndA.n950 GndA.n949 153.763
R1794 GndA.n1004 GndA.n951 153.763
R1795 GndA.n1009 GndA.n952 153.763
R1796 GndA.n973 GndA.n959 153.763
R1797 GndA.n1160 GndA.n1159 153.763
R1798 GndA.n1128 GndA.n170 153.763
R1799 GndA.n1132 GndA.n169 153.763
R1800 GndA.n1136 GndA.n168 153.763
R1801 GndA.n1140 GndA.n167 153.763
R1802 GndA.n691 GndA.n690 152.601
R1803 GndA.n873 GndA.n345 152.601
R1804 GndA.n466 GndA.n465 148.732
R1805 GndA.n467 GndA.n466 148.732
R1806 GndA.n902 GndA.n315 148.732
R1807 GndA.n904 GndA.n903 148.732
R1808 GndA.n908 GndA.n311 148.732
R1809 GndA.n1147 GndA.n183 148.732
R1810 GndA.n1112 GndA.n183 148.732
R1811 GndA.n914 GndA.n190 148.732
R1812 GndA.n915 GndA.n913 148.732
R1813 GndA.n912 GndA.n909 148.732
R1814 GndA.n1350 GndA.n1349 148.732
R1815 GndA.n1351 GndA.n29 148.732
R1816 GndA.n776 GndA.n768 148.732
R1817 GndA.n685 GndA.n684 148.732
R1818 GndA.n686 GndA.n685 148.732
R1819 GndA.n1348 GndA.n30 148.732
R1820 GndA.n1344 GndA.n1343 148.732
R1821 GndA.n1342 GndA.n34 148.732
R1822 GndA.n134 GndA.n133 148.732
R1823 GndA.n134 GndA.n132 148.732
R1824 GndA.n502 GndA.n396 143.757
R1825 GndA.n503 GndA.n395 143.757
R1826 GndA.n447 GndA.n446 143.757
R1827 GndA.n655 GndA.n590 143.757
R1828 GndA.n656 GndA.n654 143.757
R1829 GndA.n645 GndA.n601 143.757
R1830 GndA.n1255 GndA.n1254 143.757
R1831 GndA.n1303 GndA.n57 143.757
R1832 GndA.n1304 GndA.n56 143.757
R1833 GndA.n1073 GndA.n1072 143.757
R1834 GndA.n1025 GndA.n1024 143.757
R1835 GndA.n1079 GndA.n945 143.757
R1836 GndA.n472 GndA.n471 136.575
R1837 GndA.n1108 GndA.n197 136.575
R1838 GndA.n779 GndA.n778 136.575
R1839 GndA.n903 GndA.t56 126.01
R1840 GndA.n915 GndA.t52 126.01
R1841 GndA.t54 GndA.n29 126.01
R1842 GndA.n1343 GndA.t21 126.01
R1843 GndA.t0 GndA.n736 117.63
R1844 GndA.n367 GndA.t2 117.63
R1845 GndA.n1153 GndA.n165 117.454
R1846 GndA.n376 GndA.n348 117.454
R1847 GndA.n1210 GndA.n66 114.442
R1848 GndA.n745 GndA.n592 114.442
R1849 GndA.n495 GndA.n471 112.108
R1850 GndA.n1109 GndA.n1108 112.108
R1851 GndA.n778 GndA.n777 112.108
R1852 GndA.n737 GndA.t0 111.272
R1853 GndA.t2 GndA.n347 111.272
R1854 GndA.n470 GndA.n348 107.418
R1855 GndA.n1110 GndA.n165 107.418
R1856 GndA.n465 GndA.t45 105.353
R1857 GndA.t4 GndA.n1147 105.353
R1858 GndA.n745 GndA.n580 105.353
R1859 GndA.t42 GndA.n686 105.353
R1860 GndA.n66 GndA.n65 105.353
R1861 GndA.n132 GndA.t6 105.353
R1862 GndA.n77 GndA.n66 102.397
R1863 GndA.n745 GndA.n591 102.397
R1864 GndA.n965 GndA.n165 99.3845
R1865 GndA.n836 GndA.n348 99.3845
R1866 GndA.n893 GndA.t57 98.4793
R1867 GndA.n717 GndA.t55 98.4792
R1868 GndA.t24 GndA.n311 97.0897
R1869 GndA.t19 GndA.n912 97.0897
R1870 GndA.t28 GndA.n1350 97.0897
R1871 GndA.t40 GndA.n30 97.0897
R1872 GndA.n1200 GndA.n86 89.5246
R1873 GndA.n910 GndA.n305 89.4404
R1874 GndA.n907 GndA.n906 89.44
R1875 GndA.n1347 GndA.n1346 89.44
R1876 GndA.n1353 GndA.n26 89.44
R1877 GndA.n447 GndA.n445 84.7146
R1878 GndA.n646 GndA.n645 84.7146
R1879 GndA.n1296 GndA.n1255 84.7146
R1880 GndA.n1072 GndA.n1026 84.7146
R1881 GndA.n1162 GndA.n165 76.421
R1882 GndA.n145 GndA.n66 76.3937
R1883 GndA.n689 GndA.n688 75.1291
R1884 GndA.n871 GndA.n349 75.1291
R1885 GndA.n398 GndA.n348 71.8791
R1886 GndA.n746 GndA.n745 71.8791
R1887 GndA.n66 GndA.n64 71.8791
R1888 GndA.n1080 GndA.n165 71.8791
R1889 GndA.n442 GndA.n393 70.024
R1890 GndA.n1300 GndA.n1299 70.024
R1891 GndA.n614 GndA.n599 70.024
R1892 GndA.n1075 GndA.n1022 70.024
R1893 GndA.n872 GndA.n348 69.9243
R1894 GndA.n745 GndA.n744 69.8999
R1895 GndA.n901 GndA.n316 62.7616
R1896 GndA.n901 GndA.n314 62.7616
R1897 GndA.n905 GndA.n314 62.7616
R1898 GndA.n905 GndA.n312 62.7616
R1899 GndA.n1345 GndA.n31 62.7616
R1900 GndA.n1345 GndA.n33 62.7616
R1901 GndA.n1341 GndA.n33 62.7616
R1902 GndA.n1341 GndA.n35 62.7616
R1903 GndA.n1352 GndA.n28 62.7616
R1904 GndA.n1352 GndA.n27 62.7616
R1905 GndA.n771 GndA.n27 62.7616
R1906 GndA.n775 GndA.n771 62.7616
R1907 GndA.n310 GndA.n309 62.7616
R1908 GndA.n916 GndA.n310 62.7616
R1909 GndA.n916 GndA.n307 62.7616
R1910 GndA.n911 GndA.n307 62.7616
R1911 GndA.n1164 GndA.n1163 62.1474
R1912 GndA.n1202 GndA.n146 62.1474
R1913 GndA.n456 GndA.n320 61.8899
R1914 GndA.n44 GndA.n43 61.8899
R1915 GndA.n770 GndA.n579 61.8899
R1916 GndA.n1107 GndA.n189 61.8899
R1917 GndA.n1163 GndA.n164 60.8909
R1918 GndA.n146 GndA.n90 60.8909
R1919 GndA.n838 GndA.n378 60.6123
R1920 GndA.n1217 GndA.n1213 60.6123
R1921 GndA.n812 GndA.n811 60.6123
R1922 GndA.n968 GndA.n964 60.6123
R1923 GndA.n77 GndA.t50 60.2332
R1924 GndA.n965 GndA.t10 60.2332
R1925 GndA.n591 GndA.t48 60.2332
R1926 GndA.n836 GndA.t8 60.2332
R1927 GndA.n495 GndA.n470 59.9066
R1928 GndA.n1110 GndA.n1109 59.9066
R1929 GndA.n777 GndA.n580 59.9066
R1930 GndA.n65 GndA.n45 59.9066
R1931 GndA.t27 GndA.n737 57.2259
R1932 GndA.t23 GndA.n347 57.2259
R1933 GndA.n1206 GndA.n146 51.1983
R1934 GndA.n1163 GndA.n163 51.1983
R1935 GndA.n702 GndA.n690 51.1983
R1936 GndA.n874 GndA.n873 51.1983
R1937 GndA.n471 GndA.n320 45.5256
R1938 GndA.n778 GndA.n579 45.5256
R1939 GndA.n1108 GndA.n1107 45.5256
R1940 GndA.n398 GndA.n396 43.6411
R1941 GndA.n446 GndA.n395 43.6411
R1942 GndA.n746 GndA.n590 43.6411
R1943 GndA.n654 GndA.n601 43.6411
R1944 GndA.n1254 GndA.n57 43.6411
R1945 GndA.n64 GndA.n56 43.6411
R1946 GndA.n1073 GndA.n1025 43.6411
R1947 GndA.n1080 GndA.n1079 43.6411
R1948 GndA.n745 GndA.n684 43.3808
R1949 GndA.n133 GndA.n66 43.3808
R1950 GndA.n467 GndA.n348 41.3151
R1951 GndA.n1112 GndA.n165 41.3151
R1952 GndA.n503 GndA.n502 41.074
R1953 GndA.n656 GndA.n655 41.074
R1954 GndA.n1304 GndA.n1303 41.074
R1955 GndA.n1024 GndA.n945 41.074
R1956 GndA.n738 GndA.n689 38.1508
R1957 GndA.n871 GndA.n870 38.1508
R1958 GndA.n904 GndA.t37 35.1179
R1959 GndA.n913 GndA.t26 35.1179
R1960 GndA.n1351 GndA.t36 35.1179
R1961 GndA.n1344 GndA.t30 35.1179
R1962 GndA.n456 GndA.n316 33.1244
R1963 GndA.n43 GndA.n35 33.1244
R1964 GndA.n775 GndA.n770 33.1244
R1965 GndA.n309 GndA.n189 33.1244
R1966 GndA.n449 GndA.n400 31.624
R1967 GndA.n1268 GndA.n1267 31.624
R1968 GndA.n650 GndA.n649 31.624
R1969 GndA.n1070 GndA.n1069 31.624
R1970 GndA.n872 GndA.n871 31.183
R1971 GndA.n744 GndA.n689 31.1719
R1972 GndA.n1151 GndA.n1150 29.7839
R1973 GndA.n182 GndA.n181 29.7839
R1974 GndA.n1165 GndA.n160 29.7839
R1975 GndA.n1165 GndA.n161 29.7839
R1976 GndA.n1201 GndA.n88 29.7839
R1977 GndA.n1203 GndA.n83 29.7839
R1978 GndA.n89 GndA.n84 29.7839
R1979 GndA.n1201 GndA.n84 29.7839
R1980 GndA.n1203 GndA.n88 29.7839
R1981 GndA.n1205 GndA.n83 29.7839
R1982 GndA.n704 GndA.n693 29.7839
R1983 GndA.n880 GndA.n879 29.7839
R1984 GndA.n877 GndA.n875 29.7839
R1985 GndA.n344 GndA.n338 29.7839
R1986 GndA.n731 GndA.n695 29.7839
R1987 GndA.n703 GndA.n694 29.7839
R1988 GndA.n698 GndA.n694 29.7839
R1989 GndA.n344 GndA.n343 29.7839
R1990 GndA.n879 GndA.n337 29.7839
R1991 GndA.n880 GndA.n338 29.7839
R1992 GndA.n343 GndA.n341 29.7839
R1993 GndA.n875 GndA.n341 29.7839
R1994 GndA.n700 GndA.n693 29.7839
R1995 GndA.n704 GndA.n703 29.7839
R1996 GndA.n698 GndA.n692 29.7839
R1997 GndA.n695 GndA.n692 29.7839
R1998 GndA.n1150 GndA.n1149 29.7839
R1999 GndA.n1149 GndA.n160 29.7839
R2000 GndA.n180 GndA.n161 29.7839
R2001 GndA.n182 GndA.n180 29.7839
R2002 GndA.n722 GndA.n718 29.0473
R2003 GndA.n890 GndA.n886 29.0473
R2004 GndA.n1193 GndA.n1189 29.0473
R2005 GndA.n925 GndA.n921 29.0473
R2006 GndA.n898 GndA.n318 27.9848
R2007 GndA.n1337 GndA.n1336 27.9848
R2008 GndA.n772 GndA.n574 27.9848
R2009 GndA.n198 GndA.n188 27.9848
R2010 GndA.n838 GndA.n835 27.4829
R2011 GndA.n515 GndA.n514 27.4829
R2012 GndA.n519 GndA.n518 27.4829
R2013 GndA.n520 GndA.n506 27.4829
R2014 GndA.n505 GndA.n393 27.4829
R2015 GndA.n442 GndA.n441 27.4829
R2016 GndA.n440 GndA.n438 27.4829
R2017 GndA.n435 GndA.n434 27.4829
R2018 GndA.n431 GndA.n430 27.4829
R2019 GndA.n427 GndA.n426 27.4829
R2020 GndA.n423 GndA.n422 27.4829
R2021 GndA.n419 GndA.n418 27.4829
R2022 GndA.n411 GndA.n400 27.4829
R2023 GndA.n483 GndA.n479 27.4829
R2024 GndA.n487 GndA.n486 27.4829
R2025 GndA.n491 GndA.n490 27.4829
R2026 GndA.n492 GndA.n476 27.4829
R2027 GndA.n498 GndA.n451 27.4829
R2028 GndA.n500 GndA.n499 27.4829
R2029 GndA.n450 GndA.n449 27.4829
R2030 GndA.n1267 GndA.n54 27.4829
R2031 GndA.n1307 GndA.n1306 27.4829
R2032 GndA.n1308 GndA.n51 27.4829
R2033 GndA.n1314 GndA.n1313 27.4829
R2034 GndA.n1315 GndA.n48 27.4829
R2035 GndA.n1321 GndA.n1320 27.4829
R2036 GndA.n1324 GndA.n46 27.4829
R2037 GndA.n1270 GndA.n1268 27.4829
R2038 GndA.n1277 GndA.n1276 27.4829
R2039 GndA.n1280 GndA.n1279 27.4829
R2040 GndA.n1285 GndA.n1283 27.4829
R2041 GndA.n1288 GndA.n1286 27.4829
R2042 GndA.n1292 GndA.n1289 27.4829
R2043 GndA.n1294 GndA.n1293 27.4829
R2044 GndA.n1299 GndA.n1252 27.4829
R2045 GndA.n1301 GndA.n1300 27.4829
R2046 GndA.n1251 GndA.n1250 27.4829
R2047 GndA.n1230 GndA.n60 27.4829
R2048 GndA.n1234 GndA.n1231 27.4829
R2049 GndA.n1217 GndA.n1216 27.4829
R2050 GndA.n814 GndA.n812 27.4829
R2051 GndA.n677 GndA.n675 27.4829
R2052 GndA.n679 GndA.n678 27.4829
R2053 GndA.n680 GndA.n659 27.4829
R2054 GndA.n658 GndA.n599 27.4829
R2055 GndA.n649 GndA.n603 27.4829
R2056 GndA.n640 GndA.n638 27.4829
R2057 GndA.n635 GndA.n634 27.4829
R2058 GndA.n631 GndA.n630 27.4829
R2059 GndA.n627 GndA.n626 27.4829
R2060 GndA.n623 GndA.n622 27.4829
R2061 GndA.n619 GndA.n618 27.4829
R2062 GndA.n615 GndA.n614 27.4829
R2063 GndA.n765 GndA.n587 27.4829
R2064 GndA.n762 GndA.n759 27.4829
R2065 GndA.n758 GndA.n756 27.4829
R2066 GndA.n755 GndA.n753 27.4829
R2067 GndA.n750 GndA.n749 27.4829
R2068 GndA.n651 GndA.n588 27.4829
R2069 GndA.n652 GndA.n650 27.4829
R2070 GndA.n1076 GndA.n1075 27.4829
R2071 GndA.n1077 GndA.n1021 27.4829
R2072 GndA.n1020 GndA.n948 27.4829
R2073 GndA.n1005 GndA.n1002 27.4829
R2074 GndA.n969 GndA.n968 27.4829
R2075 GndA.n1039 GndA.n1022 27.4829
R2076 GndA.n1038 GndA.n1037 27.4829
R2077 GndA.n1047 GndA.n1046 27.4829
R2078 GndA.n1048 GndA.n1035 27.4829
R2079 GndA.n1054 GndA.n1034 27.4829
R2080 GndA.n1055 GndA.n1032 27.4829
R2081 GndA.n1061 GndA.n1060 27.4829
R2082 GndA.n1069 GndA.n1068 27.4829
R2083 GndA.n1070 GndA.n1029 27.4829
R2084 GndA.n1082 GndA.n943 27.4829
R2085 GndA.n1085 GndA.n1083 27.4829
R2086 GndA.n1089 GndA.n1086 27.4829
R2087 GndA.n1093 GndA.n1090 27.4829
R2088 GndA.n1097 GndA.n1094 27.4829
R2089 GndA.n1102 GndA.n1099 27.4829
R2090 GndA.n1207 GndA.n86 27.4092
R2091 GndA.n850 GndA.n378 27.1064
R2092 GndA.n851 GndA.n850 27.1064
R2093 GndA.n852 GndA.n851 27.1064
R2094 GndA.n852 GndA.n371 27.1064
R2095 GndA.n856 GndA.n371 27.1064
R2096 GndA.n857 GndA.n856 27.1064
R2097 GndA.n858 GndA.n857 27.1064
R2098 GndA.n858 GndA.n362 27.1064
R2099 GndA.n862 GndA.n362 27.1064
R2100 GndA.n863 GndA.n862 27.1064
R2101 GndA.n864 GndA.n863 27.1064
R2102 GndA.n864 GndA.n354 27.1064
R2103 GndA.n868 GndA.n354 27.1064
R2104 GndA.n868 GndA.n353 27.1064
R2105 GndA.n463 GndA.n353 27.1064
R2106 GndA.n463 GndA.n459 27.1064
R2107 GndA.n459 GndA.n458 27.1064
R2108 GndA.n458 GndA.n318 27.1064
R2109 GndA.n835 GndA.n381 27.1064
R2110 GndA.n845 GndA.n381 27.1064
R2111 GndA.n518 GndA.n515 27.1064
R2112 GndA.n520 GndA.n519 27.1064
R2113 GndA.n506 GndA.n505 27.1064
R2114 GndA.n441 GndA.n440 27.1064
R2115 GndA.n438 GndA.n435 27.1064
R2116 GndA.n434 GndA.n431 27.1064
R2117 GndA.n430 GndA.n427 27.1064
R2118 GndA.n426 GndA.n423 27.1064
R2119 GndA.n422 GndA.n419 27.1064
R2120 GndA.n418 GndA.n415 27.1064
R2121 GndA.n415 GndA.n414 27.1064
R2122 GndA.n414 GndA.n411 27.1064
R2123 GndA.n482 GndA.n319 27.1064
R2124 GndA.n483 GndA.n482 27.1064
R2125 GndA.n490 GndA.n487 27.1064
R2126 GndA.n492 GndA.n491 27.1064
R2127 GndA.n476 GndA.n451 27.1064
R2128 GndA.n499 GndA.n498 27.1064
R2129 GndA.n500 GndA.n450 27.1064
R2130 GndA.n1336 GndA.n37 27.1064
R2131 GndA.n136 GndA.n37 27.1064
R2132 GndA.n136 GndA.n128 27.1064
R2133 GndA.n140 GndA.n128 27.1064
R2134 GndA.n141 GndA.n140 27.1064
R2135 GndA.n141 GndA.n97 27.1064
R2136 GndA.n124 GndA.n97 27.1064
R2137 GndA.n124 GndA.n122 27.1064
R2138 GndA.n122 GndA.n119 27.1064
R2139 GndA.n119 GndA.n99 27.1064
R2140 GndA.n115 GndA.n99 27.1064
R2141 GndA.n115 GndA.n112 27.1064
R2142 GndA.n112 GndA.n109 27.1064
R2143 GndA.n109 GndA.n101 27.1064
R2144 GndA.n105 GndA.n101 27.1064
R2145 GndA.n105 GndA.n81 27.1064
R2146 GndA.n1212 GndA.n81 27.1064
R2147 GndA.n1213 GndA.n1212 27.1064
R2148 GndA.n1306 GndA.n54 27.1064
R2149 GndA.n1308 GndA.n1307 27.1064
R2150 GndA.n1313 GndA.n51 27.1064
R2151 GndA.n1315 GndA.n1314 27.1064
R2152 GndA.n1320 GndA.n48 27.1064
R2153 GndA.n46 GndA.n42 27.1064
R2154 GndA.n1331 GndA.n42 27.1064
R2155 GndA.n1271 GndA.n1270 27.1064
R2156 GndA.n1274 GndA.n1271 27.1064
R2157 GndA.n1276 GndA.n1274 27.1064
R2158 GndA.n1279 GndA.n1277 27.1064
R2159 GndA.n1283 GndA.n1280 27.1064
R2160 GndA.n1286 GndA.n1285 27.1064
R2161 GndA.n1289 GndA.n1288 27.1064
R2162 GndA.n1293 GndA.n1292 27.1064
R2163 GndA.n1294 GndA.n1252 27.1064
R2164 GndA.n1301 GndA.n1251 27.1064
R2165 GndA.n1250 GndA.n60 27.1064
R2166 GndA.n1231 GndA.n1230 27.1064
R2167 GndA.n1215 GndA.n1214 27.1064
R2168 GndA.n1216 GndA.n1215 27.1064
R2169 GndA.n786 GndA.n574 27.1064
R2170 GndA.n787 GndA.n786 27.1064
R2171 GndA.n788 GndA.n787 27.1064
R2172 GndA.n788 GndA.n569 27.1064
R2173 GndA.n792 GndA.n569 27.1064
R2174 GndA.n793 GndA.n792 27.1064
R2175 GndA.n794 GndA.n793 27.1064
R2176 GndA.n794 GndA.n564 27.1064
R2177 GndA.n798 GndA.n564 27.1064
R2178 GndA.n799 GndA.n798 27.1064
R2179 GndA.n800 GndA.n799 27.1064
R2180 GndA.n800 GndA.n559 27.1064
R2181 GndA.n804 GndA.n559 27.1064
R2182 GndA.n805 GndA.n804 27.1064
R2183 GndA.n806 GndA.n805 27.1064
R2184 GndA.n806 GndA.n554 27.1064
R2185 GndA.n810 GndA.n554 27.1064
R2186 GndA.n811 GndA.n810 27.1064
R2187 GndA.n816 GndA.n814 27.1064
R2188 GndA.n817 GndA.n816 27.1064
R2189 GndA.n678 GndA.n677 27.1064
R2190 GndA.n680 GndA.n679 27.1064
R2191 GndA.n659 GndA.n658 27.1064
R2192 GndA.n642 GndA.n603 27.1064
R2193 GndA.n642 GndA.n641 27.1064
R2194 GndA.n641 GndA.n640 27.1064
R2195 GndA.n638 GndA.n635 27.1064
R2196 GndA.n634 GndA.n631 27.1064
R2197 GndA.n630 GndA.n627 27.1064
R2198 GndA.n626 GndA.n623 27.1064
R2199 GndA.n622 GndA.n619 27.1064
R2200 GndA.n618 GndA.n615 27.1064
R2201 GndA.n780 GndA.n577 27.1064
R2202 GndA.n765 GndA.n577 27.1064
R2203 GndA.n759 GndA.n758 27.1064
R2204 GndA.n756 GndA.n755 27.1064
R2205 GndA.n753 GndA.n750 27.1064
R2206 GndA.n749 GndA.n588 27.1064
R2207 GndA.n652 GndA.n651 27.1064
R2208 GndA.n713 GndA.n710 27.1064
R2209 GndA.n829 GndA.n541 27.1064
R2210 GndA.n830 GndA.n829 27.1064
R2211 GndA.n831 GndA.n830 27.1064
R2212 GndA.n331 GndA.n328 27.1064
R2213 GndA.n1185 GndA.n1184 27.1064
R2214 GndA.n1077 GndA.n1076 27.1064
R2215 GndA.n1021 GndA.n1020 27.1064
R2216 GndA.n1002 GndA.n948 27.1064
R2217 GndA.n971 GndA.n970 27.1064
R2218 GndA.n971 GndA.n969 27.1064
R2219 GndA.n1039 GndA.n1038 27.1064
R2220 GndA.n1046 GndA.n1037 27.1064
R2221 GndA.n1048 GndA.n1047 27.1064
R2222 GndA.n1035 GndA.n1034 27.1064
R2223 GndA.n1055 GndA.n1054 27.1064
R2224 GndA.n1060 GndA.n1032 27.1064
R2225 GndA.n1062 GndA.n1061 27.1064
R2226 GndA.n1062 GndA.n1030 27.1064
R2227 GndA.n1068 GndA.n1030 27.1064
R2228 GndA.n1029 GndA.n943 27.1064
R2229 GndA.n1083 GndA.n1082 27.1064
R2230 GndA.n1086 GndA.n1085 27.1064
R2231 GndA.n1090 GndA.n1089 27.1064
R2232 GndA.n1094 GndA.n1093 27.1064
R2233 GndA.n1104 GndA.n1102 27.1064
R2234 GndA.n1105 GndA.n1104 27.1064
R2235 GndA.n964 GndA.n177 27.1064
R2236 GndA.n1156 GndA.n177 27.1064
R2237 GndA.n1157 GndA.n1156 27.1064
R2238 GndA.n1158 GndA.n1157 27.1064
R2239 GndA.n1158 GndA.n173 27.1064
R2240 GndA.n1129 GndA.n173 27.1064
R2241 GndA.n1130 GndA.n1129 27.1064
R2242 GndA.n1133 GndA.n1130 27.1064
R2243 GndA.n1134 GndA.n1133 27.1064
R2244 GndA.n1137 GndA.n1134 27.1064
R2245 GndA.n1138 GndA.n1137 27.1064
R2246 GndA.n1141 GndA.n1138 27.1064
R2247 GndA.n1143 GndA.n1141 27.1064
R2248 GndA.n1144 GndA.n1143 27.1064
R2249 GndA.n1145 GndA.n1144 27.1064
R2250 GndA.n1145 GndA.n186 27.1064
R2251 GndA.n1114 GndA.n186 27.1064
R2252 GndA.n1114 GndA.n188 27.1064
R2253 GndA.n932 GndA.n929 27.1064
R2254 GndA.n987 GndA.n982 27.1064
R2255 GndA.n988 GndA.n987 27.1064
R2256 GndA.n989 GndA.n988 27.1064
R2257 GndA.n1176 GndA.n1173 27.1064
R2258 GndA.n153 GndA.n150 27.1064
R2259 GndA.n911 GndA.n910 26.7727
R2260 GndA.n907 GndA.n312 26.7721
R2261 GndA.n1347 GndA.n31 26.7721
R2262 GndA.n28 GndA.n26 26.7721
R2263 GndA.n89 GndA.n86 26.7467
R2264 GndA.t45 GndA.n349 26.2958
R2265 GndA.n688 GndA.t42 26.2958
R2266 GndA.n1183 GndA.n1182 25.9611
R2267 GndA.n933 GndA.n930 25.9611
R2268 GndA.n714 GndA.n711 25.79
R2269 GndA.n332 GndA.n329 25.79
R2270 GndA.n1177 GndA.n1174 25.79
R2271 GndA.n154 GndA.n151 25.79
R2272 GndA.n1187 GndA.n1180 25.7847
R2273 GndA.n935 GndA.n934 25.7847
R2274 GndA.n716 GndA.n715 25.7818
R2275 GndA.n721 GndA.n720 25.7818
R2276 GndA.n334 GndA.n333 25.7818
R2277 GndA.n889 GndA.n888 25.7818
R2278 GndA.n1192 GndA.n1191 25.7818
R2279 GndA.n924 GndA.n923 25.7818
R2280 GndA.n1179 GndA.n1178 25.7818
R2281 GndA.n156 GndA.n155 25.7818
R2282 GndA.n1163 GndA.n1162 23.9848
R2283 GndA.n146 GndA.n145 23.9762
R2284 GndA.t56 GndA.n902 22.7235
R2285 GndA.t52 GndA.n914 22.7235
R2286 GndA.n768 GndA.t54 22.7235
R2287 GndA.t21 GndA.n1342 22.7235
R2288 GndA.n732 GndA.n691 22.2548
R2289 GndA.n345 GndA.n339 22.2548
R2290 GndA.t4 GndA.n164 21.3125
R2291 GndA.t6 GndA.n90 21.3125
R2292 GndA.n846 GndA.n845 21.0829
R2293 GndA.n530 GndA.n380 21.0829
R2294 GndA.n531 GndA.n529 21.0829
R2295 GndA.n526 GndA.n384 21.0829
R2296 GndA.n510 GndA.n508 21.0829
R2297 GndA.n1239 GndA.n1238 21.0829
R2298 GndA.n1244 GndA.n1243 21.0829
R2299 GndA.n1224 GndA.n70 21.0829
R2300 GndA.n1225 GndA.n1223 21.0829
R2301 GndA.n1214 GndA.n73 21.0829
R2302 GndA.n818 GndA.n817 21.0829
R2303 GndA.n821 GndA.n549 21.0829
R2304 GndA.n822 GndA.n548 21.0829
R2305 GndA.n664 GndA.n663 21.0829
R2306 GndA.n671 GndA.n661 21.0829
R2307 GndA.n1010 GndA.n1001 21.0829
R2308 GndA.n1015 GndA.n1014 21.0829
R2309 GndA.n996 GndA.n955 21.0829
R2310 GndA.n997 GndA.n995 21.0829
R2311 GndA.n970 GndA.n958 21.0829
R2312 GndA.n1206 GndA.n85 21.082
R2313 GndA.n1209 GndA.n1208 21.082
R2314 GndA.n1154 GndA.n1152 21.082
R2315 GndA.n179 GndA.n163 21.082
R2316 GndA.n702 GndA.n701 21.082
R2317 GndA.n699 GndA.n697 21.082
R2318 GndA.n878 GndA.n342 21.082
R2319 GndA.n874 GndA.n340 21.082
R2320 GndA.n525 GndA.n386 20.7064
R2321 GndA.n511 GndA.n507 20.7064
R2322 GndA.n1237 GndA.n1235 20.7064
R2323 GndA.n1240 GndA.n71 20.7064
R2324 GndA.n668 GndA.n667 20.7064
R2325 GndA.n672 GndA.n660 20.7064
R2326 GndA.n1007 GndA.n1006 20.7064
R2327 GndA.n1011 GndA.n956 20.7064
R2328 GndA.n897 GndA.n319 18.4476
R2329 GndA.n1331 GndA.n36 18.4476
R2330 GndA.n780 GndA.n575 18.4476
R2331 GndA.n1106 GndA.n1105 18.4476
R2332 GndA.t37 GndA.t24 16.5263
R2333 GndA.t26 GndA.t19 16.5263
R2334 GndA.t36 GndA.t28 16.5263
R2335 GndA.t30 GndA.t40 16.5263
R2336 GndA.n252 GndA.n236 13.3171
R2337 GndA.n253 GndA.n234 13.3171
R2338 GndA.n211 GndA.n210 12.8637
R2339 GndA.n209 GndA.n208 12.8637
R2340 GndA.n1235 GndA.n1228 9.49615
R2341 GndA.n670 GndA.n660 9.49615
R2342 GndA.n1006 GndA.n1000 9.49615
R2343 GndA.n509 GndA.n507 9.49615
R2344 GndA.n321 GndA.n319 9.3005
R2345 GndA.n482 GndA.n480 9.3005
R2346 GndA.n484 GndA.n483 9.3005
R2347 GndA.n322 GndA.n318 9.3005
R2348 GndA.n460 GndA.n458 9.3005
R2349 GndA.n461 GndA.n459 9.3005
R2350 GndA.n463 GndA.n462 9.3005
R2351 GndA.n355 GndA.n353 9.3005
R2352 GndA.n868 GndA.n867 9.3005
R2353 GndA.n866 GndA.n354 9.3005
R2354 GndA.n865 GndA.n864 9.3005
R2355 GndA.n863 GndA.n356 9.3005
R2356 GndA.n862 GndA.n861 9.3005
R2357 GndA.n860 GndA.n362 9.3005
R2358 GndA.n859 GndA.n858 9.3005
R2359 GndA.n857 GndA.n363 9.3005
R2360 GndA.n856 GndA.n855 9.3005
R2361 GndA.n854 GndA.n371 9.3005
R2362 GndA.n853 GndA.n852 9.3005
R2363 GndA.n851 GndA.n372 9.3005
R2364 GndA.n850 GndA.n849 9.3005
R2365 GndA.n848 GndA.n378 9.3005
R2366 GndA.n510 GndA.n509 9.3005
R2367 GndA.n386 GndA.n385 9.3005
R2368 GndA.n527 GndA.n526 9.3005
R2369 GndA.n529 GndA.n528 9.3005
R2370 GndA.n530 GndA.n379 9.3005
R2371 GndA.n847 GndA.n846 9.3005
R2372 GndA.n150 GndA.n149 9.3005
R2373 GndA.n153 GndA.n152 9.3005
R2374 GndA.n1176 GndA.n1175 9.3005
R2375 GndA.n1173 GndA.n1172 9.3005
R2376 GndA.n1213 GndA.n79 9.3005
R2377 GndA.n1212 GndA.n80 9.3005
R2378 GndA.n102 GndA.n81 9.3005
R2379 GndA.n106 GndA.n105 9.3005
R2380 GndA.n107 GndA.n101 9.3005
R2381 GndA.n109 GndA.n108 9.3005
R2382 GndA.n112 GndA.n100 9.3005
R2383 GndA.n116 GndA.n115 9.3005
R2384 GndA.n117 GndA.n99 9.3005
R2385 GndA.n119 GndA.n118 9.3005
R2386 GndA.n122 GndA.n98 9.3005
R2387 GndA.n125 GndA.n124 9.3005
R2388 GndA.n126 GndA.n97 9.3005
R2389 GndA.n141 GndA.n127 9.3005
R2390 GndA.n140 GndA.n139 9.3005
R2391 GndA.n138 GndA.n128 9.3005
R2392 GndA.n137 GndA.n136 9.3005
R2393 GndA.n39 GndA.n37 9.3005
R2394 GndA.n1336 GndA.n1335 9.3005
R2395 GndA.n1332 GndA.n1331 9.3005
R2396 GndA.n42 GndA.n41 9.3005
R2397 GndA.n1322 GndA.n46 9.3005
R2398 GndA.n1238 GndA.n1228 9.3005
R2399 GndA.n1241 GndA.n1240 9.3005
R2400 GndA.n1243 GndA.n1242 9.3005
R2401 GndA.n1227 GndA.n70 9.3005
R2402 GndA.n1226 GndA.n1225 9.3005
R2403 GndA.n73 GndA.n72 9.3005
R2404 GndA.n765 GndA.n764 9.3005
R2405 GndA.n577 GndA.n576 9.3005
R2406 GndA.n781 GndA.n780 9.3005
R2407 GndA.n784 GndA.n574 9.3005
R2408 GndA.n786 GndA.n785 9.3005
R2409 GndA.n787 GndA.n570 9.3005
R2410 GndA.n789 GndA.n788 9.3005
R2411 GndA.n790 GndA.n569 9.3005
R2412 GndA.n792 GndA.n791 9.3005
R2413 GndA.n793 GndA.n565 9.3005
R2414 GndA.n795 GndA.n794 9.3005
R2415 GndA.n796 GndA.n564 9.3005
R2416 GndA.n798 GndA.n797 9.3005
R2417 GndA.n799 GndA.n560 9.3005
R2418 GndA.n801 GndA.n800 9.3005
R2419 GndA.n802 GndA.n559 9.3005
R2420 GndA.n804 GndA.n803 9.3005
R2421 GndA.n805 GndA.n555 9.3005
R2422 GndA.n807 GndA.n806 9.3005
R2423 GndA.n808 GndA.n554 9.3005
R2424 GndA.n810 GndA.n809 9.3005
R2425 GndA.n811 GndA.n551 9.3005
R2426 GndA.n819 GndA.n818 9.3005
R2427 GndA.n821 GndA.n820 9.3005
R2428 GndA.n550 GndA.n548 9.3005
R2429 GndA.n664 GndA.n662 9.3005
R2430 GndA.n669 GndA.n668 9.3005
R2431 GndA.n671 GndA.n670 9.3005
R2432 GndA.n328 GndA.n327 9.3005
R2433 GndA.n331 GndA.n330 9.3005
R2434 GndA.n713 GndA.n712 9.3005
R2435 GndA.n710 GndA.n709 9.3005
R2436 GndA.n723 GndA.n722 9.3005
R2437 GndA.n831 GndA.n536 9.3005
R2438 GndA.n830 GndA.n537 9.3005
R2439 GndA.n829 GndA.n538 9.3005
R2440 GndA.n541 GndA.n540 9.3005
R2441 GndA.n886 GndA.n885 9.3005
R2442 GndA.n1186 GndA.n1185 9.3005
R2443 GndA.n1184 GndA.n1181 9.3005
R2444 GndA.n1194 GndA.n1193 9.3005
R2445 GndA.n1001 GndA.n1000 9.3005
R2446 GndA.n1012 GndA.n1011 9.3005
R2447 GndA.n1014 GndA.n1013 9.3005
R2448 GndA.n999 GndA.n955 9.3005
R2449 GndA.n998 GndA.n997 9.3005
R2450 GndA.n958 GndA.n957 9.3005
R2451 GndA.n1105 GndA.n940 9.3005
R2452 GndA.n1104 GndA.n941 9.3005
R2453 GndA.n1102 GndA.n942 9.3005
R2454 GndA.n188 GndA.n187 9.3005
R2455 GndA.n1115 GndA.n1114 9.3005
R2456 GndA.n1116 GndA.n186 9.3005
R2457 GndA.n1145 GndA.n1117 9.3005
R2458 GndA.n1144 GndA.n1118 9.3005
R2459 GndA.n1143 GndA.n1119 9.3005
R2460 GndA.n1141 GndA.n1120 9.3005
R2461 GndA.n1138 GndA.n1121 9.3005
R2462 GndA.n1137 GndA.n1122 9.3005
R2463 GndA.n1134 GndA.n1123 9.3005
R2464 GndA.n1133 GndA.n1124 9.3005
R2465 GndA.n1130 GndA.n1125 9.3005
R2466 GndA.n1129 GndA.n1127 9.3005
R2467 GndA.n1126 GndA.n173 9.3005
R2468 GndA.n1158 GndA.n174 9.3005
R2469 GndA.n1157 GndA.n175 9.3005
R2470 GndA.n1156 GndA.n176 9.3005
R2471 GndA.n962 GndA.n177 9.3005
R2472 GndA.n964 GndA.n963 9.3005
R2473 GndA.n921 GndA.n920 9.3005
R2474 GndA.n929 GndA.n928 9.3005
R2475 GndA.n932 GndA.n931 9.3005
R2476 GndA.n989 GndA.n977 9.3005
R2477 GndA.n988 GndA.n978 9.3005
R2478 GndA.n987 GndA.n979 9.3005
R2479 GndA.n982 GndA.n981 9.3005
R2480 GndA.n714 GndA.n713 9.2683
R2481 GndA.n715 GndA.n710 9.2683
R2482 GndA.n722 GndA.n721 9.2683
R2483 GndA.n333 GndA.n328 9.2683
R2484 GndA.n332 GndA.n331 9.2683
R2485 GndA.n889 GndA.n886 9.2683
R2486 GndA.n1184 GndA.n1183 9.2683
R2487 GndA.n1185 GndA.n1180 9.2683
R2488 GndA.n1193 GndA.n1192 9.2683
R2489 GndA.n924 GndA.n921 9.2683
R2490 GndA.n934 GndA.n929 9.2683
R2491 GndA.n933 GndA.n932 9.2683
R2492 GndA.n1177 GndA.n1176 9.2683
R2493 GndA.n1178 GndA.n1173 9.2683
R2494 GndA.n155 GndA.n150 9.2683
R2495 GndA.n154 GndA.n153 9.2683
R2496 GndA.n531 GndA.n530 6.4005
R2497 GndA.n526 GndA.n525 6.4005
R2498 GndA.n508 GndA.n386 6.4005
R2499 GndA.n511 GndA.n510 6.4005
R2500 GndA.n514 GndA.n507 6.4005
R2501 GndA.n1235 GndA.n1234 6.4005
R2502 GndA.n1238 GndA.n1237 6.4005
R2503 GndA.n1240 GndA.n1239 6.4005
R2504 GndA.n1243 GndA.n71 6.4005
R2505 GndA.n1225 GndA.n1224 6.4005
R2506 GndA.n822 GndA.n821 6.4005
R2507 GndA.n667 GndA.n664 6.4005
R2508 GndA.n668 GndA.n661 6.4005
R2509 GndA.n672 GndA.n671 6.4005
R2510 GndA.n675 GndA.n660 6.4005
R2511 GndA.n1006 GndA.n1005 6.4005
R2512 GndA.n1007 GndA.n1001 6.4005
R2513 GndA.n1011 GndA.n1010 6.4005
R2514 GndA.n1014 GndA.n956 6.4005
R2515 GndA.n997 GndA.n996 6.4005
R2516 GndA.n846 GndA.n380 6.02403
R2517 GndA.n529 GndA.n384 6.02403
R2518 GndA.n1244 GndA.n70 6.02403
R2519 GndA.n1223 GndA.n73 6.02403
R2520 GndA.n818 GndA.n549 6.02403
R2521 GndA.n663 GndA.n548 6.02403
R2522 GndA.n1015 GndA.n955 6.02403
R2523 GndA.n995 GndA.n958 6.02403
R2524 GndA.n486 GndA.n485 5.60839
R2525 GndA.n1323 GndA.n1321 5.60839
R2526 GndA.n763 GndA.n762 5.60839
R2527 GndA.n1098 GndA.n1097 5.60839
R2528 GndA.n485 GndA.n479 5.49286
R2529 GndA.n1324 GndA.n1323 5.49286
R2530 GndA.n763 GndA.n587 5.49286
R2531 GndA.n1099 GndA.n1098 5.49286
R2532 GndA.n724 GndA.n718 5.44963
R2533 GndA.n891 GndA.n890 5.44963
R2534 GndA.n1195 GndA.n1189 5.44963
R2535 GndA.n926 GndA.n925 5.44963
R2536 GndA.n900 GndA.n899 4.38907
R2537 GndA.n900 GndA.n317 4.38907
R2538 GndA.n1340 GndA.n1339 4.38907
R2539 GndA.n1340 GndA.n1338 4.38907
R2540 GndA.n773 GndA.n25 4.38907
R2541 GndA.n774 GndA.n773 4.38907
R2542 GndA.n308 GndA.n306 4.38907
R2543 GndA.n917 GndA.n306 4.38907
R2544 GndA.n1166 GndA.n159 4.36827
R2545 GndA.n876 GndA.n336 4.36827
R2546 GndA.n730 GndA.n729 4.36827
R2547 GndA.n898 GndA.n897 4.32812
R2548 GndA.n1337 GndA.n36 4.32812
R2549 GndA.n772 GndA.n575 4.32812
R2550 GndA.n1106 GndA.n198 4.32812
R2551 GndA.n291 GndA.n212 3.44112
R2552 GndA.n207 GndA.n2 3.44112
R2553 GndA.n251 GndA.n250 3.44112
R2554 GndA.n254 GndA.n232 3.44112
R2555 GndA.n279 GndA.n274 3.42261
R2556 GndA.n1379 GndA.n15 3.42261
R2557 GndA.n1371 GndA.n1370 3.42261
R2558 GndA.n220 GndA.n215 3.42261
R2559 GndA.n291 GndA.n290 3.4126
R2560 GndA.n1396 GndA.n2 3.4126
R2561 GndA.n250 GndA.n249 3.4126
R2562 GndA.n232 GndA.n230 3.4126
R2563 GndA.n285 GndA.n274 3.4112
R2564 GndA.n1379 GndA.n1378 3.4112
R2565 GndA.n1372 GndA.n1371 3.4112
R2566 GndA.n271 GndA.n215 3.4112
R2567 GndA.n213 GndA.n205 3.4105
R2568 GndA.n298 GndA.n297 3.4105
R2569 GndA.n300 GndA.n299 3.4105
R2570 GndA.n277 GndA.n275 3.4105
R2571 GndA.n284 GndA.n283 3.4105
R2572 GndA.n293 GndA.n292 3.4105
R2573 GndA.n294 GndA.n206 3.4105
R2574 GndA.n296 GndA.n295 3.4105
R2575 GndA.n203 GndA.n201 3.4105
R2576 GndA.n302 GndA.n301 3.4105
R2577 GndA.n202 GndA.n200 3.4105
R2578 GndA.n282 GndA.n281 3.4105
R2579 GndA.n280 GndA.n276 3.4105
R2580 GndA.n1381 GndA.n1380 3.4105
R2581 GndA.n1383 GndA.n1382 3.4105
R2582 GndA.n13 GndA.n11 3.4105
R2583 GndA.n9 GndA.n7 3.4105
R2584 GndA.n1390 GndA.n1389 3.4105
R2585 GndA.n1391 GndA.n5 3.4105
R2586 GndA.n1393 GndA.n1392 3.4105
R2587 GndA.n6 GndA.n4 3.4105
R2588 GndA.n12 GndA.n10 3.4105
R2589 GndA.n1385 GndA.n1384 3.4105
R2590 GndA.n1388 GndA.n1387 3.4105
R2591 GndA.n8 GndA.n3 3.4105
R2592 GndA.n1395 GndA.n1394 3.4105
R2593 GndA.n256 GndA.n255 3.4105
R2594 GndA.n233 GndA.n231 3.4105
R2595 GndA.n227 GndA.n226 3.4105
R2596 GndA.n262 GndA.n261 3.4105
R2597 GndA.n264 GndA.n263 3.4105
R2598 GndA.n266 GndA.n265 3.4105
R2599 GndA.n268 GndA.n267 3.4105
R2600 GndA.n221 GndA.n217 3.4105
R2601 GndA.n1368 GndA.n18 3.4105
R2602 GndA.n1367 GndA.n1366 3.4105
R2603 GndA.n20 GndA.n19 3.4105
R2604 GndA.n1359 GndA.n1358 3.4105
R2605 GndA.n23 GndA.n22 3.4105
R2606 GndA.n241 GndA.n240 3.4105
R2607 GndA.n243 GndA.n242 3.4105
R2608 GndA.n238 GndA.n237 3.4105
R2609 GndA.n1365 GndA.n17 3.4105
R2610 GndA.n1364 GndA.n1363 3.4105
R2611 GndA.n1361 GndA.n1360 3.4105
R2612 GndA.n239 GndA.n21 3.4105
R2613 GndA.n245 GndA.n244 3.4105
R2614 GndA.n258 GndA.n257 3.4105
R2615 GndA.n260 GndA.n259 3.4105
R2616 GndA.n229 GndA.n225 3.4105
R2617 GndA.n218 GndA.n216 3.4105
R2618 GndA.n270 GndA.n269 3.4105
R2619 GndA.n897 GndA.n896 3.01552
R2620 GndA.n1106 GndA.n939 3.01552
R2621 GndA.n1333 GndA.n36 3.01552
R2622 GndA.n782 GndA.n575 3.01552
R2623 GndA.n899 GndA.n898 2.31669
R2624 GndA.n1338 GndA.n1337 2.31669
R2625 GndA.n774 GndA.n772 2.31669
R2626 GndA.n308 GndA.n198 2.31669
R2627 GndA.n317 GndA.n313 2.19479
R2628 GndA.n906 GndA.n313 2.19479
R2629 GndA.n1346 GndA.n32 2.19479
R2630 GndA.n1339 GndA.n32 2.19479
R2631 GndA.n1354 GndA.n1353 2.19479
R2632 GndA.n1354 GndA.n25 2.19479
R2633 GndA.n918 GndA.n917 2.19479
R2634 GndA.n918 GndA.n305 2.19479
R2635 GndA.n1167 GndA.n1166 2.18439
R2636 GndA.n1167 GndA.n158 2.18439
R2637 GndA.n1200 GndA.n1199 2.18439
R2638 GndA.n1199 GndA.n147 2.18439
R2639 GndA.n882 GndA.n881 2.18439
R2640 GndA.n882 GndA.n336 2.18439
R2641 GndA.n728 GndA.n705 2.18439
R2642 GndA.n729 GndA.n728 2.18439
R2643 GndA.n485 GndA.n484 2.12326
R2644 GndA.n1323 GndA.n1322 2.12326
R2645 GndA.n764 GndA.n763 2.12326
R2646 GndA.n1098 GndA.n942 2.12326
R2647 GndA.n707 GndA.n706 1.95505
R2648 GndA.n1170 GndA.n148 1.95505
R2649 GndA.n79 GndA.n72 1.64569
R2650 GndA.n819 GndA.n551 1.64569
R2651 GndA.n963 GndA.n957 1.64569
R2652 GndA.n848 GndA.n847 1.64569
R2653 GndA.n1168 GndA.n1167 1.17454
R2654 GndA.n1199 GndA.n1198 1.17454
R2655 GndA.n883 GndA.n882 1.17454
R2656 GndA.n728 GndA.n727 1.17454
R2657 GndA.n1171 GndA.n1170 1.06757
R2658 GndA.n1170 GndA.n1169 1.06757
R2659 GndA.n707 GndA.n335 1.06641
R2660 GndA.n708 GndA.n707 1.06641
R2661 GndA.n717 GndA.n24 1.01394
R2662 GndA.n894 GndA.n893 1.01394
R2663 GndA.n1188 GndA.n40 1.01394
R2664 GndA.n937 GndA.n936 1.01394
R2665 GndA.n211 GndA.n208 0.990802
R2666 GndA.n253 GndA.n252 0.990802
R2667 GndA.n726 GndA.n725 0.919889
R2668 GndA.n892 GndA.n884 0.919889
R2669 GndA.n1197 GndA.n1196 0.919889
R2670 GndA.n927 GndA.n157 0.919889
R2671 GndA.n208 GndA.n207 0.88078
R2672 GndA.n252 GndA.n251 0.88078
R2673 GndA.n212 GndA.n211 0.879703
R2674 GndA.n254 GndA.n253 0.879703
R2675 GndA.n1188 GndA.n1187 0.7505
R2676 GndA.n936 GndA.n935 0.7505
R2677 GndA.n725 GndA.n724 0.563
R2678 GndA.n892 GndA.n891 0.563
R2679 GndA.n1196 GndA.n1195 0.563
R2680 GndA.n927 GndA.n926 0.563
R2681 GndA.n326 GndA.n313 0.517167
R2682 GndA.n222 GndA.n32 0.517167
R2683 GndA.n1355 GndA.n1354 0.517167
R2684 GndA.n919 GndA.n918 0.517167
R2685 GndA.n1334 GndA.n1333 0.392519
R2686 GndA.n783 GndA.n782 0.392519
R2687 GndA.n15 GndA.n14 0.392504
R2688 GndA.n1370 GndA.n1369 0.392504
R2689 GndA.n896 GndA.n895 0.392167
R2690 GndA.n939 GndA.n938 0.392167
R2691 GndA.n896 GndA.n321 0.390682
R2692 GndA.n940 GndA.n939 0.390682
R2693 GndA.n1333 GndA.n1332 0.39033
R2694 GndA.n782 GndA.n781 0.39033
R2695 GndA.n1378 GndA.n1377 0.3805
R2696 GndA.n1386 GndA.n1 0.3805
R2697 GndA.n1397 GndA.n1396 0.3805
R2698 GndA.n290 GndA.n289 0.3805
R2699 GndA.n287 GndA.n204 0.3805
R2700 GndA.n286 GndA.n285 0.3805
R2701 GndA.n1373 GndA.n1372 0.3805
R2702 GndA.n1362 GndA.n16 0.3805
R2703 GndA.n249 GndA.n248 0.3805
R2704 GndA.n246 GndA.n230 0.3805
R2705 GndA.n228 GndA.n214 0.3805
R2706 GndA.n272 GndA.n271 0.3805
R2707 GndA.n725 GndA.n717 0.373547
R2708 GndA.n893 GndA.n892 0.373547
R2709 GndA.n1196 GndA.n1188 0.373547
R2710 GndA.n936 GndA.n927 0.373547
R2711 GndA.n279 GndA.n278 0.33647
R2712 GndA.n220 GndA.n219 0.33647
R2713 GndA.n304 GndA.n303 0.321929
R2714 GndA.n325 GndA.n324 0.321929
R2715 GndA.n224 GndA.n223 0.321929
R2716 GndA.n1357 GndA.n1356 0.321929
R2717 GndA.n1169 GndA.n1168 0.214916
R2718 GndA.n1198 GndA.n1171 0.214916
R2719 GndA.n883 GndA.n335 0.214916
R2720 GndA.n727 GndA.n708 0.214916
R2721 GndA.n1241 GndA.n1228 0.19887
R2722 GndA.n1227 GndA.n1226 0.19887
R2723 GndA.n820 GndA.n550 0.19887
R2724 GndA.n670 GndA.n669 0.19887
R2725 GndA.n1012 GndA.n1000 0.19887
R2726 GndA.n999 GndA.n998 0.19887
R2727 GndA.n528 GndA.n379 0.19887
R2728 GndA.n509 GndA.n385 0.19887
R2729 GndA.n480 GndA.n321 0.196152
R2730 GndA.n484 GndA.n480 0.196152
R2731 GndA.n1242 GndA.n1241 0.196152
R2732 GndA.n1242 GndA.n1227 0.196152
R2733 GndA.n1226 GndA.n72 0.196152
R2734 GndA.n1335 GndA.n39 0.196152
R2735 GndA.n137 GndA.n39 0.196152
R2736 GndA.n138 GndA.n137 0.196152
R2737 GndA.n139 GndA.n138 0.196152
R2738 GndA.n139 GndA.n127 0.196152
R2739 GndA.n127 GndA.n126 0.196152
R2740 GndA.n126 GndA.n125 0.196152
R2741 GndA.n125 GndA.n98 0.196152
R2742 GndA.n118 GndA.n98 0.196152
R2743 GndA.n118 GndA.n117 0.196152
R2744 GndA.n117 GndA.n116 0.196152
R2745 GndA.n116 GndA.n100 0.196152
R2746 GndA.n108 GndA.n100 0.196152
R2747 GndA.n108 GndA.n107 0.196152
R2748 GndA.n107 GndA.n106 0.196152
R2749 GndA.n106 GndA.n102 0.196152
R2750 GndA.n102 GndA.n80 0.196152
R2751 GndA.n80 GndA.n79 0.196152
R2752 GndA.n1322 GndA.n41 0.196152
R2753 GndA.n1332 GndA.n41 0.196152
R2754 GndA.n781 GndA.n576 0.196152
R2755 GndA.n764 GndA.n576 0.196152
R2756 GndA.n540 GndA.n538 0.196152
R2757 GndA.n537 GndA.n536 0.196152
R2758 GndA.n820 GndA.n819 0.196152
R2759 GndA.n662 GndA.n550 0.196152
R2760 GndA.n669 GndA.n662 0.196152
R2761 GndA.n785 GndA.n784 0.196152
R2762 GndA.n785 GndA.n570 0.196152
R2763 GndA.n789 GndA.n570 0.196152
R2764 GndA.n790 GndA.n789 0.196152
R2765 GndA.n791 GndA.n790 0.196152
R2766 GndA.n791 GndA.n565 0.196152
R2767 GndA.n795 GndA.n565 0.196152
R2768 GndA.n796 GndA.n795 0.196152
R2769 GndA.n797 GndA.n796 0.196152
R2770 GndA.n797 GndA.n560 0.196152
R2771 GndA.n801 GndA.n560 0.196152
R2772 GndA.n802 GndA.n801 0.196152
R2773 GndA.n803 GndA.n802 0.196152
R2774 GndA.n803 GndA.n555 0.196152
R2775 GndA.n807 GndA.n555 0.196152
R2776 GndA.n808 GndA.n807 0.196152
R2777 GndA.n809 GndA.n808 0.196152
R2778 GndA.n809 GndA.n551 0.196152
R2779 GndA.n963 GndA.n962 0.196152
R2780 GndA.n962 GndA.n176 0.196152
R2781 GndA.n176 GndA.n175 0.196152
R2782 GndA.n175 GndA.n174 0.196152
R2783 GndA.n1126 GndA.n174 0.196152
R2784 GndA.n1127 GndA.n1126 0.196152
R2785 GndA.n1127 GndA.n1125 0.196152
R2786 GndA.n1125 GndA.n1124 0.196152
R2787 GndA.n1124 GndA.n1123 0.196152
R2788 GndA.n1123 GndA.n1122 0.196152
R2789 GndA.n1122 GndA.n1121 0.196152
R2790 GndA.n1121 GndA.n1120 0.196152
R2791 GndA.n1120 GndA.n1119 0.196152
R2792 GndA.n1119 GndA.n1118 0.196152
R2793 GndA.n1118 GndA.n1117 0.196152
R2794 GndA.n1117 GndA.n1116 0.196152
R2795 GndA.n1116 GndA.n1115 0.196152
R2796 GndA.n1115 GndA.n187 0.196152
R2797 GndA.n942 GndA.n941 0.196152
R2798 GndA.n941 GndA.n940 0.196152
R2799 GndA.n1013 GndA.n1012 0.196152
R2800 GndA.n1013 GndA.n999 0.196152
R2801 GndA.n998 GndA.n957 0.196152
R2802 GndA.n981 GndA.n979 0.196152
R2803 GndA.n978 GndA.n977 0.196152
R2804 GndA.n847 GndA.n379 0.196152
R2805 GndA.n528 GndA.n527 0.196152
R2806 GndA.n527 GndA.n385 0.196152
R2807 GndA.n849 GndA.n848 0.196152
R2808 GndA.n849 GndA.n372 0.196152
R2809 GndA.n853 GndA.n372 0.196152
R2810 GndA.n854 GndA.n853 0.196152
R2811 GndA.n855 GndA.n854 0.196152
R2812 GndA.n855 GndA.n363 0.196152
R2813 GndA.n859 GndA.n363 0.196152
R2814 GndA.n860 GndA.n859 0.196152
R2815 GndA.n861 GndA.n860 0.196152
R2816 GndA.n861 GndA.n356 0.196152
R2817 GndA.n865 GndA.n356 0.196152
R2818 GndA.n866 GndA.n865 0.196152
R2819 GndA.n867 GndA.n866 0.196152
R2820 GndA.n867 GndA.n355 0.196152
R2821 GndA.n462 GndA.n355 0.196152
R2822 GndA.n462 GndA.n461 0.196152
R2823 GndA.n461 GndA.n460 0.196152
R2824 GndA.n460 GndA.n322 0.196152
R2825 GndA.n895 GndA.n894 0.16137
R2826 GndA.n1334 GndA.n40 0.16137
R2827 GndA.n783 GndA.n24 0.16137
R2828 GndA.n938 GndA.n937 0.16137
R2829 GndA.n1186 GndA.n1181 0.14915
R2830 GndA.n931 GndA.n928 0.14915
R2831 GndA.n236 GndA.n235 0.134429
R2832 GndA.n235 GndA.n234 0.134429
R2833 GndA GndA.n209 0.134429
R2834 GndA.n210 GndA 0.134429
R2835 GndA.n157 GndA.n156 0.123675
R2836 GndA.n1197 GndA.n1179 0.123675
R2837 GndA.n884 GndA.n334 0.123675
R2838 GndA.n726 GndA.n716 0.123675
R2839 GndA.n706 GndA.n538 0.0983261
R2840 GndA.n706 GndA.n537 0.0983261
R2841 GndA.n979 GndA.n148 0.0983261
R2842 GndA.n978 GndA.n148 0.0983261
R2843 GndA.n288 GndA 0.089089
R2844 GndA.n223 GndA 0.0768037
R2845 GndA.n1356 GndA 0.0768037
R2846 GndA.n304 GndA.n199 0.0758528
R2847 GndA.n325 GndA.n323 0.0758528
R2848 GndA.n723 GndA.n720 0.0708125
R2849 GndA.n888 GndA.n885 0.0708125
R2850 GndA.n1194 GndA.n1191 0.0708125
R2851 GndA.n923 GndA.n920 0.0708125
R2852 GndA.n1187 GndA.n1186 0.0678828
R2853 GndA.n935 GndA.n928 0.0678828
R2854 GndA.n156 GndA.n149 0.0661934
R2855 GndA.n152 GndA.n149 0.0661934
R2856 GndA.n1175 GndA.n1172 0.0661934
R2857 GndA.n1179 GndA.n1172 0.0661934
R2858 GndA.n334 GndA.n327 0.0661934
R2859 GndA.n330 GndA.n327 0.0661934
R2860 GndA.n712 GndA.n709 0.0661934
R2861 GndA.n716 GndA.n709 0.0661934
R2862 GndA.n540 GndA.n539 0.0657174
R2863 GndA.n536 GndA 0.0657174
R2864 GndA.n981 GndA.n980 0.0657174
R2865 GndA.n977 GndA.n976 0.0657174
R2866 GndA.n894 GndA.n326 0.059875
R2867 GndA.n222 GndA.n40 0.059875
R2868 GndA.n1355 GndA.n24 0.059875
R2869 GndA.n937 GndA.n919 0.059875
R2870 GndA.n152 GndA.n151 0.0579818
R2871 GndA.n1175 GndA.n1174 0.0579818
R2872 GndA.n330 GndA.n329 0.0579818
R2873 GndA.n712 GndA.n711 0.0579818
R2874 GndA.n296 GndA.n206 0.0574697
R2875 GndA.n301 GndA.n202 0.0574697
R2876 GndA.n11 GndA.n9 0.0574697
R2877 GndA.n1393 GndA.n5 0.0574697
R2878 GndA.n1359 GndA.n20 0.0574697
R2879 GndA.n243 GndA.n240 0.0574697
R2880 GndA.n231 GndA.n227 0.0574697
R2881 GndA.n265 GndA.n264 0.0574697
R2882 GndA.n282 GndA.n277 0.0553333
R2883 GndA.n1384 GndA.n1383 0.0553333
R2884 GndA.n1366 GndA.n1364 0.0553333
R2885 GndA.n268 GndA.n218 0.0553333
R2886 GndA.n1374 GndA.n0 0.0546794
R2887 GndA.n273 GndA.n0 0.0546794
R2888 GndA.n292 GndA.n213 0.0524848
R2889 GndA.n1394 GndA.n4 0.0524848
R2890 GndA.n244 GndA.n238 0.0524848
R2891 GndA.n257 GndA.n256 0.0524848
R2892 GndA.n293 GndA.n212 0.0505
R2893 GndA.n294 GndA.n293 0.0505
R2894 GndA.n295 GndA.n294 0.0505
R2895 GndA.n295 GndA.n201 0.0505
R2896 GndA.n302 GndA.n201 0.0505
R2897 GndA.n281 GndA.n200 0.0505
R2898 GndA.n281 GndA.n280 0.0505
R2899 GndA.n280 GndA.n279 0.0505
R2900 GndA.n1381 GndA.n15 0.0505
R2901 GndA.n1382 GndA.n1381 0.0505
R2902 GndA.n1382 GndA.n13 0.0505
R2903 GndA.n1390 GndA.n7 0.0505
R2904 GndA.n1391 GndA.n1390 0.0505
R2905 GndA.n1392 GndA.n1391 0.0505
R2906 GndA.n1392 GndA.n6 0.0505
R2907 GndA.n207 GndA.n6 0.0505
R2908 GndA.n255 GndA.n254 0.0505
R2909 GndA.n255 GndA.n233 0.0505
R2910 GndA.n233 GndA.n226 0.0505
R2911 GndA.n262 GndA.n226 0.0505
R2912 GndA.n263 GndA.n262 0.0505
R2913 GndA.n267 GndA.n266 0.0505
R2914 GndA.n267 GndA.n221 0.0505
R2915 GndA.n221 GndA.n220 0.0505
R2916 GndA.n1370 GndA.n1368 0.0505
R2917 GndA.n1368 GndA.n1367 0.0505
R2918 GndA.n1367 GndA.n19 0.0505
R2919 GndA.n1358 GndA.n23 0.0505
R2920 GndA.n241 GndA.n23 0.0505
R2921 GndA.n242 GndA.n241 0.0505
R2922 GndA.n242 GndA.n237 0.0505
R2923 GndA.n251 GndA.n237 0.0505
R2924 GndA.n276 GndA.n274 0.0453636
R2925 GndA.n1380 GndA.n1379 0.0453636
R2926 GndA.n1371 GndA.n18 0.0453636
R2927 GndA.n217 GndA.n215 0.0453636
R2928 GndA.n297 GndA.n203 0.0410909
R2929 GndA.n1389 GndA.n8 0.0410909
R2930 GndA.n239 GndA.n22 0.0410909
R2931 GndA.n261 GndA.n260 0.0410909
R2932 GndA.n247 GndA.n0 0.0401794
R2933 GndA.n300 GndA.n203 0.0382424
R2934 GndA.n1389 GndA.n1388 0.0382424
R2935 GndA.n1360 GndA.n22 0.0382424
R2936 GndA.n261 GndA.n225 0.0382424
R2937 GndA.n286 GndA.n273 0.0376687
R2938 GndA.n1374 GndA.n1373 0.0376687
R2939 GndA.n273 GndA.n272 0.0376687
R2940 GndA.n223 GndA.n222 0.0375399
R2941 GndA.n1356 GndA.n1355 0.0375399
R2942 GndA.n1168 GndA.n157 0.0351715
R2943 GndA.n1198 GndA.n1197 0.0351715
R2944 GndA.n884 GndA.n883 0.0351715
R2945 GndA.n727 GndA.n726 0.0351715
R2946 GndA.n724 GndA.n723 0.0346797
R2947 GndA.n891 GndA.n885 0.0346797
R2948 GndA.n1195 GndA.n1194 0.0346797
R2949 GndA.n926 GndA.n920 0.0346797
R2950 GndA.n283 GndA.n276 0.0339697
R2951 GndA.n1380 GndA.n12 0.0339697
R2952 GndA.n1365 GndA.n18 0.0339697
R2953 GndA.n269 GndA.n217 0.0339697
R2954 GndA.n1399 GndA.n1398 0.0295
R2955 GndA.n1376 GndA.n1374 0.0288048
R2956 GndA.n303 GndA.n302 0.027375
R2957 GndA.n324 GndA.n7 0.027375
R2958 GndA.n263 GndA.n224 0.027375
R2959 GndA.n1358 GndA.n1357 0.027375
R2960 GndA.n292 GndA.n291 0.0268485
R2961 GndA.n4 GndA.n2 0.0268485
R2962 GndA.n250 GndA.n238 0.0268485
R2963 GndA.n256 GndA.n232 0.0268485
R2964 GndA.n326 GndA.n325 0.0262812
R2965 GndA.n919 GndA.n304 0.0262812
R2966 GndA.n283 GndA.n282 0.024
R2967 GndA.n1383 GndA.n12 0.024
R2968 GndA.n1366 GndA.n1365 0.024
R2969 GndA.n269 GndA.n268 0.024
R2970 GndA.n303 GndA.n200 0.023625
R2971 GndA.n324 GndA.n13 0.023625
R2972 GndA.n266 GndA.n224 0.023625
R2973 GndA.n1357 GndA.n19 0.023625
R2974 GndA.n301 GndA.n300 0.0197273
R2975 GndA.n1388 GndA.n9 0.0197273
R2976 GndA.n1360 GndA.n1359 0.0197273
R2977 GndA.n264 GndA.n225 0.0197273
R2978 GndA.n1398 GndA.n1397 0.0185505
R2979 GndA.n289 GndA.n288 0.0185505
R2980 GndA.n248 GndA.n247 0.0185505
R2981 GndA.n247 GndA.n246 0.0185505
R2982 GndA.n297 GndA.n296 0.0168788
R2983 GndA.n8 GndA.n5 0.0168788
R2984 GndA.n240 GndA.n239 0.0168788
R2985 GndA.n260 GndA.n227 0.0168788
R2986 GndA.n1335 GndA.n1334 0.0168043
R2987 GndA.n784 GndA.n783 0.0168043
R2988 GndA.n1182 GndA.n1181 0.0168043
R2989 GndA.n938 GndA.n187 0.0168043
R2990 GndA.n931 GndA.n930 0.0168043
R2991 GndA.n895 GndA.n322 0.0168043
R2992 GndA.n298 GndA.n205 0.0158869
R2993 GndA.n299 GndA.n298 0.0158869
R2994 GndA.n284 GndA.n275 0.0158869
R2995 GndA.n1385 GndA.n10 0.0158869
R2996 GndA.n1387 GndA.n3 0.0158869
R2997 GndA.n1395 GndA.n3 0.0158869
R2998 GndA.n1363 GndA.n17 0.0158869
R2999 GndA.n1361 GndA.n21 0.0158869
R3000 GndA.n245 GndA.n21 0.0158869
R3001 GndA.n259 GndA.n258 0.0158869
R3002 GndA.n259 GndA.n229 0.0158869
R3003 GndA.n270 GndA.n216 0.0158869
R3004 GndA.n275 GndA.n204 0.0151875
R3005 GndA.n285 GndA.n284 0.0151875
R3006 GndA.n1378 GndA.n10 0.0151875
R3007 GndA.n1386 GndA.n1385 0.0151875
R3008 GndA.n1372 GndA.n17 0.0151875
R3009 GndA.n1363 GndA.n1362 0.0151875
R3010 GndA.n228 GndA.n216 0.0151875
R3011 GndA.n271 GndA.n270 0.0151875
R3012 GndA.n1376 GndA.n1375 0.015
R3013 GndA.n290 GndA.n205 0.0137887
R3014 GndA.n1396 GndA.n1395 0.0137887
R3015 GndA.n249 GndA.n245 0.0137887
R3016 GndA.n258 GndA.n230 0.0137887
R3017 GndA.n720 GndA.n719 0.0122188
R3018 GndA.n888 GndA.n887 0.0122188
R3019 GndA.n1191 GndA.n1190 0.0122188
R3020 GndA.n923 GndA.n922 0.0122188
R3021 GndA.n1377 GndA.n1376 0.00936387
R3022 GndA.n1377 GndA.n1 0.00844521
R3023 GndA.n1397 GndA.n1 0.00844521
R3024 GndA.n289 GndA.n287 0.00844521
R3025 GndA.n287 GndA.n286 0.00844521
R3026 GndA.n1373 GndA.n16 0.00844521
R3027 GndA.n248 GndA.n16 0.00844521
R3028 GndA.n246 GndA.n214 0.00844521
R3029 GndA.n272 GndA.n214 0.00844521
R3030 GndA.n1398 GndA.n0 0.00841594
R3031 GndA.n288 GndA.n0 0.00841594
R3032 GndA.n213 GndA.n206 0.00548485
R3033 GndA.n1394 GndA.n1393 0.00548485
R3034 GndA.n244 GndA.n243 0.00548485
R3035 GndA.n257 GndA.n231 0.00548485
R3036 GndA.n277 GndA.n202 0.00263636
R3037 GndA.n1384 GndA.n11 0.00263636
R3038 GndA.n1364 GndA.n20 0.00263636
R3039 GndA.n265 GndA.n218 0.00263636
R3040 GndA.n299 GndA.n204 0.0011994
R3041 GndA.n1387 GndA.n1386 0.0011994
R3042 GndA.n1362 GndA.n1361 0.0011994
R3043 GndA.n229 GndA.n228 0.0011994
R3044 openDVS_pixel_1.DiffBn openDVS_pixel_1.DiffBn.t0 75.4171
R3045 openDVS_pixel_1.vpr.n0 openDVS_pixel_1.vpr.t1 242.743
R3046 openDVS_pixel_1.vpr openDVS_pixel_1.vpr.n0 9.46888
R3047 openDVS_pixel_1.vpr openDVS_pixel_1.vpr.n1 0.00496429
R3048 openDVS_pixel_1.vpr.n1 openDVS_pixel_1.vpr.t3 270.712
R3049 openDVS_pixel_1.vpr.n1 openDVS_pixel_1.vpr.t0 653.798
R3050 openDVS_pixel_1.vpr.n0 openDVS_pixel_1.vpr.t2 264.62
R3051 openDVS_pixel_2.vpr.t0 openDVS_pixel_2.vpr 918.417
R3052 openDVS_pixel_1.vsf openDVS_pixel_1.vsf.n0 665.438
R3053 openDVS_pixel_1.vsf.n0 openDVS_pixel_1.vsf.t0 8.57829
R3054 openDVS_pixel_1.vsf.t0 openDVS_pixel_1.vsf.t1 0.428845
R3055 openDVS_pixel_1.vsf.n0 openDVS_pixel_1.vsf.t2 665.676
R3056 openDVS_pixel_2.vsf openDVS_pixel_2.vsf.n0 665.438
R3057 openDVS_pixel_2.vsf.n0 openDVS_pixel_2.vsf.t2 8.57829
R3058 openDVS_pixel_2.vsf.t2 openDVS_pixel_2.vsf.t1 0.428845
R3059 openDVS_pixel_2.vsf.n0 openDVS_pixel_2.vsf.t0 665.676
R3060 a_1070_n607# a_1070_n607.t0 142.857
R3061 openDVS_pixel_1.nRst.t0 openDVS_pixel_1.nRst.n3 664.658
R3062 openDVS_pixel_1.nRst openDVS_pixel_1.nRst.n3 1.063
R3063 openDVS_pixel_1.nRst openDVS_pixel_1.nRst.t3 86.4791
R3064 openDVS_pixel_1.nRst.n3 openDVS_pixel_1.nRst.n2 0.220328
R3065 openDVS_pixel_1.nRst.n2 openDVS_pixel_1.nRst.n0 20.2665
R3066 openDVS_pixel_1.nRst.n0 openDVS_pixel_1.nRst.n1 0.0586897
R3067 openDVS_pixel_1.nRst.n0 openDVS_pixel_1.nRst.t1 237.157
R3068 openDVS_pixel_1.nRst.n2 openDVS_pixel_1.nRst.t2 233.317
R3069 a_n3520_n607# a_n3520_n607.t0 142.857
R3070 openDVS_pixel_2.nRst.n3 openDVS_pixel_2.nRst.t0 664.658
R3071 openDVS_pixel_2.nRst.n2 openDVS_pixel_2.nRst.n3 1.063
R3072 openDVS_pixel_2.nRst.n2 openDVS_pixel_2.nRst.t3 86.4788
R3073 openDVS_pixel_2.nRst.n3 openDVS_pixel_2.nRst.n1 0.220328
R3074 openDVS_pixel_2.nRst.n1 openDVS_pixel_2.nRst.n0 20.2665
R3075 openDVS_pixel_2.nRst.n0 openDVS_pixel_2.nRst 0.0586897
R3076 openDVS_pixel_2.nRst.n0 openDVS_pixel_2.nRst.t1 237.157
R3077 openDVS_pixel_2.nRst.n1 openDVS_pixel_2.nRst.t2 233.317
R3078 a_788_n281# a_788_n281.t0 142.857
R3079 a_528_n281# a_528_n281.t0 142.857
R3080 openDVS_pixel_1.ON openDVS_pixel_1.ON.t0 235.186
R3081 openDVS_pixel_1.ON openDVS_pixel_1.ON.n0 3.84612
R3082 openDVS_pixel_1.ON.n0 openDVS_pixel_1.ON.t2 322.777
R3083 openDVS_pixel_1.ON.n0 openDVS_pixel_1.ON.t1 111.662
R3084 openDVS_pixel_1.nOFF.t0 openDVS_pixel_1.nOFF.n0 102.439
R3085 openDVS_pixel_1.nOFF.n1 openDVS_pixel_1.nOFF.n0 4.30407
R3086 openDVS_pixel_1.nOFF openDVS_pixel_1.nOFF.n1 0.0249565
R3087 openDVS_pixel_1.nOFF.n1 openDVS_pixel_1.nOFF.t1 235.626
R3088 openDVS_pixel_1.nOFF.n0 openDVS_pixel_1.nOFF.t2 376.247
R3089 a_n2994_n281# a_n2994_n281.t0 142.857
R3090 a_n3254_n281# a_n3254_n281.t0 142.857
R3091 openDVS_pixel_1.vdiff.t0 openDVS_pixel_1.vdiff 803.622
R3092 openDVS_pixel_1.vd.t0 openDVS_pixel_1.vd.n5 664.658
R3093 openDVS_pixel_1.vd.n4 openDVS_pixel_1.vd.n5 0.0177414
R3094 openDVS_pixel_1.vd.n5 openDVS_pixel_1.vd.n0 16.0549
R3095 openDVS_pixel_1.vd.n0 openDVS_pixel_1.vd.t1 1.1255
R3096 openDVS_pixel_1.vd.n1 openDVS_pixel_1.vd.t3 1.1255
R3097 openDVS_pixel_1.vd.n2 openDVS_pixel_1.vd.t2 1.1255
R3098 openDVS_pixel_1.vd.n2 openDVS_pixel_1.vd.n1 0.152681
R3099 openDVS_pixel_1.vd.n0 openDVS_pixel_1.vd.n2 0.748059
R3100 openDVS_pixel_1.vd openDVS_pixel_1.vd.n3 0.0577992
R3101 openDVS_pixel_1.vd.n1 openDVS_pixel_1.vd.n3 13.5756
R3102 openDVS_pixel_1.vd.n3 openDVS_pixel_1.vd.t4 86.2106
R3103 openDVS_pixel_2.vd.n5 openDVS_pixel_2.vd.t0 664.658
R3104 openDVS_pixel_2.vd.n4 openDVS_pixel_2.vd.n5 0.0177414
R3105 openDVS_pixel_2.vd.n5 openDVS_pixel_2.vd.n0 16.0549
R3106 openDVS_pixel_2.vd.n0 openDVS_pixel_2.vd.t1 1.1255
R3107 openDVS_pixel_2.vd.n1 openDVS_pixel_2.vd.t3 1.1255
R3108 openDVS_pixel_2.vd.n2 openDVS_pixel_2.vd.t2 1.1255
R3109 openDVS_pixel_2.vd.n0 openDVS_pixel_2.vd.n1 0.748544
R3110 openDVS_pixel_2.vd.n1 openDVS_pixel_2.vd.n2 0.152681
R3111 openDVS_pixel_2.vd.n3 openDVS_pixel_2.vd 0.0577992
R3112 openDVS_pixel_2.vd.n3 openDVS_pixel_2.vd.t4 86.211
R3113 openDVS_pixel_2.vd.n2 openDVS_pixel_2.vd.n3 13.5756
R3114 openDVS_pixel_2.vdiff.t2 openDVS_pixel_2.vdiff.n5 687.544
R3115 openDVS_pixel_2.vdiff.n4 openDVS_pixel_2.vdiff.n5 4.5005
R3116 openDVS_pixel_2.vdiff.n5 openDVS_pixel_2.vdiff.n6 1.38709
R3117 openDVS_pixel_2.vdiff.n6 openDVS_pixel_2.vdiff.t3 116.109
R3118 openDVS_pixel_2.vdiff.n6 openDVS_pixel_2.vdiff.t0 3.51784
R3119 openDVS_pixel_2.vdiff openDVS_pixel_2.vdiff.n4 0.157047
R3120 openDVS_pixel_2.vdiff openDVS_pixel_2.vdiff.t1 235.643
R3121 openDVS_pixel_2.vdiff.n2 openDVS_pixel_2.vdiff.n3 0.00530769
R3122 openDVS_pixel_2.vdiff.n3 openDVS_pixel_2.vdiff.n0 0.111077
R3123 openDVS_pixel_2.vdiff.n4 openDVS_pixel_2.vdiff.n0 1.51126
R3124 openDVS_pixel_2.vdiff.n2 openDVS_pixel_2.vdiff.t5 87.4114
R3125 openDVS_pixel_2.vdiff.n0 openDVS_pixel_2.vdiff.n1 15.6111
R3126 openDVS_pixel_2.vdiff.n1 openDVS_pixel_2.vdiff.n2 27.537
R3127 openDVS_pixel_2.vdiff.n1 openDVS_pixel_2.vdiff.t4 76.2275
R3128 a_788_125# a_788_125.t0 142.857
R3129 a_528_125# a_528_125.t0 142.857
R3130 openDVS_pixel_2.nOFF.t0 openDVS_pixel_2.nOFF.n0 102.439
R3131 openDVS_pixel_2.nOFF.n1 openDVS_pixel_2.nOFF.n0 4.30407
R3132 openDVS_pixel_2.nOFF openDVS_pixel_2.nOFF.n1 0.0249565
R3133 openDVS_pixel_2.nOFF.n1 openDVS_pixel_2.nOFF.t1 235.626
R3134 openDVS_pixel_2.nOFF.n0 openDVS_pixel_2.nOFF.t2 376.247
R3135 openDVS_pixel_2.ON.n0 openDVS_pixel_2.ON.t0 111.662
R3136 openDVS_pixel_2.ON openDVS_pixel_2.ON.n0 3.84613
R3137 openDVS_pixel_2.ON openDVS_pixel_2.ON.t1 235.186
R3138 openDVS_pixel_2.ON.n0 openDVS_pixel_2.ON.t2 322.777
R3139 a_n2994_125# a_n2994_125.t0 142.857
R3140 a_n3254_125# a_n3254_125.t0 142.857
R3141 a_1070_435# a_1070_435.t0 142.857
R3142 openDVS_pixel_3.nOFF.n0 openDVS_pixel_3.nOFF.t0 102.439
R3143 openDVS_pixel_3.nOFF.n1 openDVS_pixel_3.nOFF.n0 4.30407
R3144 openDVS_pixel_3.nOFF.n1 openDVS_pixel_3.nOFF.t1 235.626
R3145 openDVS_pixel_3.nOFF openDVS_pixel_3.nOFF.n1 0.0249565
R3146 openDVS_pixel_3.nOFF.n0 openDVS_pixel_3.nOFF.t2 376.247
R3147 openDVS_pixel_3.ON.t0 openDVS_pixel_3.ON 235.186
R3148 openDVS_pixel_3.ON openDVS_pixel_3.ON.n0 3.84612
R3149 openDVS_pixel_3.ON.n0 openDVS_pixel_3.ON.t1 111.662
R3150 openDVS_pixel_3.ON.n0 openDVS_pixel_3.ON.t2 322.777
R3151 a_n3520_435# a_n3520_435.t0 142.857
R3152 openDVS_pixel_3.vsf openDVS_pixel_3.vsf.n0 665.438
R3153 openDVS_pixel_3.vsf.n0 openDVS_pixel_3.vsf.t2 8.57829
R3154 openDVS_pixel_3.vsf.t2 openDVS_pixel_3.vsf.t1 0.428845
R3155 openDVS_pixel_3.vsf.n0 openDVS_pixel_3.vsf.t0 665.676
R3156 openDVS_pixel_0.vsf openDVS_pixel_0.vsf.n0 665.438
R3157 openDVS_pixel_0.vsf.n0 openDVS_pixel_0.vsf.t1 8.57829
R3158 openDVS_pixel_0.vsf.t1 openDVS_pixel_0.vsf.t2 0.428845
R3159 openDVS_pixel_0.vsf.n0 openDVS_pixel_0.vsf.t0 665.676
R3160 openDVS_pixel_0.nOFF.n0 openDVS_pixel_0.nOFF.t0 102.439
R3161 openDVS_pixel_0.nOFF.n1 openDVS_pixel_0.nOFF.n0 4.30407
R3162 openDVS_pixel_0.nOFF.n1 openDVS_pixel_0.nOFF.t1 235.626
R3163 openDVS_pixel_0.nOFF openDVS_pixel_0.nOFF.n1 0.0249565
R3164 openDVS_pixel_0.nOFF.n0 openDVS_pixel_0.nOFF.t2 376.247
R3165 openDVS_pixel_0.ON.t0 openDVS_pixel_0.ON 235.186
R3166 openDVS_pixel_0.ON openDVS_pixel_0.ON.n0 3.84612
R3167 openDVS_pixel_0.ON.n0 openDVS_pixel_0.ON.t1 111.662
R3168 openDVS_pixel_0.ON.n0 openDVS_pixel_0.ON.t2 322.777
R3169 DiffBn DiffBn.t0 204.851
R3170 openDVS_pixel_3.vpr.n0 openDVS_pixel_3.vpr.t1 242.743
R3171 openDVS_pixel_3.vpr openDVS_pixel_3.vpr.n1 0.00496429
R3172 openDVS_pixel_3.vpr openDVS_pixel_3.vpr.n0 9.46888
R3173 openDVS_pixel_3.vpr.n1 openDVS_pixel_3.vpr.t2 270.712
R3174 openDVS_pixel_3.vpr.n1 openDVS_pixel_3.vpr.t0 653.798
R3175 openDVS_pixel_3.vpr.n0 openDVS_pixel_3.vpr.t3 264.62
R3176 openDVS_pixel_3.vd.t0 openDVS_pixel_3.vd.n5 664.658
R3177 openDVS_pixel_3.vd.n4 openDVS_pixel_3.vd.n5 0.0177414
R3178 openDVS_pixel_3.vd.n5 openDVS_pixel_3.vd.n0 16.0549
R3179 openDVS_pixel_3.vd.n0 openDVS_pixel_3.vd.t3 1.1255
R3180 openDVS_pixel_3.vd.n1 openDVS_pixel_3.vd.t2 1.1255
R3181 openDVS_pixel_3.vd.n2 openDVS_pixel_3.vd.t1 1.1255
R3182 openDVS_pixel_3.vd.n1 openDVS_pixel_3.vd.n2 0.152681
R3183 openDVS_pixel_3.vd.n0 openDVS_pixel_3.vd.n1 0.748059
R3184 openDVS_pixel_3.vd openDVS_pixel_3.vd.n3 0.0577992
R3185 openDVS_pixel_3.vd.n2 openDVS_pixel_3.vd.n3 13.5756
R3186 openDVS_pixel_3.vd.n3 openDVS_pixel_3.vd.t4 86.211
R3187 openDVS_pixel_3.vdiff.t0 openDVS_pixel_3.vdiff 803.622
R3188 openDVS_pixel_0.vd.n5 openDVS_pixel_0.vd.t0 664.658
R3189 openDVS_pixel_0.vd.n4 openDVS_pixel_0.vd.n5 0.0177414
R3190 openDVS_pixel_0.vd.n5 openDVS_pixel_0.vd.n0 16.0549
R3191 openDVS_pixel_0.vd.n0 openDVS_pixel_0.vd.t3 1.1255
R3192 openDVS_pixel_0.vd.n1 openDVS_pixel_0.vd.t2 1.1255
R3193 openDVS_pixel_0.vd.n2 openDVS_pixel_0.vd.t1 1.1255
R3194 openDVS_pixel_0.vd.n0 openDVS_pixel_0.vd.n1 0.748544
R3195 openDVS_pixel_0.vd.n1 openDVS_pixel_0.vd.n2 0.152681
R3196 openDVS_pixel_0.vd.n3 openDVS_pixel_0.vd 0.0577992
R3197 openDVS_pixel_0.vd.n3 openDVS_pixel_0.vd.t4 86.2106
R3198 openDVS_pixel_0.vd.n2 openDVS_pixel_0.vd.n3 13.5756
R3199 openDVS_pixel_3.nRst.t0 openDVS_pixel_3.nRst.n3 664.658
R3200 openDVS_pixel_3.nRst.n2 openDVS_pixel_3.nRst.n3 1.063
R3201 openDVS_pixel_3.nRst.n2 openDVS_pixel_3.nRst.t2 86.4791
R3202 openDVS_pixel_3.nRst.n3 openDVS_pixel_3.nRst.n1 0.220328
R3203 openDVS_pixel_3.nRst.n1 openDVS_pixel_3.nRst.t3 233.317
R3204 openDVS_pixel_3.nRst.n1 openDVS_pixel_3.nRst.n0 20.2665
R3205 openDVS_pixel_3.nRst openDVS_pixel_3.nRst.n0 0.0586897
R3206 openDVS_pixel_3.nRst.n0 openDVS_pixel_3.nRst.t1 237.157
R3207 openDVS_pixel_0.nRst.n3 openDVS_pixel_0.nRst.t0 664.658
R3208 openDVS_pixel_0.nRst openDVS_pixel_0.nRst.n3 1.063
R3209 openDVS_pixel_0.nRst openDVS_pixel_0.nRst.t2 86.4788
R3210 openDVS_pixel_0.nRst.n3 openDVS_pixel_0.nRst.n2 0.220328
R3211 openDVS_pixel_0.nRst.n2 openDVS_pixel_0.nRst.t3 233.317
R3212 openDVS_pixel_0.nRst.n2 openDVS_pixel_0.nRst.n0 20.2665
R3213 openDVS_pixel_0.nRst.n1 openDVS_pixel_0.nRst.n0 0.0586897
R3214 openDVS_pixel_0.nRst.n0 openDVS_pixel_0.nRst.t1 237.157
R3215 openDVS_pixel_0.vdiff.t2 openDVS_pixel_0.vdiff.n5 687.544
R3216 openDVS_pixel_0.vdiff.n4 openDVS_pixel_0.vdiff.n5 4.5005
R3217 openDVS_pixel_0.vdiff.n5 openDVS_pixel_0.vdiff.n6 1.38709
R3218 openDVS_pixel_0.vdiff.n6 openDVS_pixel_0.vdiff.t3 116.109
R3219 openDVS_pixel_0.vdiff.n6 openDVS_pixel_0.vdiff.t0 3.51784
R3220 openDVS_pixel_0.vdiff.n3 openDVS_pixel_0.vdiff.t1 235.643
R3221 openDVS_pixel_0.vdiff.n3 openDVS_pixel_0.vdiff.n4 0.157047
R3222 openDVS_pixel_0.vdiff.n2 openDVS_pixel_0.vdiff 0.00530769
R3223 openDVS_pixel_0.vdiff openDVS_pixel_0.vdiff.n0 0.111077
R3224 openDVS_pixel_0.vdiff.n4 openDVS_pixel_0.vdiff.n0 1.51126
R3225 openDVS_pixel_0.vdiff.n2 openDVS_pixel_0.vdiff.t5 87.4111
R3226 openDVS_pixel_0.vdiff.n0 openDVS_pixel_0.vdiff.n1 15.6111
R3227 openDVS_pixel_0.vdiff.n1 openDVS_pixel_0.vdiff.n2 27.537
R3228 openDVS_pixel_0.vdiff.n1 openDVS_pixel_0.vdiff.t4 76.2275
R3229 openDVS_pixel_0.vpr.t0 openDVS_pixel_0.vpr 918.417
C605 readLine[1] GndA 2.51298f
C606 rowReadOFF[1] GndA 0.46579f
C607 rowReadON[1] GndA 1.11144f
C608 readLine[0] GndA 2.51229f
C609 GndD GndA 3.32665f
C610 rowReadOFF[0] GndA 0.46579f
C611 pixRst[1] GndA 1.13564f
C612 pixRst[0] GndA 1.13549f
C613 rowReadON[0] GndA 1.11144f
C614 RefrBp GndA 0.29579f
C615 PrSFBp GndA 0.33384f
C616 OffBn GndA 6.56245f
C617 PrBp GndA 0.33922f
C618 OnBn GndA 5.92126f
C619 DiffBn_uq1 GndA 4.14791f
C620 VddA18 GndA 67.8634f
C621 vpd[3] GndA 2.27475f
C622 vpd[1] GndA 2.27475f
C623 vpd[2] GndA 2.33462f
C624 vpd[0] GndA 2.33462f
C625 openDVS_pixel_1.DiffBn GndA 1.42188f $ **FLOATING
C626 openDVS_pixel_1.vpr GndA 0.58004f $ **FLOATING
C627 openDVS_pixel_2.vpr GndA 0.58003f $ **FLOATING
C628 openDVS_pixel_1.vsf GndA 2.08345f $ **FLOATING
C629 openDVS_pixel_2.vsf GndA 2.08345f $ **FLOATING
C630 a_1070_n607# GndA 0.00972f $ **FLOATING
C631 openDVS_pixel_1.nRst GndA 0.71895f $ **FLOATING
C632 a_n3520_n607# GndA 0.00972f $ **FLOATING
C633 openDVS_pixel_2.nRst GndA 0.71947f $ **FLOATING
C634 a_528_n281# GndA 0.00149f $ **FLOATING
C635 openDVS_pixel_1.ON GndA 0.80387f $ **FLOATING
C636 openDVS_pixel_1.nOFF GndA 1.18083f $ **FLOATING
C637 a_n2994_n281# GndA 0.00149f $ **FLOATING
C638 openDVS_pixel_1.vdiff GndA 2.05012f $ **FLOATING
C639 openDVS_pixel_1.vd GndA 4.29796f $ **FLOATING
C640 openDVS_pixel_2.vd GndA 4.29796f $ **FLOATING
C641 openDVS_pixel_2.vdiff GndA 2.04994f $ **FLOATING
C642 a_528_125# GndA 0.00149f $ **FLOATING
C643 openDVS_pixel_2.nOFF GndA 1.18083f $ **FLOATING
C644 openDVS_pixel_2.ON GndA 0.80387f $ **FLOATING
C645 a_n2994_125# GndA 0.00149f $ **FLOATING
C646 a_1070_435# GndA 0.00972f $ **FLOATING
C647 openDVS_pixel_3.nOFF GndA 1.18083f $ **FLOATING
C648 openDVS_pixel_3.ON GndA 0.8039f $ **FLOATING
C649 a_n3520_435# GndA 0.00972f $ **FLOATING
C650 openDVS_pixel_3.vsf GndA 2.1981f $ **FLOATING
C651 openDVS_pixel_0.vsf GndA 2.19811f $ **FLOATING
C652 openDVS_pixel_0.nOFF GndA 1.18083f $ **FLOATING
C653 openDVS_pixel_0.ON GndA 0.80389f $ **FLOATING
C654 DiffBn GndA 2.12323f $ **FLOATING
C655 openDVS_pixel_3.vpr GndA 1.33163f $ **FLOATING
C656 openDVS_pixel_3.vd GndA 4.3924f $ **FLOATING
C657 openDVS_pixel_3.vdiff GndA 2.12292f $ **FLOATING
C658 openDVS_pixel_0.vd GndA 4.39241f $ **FLOATING
C659 openDVS_pixel_3.nRst GndA 0.75741f $ **FLOATING
C660 openDVS_pixel_0.nRst GndA 0.75686f $ **FLOATING
C661 openDVS_pixel_0.vdiff GndA 2.12281f $ **FLOATING
C662 openDVS_pixel_0.vpr GndA 1.33163f $ **FLOATING
.ends
.subckt openDVS_pixel2x2 pixRst[1] pixRst[0] rowReadON[1] rowReadON[0] rowReadOFF[1]
+ rowReadOFF[0] readLine[1] readLine[0] vpd[3] vpd[2] vpd[1] vpd[0] VddA18 GndA GndD OnBn OffBn
+ DiffBn PrSFBp RefrBp PrBp
Xdiffbn_physical_core pixRst[1] pixRst[0] rowReadON[1] rowReadON[0] rowReadOFF[1] rowReadOFF[0]
+ readLine[1] readLine[0] vpd[3] vpd[2] vpd[1] vpd[0] VddA18 GndA GndD OnBn OffBn DiffBn DiffBn
+ DiffBn PrSFBp RefrBp PrBp openDVS_pixel2x2__diffbn_physical_core
.ends openDVS_pixel2x2
