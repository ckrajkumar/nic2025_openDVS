* RESET_APPARATUS exact-cace-reset-physical-photodiode-v2
* RESET_BASE_PATH magic_rcc_ngspice
* RESET_BASE_SHA256 f5f5392895a2447ab9915b6abbac6b9099c342876fc751300d046608d7d6549b
* Physical photodiodes retained; no artificial photodiode or vd DC paths
* NGSPICE file created from openDVS_pixel2x2_top.ext - technology: sky130A

.subckt openDVS_pixel2x2__diffbn_physical_core pixRst[1] pixRst[0] rowReadON[1] rowReadON[0]
+ rowReadOFF[1] rowReadOFF[0] readLine[1] readLine[0] vpd[3] vpd[2] vpd[1] vpd[0] VddA18 GndA
+ GndD OnBn OffBn DiffBn_uq1 DiffBn openDVS_pixel_1.DiffBn PrSFBp RefrBp PrBp
X0 GndA.t20 vpd[2].t1 openDVS_pixel_3.vpr.t1 GndA.t19 sky130_fd_pr__nfet_01v8 ad=0.126 pd=1.44 as=0.126 ps=1.44 w=0.42 l=0.3
X1 openDVS_pixel_2.nOFF.t0 OffBn.t1 GndA.t5 GndA.t4 sky130_fd_pr__nfet_01v8 ad=0.45 pd=3.6 as=0.45 ps=3.6 w=1.5 l=1.5
X2 GndA.t41 vpd[3].t1 openDVS_pixel_1.vpr.t1 GndA.t40 sky130_fd_pr__nfet_01v8 ad=0.126 pd=1.44 as=0.126 ps=1.44 w=0.42 l=0.3
X3 openDVS_pixel_1.vd.t0 openDVS_pixel_1.nRst.t2 openDVS_pixel_1.vdiff VddA18.t21 sky130_fd_pr__pfet_01v8_hvt ad=0.126 pd=1.44 as=0.126 ps=1.44 w=0.42 l=0.42
X4 openDVS_pixel_2.vd.t1 openDVS_pixel_2.vsf.t0 sky130_fd_pr__cap_mim_m3_1 l=1.505 w=6.47
X5 GndA.t46 OnBn.t2 openDVS_pixel_3.ON.t1 GndA.t0 sky130_fd_pr__nfet_01v8 ad=0.45 pd=3.6 as=0.45 ps=3.6 w=1.5 l=1.5
X6 a_n3254_125.t0 openDVS_pixel_0.ON.t2 GndD.t5 GndA.t12 sky130_fd_pr__nfet_01v8 ad=0.105 pd=0.92 as=0.126 ps=1.44 w=0.42 l=0.15
X7 openDVS_pixel_3.vd.t0 openDVS_pixel_3.nRst.t3 openDVS_pixel_3.vdiff VddA18.t21 sky130_fd_pr__pfet_01v8_hvt ad=0.126 pd=1.44 as=0.126 ps=1.44 w=0.42 l=0.42
X8 VddA18.t37 openDVS_pixel_2.vd.t4 openDVS_pixel_2.vdiff.t2 VddA18.t0 sky130_fd_pr__pfet_01v8 ad=0.225 pd=1.8 as=0.45 ps=3.6 w=1.5 l=1.5
X9 openDVS_pixel_2.ON.t0 OnBn.t1 GndA.t43 GndA.t42 sky130_fd_pr__nfet_01v8 ad=0.45 pd=3.6 as=0.45 ps=3.6 w=1.5 l=1.5
X10 readLine[0].t2 rowReadON[0].t1 a_n3254_125# GndA.t12 sky130_fd_pr__nfet_01v8 ad=0.105 pd=0.92 as=0.105 ps=0.92 w=0.42 l=0.15
X11 openDVS_pixel_3.vdiff.t0 openDVS_pixel_3.vd.t4 VddA18.t45 VddA18.t2 sky130_fd_pr__pfet_01v8 ad=0.45 pd=3.6 as=0.225 ps=1.8 w=1.5 l=1.5
X12 openDVS_pixel_1.vsf PrSFBp.t0 VddA18.t3 VddA18.t2 sky130_fd_pr__pfet_01v8_hvt ad=0.126 pd=1.44 as=0.063 ps=0.72 w=0.42 l=1.5
X13 VddA18.t29 openDVS_pixel_2.vpr vpd[1].t0 GndA.t32 sky130_fd_pr__nfet_01v8 ad=0.15 pd=1.6 as=0.15 ps=1.6 w=0.5 l=0.3
X14 vpd[3].t0 openDVS_pixel_1.vpr.t2 VddA18.t30 GndA.t33 sky130_fd_pr__nfet_01v8 ad=0.15 pd=1.6 as=0.15 ps=1.6 w=0.5 l=0.3
X15 GndA.t49 DiffBn.t0 openDVS_pixel_3.vdiff.t0 GndA.t48 sky130_fd_pr__nfet_01v8 ad=0.45 pd=3.6 as=0.45 ps=3.6 w=1.5 l=1.5
X16 VddA18.t13 RefrBp.t3 openDVS_pixel_0.nRst.t0 VddA18.t0 sky130_fd_pr__pfet_01v8 ad=0.063 pd=0.72 as=0.126 ps=1.44 w=0.42 l=1.5
X17 VddA18.t41 openDVS_pixel_0.vdiff.t5 openDVS_pixel_0.ON.t0 VddA18.t25 sky130_fd_pr__pfet_01v8 ad=0.225 pd=1.8 as=0.45 ps=3.6 w=1.5 l=1.5
X18 VddA18.t23 openDVS_pixel_1.nRst.t3 VddA18.t23 VddA18.t22 sky130_fd_pr__pfet_01v8 ad=0.45 pd=3.6 as=0 ps=0 w=1.5 l=1.5
X19 openDVS_pixel_3.vd.t1 openDVS_pixel_3.vsf.t2 sky130_fd_pr__cap_mim_m3_1 l=2.27 w=3.985
X20 openDVS_pixel_1.vd.t2 openDVS_pixel_1.vsf.t0 sky130_fd_pr__cap_mim_m3_1 l=2.27 w=3.985
D0 GndA.t39 vpd[3] sky130_fd_pr__model__parasitic__diode_ps2dn area=32.49 pj=22.8 m=1
X21 openDVS_pixel_3.vd.t2 openDVS_pixel_3.vdiff.t0 sky130_fd_pr__cap_mim_m3_1 l=1 w=1
X22 a_n2994_125.t0 rowReadOFF[0].t1 readLine[0].t1 GndA.t12 sky130_fd_pr__nfet_01v8 ad=0.105 pd=0.92 as=0.105 ps=0.92 w=0.42 l=0.15
X23 openDVS_pixel_3.vsf PrSFBp.t2 VddA18.t5 VddA18.t2 sky130_fd_pr__pfet_01v8_hvt ad=0.126 pd=1.44 as=0.063 ps=0.72 w=0.42 l=1.5
X24 GndD.t6 openDVS_pixel_0.nOFF.t2 a_n2994_125# GndA.t12 sky130_fd_pr__nfet_01v8 ad=0.126 pd=1.44 as=0.105 ps=0.92 w=0.42 l=0.15
X25 openDVS_pixel_1.ON.t0 openDVS_pixel_1.vdiff.t0 VddA18.t19 VddA18.t18 sky130_fd_pr__pfet_01v8 ad=0.45 pd=3.6 as=0.225 ps=1.8 w=1.5 l=1.5
X26 openDVS_pixel_1.nRst.t0 RefrBp.t0 VddA18.t15 VddA18.t2 sky130_fd_pr__pfet_01v8 ad=0.126 pd=1.44 as=0.063 ps=0.72 w=0.42 l=1.5
X27 openDVS_pixel_2.vd.t3 openDVS_pixel_2.vsf.t2 sky130_fd_pr__cap_mim_m3_1 l=2.27 w=3.985
X28 VddA18.t34 openDVS_pixel_0.vpr vpd[0].t0 GndA.t35 sky130_fd_pr__nfet_01v8 ad=0.15 pd=1.6 as=0.15 ps=1.6 w=0.5 l=0.3
X29 GndD.t1 openDVS_pixel_1.ON.t2 a_788_n281# GndA.t17 sky130_fd_pr__nfet_01v8 ad=0.126 pd=1.44 as=0.105 ps=0.92 w=0.42 l=0.15
X30 openDVS_pixel_1.vsf.t1 openDVS_pixel_1.vpr.t3 GndA.t25 VddA18.t20 sky130_fd_pr__pfet_01v8 ad=0.126 pd=1.44 as=0.126 ps=1.44 w=0.42 l=0.25
X31 openDVS_pixel_0.ON.t1 OnBn.t3 GndA.t45 GndA.t44 sky130_fd_pr__nfet_01v8 ad=0.45 pd=3.6 as=0.45 ps=3.6 w=1.5 l=1.5
X32 a_n3254_n281# openDVS_pixel_2.ON.t2 GndD.t3 GndA.t16 sky130_fd_pr__nfet_01v8 ad=0.105 pd=0.92 as=0.126 ps=1.44 w=0.42 l=0.15
D1 GndA.t18 vpd[2] sky130_fd_pr__model__parasitic__diode_ps2dn area=32.49 pj=22.8 m=1
X33 openDVS_pixel_0.vdiff.t3 DiffBn_uq1.t1 GndA.t55 GndA.t54 sky130_fd_pr__nfet_01v8 ad=0.45 pd=3.6 as=0.45 ps=3.6 w=1.5 l=1.5
X34 GndA.t1 OffBn.t2 openDVS_pixel_3.nOFF.t0 GndA.t0 sky130_fd_pr__nfet_01v8 ad=0.45 pd=3.6 as=0.45 ps=3.6 w=1.5 l=1.5
X35 VddA18.t39 openDVS_pixel_0.vd.t4 openDVS_pixel_0.vdiff.t2 VddA18.t0 sky130_fd_pr__pfet_01v8 ad=0.225 pd=1.8 as=0.45 ps=3.6 w=1.5 l=1.5
X36 GndA.t30 openDVS_pixel_1.DiffBn.t0 openDVS_pixel_1.vdiff.t0 GndA.t29 sky130_fd_pr__nfet_01v8 ad=0.45 pd=3.6 as=0.45 ps=3.6 w=1.5 l=1.5
X37 openDVS_pixel_0.vdiff.t0 openDVS_pixel_0.nRst.t3 openDVS_pixel_0.vd.t0 VddA18.t24 sky130_fd_pr__pfet_01v8_hvt ad=0.126 pd=1.44 as=0.126 ps=1.44 w=0.42 l=0.42
X38 GndA.t11 rowReadON[0].t2 a_1070_435# GndA.t10 sky130_fd_pr__nfet_01v8 ad=0.126 pd=1.44 as=0.105 ps=0.92 w=0.42 l=0.15
X39 a_788_n281.t0 rowReadON[1].t2 readLine[1].t0 GndA.t17 sky130_fd_pr__nfet_01v8 ad=0.105 pd=0.92 as=0.105 ps=0.92 w=0.42 l=0.15
X40 openDVS_pixel_2.vpr vpd[1].t1 GndA.t28 GndA.t27 sky130_fd_pr__nfet_01v8 ad=0.126 pd=1.44 as=0.126 ps=1.44 w=0.42 l=0.3
X41 openDVS_pixel_2.vdiff.t0 openDVS_pixel_2.nRst.t2 openDVS_pixel_2.vd.t0 VddA18.t24 sky130_fd_pr__pfet_01v8_hvt ad=0.126 pd=1.44 as=0.126 ps=1.44 w=0.42 l=0.42
X42 openDVS_pixel_0.vd.t1 openDVS_pixel_0.vdiff.t1 sky130_fd_pr__cap_mim_m3_1 l=1 w=1
X43 openDVS_pixel_2.nOFF.t1 openDVS_pixel_2.vdiff.t4 VddA18.t42 VddA18.t31 sky130_fd_pr__pfet_01v8 ad=0.45 pd=3.6 as=0.225 ps=1.8 w=1.5 l=1.5
X44 a_1070_n607.t0 rowReadON[1].t0 GndA.t51 GndA.t50 sky130_fd_pr__nfet_01v8 ad=0.105 pd=0.92 as=0.126 ps=1.44 w=0.42 l=0.15
X45 openDVS_pixel_1.vd.t3 openDVS_pixel_1.vdiff.t0 sky130_fd_pr__cap_mim_m3_1 l=1 w=1
X46 VddA18.t1 PrSFBp.t3 openDVS_pixel_0.vsf VddA18.t0 sky130_fd_pr__pfet_01v8_hvt ad=0.063 pd=0.72 as=0.126 ps=1.44 w=0.42 l=1.5
X47 GndA.t9 rowReadON[0].t3 a_n3520_435# GndA.t8 sky130_fd_pr__nfet_01v8 ad=0.126 pd=1.44 as=0.105 ps=0.92 w=0.42 l=0.15
X48 readLine[0].t3 rowReadON[1].t3 a_n3254_n281.t0 GndA.t16 sky130_fd_pr__nfet_01v8 ad=0.105 pd=0.92 as=0.105 ps=0.92 w=0.42 l=0.15
X49 VddA18.t17 openDVS_pixel_1.vdiff.t0 openDVS_pixel_1.nOFF.t1 VddA18.t16 sky130_fd_pr__pfet_01v8 ad=0.225 pd=1.8 as=0.45 ps=3.6 w=1.5 l=1.5
X50 GndA.t3 OffBn.t0 openDVS_pixel_1.nOFF.t0 GndA.t2 sky130_fd_pr__nfet_01v8 ad=0.45 pd=3.6 as=0.45 ps=3.6 w=1.5 l=1.5
X51 a_n3520_n607.t0 rowReadON[1].t1 GndA.t53 GndA.t52 sky130_fd_pr__nfet_01v8 ad=0.105 pd=0.92 as=0.126 ps=1.44 w=0.42 l=0.15
X52 readLine[1].t2 rowReadOFF[1].t0 a_528_n281# GndA.t17 sky130_fd_pr__nfet_01v8 ad=0.105 pd=0.92 as=0.105 ps=0.92 w=0.42 l=0.15
X53 openDVS_pixel_0.vd.t3 openDVS_pixel_0.vsf.t1 sky130_fd_pr__cap_mim_m3_1 l=1.505 w=6.47
X54 a_528_125# openDVS_pixel_3.nOFF.t2 GndD.t7 GndA.t13 sky130_fd_pr__nfet_01v8 ad=0.105 pd=0.92 as=0.126 ps=1.44 w=0.42 l=0.15
X55 VddA18.t36 openDVS_pixel_2.nRst.t3 VddA18.t36 VddA18.t35 sky130_fd_pr__pfet_01v8 ad=0.45 pd=3.6 as=0 ps=0 w=1.5 l=1.5
X56 GndA.t47 OnBn.t0 openDVS_pixel_1.ON.t1 GndA.t2 sky130_fd_pr__nfet_01v8 ad=0.45 pd=3.6 as=0.45 ps=3.6 w=1.5 l=1.5
X57 openDVS_pixel_3.vd.t3 openDVS_pixel_3.vsf.t1 sky130_fd_pr__cap_mim_m3_1 l=1.505 w=6.47
X58 openDVS_pixel_1.vd.t1 openDVS_pixel_1.vsf.t2 sky130_fd_pr__cap_mim_m3_1 l=1.505 w=6.47
X59 VddA18.t38 openDVS_pixel_3.nRst.t2 VddA18.t38 VddA18.t22 sky130_fd_pr__pfet_01v8 ad=0.42 pd=3.56 as=0 ps=0 w=1.5 l=1.5
X60 a_1070_435.t0 pixRst[1].t1 openDVS_pixel_3.nRst.t1 GndA.t37 sky130_fd_pr__nfet_01v8 ad=0.105 pd=0.92 as=0.126 ps=1.44 w=0.42 l=0.15
X61 GndD.t2 openDVS_pixel_3.ON.t2 a_788_125.t0 GndA.t13 sky130_fd_pr__nfet_01v8 ad=0.126 pd=1.44 as=0.105 ps=0.92 w=0.42 l=0.15
X62 a_n2994_n281# rowReadOFF[1].t1 readLine[0].t0 GndA.t16 sky130_fd_pr__nfet_01v8 ad=0.105 pd=0.92 as=0.105 ps=0.92 w=0.42 l=0.15
X63 GndA.t24 openDVS_pixel_3.vpr.t2 openDVS_pixel_3.vsf.t0 VddA18.t20 sky130_fd_pr__pfet_01v8 ad=0.126 pd=1.44 as=0.126 ps=1.44 w=0.42 l=0.25
X64 openDVS_pixel_3.ON.t0 openDVS_pixel_3.vdiff.t0 VddA18.t44 VddA18.t18 sky130_fd_pr__pfet_01v8 ad=0.45 pd=3.6 as=0.225 ps=1.8 w=1.5 l=1.5
X65 VddA18.t26 openDVS_pixel_2.vdiff.t5 openDVS_pixel_2.ON.t1 VddA18.t25 sky130_fd_pr__pfet_01v8 ad=0.225 pd=1.8 as=0.45 ps=3.6 w=1.5 l=1.5
X66 openDVS_pixel_1.nRst.t1 pixRst[1].t0 a_1070_n607# GndA.t38 sky130_fd_pr__nfet_01v8 ad=0.126 pd=1.44 as=0.105 ps=0.92 w=0.42 l=0.15
X67 openDVS_pixel_0.vd.t2 openDVS_pixel_0.vsf.t2 sky130_fd_pr__cap_mim_m3_1 l=2.27 w=3.985
X68 openDVS_pixel_0.nOFF.t0 OffBn.t3 GndA.t7 GndA.t6 sky130_fd_pr__nfet_01v8 ad=0.45 pd=3.6 as=0.45 ps=3.6 w=1.5 l=1.5
X69 a_n3520_435.t0 pixRst[0].t1 openDVS_pixel_0.nRst.t1 GndA.t14 sky130_fd_pr__nfet_01v8 ad=0.105 pd=0.92 as=0.126 ps=1.44 w=0.42 l=0.15
X70 a_788_125# rowReadON[0].t0 readLine[1].t3 GndA.t13 sky130_fd_pr__nfet_01v8 ad=0.105 pd=0.92 as=0.105 ps=0.92 w=0.42 l=0.15
X71 GndD.t4 openDVS_pixel_2.nOFF.t2 a_n2994_n281.t0 GndA.t16 sky130_fd_pr__nfet_01v8 ad=0.126 pd=1.44 as=0.105 ps=0.92 w=0.42 l=0.15
X72 VddA18.t4 PrSFBp.t1 openDVS_pixel_2.vsf VddA18.t0 sky130_fd_pr__pfet_01v8_hvt ad=0.063 pd=0.72 as=0.126 ps=1.44 w=0.42 l=1.5
X73 openDVS_pixel_2.vpr.t0 PrBp.t1 VddA18.t9 VddA18.t8 sky130_fd_pr__pfet_01v8 ad=0.15 pd=1.6 as=0.15 ps=1.6 w=0.5 l=0.15
X74 VddA18.t7 PrBp.t2 openDVS_pixel_3.vpr.t0 VddA18.t6 sky130_fd_pr__pfet_01v8 ad=0.15 pd=1.6 as=0.15 ps=1.6 w=0.5 l=0.15
X75 readLine[1].t1 rowReadOFF[0].t0 a_528_125.t0 GndA.t13 sky130_fd_pr__nfet_01v8 ad=0.105 pd=0.92 as=0.105 ps=0.92 w=0.42 l=0.15
X76 openDVS_pixel_2.nRst.t1 pixRst[0].t0 a_n3520_n607# GndA.t15 sky130_fd_pr__nfet_01v8 ad=0.126 pd=1.44 as=0.105 ps=0.92 w=0.42 l=0.15
X77 openDVS_pixel_0.vpr vpd[0].t1 GndA.t23 GndA.t22 sky130_fd_pr__nfet_01v8 ad=0.126 pd=1.44 as=0.126 ps=1.44 w=0.42 l=0.3
X78 VddA18.t10 PrBp.t3 openDVS_pixel_0.vpr.t0 VddA18.t8 sky130_fd_pr__pfet_01v8 ad=0.15 pd=1.6 as=0.15 ps=1.6 w=0.5 l=0.15
X79 openDVS_pixel_1.vdiff.t0 openDVS_pixel_1.vd.t4 VddA18.t27 VddA18.t2 sky130_fd_pr__pfet_01v8 ad=0.45 pd=3.6 as=0.225 ps=1.8 w=1.5 l=1.5
X80 openDVS_pixel_2.vd.t2 openDVS_pixel_2.vdiff.t1 sky130_fd_pr__cap_mim_m3_1 l=1 w=1
D2 GndA.t26 vpd[1] sky130_fd_pr__model__parasitic__diode_ps2dn area=32.49 pj=22.8 m=1
X81 openDVS_pixel_0.nOFF.t1 openDVS_pixel_0.vdiff.t4 VddA18.t32 VddA18.t31 sky130_fd_pr__pfet_01v8 ad=0.45 pd=3.6 as=0.225 ps=1.8 w=1.5 l=1.5
X82 VddA18.t12 RefrBp.t1 openDVS_pixel_2.nRst.t0 VddA18.t0 sky130_fd_pr__pfet_01v8 ad=0.063 pd=0.72 as=0.126 ps=1.44 w=0.42 l=1.5
X83 openDVS_pixel_2.vsf.t1 openDVS_pixel_2.vpr GndA.t31 VddA18.t28 sky130_fd_pr__pfet_01v8 ad=0.126 pd=1.44 as=0.126 ps=1.44 w=0.42 l=0.25
D3 GndA.t21 vpd[0] sky130_fd_pr__model__parasitic__diode_ps2dn area=32.49 pj=22.8 m=1
X84 vpd[2].t0 openDVS_pixel_3.vpr.t3 VddA18.t33 GndA.t34 sky130_fd_pr__nfet_01v8 ad=0.15 pd=1.6 as=0.15 ps=1.6 w=0.5 l=0.3
X85 GndA.t36 openDVS_pixel_0.vpr openDVS_pixel_0.vsf.t0 VddA18.t28 sky130_fd_pr__pfet_01v8 ad=0.126 pd=1.44 as=0.126 ps=1.44 w=0.42 l=0.25
X86 openDVS_pixel_3.nRst.t0 RefrBp.t2 VddA18.t14 VddA18.t2 sky130_fd_pr__pfet_01v8 ad=0.126 pd=1.44 as=0.063 ps=0.72 w=0.42 l=1.5
X87 VddA18.t40 openDVS_pixel_0.nRst.t2 VddA18.t40 VddA18.t35 sky130_fd_pr__pfet_01v8 ad=0.42 pd=3.56 as=0 ps=0 w=1.5 l=1.5
X88 openDVS_pixel_2.vdiff.t3 DiffBn_uq1.t0 GndA.t57 GndA.t56 sky130_fd_pr__nfet_01v8 ad=0.45 pd=3.6 as=0.45 ps=3.6 w=1.5 l=1.5
X89 openDVS_pixel_1.vpr.t0 PrBp.t0 VddA18.t11 VddA18.t6 sky130_fd_pr__pfet_01v8 ad=0.15 pd=1.6 as=0.15 ps=1.6 w=0.5 l=0.15
X90 VddA18.t43 openDVS_pixel_3.vdiff.t0 openDVS_pixel_3.nOFF.t1 VddA18.t16 sky130_fd_pr__pfet_01v8 ad=0.225 pd=1.8 as=0.45 ps=3.6 w=1.5 l=1.5
X91 a_528_n281.t0 openDVS_pixel_1.nOFF.t2 GndD.t0 GndA.t17 sky130_fd_pr__nfet_01v8 ad=0.105 pd=0.92 as=0.126 ps=1.44 w=0.42 l=0.15
C0 PrBp openDVS_pixel_3.nRst 0.02209f
C1 m1_637_714# openDVS_pixel_3.nRst 0.01253f
C2 openDVS_pixel_3.ON OnBn 0.11114f
C3 m1_n395_972# m2_n395_972# 0.01126f
C4 vpd[2] m1_n137_1488# 0.00112f
C5 openDVS_pixel_2.vdiff openDVS_pixel_1.vdiff 0.14513f
C6 PrSFBp VddA18 3.56875f
C7 openDVS_pixel_2.vd openDVS_pixel_1.vd 0.04919f
C8 readLine[1] a_528_125# 0.0037f
C9 VddA18 openDVS_pixel_3.nOFF 0.7785f
C10 openDVS_pixel_3.vsf OffBn 0.24044f
C11 openDVS_pixel_0.vdiff OffBn 0.33753f
C12 m1_637_n1102# m1_637_n844# 0.01021f
C13 openDVS_pixel_0.nRst PrSFBp 0.04525f
C14 openDVS_pixel_2.vd OffBn 0.0719f
C15 PrSFBp rowReadON[0] 0.01434f
C16 openDVS_pixel_0.ON openDVS_pixel_0.vsf 0.07438f
C17 openDVS_pixel_3.nOFF rowReadON[0] 0.03698f
C18 openDVS_pixel_0.ON rowReadOFF[0] 0.05739f
C19 openDVS_pixel_0.nOFF readLine[0] 0.01086f
C20 openDVS_pixel_0.ON a_n2994_125# 0.00126f
C21 readLine[1] a_788_n281# 0.0037f
C22 openDVS_pixel_0.vd pixRst[0] 0.00113f
C23 m1_n3061_1488# m1_n3061_1230# 0.01021f
C24 openDVS_pixel_2.vd openDVS_pixel_2.nRst 0.06242f
C25 m1_n2545_1488# m2_n2545_1488# 0.01126f
C26 RefrBp openDVS_pixel_2.vsf 0.00112f
C27 openDVS_pixel_1.vsf GndD 0.47962f
C28 pixRst[1] rowReadOFF[0] 0.02444f
C29 m2_121_1488# m1_121_1488# 0.01126f
C30 PrSFBp DiffBn_uq1 0.02919f
C31 OnBn openDVS_pixel_2.vsf 0.47977f
C32 vpd[0] OffBn 0.03962f
C33 openDVS_pixel_2.vpr VddA18 1.28084f
C34 m2_121_n844# m1_121_n844# 0.01126f
C35 m2_n3061_n1876# openDVS_pixel_2.vsf 0.02952f
C36 m2_121_n1876# m2_379_n1876# 0.01115f
C37 m2_121_1488# openDVS_pixel_3.vsf 0.00145f
C38 openDVS_pixel_3.vdiff m1_637_972# 0.00947f
C39 readLine[1] rowReadON[1] 0.15034f
C40 m2_n2803_n1876# m2_n2545_n1876# 0.01115f
C41 openDVS_pixel_0.vsf pixRst[0] 0.05659f
C42 rowReadOFF[0] pixRst[0] 0.02444f
C43 rowReadOFF[1] openDVS_pixel_2.nOFF 0.08314f
C44 openDVS_pixel_2.vdiff openDVS_pixel_1.nRst 0.00191f
C45 m1_121_n1876# openDVS_pixel_1.vsf 0.00578f
C46 openDVS_pixel_2.vdiff pixRst[0] 0.00548f
C47 openDVS_pixel_1.nOFF a_528_n281# 0.00168f
C48 readLine[1] openDVS_pixel_1.vdiff 0.00615f
C49 openDVS_pixel_3.vsf m2_121_1746# 0.03728f
C50 vpd[1] m1_n2545_n1360# 0.00217f
C51 a_n2994_n281# readLine[0] 0.0037f
C52 openDVS_pixel_3.vd DiffBn 0.02437f
C53 rowReadOFF[1] openDVS_pixel_2.vsf 0.07403f
C54 rowReadON[1] VddA18 0.76249f
C55 openDVS_pixel_3.nRst RefrBp 0.09365f
C56 m1_n2287_n1360# m2_n2287_n1360# 0.01126f
C57 openDVS_pixel_0.vd GndD 0.05667f
C58 OnBn openDVS_pixel_3.nRst 0.04735f
C59 openDVS_pixel_2.vpr DiffBn_uq1 0.73368f
C60 m2_379_n844# m1_379_n844# 0.01126f
C61 openDVS_pixel_1.vdiff VddA18 3.46429f
C62 rowReadON[1] rowReadON[0] 2.80688f
C63 m1_n3061_n1876# m1_n2803_n1876# 0.01021f
C64 m1_n3061_n844# openDVS_pixel_2.vsf 0.00678f
C65 openDVS_pixel_3.vdiff m2_637_1746# 0.02921f
C66 openDVS_pixel_3.vdiff openDVS_pixel_3.ON 0.17527f
C67 openDVS_pixel_1.vd PrSFBp 0.00632f
C68 openDVS_pixel_0.vsf GndD 0.47962f
C69 m1_n2545_n1876# openDVS_pixel_2.vsf 0.00578f
C70 rowReadOFF[0] GndD 3.07829f
C71 openDVS_pixel_1.vdiff rowReadON[0] 0.00365f
C72 a_n2994_125# GndD 0.00883f
C73 readLine[1] pixRst[1] 3.45468f
C74 openDVS_pixel_3.vpr openDVS_pixel_3.nRst 0.0935f
C75 readLine[1] openDVS_pixel_1.ON 0.09687f
C76 openDVS_pixel_2.vdiff GndD 0.63037f
C77 readLine[0] OnBn 0.0032f
C78 rowReadON[1] DiffBn_uq1 0.02072f
C79 openDVS_pixel_0.ON VddA18 0.32745f
C80 PrSFBp OffBn 2.63317f
C81 vpd[1] RefrBp 0.00269f
C82 m2_n2545_n1618# openDVS_pixel_2.vsf 0.00145f
C83 readLine[1] openDVS_pixel_1.nRst 0.20309f
C84 openDVS_pixel_3.nOFF OffBn 0.09214f
C85 vpd[1] OnBn 0.03643f
C86 openDVS_pixel_0.nRst openDVS_pixel_0.ON 0.05094f
C87 openDVS_pixel_0.vdiff openDVS_pixel_0.nOFF 0.64523f
C88 m1_637_714# openDVS_pixel_3.vsf 0.00678f
C89 PrBp openDVS_pixel_3.vsf 0.02141f
C90 openDVS_pixel_0.vdiff PrBp 0.18695f
C91 openDVS_pixel_0.ON rowReadON[0] 0.21792f
C92 PrSFBp openDVS_pixel_2.nRst 0.04487f
C93 m1_n2803_n844# m2_n2803_n844# 0.01126f
C94 vpd[2] openDVS_pixel_3.nRst 0.01091f
C95 pixRst[1] VddA18 2.25797f
C96 m2_n3061_1746# OnBn 0.02589f
C97 openDVS_pixel_1.ON VddA18 0.32747f
C98 readLine[1] a_788_125# 0.0037f
C99 m2_n3061_1746# m2_n2803_1746# 0.01115f
C100 rowReadOFF[1] readLine[0] 0.13225f
C101 VddA18 openDVS_pixel_1.nRst 2.15079f
C102 pixRst[1] rowReadON[0] 0.10756f
C103 VddA18 pixRst[0] 2.25797f
C104 openDVS_pixel_1.nOFF openDVS_pixel_3.nOFF 0.01293f
C105 openDVS_pixel_2.vpr OffBn 0.18367f
C106 openDVS_pixel_0.nRst pixRst[0] 0.08095f
C107 openDVS_pixel_1.vpr PrSFBp 0.03088f
C108 rowReadON[0] pixRst[0] 0.10756f
C109 openDVS_pixel_2.vdiff m1_n3061_n1618# 0.0197f
C110 m2_n395_n844# m1_n395_n844# 0.01126f
C111 m1_n3061_1746# OnBn 0.00154f
C112 readLine[1] GndD 0.59188f
C113 openDVS_pixel_1.vd rowReadON[1] 0.00276f
C114 openDVS_pixel_2.vpr openDVS_pixel_2.nRst 0.09344f
C115 m1_n2803_972# m2_n2803_972# 0.01126f
C116 a_788_125# rowReadON[0] 0.00812f
C117 m2_n137_972# m1_n137_972# 0.01126f
C118 vpd[1] m1_n2545_n1876# 0.01847f
C119 openDVS_pixel_3.vdiff m1_637_1488# 0.0197f
C120 openDVS_pixel_3.vdiff openDVS_pixel_3.nRst 0.37827f
C121 m1_n2803_1746# m1_n3061_1746# 0.01021f
C122 DiffBn_uq1 pixRst[0] 0.09749f
C123 rowReadON[1] OffBn 0.02839f
C124 openDVS_pixel_1.vd openDVS_pixel_1.vdiff 0.57036f
C125 m2_n395_n1102# m1_n395_n1102# 0.01126f
C126 VddA18 GndD 3.41007f
C127 openDVS_pixel_1.vdiff m1_637_n1360# 0.00987f
C128 openDVS_pixel_1.vdiff OffBn 0.20823f
C129 m1_379_n1618# m2_379_n1618# 0.01126f
C130 openDVS_pixel_2.vpr openDVS_pixel_1.vpr 0.04796f
C131 rowReadON[1] openDVS_pixel_2.nRst 0.03176f
C132 RefrBp openDVS_pixel_3.vsf 0.01027f
C133 openDVS_pixel_0.nRst GndD 0.00484f
C134 openDVS_pixel_0.vdiff RefrBp 0.11489f
C135 m1_121_1746# openDVS_pixel_3.vsf 0.00578f
C136 OnBn openDVS_pixel_3.vsf 0.71135f
C137 openDVS_pixel_2.vd RefrBp 0.01069f
C138 openDVS_pixel_0.vdiff OnBn 0.53789f
C139 rowReadON[0] GndD 0.41506f
C140 m2_637_n1876# OnBn 0.02589f
C141 openDVS_pixel_1.vdiff openDVS_pixel_2.nRst 0.00195f
C142 m1_n2545_714# m2_n2545_714# 0.01126f
C143 openDVS_pixel_1.DiffBn openDVS_pixel_1.vsf 0.15304f
C144 m1_n3061_1488# m1_n3061_1746# 0.01021f
C145 openDVS_pixel_2.vd OnBn 0.05463f
C146 m2_n2545_1746# openDVS_pixel_0.vsf 0.03728f
C147 openDVS_pixel_1.nOFF rowReadON[1] 0.03698f
C148 m1_637_n1876# m1_637_n1618# 0.01021f
C149 openDVS_pixel_0.ON OffBn 0.16176f
C150 openDVS_pixel_0.vpr openDVS_pixel_0.vd 0.02623f
C151 openDVS_pixel_2.nOFF openDVS_pixel_2.vsf 0.0918f
C152 m1_n2545_1746# openDVS_pixel_0.vsf 0.00578f
C153 openDVS_pixel_1.vd pixRst[1] 0.00113f
C154 m1_637_n1618# openDVS_pixel_1.vsf 0.00712f
C155 PrBp PrSFBp 2.71062f
C156 openDVS_pixel_1.vdiff openDVS_pixel_1.nOFF 0.64523f
C157 openDVS_pixel_1.vd openDVS_pixel_1.ON 0.00572f
C158 DiffBn_uq1 GndD 0.16316f
C159 openDVS_pixel_3.vpr openDVS_pixel_3.vsf 0.11259f
C160 vpd[3] PrSFBp 0.00271f
C161 openDVS_pixel_0.vdiff openDVS_pixel_3.vpr 0.00107f
C162 m1_637_1488# openDVS_pixel_3.ON 0.00106f
C163 vpd[0] RefrBp 0.00269f
C164 openDVS_pixel_3.ON openDVS_pixel_3.nRst 0.05094f
C165 rowReadOFF[1] openDVS_pixel_3.vsf 0.01196f
C166 openDVS_pixel_0.vdiff rowReadOFF[1] 0.00263f
C167 openDVS_pixel_1.vd openDVS_pixel_1.nRst 0.06241f
C168 pixRst[1] OffBn 0.02108f
C169 openDVS_pixel_2.nRst a_n3520_n607# 0.01085f
C170 vpd[0] OnBn 0.03643f
C171 openDVS_pixel_1.vdiff openDVS_pixel_1.vpr 0.03774f
C172 openDVS_pixel_1.ON OffBn 0.16176f
C173 openDVS_pixel_2.vd rowReadOFF[1] 0.00298f
C174 m1_121_n1876# m2_121_n1876# 0.01126f
C175 m1_121_1488# vpd[2] 0.00112f
C176 pixRst[1] a_1070_435# 0.00105f
C177 openDVS_pixel_0.vpr openDVS_pixel_0.vsf 0.11259f
C178 m1_379_1746# m1_121_1746# 0.01021f
C179 openDVS_pixel_1.nRst OffBn 0.02738f
C180 vpd[2] openDVS_pixel_3.vsf 0.07149f
C181 m1_379_1746# OnBn 0.0013f
C182 openDVS_pixel_0.vdiff m1_n3061_1488# 0.0197f
C183 pixRst[0] OffBn 0.02108f
C184 openDVS_pixel_0.vsf m2_n2545_1488# 0.00145f
C185 rowReadOFF[1] a_528_n281# 0.0059f
C186 openDVS_pixel_1.nRst openDVS_pixel_2.nRst 0.12596f
C187 pixRst[0] openDVS_pixel_2.nRst 0.08095f
C188 openDVS_pixel_2.vpr PrBp 0.03623f
C189 openDVS_pixel_1.nOFF pixRst[1] 0.00166f
C190 openDVS_pixel_1.nOFF openDVS_pixel_1.ON 0.8177f
C191 openDVS_pixel_3.vd openDVS_pixel_0.vd 0.04919f
C192 OnBn m2_n2803_n1876# 0.02589f
C193 openDVS_pixel_1.nOFF openDVS_pixel_1.nRst 0.08648f
C194 m1_n3061_n1618# m1_n3061_n1360# 0.01021f
C195 m2_n2803_n1876# m2_n3061_n1876# 0.01115f
C196 m1_121_n1360# m2_121_n1360# 0.01126f
C197 openDVS_pixel_1.vpr pixRst[1] 0.00207f
C198 m1_n3061_972# openDVS_pixel_0.vsf 0.00668f
C199 openDVS_pixel_2.ON openDVS_pixel_0.vsf 0.0014f
C200 openDVS_pixel_1.vd GndD 0.05667f
C201 openDVS_pixel_2.nOFF readLine[0] 0.01086f
C202 m1_n3061_n1618# m1_n3061_n1876# 0.01021f
C203 openDVS_pixel_2.vdiff openDVS_pixel_2.ON 0.17527f
C204 openDVS_pixel_1.vpr openDVS_pixel_1.nRst 0.09371f
C205 m1_n2029_714# m2_n2029_714# 0.01126f
C206 openDVS_pixel_2.vdiff m1_n3061_n1102# 0.00947f
C207 PrBp rowReadON[1] 0.01434f
C208 GndD OffBn 0.11706f
C209 readLine[1] DiffBn 0.03501f
C210 openDVS_pixel_3.vdiff openDVS_pixel_3.vsf 0.57748f
C211 PrSFBp RefrBp 0.53208f
C212 openDVS_pixel_3.vd rowReadOFF[0] 0.00298f
C213 openDVS_pixel_0.vdiff openDVS_pixel_3.vdiff 0.14513f
C214 readLine[0] openDVS_pixel_2.vsf 0.05667f
C215 m1_637_972# openDVS_pixel_3.vsf 0.00668f
C216 m2_121_n1618# openDVS_pixel_1.vsf 0.00145f
C217 PrSFBp OnBn 0.32641f
C218 openDVS_pixel_1.vdiff PrBp 0.40434f
C219 OnBn openDVS_pixel_3.nOFF 0.0028f
C220 vpd[1] openDVS_pixel_2.vsf 0.07171f
C221 openDVS_pixel_2.nRst GndD 0.00484f
C222 vpd[3] openDVS_pixel_1.vdiff 0.01034f
C223 m2_121_1746# m2_379_1746# 0.01115f
C224 rowReadON[1] a_1070_n607# 0.00336f
C225 DiffBn VddA18 0.2536f
C226 OnBn m2_379_n1876# 0.02589f
C227 m1_637_n1876# openDVS_pixel_1.vsf 0.00648f
C228 vpd[3] m1_121_n1618# 0.00112f
C229 openDVS_pixel_0.ON openDVS_pixel_0.nOFF 0.8177f
C230 openDVS_pixel_1.nOFF GndD 0.17875f
C231 m1_n395_1230# m2_n395_1230# 0.01126f
C232 openDVS_pixel_3.vpr PrSFBp 0.03541f
C233 VddA18 openDVS_pixel_0.vpr 0.533f
C234 rowReadOFF[1] PrSFBp 0.01434f
C235 m2_n2287_n844# m1_n2287_n844# 0.01126f
C236 openDVS_pixel_0.vdiff m1_n3061_1230# 0.00987f
C237 m1_379_n1876# m2_379_n1876# 0.01126f
C238 readLine[1] openDVS_pixel_1.DiffBn 0.02964f
C239 OnBn m1_n2803_n1876# 0.0013f
C240 openDVS_pixel_0.nRst openDVS_pixel_0.vpr 0.09371f
C241 openDVS_pixel_2.vpr OnBn 0.07546f
C242 m2_637_1746# openDVS_pixel_3.vsf 0.02952f
C243 vpd[2] PrSFBp 0.00271f
C244 m2_121_n1102# m1_121_n1102# 0.01126f
C245 openDVS_pixel_3.ON openDVS_pixel_3.vsf 0.07438f
C246 openDVS_pixel_0.nRst a_n3520_435# 0.01085f
C247 m1_379_1488# m2_379_1488# 0.01126f
C248 openDVS_pixel_0.nOFF pixRst[0] 0.00166f
C249 PrBp openDVS_pixel_1.nRst 0.02171f
C250 a_n3520_435# rowReadON[0] 0.00336f
C251 openDVS_pixel_1.DiffBn VddA18 0.9442f
C252 vpd[3] openDVS_pixel_1.nRst 0.01059f
C253 openDVS_pixel_3.vd readLine[1] 0.00508f
C254 rowReadON[1] RefrBp 0.01434f
C255 DiffBn_uq1 openDVS_pixel_0.vpr 0.73117f
C256 readLine[0] a_n3254_125# 0.0037f
C257 openDVS_pixel_2.ON VddA18 0.32747f
C258 pixRst[1] a_1070_n607# 0.00105f
C259 rowReadON[1] OnBn 0.02088f
C260 m1_379_n1360# m2_379_n1360# 0.01126f
C261 openDVS_pixel_1.vdiff RefrBp 0.27274f
C262 m2_n2803_714# m1_n2803_714# 0.01126f
C263 openDVS_pixel_1.nRst a_1070_n607# 0.01085f
C264 m2_n137_1230# vpd[2] 0.00221f
C265 openDVS_pixel_2.vd openDVS_pixel_2.nOFF 0.01149f
C266 openDVS_pixel_1.vdiff OnBn 0.69245f
C267 openDVS_pixel_3.vd VddA18 4.14543f
C268 m2_n2803_1230# m1_n2803_1230# 0.01126f
C269 openDVS_pixel_0.vdiff openDVS_pixel_2.vsf 0.00156f
C270 rowReadOFF[0] openDVS_pixel_1.vsf 0.01196f
C271 m1_n2545_n1876# m1_n2803_n1876# 0.01021f
C272 openDVS_pixel_3.vdiff PrSFBp 0.14088f
C273 openDVS_pixel_2.vd openDVS_pixel_2.vsf 2.20422f
C274 openDVS_pixel_3.vd rowReadON[0] 0.00276f
C275 rowReadOFF[1] rowReadON[1] 2.90971f
C276 openDVS_pixel_3.vdiff openDVS_pixel_3.nOFF 0.64523f
C277 openDVS_pixel_0.nOFF GndD 0.17874f
C278 PrBp GndD 0.12899f
C279 openDVS_pixel_0.ON OnBn 0.11103f
C280 m1_n3061_n1360# m1_n3061_n1102# 0.01021f
C281 rowReadOFF[1] openDVS_pixel_1.vdiff 0.02703f
C282 m1_n137_n1360# vpd[3] 0.00217f
C283 m1_n395_714# m2_n395_714# 0.01126f
C284 DiffBn OffBn 0.63449f
C285 openDVS_pixel_1.ON OnBn 0.11114f
C286 pixRst[1] OnBn 0.01305f
C287 m1_637_1488# openDVS_pixel_3.vsf 0.00712f
C288 openDVS_pixel_0.vd openDVS_pixel_0.vsf 2.20391f
C289 openDVS_pixel_0.vdiff m1_n3061_714# 0.00938f
C290 openDVS_pixel_3.nRst openDVS_pixel_3.vsf 0.13859f
C291 RefrBp openDVS_pixel_1.nRst 0.09297f
C292 openDVS_pixel_0.vdiff openDVS_pixel_3.nRst 0.00191f
C293 rowReadOFF[0] openDVS_pixel_0.vd 0.00298f
C294 vpd[3] m1_121_n1876# 0.01847f
C295 openDVS_pixel_2.vdiff openDVS_pixel_0.vd 0.00221f
C296 openDVS_pixel_0.vpr OffBn 0.1829f
C297 OnBn openDVS_pixel_1.nRst 0.04715f
C298 m2_n3061_1746# m1_n3061_1746# 0.01126f
C299 OnBn pixRst[0] 0.013f
C300 a_n2994_n281# GndD 0.00883f
C301 OnBn m2_379_1746# 0.02589f
C302 openDVS_pixel_3.vpr pixRst[1] 0.00214f
C303 m1_n3061_1488# openDVS_pixel_0.ON 0.00106f
C304 openDVS_pixel_1.vd openDVS_pixel_1.DiffBn 0.02437f
C305 rowReadOFF[1] pixRst[1] 0.02444f
C306 openDVS_pixel_3.ON openDVS_pixel_3.nOFF 0.8177f
C307 rowReadOFF[0] openDVS_pixel_0.vsf 0.07403f
C308 rowReadOFF[1] openDVS_pixel_1.ON 0.0574f
C309 readLine[1] openDVS_pixel_1.vsf 0.05667f
C310 rowReadOFF[0] a_n2994_125# 0.0059f
C311 openDVS_pixel_0.vdiff readLine[0] 0.00623f
C312 openDVS_pixel_2.vdiff openDVS_pixel_0.vsf 0.00156f
C313 openDVS_pixel_1.vdiff m1_637_n1102# 0.00947f
C314 m2_n2803_n1876# openDVS_pixel_2.vsf 0.0287f
C315 openDVS_pixel_2.vdiff rowReadOFF[0] 0.00263f
C316 openDVS_pixel_1.DiffBn OffBn 0.63449f
C317 openDVS_pixel_2.vd readLine[0] 0.00508f
C318 openDVS_pixel_3.vdiff rowReadON[1] 0.00365f
C319 openDVS_pixel_1.vdiff m1_637_n844# 0.00938f
C320 rowReadOFF[1] pixRst[0] 0.02444f
C321 openDVS_pixel_2.vd vpd[1] 0.03846f
C322 openDVS_pixel_2.ON OffBn 0.16176f
C323 m2_n2287_1230# m1_n2287_1230# 0.01126f
C324 openDVS_pixel_3.ON a_528_125# 0.00126f
C325 m1_637_n1360# m1_637_n1618# 0.01021f
C326 RefrBp GndD 0.11616f
C327 openDVS_pixel_3.vdiff openDVS_pixel_1.vdiff 0.29696f
C328 openDVS_pixel_3.vd openDVS_pixel_1.vd 0.12479f
C329 openDVS_pixel_0.vdiff m2_n3061_1746# 0.02921f
C330 VddA18 openDVS_pixel_1.vsf 1.01322f
C331 OnBn GndD 0.16316f
C332 vpd[0] m1_n2545_972# 0.00217f
C333 m2_n2545_1230# m1_n2545_1230# 0.01126f
C334 openDVS_pixel_2.ON openDVS_pixel_2.nRst 0.05094f
C335 openDVS_pixel_3.vd OffBn 0.02392f
C336 PrSFBp openDVS_pixel_2.vsf 0.23151f
C337 rowReadON[0] openDVS_pixel_1.vsf 0.01747f
C338 openDVS_pixel_1.vpr openDVS_pixel_1.DiffBn 0.69292f
C339 m2_121_n1876# openDVS_pixel_1.vsf 0.03728f
C340 rowReadOFF[1] GndD 3.07829f
C341 m2_n2803_n1360# m1_n2803_n1360# 0.01126f
C342 VddA18 openDVS_pixel_0.vd 4.14561f
C343 m1_637_n844# openDVS_pixel_1.nRst 0.01253f
C344 openDVS_pixel_3.vdiff pixRst[1] 0.0056f
C345 readLine[1] rowReadOFF[0] 0.13224f
C346 m1_121_n1876# m1_379_n1876# 0.01021f
C347 openDVS_pixel_0.nRst openDVS_pixel_0.vd 0.06241f
C348 openDVS_pixel_2.vsf m1_n2803_n1876# 0.00703f
C349 PrSFBp openDVS_pixel_3.nRst 0.04101f
C350 openDVS_pixel_0.vd rowReadON[0] 0.00276f
C351 vpd[2] m1_n137_1230# 0.00217f
C352 openDVS_pixel_2.vpr openDVS_pixel_2.vsf 0.11236f
C353 openDVS_pixel_3.nRst openDVS_pixel_3.nOFF 0.08648f
C354 VddA18 openDVS_pixel_0.vsf 0.90013f
C355 rowReadOFF[0] VddA18 0.65497f
C356 openDVS_pixel_2.nOFF rowReadON[1] 0.03698f
C357 PrBp openDVS_pixel_0.vpr 0.03623f
C358 openDVS_pixel_2.vdiff VddA18 3.47857f
C359 openDVS_pixel_0.nRst openDVS_pixel_0.vsf 0.13862f
C360 DiffBn_uq1 openDVS_pixel_0.vd 0.32742f
C361 openDVS_pixel_0.vsf rowReadON[0] 0.03922f
C362 rowReadOFF[0] rowReadON[0] 2.90971f
C363 openDVS_pixel_0.vdiff openDVS_pixel_2.vd 0.00221f
C364 rowReadON[1] openDVS_pixel_2.vsf 0.03922f
C365 openDVS_pixel_2.vdiff rowReadON[0] 0.00365f
C366 vpd[1] PrSFBp 0.00271f
C367 m2_n2029_1230# m1_n2029_1230# 0.01126f
C368 openDVS_pixel_1.vd openDVS_pixel_1.vsf 2.20391f
C369 openDVS_pixel_3.ON pixRst[1] 0.12107f
C370 openDVS_pixel_1.ON openDVS_pixel_3.ON 0.02941f
C371 m2_n2287_n1618# m1_n2287_n1618# 0.01126f
C372 DiffBn_uq1 openDVS_pixel_0.vsf 0.38479f
C373 rowReadOFF[0] DiffBn_uq1 0.02074f
C374 openDVS_pixel_3.vdiff GndD 0.63037f
C375 vpd[3] openDVS_pixel_1.DiffBn 0.06583f
C376 openDVS_pixel_2.vdiff DiffBn_uq1 0.29447f
C377 openDVS_pixel_0.vdiff vpd[0] 0.01034f
C378 m1_637_n1360# openDVS_pixel_1.vsf 0.00664f
C379 openDVS_pixel_1.vsf OffBn 0.24044f
C380 openDVS_pixel_2.vdiff m1_n3061_n1360# 0.00987f
C381 m2_637_1746# m2_379_1746# 0.01115f
C382 m1_379_1746# openDVS_pixel_3.vsf 0.00703f
C383 OnBn m2_n2545_1746# 0.0145f
C384 openDVS_pixel_0.ON openDVS_pixel_2.vsf 0.0014f
C385 openDVS_pixel_3.vd PrBp 0.0031f
C386 m2_n2803_1746# m2_n2545_1746# 0.01115f
C387 openDVS_pixel_3.ON a_788_125# 0.00314f
C388 vpd[1] openDVS_pixel_2.vpr 0.22362f
C389 m1_n395_n1360# m2_n395_n1360# 0.01126f
C390 readLine[1] VddA18 0.07625f
C391 DiffBn OnBn 0.24507f
C392 openDVS_pixel_2.nOFF pixRst[0] 0.00166f
C393 openDVS_pixel_1.nOFF openDVS_pixel_1.vsf 0.0918f
C394 m1_379_714# m2_379_714# 0.01126f
C395 m1_n2803_1746# m1_n2545_1746# 0.01021f
C396 readLine[1] rowReadON[0] 0.15034f
C397 openDVS_pixel_2.ON a_n2994_n281# 0.00126f
C398 openDVS_pixel_0.vd OffBn 0.07226f
C399 OnBn openDVS_pixel_0.vpr 0.07574f
C400 readLine[0] rowReadON[1] 0.15034f
C401 openDVS_pixel_1.vpr openDVS_pixel_1.vsf 0.11236f
C402 pixRst[0] openDVS_pixel_2.vsf 0.05659f
C403 vpd[0] m1_n2287_1488# 0.00112f
C404 openDVS_pixel_3.ON GndD 0.24091f
C405 openDVS_pixel_3.vpr DiffBn 0.69292f
C406 openDVS_pixel_0.nRst VddA18 2.1424f
C407 VddA18 rowReadON[0] 0.76249f
C408 openDVS_pixel_0.vsf OffBn 0.24959f
C409 rowReadOFF[0] OffBn 0.01442f
C410 PrSFBp openDVS_pixel_3.vsf 0.22518f
C411 openDVS_pixel_3.vpr openDVS_pixel_0.vpr 0.04796f
C412 openDVS_pixel_0.vdiff PrSFBp 0.35361f
C413 pixRst[1] openDVS_pixel_3.nRst 0.08095f
C414 openDVS_pixel_3.nOFF openDVS_pixel_3.vsf 0.0918f
C415 openDVS_pixel_0.nRst rowReadON[0] 0.03176f
C416 openDVS_pixel_2.vdiff OffBn 0.34053f
C417 openDVS_pixel_1.DiffBn OnBn 0.24507f
C418 vpd[2] DiffBn 0.06583f
C419 openDVS_pixel_2.vd PrSFBp 0.00929f
C420 openDVS_pixel_2.nOFF GndD 0.17875f
C421 openDVS_pixel_3.nRst openDVS_pixel_1.nRst 0.00441f
C422 openDVS_pixel_0.ON a_n3254_125# 0.00314f
C423 openDVS_pixel_0.ON readLine[0] 0.09687f
C424 openDVS_pixel_2.ON OnBn 0.11103f
C425 m1_n137_n1618# vpd[3] 0.00112f
C426 DiffBn_uq1 VddA18 3.30208f
C427 m2_637_n1876# m2_379_n1876# 0.01115f
C428 openDVS_pixel_2.vdiff openDVS_pixel_2.nRst 0.37885f
C429 m1_379_1230# m2_379_1230# 0.01126f
C430 openDVS_pixel_2.vsf GndD 0.47962f
C431 openDVS_pixel_3.vd RefrBp 0.05924f
C432 openDVS_pixel_0.nRst DiffBn_uq1 0.03972f
C433 m1_n2545_n1102# vpd[1] 0.00217f
C434 DiffBn_uq1 rowReadON[0] 0.02072f
C435 openDVS_pixel_3.vd OnBn 0.35778f
C436 m1_n2803_1488# m2_n2803_1488# 0.01126f
C437 vpd[0] PrSFBp 0.00271f
C438 rowReadOFF[1] openDVS_pixel_2.ON 0.0574f
C439 readLine[0] pixRst[0] 3.45468f
C440 openDVS_pixel_2.vdiff openDVS_pixel_1.vpr 0.00107f
C441 openDVS_pixel_2.vd openDVS_pixel_2.vpr 0.02621f
C442 PrBp openDVS_pixel_1.vsf 0.02141f
C443 vpd[3] m1_121_n1102# 0.00217f
C444 readLine[1] openDVS_pixel_1.vd 0.00508f
C445 vpd[3] openDVS_pixel_1.vsf 0.07157f
C446 m1_n137_n1360# m2_n137_n1360# 0.01126f
C447 a_n3254_n281# readLine[0] 0.0037f
C448 openDVS_pixel_3.vdiff DiffBn 0.13826f
C449 openDVS_pixel_3.vd openDVS_pixel_3.vpr 0.02623f
C450 m1_n2803_n1102# m2_n2803_n1102# 0.01126f
C451 openDVS_pixel_3.nRst GndD 0.00484f
C452 readLine[1] OffBn 0.00271f
C453 m1_n3061_n844# m1_n3061_n1102# 0.01021f
C454 rowReadON[1] openDVS_pixel_3.vsf 0.01747f
C455 openDVS_pixel_0.vdiff rowReadON[1] 0.00365f
C456 openDVS_pixel_3.vdiff openDVS_pixel_0.vpr 0.00107f
C457 m2_n2287_n1102# m1_n2287_n1102# 0.01126f
C458 openDVS_pixel_1.vd VddA18 4.27232f
C459 m1_n3061_n1618# openDVS_pixel_2.vsf 0.00712f
C460 openDVS_pixel_3.vd vpd[2] 0.03846f
C461 openDVS_pixel_2.vd rowReadON[1] 0.00276f
C462 openDVS_pixel_0.nOFF openDVS_pixel_0.vd 0.01149f
C463 openDVS_pixel_1.vdiff openDVS_pixel_3.vsf 0.00156f
C464 openDVS_pixel_1.vdiff m2_637_n1876# 0.02921f
C465 VddA18 OffBn 2.75524f
C466 a_n3254_125# GndD 0.00974f
C467 readLine[0] GndD 0.59188f
C468 readLine[1] openDVS_pixel_1.nOFF 0.01086f
C469 openDVS_pixel_0.nRst OffBn 0.04175f
C470 rowReadON[0] OffBn 0.02839f
C471 vpd[3] m1_121_n1360# 0.00217f
C472 VddA18 openDVS_pixel_2.nRst 2.15493f
C473 openDVS_pixel_0.nOFF openDVS_pixel_0.vsf 0.0918f
C474 openDVS_pixel_0.vdiff openDVS_pixel_0.ON 0.17527f
C475 openDVS_pixel_0.nOFF rowReadOFF[0] 0.08313f
C476 a_1070_435# rowReadON[0] 0.00336f
C477 m2_n2803_n1876# m1_n2803_n1876# 0.01126f
C478 openDVS_pixel_0.nOFF a_n2994_125# 0.00168f
C479 PrBp openDVS_pixel_0.vsf 0.00872f
C480 openDVS_pixel_0.nRst openDVS_pixel_2.nRst 0.00441f
C481 PrBp rowReadOFF[0] 0.01434f
C482 openDVS_pixel_2.vdiff PrBp 0.18695f
C483 openDVS_pixel_1.nOFF VddA18 0.7785f
C484 m1_637_n1876# OnBn 0.00154f
C485 RefrBp openDVS_pixel_1.vsf 0.01027f
C486 DiffBn_uq1 OffBn 3.85643f
C487 openDVS_pixel_1.ON openDVS_pixel_3.vsf 0.0014f
C488 pixRst[1] openDVS_pixel_3.vsf 0.05659f
C489 OnBn openDVS_pixel_1.vsf 0.71122f
C490 openDVS_pixel_3.vdiff openDVS_pixel_3.vd 0.57037f
C491 openDVS_pixel_1.vpr VddA18 1.28092f
C492 m2_379_972# m1_379_972# 0.01126f
C493 a_528_125# openDVS_pixel_3.nOFF 0.00168f
C494 m1_637_n1876# m1_379_n1876# 0.01021f
C495 DiffBn_uq1 openDVS_pixel_2.nRst 0.03956f
C496 openDVS_pixel_0.vdiff pixRst[0] 0.00557f
C497 openDVS_pixel_2.vpr PrSFBp 0.04022f
C498 m1_379_n1876# openDVS_pixel_1.vsf 0.00703f
C499 openDVS_pixel_1.ON a_528_n281# 0.00126f
C500 openDVS_pixel_2.vd pixRst[0] 0.00113f
C501 m1_n3061_972# m1_n3061_1230# 0.01021f
C502 openDVS_pixel_3.vsf m2_379_1746# 0.0287f
C503 vpd[2] m1_121_972# 0.00217f
C504 rowReadOFF[1] openDVS_pixel_1.vsf 0.07403f
C505 openDVS_pixel_0.vd RefrBp 0.01069f
C506 m2_121_972# m1_121_972# 0.01126f
C507 OnBn openDVS_pixel_0.vd 0.05285f
C508 PrSFBp rowReadON[1] 0.01434f
C509 m2_n2029_n844# m1_n2029_n844# 0.01126f
C510 openDVS_pixel_1.vd OffBn 0.02392f
C511 openDVS_pixel_3.vd openDVS_pixel_3.ON 0.00572f
C512 m2_n2803_n1618# openDVS_pixel_2.vsf 0.00145f
C513 openDVS_pixel_1.vdiff PrSFBp 0.14088f
C514 m1_n2029_n1102# m2_n2029_n1102# 0.01126f
C515 RefrBp openDVS_pixel_0.vsf 0.00112f
C516 openDVS_pixel_3.vsf GndD 0.47962f
C517 rowReadOFF[0] RefrBp 0.01435f
C518 openDVS_pixel_0.vdiff GndD 0.63037f
C519 vpd[0] m1_n2545_1230# 0.00217f
C520 openDVS_pixel_2.ON openDVS_pixel_2.nOFF 0.8177f
C521 OnBn openDVS_pixel_0.vsf 0.47964f
C522 openDVS_pixel_2.vd GndD 0.05667f
C523 openDVS_pixel_2.vdiff RefrBp 0.11489f
C524 rowReadOFF[0] OnBn 0.02075f
C525 DiffBn openDVS_pixel_3.nRst 0.00236f
C526 m1_379_1746# m2_379_1746# 0.01126f
C527 openDVS_pixel_0.nOFF VddA18 0.7785f
C528 m2_n2545_n844# m1_n2545_n844# 0.01126f
C529 openDVS_pixel_2.vdiff OnBn 0.53481f
C530 m2_n2803_1746# openDVS_pixel_0.vsf 0.0287f
C531 PrBp VddA18 2.49106f
C532 openDVS_pixel_2.vdiff m2_n3061_n1876# 0.02921f
C533 openDVS_pixel_0.nRst openDVS_pixel_0.nOFF 0.08648f
C534 m1_n2029_972# m2_n2029_972# 0.01126f
C535 a_528_n281# GndD 0.00883f
C536 vpd[3] VddA18 0.21159f
C537 m1_n2803_1746# openDVS_pixel_0.vsf 0.00703f
C538 openDVS_pixel_2.ON openDVS_pixel_2.vsf 0.07438f
C539 m1_637_n1102# openDVS_pixel_1.vsf 0.00668f
C540 openDVS_pixel_0.nRst PrBp 0.018f
C541 openDVS_pixel_0.nOFF rowReadON[0] 0.03698f
C542 openDVS_pixel_2.nRst OffBn 0.04119f
C543 vpd[2] m1_121_1230# 0.00217f
C544 m1_637_n844# openDVS_pixel_1.vsf 0.00678f
C545 m1_n3061_n1102# openDVS_pixel_2.vsf 0.00668f
C546 openDVS_pixel_1.vd openDVS_pixel_1.nOFF 0.01149f
C547 PrBp rowReadON[0] 0.01434f
C548 a_788_n281# rowReadON[1] 0.00812f
C549 m1_n137_714# m2_n137_714# 0.01126f
C550 rowReadOFF[1] openDVS_pixel_0.vsf 0.01196f
C551 rowReadOFF[1] rowReadOFF[0] 0.0371f
C552 openDVS_pixel_3.vdiff openDVS_pixel_1.vsf 0.00156f
C553 openDVS_pixel_1.vdiff openDVS_pixel_2.vpr 0.00107f
C554 openDVS_pixel_1.nOFF OffBn 0.09214f
C555 openDVS_pixel_1.vd openDVS_pixel_1.vpr 0.02621f
C556 openDVS_pixel_2.vdiff rowReadOFF[1] 0.02703f
C557 m2_379_n1102# m1_379_n1102# 0.01126f
C558 pixRst[1] openDVS_pixel_3.nOFF 0.00166f
C559 openDVS_pixel_0.nOFF DiffBn_uq1 0.0028f
C560 vpd[3] m2_121_n1876# 0.00171f
C561 PrSFBp openDVS_pixel_1.nRst 0.04094f
C562 m1_n3061_1488# openDVS_pixel_0.vsf 0.00712f
C563 openDVS_pixel_1.vpr OffBn 0.14102f
C564 openDVS_pixel_0.vsf m2_n2803_1488# 0.00145f
C565 m1_n3061_972# m1_n3061_714# 0.01021f
C566 openDVS_pixel_2.vdiff m1_n3061_n844# 0.00938f
C567 vpd[2] m1_n137_972# 0.00217f
C568 openDVS_pixel_1.vdiff rowReadON[1] 0.00843f
C569 readLine[1] OnBn 0.00324f
C570 vpd[1] m1_n2287_n1360# 0.00217f
C571 openDVS_pixel_3.vd openDVS_pixel_3.nRst 0.06242f
C572 vpd[1] m1_n2287_n1102# 0.00217f
C573 vpd[1] m1_n2287_n1618# 0.00112f
C574 openDVS_pixel_2.ON readLine[0] 0.09687f
C575 openDVS_pixel_1.ON a_788_n281# 0.00314f
C576 VddA18 RefrBp 4.33169f
C577 vpd[1] m2_n2287_n1360# 0.00221f
C578 openDVS_pixel_3.ON openDVS_pixel_1.vsf 0.0014f
C579 rowReadON[1] a_n3520_n607# 0.00336f
C580 OnBn VddA18 3.89627f
C581 openDVS_pixel_2.vpr pixRst[0] 0.00207f
C582 openDVS_pixel_0.nRst RefrBp 0.07324f
C583 PrSFBp GndD 0.12899f
C584 rowReadOFF[1] readLine[1] 0.13225f
C585 openDVS_pixel_3.vdiff rowReadOFF[0] 0.02703f
C586 RefrBp rowReadON[0] 0.01434f
C587 openDVS_pixel_0.nRst OnBn 0.01061f
C588 openDVS_pixel_3.nOFF GndD 0.17874f
C589 openDVS_pixel_1.vd PrBp 0.0031f
C590 OnBn rowReadON[0] 0.02088f
C591 pixRst[1] rowReadON[1] 0.10756f
C592 openDVS_pixel_1.ON rowReadON[1] 0.21792f
C593 vpd[3] openDVS_pixel_1.vd 0.03869f
C594 openDVS_pixel_0.nOFF OffBn 0.09218f
C595 rowReadON[1] openDVS_pixel_1.nRst 0.03176f
C596 PrBp OffBn 0.08477f
C597 openDVS_pixel_3.vpr VddA18 0.533f
C598 openDVS_pixel_1.vdiff pixRst[1] 0.00551f
C599 OnBn m2_121_n1876# 0.01453f
C600 rowReadOFF[1] VddA18 0.65497f
C601 rowReadON[1] pixRst[0] 0.10756f
C602 openDVS_pixel_1.vdiff openDVS_pixel_1.ON 0.17527f
C603 DiffBn_uq1 RefrBp 0.02729f
C604 vpd[3] OffBn 0.03962f
C605 a_528_125# GndD 0.00883f
C606 DiffBn openDVS_pixel_3.vsf 0.15304f
C607 m1_n395_n1618# m2_n395_n1618# 0.01126f
C608 DiffBn_uq1 OnBn 0.52875f
C609 openDVS_pixel_1.vdiff openDVS_pixel_1.nRst 0.37827f
C610 openDVS_pixel_2.vsf openDVS_pixel_1.vsf 0.02957f
C611 a_n3254_n281# rowReadON[1] 0.00812f
C612 PrBp openDVS_pixel_2.nRst 0.01793f
C613 m1_n3061_1230# openDVS_pixel_0.vsf 0.00664f
C614 rowReadOFF[1] rowReadON[0] 0.00278f
C615 vpd[2] VddA18 0.1542f
C616 m1_121_1230# m2_121_1230# 0.01126f
C617 m2_n137_1230# m1_n137_1230# 0.01126f
C618 OnBn m1_n3061_n1876# 0.00154f
C619 vpd[0] m2_n2545_1746# 0.00171f
C620 m2_n137_n844# m1_n137_n844# 0.01126f
C621 openDVS_pixel_0.vdiff openDVS_pixel_0.vpr 0.03774f
C622 m2_n2545_972# m1_n2545_972# 0.01126f
C623 m1_637_1746# OnBn 0.00154f
C624 a_788_n281# GndD 0.00974f
C625 openDVS_pixel_3.vdiff m1_637_1230# 0.00987f
C626 m2_n3061_n1876# m1_n3061_n1876# 0.01126f
C627 m1_n2545_1746# vpd[0] 0.01847f
C628 m1_637_972# m1_637_1230# 0.01021f
C629 openDVS_pixel_3.ON rowReadOFF[0] 0.05739f
C630 rowReadOFF[1] DiffBn_uq1 0.02074f
C631 openDVS_pixel_0.ON pixRst[0] 0.12107f
C632 openDVS_pixel_1.vpr PrBp 0.04123f
C633 pixRst[0] a_n3520_n607# 0.00105f
C634 m1_n2029_n1360# m2_n2029_n1360# 0.01126f
C635 m2_379_1488# openDVS_pixel_3.vsf 0.00145f
C636 openDVS_pixel_1.ON pixRst[1] 0.12107f
C637 openDVS_pixel_3.vdiff readLine[1] 0.00623f
C638 rowReadON[1] GndD 0.41506f
C639 vpd[0] m1_n2545_1488# 0.00112f
C640 vpd[3] openDVS_pixel_1.vpr 0.22393f
C641 OnBn m2_n2545_n1876# 0.0145f
C642 pixRst[1] openDVS_pixel_1.nRst 0.08095f
C643 openDVS_pixel_1.ON openDVS_pixel_1.nRst 0.05094f
C644 vpd[0] openDVS_pixel_0.vpr 0.22393f
C645 openDVS_pixel_1.vd RefrBp 0.05875f
C646 openDVS_pixel_0.vdiff m1_n3061_972# 0.00947f
C647 openDVS_pixel_1.vdiff GndD 0.63037f
C648 openDVS_pixel_2.vd openDVS_pixel_2.ON 0.00572f
C649 openDVS_pixel_2.vdiff openDVS_pixel_2.nOFF 0.64523f
C650 openDVS_pixel_1.vd OnBn 0.35539f
C651 openDVS_pixel_3.vdiff VddA18 3.37647f
C652 RefrBp OffBn 0.11536f
C653 openDVS_pixel_0.vsf openDVS_pixel_2.vsf 0.19726f
C654 rowReadOFF[0] openDVS_pixel_2.vsf 0.01196f
C655 openDVS_pixel_3.vd openDVS_pixel_3.vsf 2.20422f
C656 openDVS_pixel_0.nRst openDVS_pixel_3.vdiff 0.00195f
C657 OnBn OffBn 6.23814f
C658 m2_379_n1618# openDVS_pixel_1.vsf 0.00145f
C659 openDVS_pixel_3.vdiff rowReadON[0] 0.00843f
C660 openDVS_pixel_2.vdiff openDVS_pixel_2.vsf 0.5785f
C661 openDVS_pixel_0.ON GndD 0.24091f
C662 RefrBp openDVS_pixel_2.nRst 0.07324f
C663 OnBn openDVS_pixel_2.nRst 0.01061f
C664 rowReadOFF[1] openDVS_pixel_1.vd 0.00298f
C665 readLine[1] openDVS_pixel_3.ON 0.09687f
C666 pixRst[1] GndD 0.21716f
C667 m1_n137_n1618# m2_n137_n1618# 0.01126f
C668 openDVS_pixel_3.vpr OffBn 0.14102f
C669 openDVS_pixel_1.ON GndD 0.24091f
C670 m1_n2545_n1876# m2_n2545_n1876# 0.01126f
C671 rowReadOFF[1] OffBn 0.01442f
C672 openDVS_pixel_1.nOFF OnBn 0.0028f
C673 m1_n3061_714# openDVS_pixel_0.vsf 0.00678f
C674 openDVS_pixel_1.nRst GndD 0.00484f
C675 readLine[0] openDVS_pixel_0.vd 0.00508f
C676 openDVS_pixel_1.vpr RefrBp 0.04217f
C677 pixRst[0] GndD 0.21716f
C678 PrSFBp openDVS_pixel_0.vpr 0.0357f
C679 openDVS_pixel_1.vpr OnBn 0.11385f
C680 openDVS_pixel_3.ON VddA18 0.32745f
C681 vpd[2] OffBn 0.03962f
C682 a_n3254_n281# GndD 0.00974f
C683 m1_121_1746# m2_121_1746# 0.01126f
C684 a_788_125# GndD 0.00974f
C685 OnBn m2_121_1746# 0.01453f
C686 openDVS_pixel_3.ON rowReadON[0] 0.21792f
C687 rowReadOFF[1] openDVS_pixel_1.nOFF 0.08314f
C688 m1_n3061_n844# openDVS_pixel_2.nRst 0.01253f
C689 readLine[0] openDVS_pixel_0.vsf 0.05667f
C690 rowReadOFF[0] readLine[0] 0.13224f
C691 m1_n137_n1102# m2_n137_n1102# 0.01126f
C692 readLine[0] a_n2994_125# 0.0037f
C693 openDVS_pixel_2.nOFF VddA18 0.7785f
C694 openDVS_pixel_2.vdiff readLine[0] 0.00615f
C695 m1_637_1488# m1_637_1230# 0.01021f
C696 openDVS_pixel_2.vdiff vpd[1] 0.01037f
C697 m1_637_n1102# m1_637_n1360# 0.01021f
C698 m2_n3061_1746# openDVS_pixel_0.vsf 0.02952f
C699 openDVS_pixel_3.vdiff openDVS_pixel_1.vd 0.00221f
C700 m1_637_n1876# m2_637_n1876# 0.01126f
C701 m1_n2803_n1618# m2_n2803_n1618# 0.01126f
C702 VddA18 openDVS_pixel_2.vsf 1.01313f
C703 m1_637_1746# m2_637_1746# 0.01126f
C704 openDVS_pixel_3.vsf openDVS_pixel_1.vsf 0.19726f
C705 m2_637_n1876# openDVS_pixel_1.vsf 0.02952f
C706 m2_n2545_n1102# m1_n2545_n1102# 0.01126f
C707 openDVS_pixel_3.vdiff OffBn 0.20823f
C708 openDVS_pixel_3.vd PrSFBp 0.00632f
C709 rowReadON[0] openDVS_pixel_2.vsf 0.01747f
C710 vpd[2] m2_121_1746# 0.00171f
C711 m1_n2545_n1618# m2_n2545_n1618# 0.01126f
C712 readLine[1] openDVS_pixel_3.nRst 0.20309f
C713 openDVS_pixel_3.vd openDVS_pixel_3.nOFF 0.01149f
C714 openDVS_pixel_2.nOFF DiffBn_uq1 0.0028f
C715 PrBp RefrBp 2.55722f
C716 m1_n2029_n1618# m2_n2029_n1618# 0.01126f
C717 vpd[3] RefrBp 0.00269f
C718 PrBp OnBn 0.12432f
C719 m1_n3061_1746# openDVS_pixel_0.vsf 0.00648f
C720 vpd[3] OnBn 0.03783f
C721 VddA18 openDVS_pixel_3.nRst 2.1406f
C722 DiffBn_uq1 openDVS_pixel_2.vsf 0.38479f
C723 m1_n3061_n1360# openDVS_pixel_2.vsf 0.00664f
C724 openDVS_pixel_0.nRst m1_n3061_714# 0.01253f
C725 openDVS_pixel_0.vdiff openDVS_pixel_0.vd 0.57036f
C726 openDVS_pixel_0.nRst openDVS_pixel_3.nRst 0.12596f
C727 openDVS_pixel_2.vsf m1_n3061_n1876# 0.00648f
C728 openDVS_pixel_2.vd openDVS_pixel_0.vd 0.12479f
C729 openDVS_pixel_3.nRst rowReadON[0] 0.03176f
C730 openDVS_pixel_3.vpr PrBp 0.04123f
C731 rowReadOFF[1] PrBp 0.01434f
C732 openDVS_pixel_3.ON OffBn 0.16176f
C733 openDVS_pixel_2.ON rowReadON[1] 0.21792f
C734 readLine[0] VddA18 0.07625f
C735 DiffBn pixRst[1] 0.05232f
C736 openDVS_pixel_1.vdiff openDVS_pixel_1.DiffBn 0.13826f
C737 openDVS_pixel_0.vsf openDVS_pixel_3.vsf 0.02957f
C738 openDVS_pixel_0.vdiff openDVS_pixel_0.vsf 0.57911f
C739 rowReadOFF[0] openDVS_pixel_3.vsf 0.07403f
C740 openDVS_pixel_0.vdiff rowReadOFF[0] 0.02703f
C741 vpd[1] VddA18 0.21391f
C742 openDVS_pixel_0.nRst readLine[0] 0.20309f
C743 vpd[0] openDVS_pixel_0.vd 0.03869f
C744 m2_n2545_n1876# openDVS_pixel_2.vsf 0.03728f
C745 openDVS_pixel_0.vdiff openDVS_pixel_2.vdiff 0.29696f
C746 a_n3254_125# rowReadON[0] 0.00812f
C747 readLine[0] rowReadON[0] 0.15034f
C748 openDVS_pixel_1.vdiff m1_637_n1618# 0.0197f
C749 openDVS_pixel_2.vdiff openDVS_pixel_2.vd 0.57034f
C750 m1_637_1746# m1_637_1488# 0.01021f
C751 openDVS_pixel_2.nOFF OffBn 0.09218f
C752 openDVS_pixel_0.vpr pixRst[0] 0.00214f
C753 rowReadOFF[1] a_n2994_n281# 0.0059f
C754 openDVS_pixel_3.vd openDVS_pixel_1.vdiff 0.00221f
C755 m2_n395_1488# m1_n395_1488# 0.01126f
C756 m1_n2287_1488# m2_n2287_1488# 0.01126f
C757 openDVS_pixel_2.ON openDVS_pixel_0.ON 0.02941f
C758 OnBn RefrBp 2.77422f
C759 vpd[0] m1_n2287_972# 0.00217f
C760 readLine[0] DiffBn_uq1 0.06445f
C761 vpd[0] m2_n2287_1230# 0.00221f
C762 vpd[0] openDVS_pixel_0.vsf 0.07135f
C763 openDVS_pixel_2.nOFF openDVS_pixel_2.nRst 0.08648f
C764 openDVS_pixel_2.vsf OffBn 0.24959f
C765 a_n3520_435# pixRst[0] 0.00105f
C766 PrSFBp openDVS_pixel_1.vsf 0.22518f
C767 m1_n2545_n1360# m2_n2545_n1360# 0.01126f
C768 pixRst[1] openDVS_pixel_1.DiffBn 0.04546f
C769 vpd[1] DiffBn_uq1 0.06723f
C770 OnBn m2_n3061_n1876# 0.02589f
C771 OnBn m2_n2803_1746# 0.02589f
C772 m1_637_1230# openDVS_pixel_3.vsf 0.00664f
C773 openDVS_pixel_1.DiffBn openDVS_pixel_1.nRst 0.00236f
C774 openDVS_pixel_2.nRst openDVS_pixel_2.vsf 0.13859f
C775 m1_n2803_1746# OnBn 0.0013f
C776 openDVS_pixel_3.vdiff m1_637_714# 0.00938f
C777 OnBn m1_379_n1876# 0.0013f
C778 openDVS_pixel_3.vdiff PrBp 0.40517f
C779 m2_379_n1876# openDVS_pixel_1.vsf 0.0287f
C780 openDVS_pixel_1.ON m1_637_n1618# 0.00106f
C781 openDVS_pixel_3.vpr RefrBp 0.04218f
C782 vpd[0] m1_n2287_1230# 0.00217f
C783 m1_637_972# m1_637_714# 0.01021f
C784 rowReadOFF[1] RefrBp 0.01435f
C785 m1_n2803_1746# m2_n2803_1746# 0.01126f
C786 openDVS_pixel_3.vpr OnBn 0.11396f
C787 openDVS_pixel_2.ON pixRst[0] 0.12107f
C788 m1_n2287_714# m2_n2287_714# 0.01126f
C789 readLine[1] openDVS_pixel_3.vsf 0.05667f
C790 rowReadOFF[1] OnBn 0.02075f
C791 openDVS_pixel_3.vd pixRst[1] 0.00113f
C792 openDVS_pixel_3.nRst OffBn 0.02737f
C793 openDVS_pixel_2.ON a_n3254_n281# 0.00314f
C794 vpd[2] RefrBp 0.00269f
C795 PrSFBp openDVS_pixel_0.vd 0.00929f
C796 m1_121_714# m2_121_714# 0.01126f
C797 vpd[2] m1_121_1746# 0.01847f
C798 openDVS_pixel_3.nRst a_1070_435# 0.01085f
C799 vpd[2] OnBn 0.03777f
C800 vpd[1] m2_n2545_n1876# 0.00171f
C801 readLine[1] a_528_n281# 0.0037f
C802 VddA18 openDVS_pixel_3.vsf 0.90024f
C803 openDVS_pixel_0.vdiff VddA18 3.39097f
C804 openDVS_pixel_2.vd VddA18 4.27255f
C805 openDVS_pixel_0.vdiff openDVS_pixel_0.nRst 0.37892f
C806 PrSFBp openDVS_pixel_0.vsf 0.23151f
C807 PrSFBp rowReadOFF[0] 0.01434f
C808 openDVS_pixel_3.vsf rowReadON[0] 0.03922f
C809 readLine[0] OffBn 0.00271f
C810 m1_121_n1618# m2_121_n1618# 0.01126f
C811 openDVS_pixel_0.vdiff rowReadON[0] 0.00843f
C812 rowReadON[1] openDVS_pixel_1.vsf 0.03922f
C813 vpd[2] openDVS_pixel_3.vpr 0.22362f
C814 rowReadOFF[0] openDVS_pixel_3.nOFF 0.08313f
C815 openDVS_pixel_2.vdiff PrSFBp 0.35278f
C816 openDVS_pixel_2.ON GndD 0.24091f
C817 vpd[1] OffBn 0.03962f
C818 readLine[0] openDVS_pixel_2.nRst 0.20309f
C819 openDVS_pixel_1.vdiff openDVS_pixel_1.vsf 0.57809f
C820 vpd[0] VddA18 0.1518f
C821 vpd[1] openDVS_pixel_2.nRst 0.01091f
C822 openDVS_pixel_3.vdiff RefrBp 0.27274f
C823 m1_n2029_1488# m2_n2029_1488# 0.01126f
C824 openDVS_pixel_2.nOFF openDVS_pixel_0.nOFF 0.01293f
C825 openDVS_pixel_0.vdiff DiffBn_uq1 0.29461f
C826 openDVS_pixel_3.vd GndD 0.05667f
C827 rowReadOFF[0] a_528_125# 0.0059f
C828 openDVS_pixel_0.nRst vpd[0] 0.01059f
C829 openDVS_pixel_3.vdiff OnBn 0.69034f
C830 openDVS_pixel_2.vd DiffBn_uq1 0.327f
C831 m1_637_1746# openDVS_pixel_3.vsf 0.00648f
C832 vpd[1] m1_n2545_n1618# 0.00112f
C833 PrBp openDVS_pixel_2.vsf 0.00872f
C834 openDVS_pixel_2.vdiff openDVS_pixel_2.vpr 0.03758f
C835 vpd[3] m1_n137_n1102# 0.00217f
C836 m1_n2545_1746# m2_n2545_1746# 0.01126f
C837 openDVS_pixel_3.vdiff openDVS_pixel_3.vpr 0.03774f
C838 openDVS_pixel_2.ON m1_n3061_n1618# 0.00106f
C839 vpd[0] DiffBn_uq1 0.06717f
C840 openDVS_pixel_3.vdiff rowReadOFF[1] 0.00263f
C841 pixRst[1] openDVS_pixel_1.vsf 0.05659f
C842 openDVS_pixel_1.ON openDVS_pixel_1.vsf 0.07438f
C843 m1_n2287_972# m2_n2287_972# 0.01126f
C844 rowReadON[1] openDVS_pixel_0.vsf 0.01747f
C845 openDVS_pixel_2.nOFF a_n2994_n281# 0.00168f
C846 rowReadOFF[0] rowReadON[1] 0.00278f
C847 readLine[1] openDVS_pixel_3.nOFF 0.01086f
C848 openDVS_pixel_1.nRst openDVS_pixel_1.vsf 0.13862f
C849 openDVS_pixel_2.vdiff rowReadON[1] 0.00843f
C850 openDVS_pixel_3.vdiff vpd[2] 0.01037f
C851 m1_n137_1488# m2_n137_1488# 0.01126f
C852 vpd[3] m2_n137_n1360# 0.00221f
C853 openDVS_pixel_0.ON openDVS_pixel_0.vd 0.00572f
C854 m2_637_1746# OnBn 0.02589f
C855 m1_379_1746# m1_637_1746# 0.01021f
C856 openDVS_pixel_1.vdiff rowReadOFF[0] 0.00263f
R0 readLine[1].n3 readLine[1].n2 208.198
R1 readLine[1].n1 readLine[1].n0 208.198
R2 readLine[1].n2 readLine[1].t3 71.4291
R3 readLine[1].n2 readLine[1].t1 71.4291
R4 readLine[1].n0 readLine[1].t0 71.4291
R5 readLine[1].n0 readLine[1].t2 71.4291
R6 readLine[1].n4 readLine[1].n3 4.95652
R7 readLine[1].n1 readLine[1] 4.75855
R8 readLine[1].n3 readLine[1].n1 0.48359
R9 rowReadOFF[1].n0 rowReadOFF[1].t0 322.502
R10 rowReadOFF[1].n2 rowReadOFF[1].t1 322.502
R11 rowReadOFF[1].n3 rowReadOFF[1].n1 15.9579
R12 rowReadOFF[1].n1 rowReadOFF[1].n0 4.96772
R13 rowReadOFF[1].n3 rowReadOFF[1].n2 4.96772
R14 rowReadOFF[1].n4 rowReadOFF[1].n3 2.48882
R15 rowReadOFF[1].n1 rowReadOFF[1] 2.25668
R16 rowReadOFF[1].n0 rowReadOFF[1] 0.0575652
R17 rowReadOFF[1].n2 rowReadOFF[1] 0.0575652
R18 rowReadON[1].n3 rowReadON[1].t1 468.889
R19 rowReadON[1].n0 rowReadON[1].t0 468.889
R20 rowReadON[1].n3 rowReadON[1].t3 313.202
R21 rowReadON[1].n0 rowReadON[1].t2 313.202
R22 rowReadON[1].n5 rowReadON[1].n2 17.5472
R23 rowReadON[1].n4 rowReadON[1].n3 9.3005
R24 rowReadON[1].n1 rowReadON[1].n0 9.3005
R25 rowReadON[1].n5 rowReadON[1].n4 5.14191
R26 rowReadON[1].n2 rowReadON[1].n1 5.14191
R27 rowReadON[1].n6 rowReadON[1].n5 1.80957
R28 rowReadON[1].n2 rowReadON[1] 1.57742
R29 rowReadON[1].n4 rowReadON[1] 0.0575652
R30 rowReadON[1].n1 rowReadON[1] 0.0575652
R31 readLine[0].n1 readLine[0].n0 194.3
R32 readLine[0].n4 readLine[0].n3 194.3
R33 readLine[0].n0 readLine[0].t2 71.4291
R34 readLine[0].n0 readLine[0].t1 71.4291
R35 readLine[0].n3 readLine[0].t3 71.4291
R36 readLine[0].n3 readLine[0].t0 71.4291
R37 readLine[0].n2 readLine[0].n1 13.8358
R38 readLine[0].n5 readLine[0].n4 13.8358
R39 readLine[0].n2 readLine[0] 4.95652
R40 readLine[0].n6 readLine[0].n5 4.75855
R41 readLine[0].n5 readLine[0].n2 0.48359
R42 readLine[0].n1 readLine[0] 0.063
R43 readLine[0].n4 readLine[0] 0.063
R44 GndD.n16 GndD.t3 237.202
R45 GndD.n3 GndD.t1 237.202
R46 GndD.n1 GndD.t2 237.202
R47 GndD.n15 GndD.t5 237.202
R48 GndD.n2 GndD.t0 237.157
R49 GndD.n8 GndD.t7 237.157
R50 GndD.n10 GndD.t4 237.157
R51 GndD.n13 GndD.t6 237.157
R52 GndD.n5 GndD 4.55519
R53 GndD.n9 GndD 4.55519
R54 GndD GndD.n0 4.55519
R55 GndD.n14 GndD 4.55519
R56 GndD.n11 GndD.n0 4.5005
R57 GndD.n6 GndD.n5 4.5005
R58 GndD.n14 GndD.n12 4.5005
R59 GndD.n9 GndD.n7 4.5005
R60 GndD.n5 GndD.n0 2.95407
R61 GndD.n14 GndD.n9 2.95407
R62 GndD.n15 GndD.n14 2.71744
R63 GndD.n9 GndD.n1 2.71744
R64 GndD.n17 GndD.n16 2.24764
R65 GndD.n4 GndD.n3 2.24764
R66 GndD.n16 GndD.n15 0.707079
R67 GndD.n3 GndD.n1 0.707079
R68 GndD.n7 GndD.n6 0.598156
R69 GndD.n12 GndD.n11 0.598156
R70 GndD.n5 GndD.n4 0.489478
R71 GndD.n17 GndD.n0 0.489478
R72 GndD.n18 GndD.n17 0.243357
R73 GndD.n4 GndD 0.196929
R74 GndD.n6 GndD.n2 0.0981562
R75 GndD.n8 GndD.n7 0.0981562
R76 GndD.n11 GndD.n10 0.0981562
R77 GndD.n13 GndD.n12 0.0981562
R78 GndD GndD.n2 0.0180781
R79 GndD GndD.n8 0.0180781
R80 GndD.n10 GndD 0.0180781
R81 GndD GndD.n13 0.0180781
R82 rowReadOFF[0].n0 rowReadOFF[0].t0 322.502
R83 rowReadOFF[0].n2 rowReadOFF[0].t1 322.502
R84 rowReadOFF[0].n3 rowReadOFF[0].n1 15.9579
R85 rowReadOFF[0].n1 rowReadOFF[0].n0 4.96772
R86 rowReadOFF[0].n3 rowReadOFF[0].n2 4.96772
R87 rowReadOFF[0].n4 rowReadOFF[0].n3 2.48882
R88 rowReadOFF[0].n1 rowReadOFF[0] 2.25668
R89 rowReadOFF[0].n0 rowReadOFF[0] 0.0575652
R90 rowReadOFF[0].n2 rowReadOFF[0] 0.0575652
R91 pixRst[1] pixRst[1].t1 322.741
R92 pixRst[1] pixRst[1].t0 322.741
R93 pixRst[1].n1 pixRst[1] 11.452
R94 pixRst[1].n0 pixRst[1] 11.452
R95 pixRst[1].n2 pixRst[1].n1 4.95652
R96 pixRst[1].n0 pixRst[1] 4.75855
R97 pixRst[1].n1 pixRst[1].n0 0.48359
R98 pixRst[0] pixRst[0].t0 322.741
R99 pixRst[0] pixRst[0].t1 322.741
R100 pixRst[0].n1 pixRst[0] 11.452
R101 pixRst[0].n0 pixRst[0] 11.452
R102 pixRst[0].n0 pixRst[0] 4.95652
R103 pixRst[0].n2 pixRst[0].n1 4.75855
R104 pixRst[0].n1 pixRst[0].n0 0.48359
R105 rowReadON[0].n3 rowReadON[0].t3 468.889
R106 rowReadON[0].n0 rowReadON[0].t2 468.889
R107 rowReadON[0].n3 rowReadON[0].t1 313.202
R108 rowReadON[0].n0 rowReadON[0].t0 313.202
R109 rowReadON[0].n5 rowReadON[0].n2 17.5472
R110 rowReadON[0].n4 rowReadON[0].n3 9.3005
R111 rowReadON[0].n1 rowReadON[0].n0 9.3005
R112 rowReadON[0].n5 rowReadON[0].n4 5.14191
R113 rowReadON[0].n2 rowReadON[0].n1 5.14191
R114 rowReadON[0].n6 rowReadON[0].n5 1.80957
R115 rowReadON[0].n2 rowReadON[0] 1.57742
R116 rowReadON[0].n4 rowReadON[0] 0.0575652
R117 rowReadON[0].n1 rowReadON[0] 0.0575652
R118 RefrBp.n2 RefrBp.n0 99.5497
R119 RefrBp.n10 RefrBp.n8 99.5497
R120 RefrBp.n3 RefrBp.n2 93.5476
R121 RefrBp.n11 RefrBp.n10 93.5476
R122 RefrBp.n1 RefrBp.t1 59.5326
R123 RefrBp.n9 RefrBp.t3 59.5326
R124 RefrBp.n4 RefrBp.n0 29.507
R125 RefrBp.n12 RefrBp.n8 29.507
R126 RefrBp.n3 RefrBp.n1 23.0638
R127 RefrBp.n11 RefrBp.n9 23.0638
R128 RefrBp.n4 RefrBp.n3 11.3247
R129 RefrBp.n12 RefrBp.n11 11.3247
R130 RefrBp.n5 RefrBp.n4 9.3005
R131 RefrBp.n13 RefrBp.n12 9.3005
R132 RefrBp.n7 RefrBp.n6 7.91219
R133 RefrBp.n15 RefrBp.n14 7.91219
R134 RefrBp.n2 RefrBp.t0 6.7485
R135 RefrBp.n10 RefrBp.t2 6.7485
R136 RefrBp.n6 RefrBp.n0 4.97707
R137 RefrBp.n14 RefrBp.n8 4.97707
R138 RefrBp.n15 RefrBp.n7 1.48456
R139 RefrBp.n7 RefrBp 0.967561
R140 RefrBp.n16 RefrBp.n15 0.926258
R141 RefrBp.n5 RefrBp.n1 0.196152
R142 RefrBp.n13 RefrBp.n9 0.196152
R143 RefrBp.n6 RefrBp.n5 0.0871627
R144 RefrBp.n14 RefrBp.n13 0.0871627
R145 PrSFBp.n1 PrSFBp.t1 59.1003
R146 PrSFBp.n5 PrSFBp.t3 59.1003
R147 PrSFBp.n0 PrSFBp.t0 59.0996
R148 PrSFBp.n4 PrSFBp.t2 59.0996
R149 PrSFBp.n3 PrSFBp.n2 7.91388
R150 PrSFBp.n7 PrSFBp.n6 7.91388
R151 PrSFBp.n7 PrSFBp.n3 2.16677
R152 PrSFBp.n3 PrSFBp 0.626455
R153 PrSFBp.n8 PrSFBp.n7 0.585151
R154 PrSFBp.n2 PrSFBp.n0 0.396375
R155 PrSFBp.n6 PrSFBp.n4 0.396375
R156 PrSFBp.n2 PrSFBp.n1 0.0615595
R157 PrSFBp.n6 PrSFBp.n5 0.0615595
R158 PrSFBp.n0 PrSFBp 0.0139972
R159 PrSFBp.n4 PrSFBp 0.0139972
R160 PrSFBp.n1 PrSFBp 0.0124987
R161 PrSFBp.n5 PrSFBp 0.0124987
R162 OffBn.n2 OffBn.t1 76.373
R163 OffBn.n7 OffBn.t3 76.373
R164 OffBn.n0 OffBn.t0 67.0007
R165 OffBn.n5 OffBn.t2 67.0007
R166 OffBn OffBn.n0 18.7964
R167 OffBn OffBn.n5 18.7964
R168 OffBn.n8 OffBn.n6 18.7335
R169 OffBn.n3 OffBn.n1 18.7232
R170 OffBn.n1 OffBn.n0 18.7186
R171 OffBn.n6 OffBn.n5 18.7186
R172 OffBn.n8 OffBn.n7 16.0909
R173 OffBn.n3 OffBn.n2 16.0806
R174 OffBn.n9 OffBn.n8 3.4105
R175 OffBn.n4 OffBn.n3 3.4105
R176 OffBn.n9 OffBn.n4 2.8732
R177 OffBn.n4 OffBn 0.276091
R178 OffBn.n10 OffBn.n9 0.229091
R179 OffBn.n1 OffBn 0.0269423
R180 OffBn.n6 OffBn 0.0269423
R181 OffBn.n2 OffBn 0.0142392
R182 OffBn.n7 OffBn 0.0142392
R183 PrBp.n2 PrBp.t3 174.056
R184 PrBp.n2 PrBp.t2 174.056
R185 PrBp.n0 PrBp.t1 174.056
R186 PrBp.n0 PrBp.t0 174.056
R187 PrBp.n3 PrBp.n2 170.696
R188 PrBp.n1 PrBp.n0 170.696
R189 PrBp.n3 PrBp.n1 2.25792
R190 PrBp.n1 PrBp 0.580879
R191 PrBp.n4 PrBp.n3 0.539576
R192 OnBn.n2 OnBn.t3 97.5819
R193 OnBn.n0 OnBn.t1 97.5819
R194 OnBn.n2 OnBn.t2 89.256
R195 OnBn.n0 OnBn.t0 89.256
R196 OnBn.n1 OnBn.n0 3.4105
R197 OnBn.n3 OnBn.n2 3.4105
R198 OnBn.n3 OnBn.n1 2.78774
R199 OnBn.n1 OnBn 0.31597
R200 OnBn.n4 OnBn.n3 0.274667
R201 DiffBn_uq1.n0 DiffBn_uq1.t1 94.4876
R202 DiffBn_uq1.n0 DiffBn_uq1.t0 91.4881
R203 DiffBn_uq1 DiffBn_uq1.n0 0.209864
R204 VddA18.n112 VddA18.t7 653.41
R205 VddA18.n113 VddA18.t10 653.41
R206 VddA18.n268 VddA18.t11 653.41
R207 VddA18 VddA18.t9 653.41
R208 VddA18.n301 VddA18.n8 594.534
R209 VddA18.n306 VddA18.n305 594.534
R210 VddA18.n300 VddA18.n9 594.301
R211 VddA18.n307 VddA18.n6 594.301
R212 VddA18.t18 VddA18.t16 394.92
R213 VddA18.t31 VddA18.t25 394.92
R214 VddA18.n285 VddA18.t18 343.361
R215 VddA18.t25 VddA18.n69 343.361
R216 VddA18.n284 VddA18.n24 329.142
R217 VddA18.n235 VddA18.n70 329.142
R218 VddA18.t16 VddA18.n284 301.675
R219 VddA18.n70 VddA18.t31 301.675
R220 VddA18.t23 VddA18.n2 297.363
R221 VddA18.n12 VddA18.t38 297.363
R222 VddA18.t36 VddA18.n2 297.363
R223 VddA18.n12 VddA18.t40 297.363
R224 VddA18.n3 VddA18.t23 291.587
R225 VddA18.t38 VddA18.n11 291.587
R226 VddA18.n3 VddA18.t36 291.587
R227 VddA18.t40 VddA18.n11 291.587
R228 VddA18.n303 VddA18.n302 261.224
R229 VddA18.n302 VddA18.n7 261.224
R230 VddA18.n23 VddA18.n17 260.327
R231 VddA18.n287 VddA18.n286 260.327
R232 VddA18.n62 VddA18.n59 260.327
R233 VddA18.n68 VddA18.n67 260.327
R234 VddA18.n22 VddA18.n20 254.119
R235 VddA18.n63 VddA18.n60 254.119
R236 VddA18.n99 VddA18.t33 231.351
R237 VddA18.n233 VddA18.t34 231.351
R238 VddA18.n26 VddA18.t30 231.213
R239 VddA18.n239 VddA18.t29 231.213
R240 VddA18.n306 VddA18.n304 186.309
R241 VddA18.n22 VddA18.n21 185
R242 VddA18.n20 VddA18.n19 185
R243 VddA18.n64 VddA18.n63 185
R244 VddA18.n61 VddA18.n60 185
R245 VddA18.n296 VddA18.n295 157.042
R246 VddA18.n293 VddA18.n292 157.042
R247 VddA18.n291 VddA18.n290 151.649
R248 VddA18.n16 VddA18.n15 151.649
R249 VddA18.n291 VddA18.n289 151.649
R250 VddA18.n16 VddA18.n14 151.649
R251 VddA18.n25 VddA18.n24 132.445
R252 VddA18.n236 VddA18.n235 132.445
R253 VddA18.n283 VddA18.n282 107.186
R254 VddA18.n240 VddA18.n237 107.186
R255 VddA18.n286 VddA18.n20 75.3262
R256 VddA18.n23 VddA18.n22 75.3262
R257 VddA18.n68 VddA18.n60 75.3262
R258 VddA18.n63 VddA18.n59 75.3262
R259 VddA18.n8 VddA18.t1 70.3576
R260 VddA18.n8 VddA18.t5 70.3576
R261 VddA18.n9 VddA18.t13 70.3576
R262 VddA18.n9 VddA18.t14 70.3576
R263 VddA18.n305 VddA18.t4 70.3576
R264 VddA18.n305 VddA18.t3 70.3576
R265 VddA18.n6 VddA18.t12 70.3576
R266 VddA18.n6 VddA18.t15 70.3576
R267 VddA18.n4 VddA18.n2 64.9026
R268 VddA18.n13 VddA18.n12 64.9017
R269 VddA18.n302 VddA18.n301 59.0399
R270 VddA18.n285 VddA18.n23 54.8384
R271 VddA18.n286 VddA18.n285 54.8384
R272 VddA18.n69 VddA18.n59 54.8384
R273 VddA18.n69 VddA18.n68 54.8384
R274 VddA18.n236 VddA18.t35 31.2731
R275 VddA18.n25 VddA18.t22 31.2731
R276 VddA18.n287 VddA18.n19 27.1064
R277 VddA18.n21 VddA18.n17 27.1064
R278 VddA18.n67 VddA18.n61 27.1064
R279 VddA18.n64 VddA18.n62 27.1064
R280 VddA18.n289 VddA18.t43 19.7005
R281 VddA18.n289 VddA18.t44 19.7005
R282 VddA18.n290 VddA18.t17 19.7005
R283 VddA18.n290 VddA18.t19 19.7005
R284 VddA18.n14 VddA18.t41 19.7005
R285 VddA18.n14 VddA18.t32 19.7005
R286 VddA18.n15 VddA18.t26 19.7005
R287 VddA18.n15 VddA18.t42 19.7005
R288 VddA18.n295 VddA18.t39 19.7005
R289 VddA18.n295 VddA18.t45 19.7005
R290 VddA18.n292 VddA18.t37 19.7005
R291 VddA18.n292 VddA18.t27 19.7005
R292 VddA18.n13 VddA18.n11 18.2203
R293 VddA18.n4 VddA18.n3 18.2194
R294 VddA18.n100 VddA18.n24 15.6558
R295 VddA18.n235 VddA18.n234 15.6558
R296 VddA18.t28 VddA18.n7 13.1579
R297 VddA18.n303 VddA18.t20 13.1579
R298 VddA18.n284 VddA18.n283 10.1481
R299 VddA18.n237 VddA18.n70 10.1481
R300 VddA18.n288 VddA18.n287 9.47985
R301 VddA18.n288 VddA18.n17 9.47985
R302 VddA18.n67 VddA18.n66 9.47985
R303 VddA18.n66 VddA18.n62 9.47985
R304 VddA18.t0 VddA18.t24 7.0559
R305 VddA18.t2 VddA18.t21 7.0559
R306 VddA18.n304 VddA18.n7 6.68993
R307 VddA18.n304 VddA18.n303 6.68993
R308 VddA18.t35 VddA18.t0 5.72109
R309 VddA18.t22 VddA18.t2 5.72109
R310 VddA18.n19 VddA18.n18 5.51637
R311 VddA18.n21 VddA18.n18 5.51637
R312 VddA18.n65 VddA18.n61 5.51637
R313 VddA18.n65 VddA18.n64 5.51637
R314 VddA18.n134 VddA18.n123 4.62171
R315 VddA18.n153 VddA18.n152 4.62171
R316 VddA18.n178 VddA18.n177 4.62171
R317 VddA18.n191 VddA18.n187 4.62171
R318 VddA18.n194 VddA18.n184 4.5005
R319 VddA18.n193 VddA18.n192 4.5005
R320 VddA18.n191 VddA18.n190 4.5005
R321 VddA18.n154 VddA18.n153 4.5005
R322 VddA18.n151 VddA18.n144 4.5005
R323 VddA18.n150 VddA18.n149 4.5005
R324 VddA18.n131 VddA18.n126 4.5005
R325 VddA18.n133 VddA18.n132 4.5005
R326 VddA18.n135 VddA18.n134 4.5005
R327 VddA18.n177 VddA18.n176 4.5005
R328 VddA18.n173 VddA18.n166 4.5005
R329 VddA18.n172 VddA18.n171 4.5005
R330 VddA18.n237 VddA18.n236 4.08412
R331 VddA18.n283 VddA18.n25 4.08412
R332 VddA18.t24 VddA18.t8 3.81423
R333 VddA18.t21 VddA18.t6 3.81423
R334 VddA18.n152 VddA18.n140 3.46728
R335 VddA18.n138 VddA18.n123 3.46728
R336 VddA18.n179 VddA18.n178 3.46728
R337 VddA18.n221 VddA18.n220 3.45252
R338 VddA18.n91 VddA18.n88 3.45252
R339 VddA18.n248 VddA18.n245 3.45252
R340 VddA18.n36 VddA18.n35 3.45252
R341 VddA18.n187 VddA18.n181 3.45248
R342 VddA18.n115 VddA18.n114 3.44306
R343 VddA18.t8 VddA18.t28 3.43286
R344 VddA18.t6 VddA18.t20 3.43286
R345 VddA18.n92 VddA18.n91 3.42607
R346 VddA18.n36 VddA18.n31 3.42607
R347 VddA18.n206 VddA18.n78 3.41121
R348 VddA18.n117 VddA18.n116 3.41121
R349 VddA18.n267 VddA18.n266 3.41121
R350 VddA18.n271 VddA18.n47 3.41121
R351 VddA18.n199 VddA18.n181 3.4105
R352 VddA18.n195 VddA18.n183 3.4105
R353 VddA18.n186 VddA18.n185 3.4105
R354 VddA18.n189 VddA18.n188 3.4105
R355 VddA18.n145 VddA18.n143 3.4105
R356 VddA18.n156 VddA18.n155 3.4105
R357 VddA18.n148 VddA18.n142 3.4105
R358 VddA18.n130 VddA18.n129 3.4105
R359 VddA18.n125 VddA18.n124 3.4105
R360 VddA18.n137 VddA18.n136 3.4105
R361 VddA18.n90 VddA18.n89 3.4105
R362 VddA18.n86 VddA18.n85 3.4105
R363 VddA18.n96 VddA18.n95 3.4105
R364 VddA18.n97 VddA18.n84 3.4105
R365 VddA18.n103 VddA18.n102 3.4105
R366 VddA18.n82 VddA18.n81 3.4105
R367 VddA18.n110 VddA18.n109 3.4105
R368 VddA18.n111 VddA18.n80 3.4105
R369 VddA18.n209 VddA18.n208 3.4105
R370 VddA18.n210 VddA18.n76 3.4105
R371 VddA18.n212 VddA18.n211 3.4105
R372 VddA18.n77 VddA18.n71 3.4105
R373 VddA18.n230 VddA18.n229 3.4105
R374 VddA18.n74 VddA18.n72 3.4105
R375 VddA18.n224 VddA18.n223 3.4105
R376 VddA18.n222 VddA18.n218 3.4105
R377 VddA18.n206 VddA18.n205 3.4105
R378 VddA18.n220 VddA18.n217 3.4105
R379 VddA18.n226 VddA18.n225 3.4105
R380 VddA18.n228 VddA18.n227 3.4105
R381 VddA18.n215 VddA18.n73 3.4105
R382 VddA18.n214 VddA18.n213 3.4105
R383 VddA18.n207 VddA18.n75 3.4105
R384 VddA18.n118 VddA18.n117 3.4105
R385 VddA18.n108 VddA18.n79 3.4105
R386 VddA18.n107 VddA18.n106 3.4105
R387 VddA18.n105 VddA18.n104 3.4105
R388 VddA18.n94 VddA18.n83 3.4105
R389 VddA18.n93 VddA18.n92 3.4105
R390 VddA18.n37 VddA18.n33 3.4105
R391 VddA18.n39 VddA18.n38 3.4105
R392 VddA18.n41 VddA18.n40 3.4105
R393 VddA18.n42 VddA18.n27 3.4105
R394 VddA18.n280 VddA18.n279 3.4105
R395 VddA18.n278 VddA18.n28 3.4105
R396 VddA18.n48 VddA18.n30 3.4105
R397 VddA18.n273 VddA18.n272 3.4105
R398 VddA18.n50 VddA18.n49 3.4105
R399 VddA18.n262 VddA18.n261 3.4105
R400 VddA18.n260 VddA18.n259 3.4105
R401 VddA18.n258 VddA18.n55 3.4105
R402 VddA18.n242 VddA18.n56 3.4105
R403 VddA18.n253 VddA18.n252 3.4105
R404 VddA18.n251 VddA18.n250 3.4105
R405 VddA18.n249 VddA18.n243 3.4105
R406 VddA18.n266 VddA18.n265 3.4105
R407 VddA18.n248 VddA18.n247 3.4105
R408 VddA18.n58 VddA18.n57 3.4105
R409 VddA18.n255 VddA18.n254 3.4105
R410 VddA18.n257 VddA18.n256 3.4105
R411 VddA18.n54 VddA18.n53 3.4105
R412 VddA18.n264 VddA18.n263 3.4105
R413 VddA18.n47 VddA18.n46 3.4105
R414 VddA18.n275 VddA18.n274 3.4105
R415 VddA18.n277 VddA18.n276 3.4105
R416 VddA18.n45 VddA18.n29 3.4105
R417 VddA18.n44 VddA18.n43 3.4105
R418 VddA18.n32 VddA18.n31 3.4105
R419 VddA18.n165 VddA18.n164 3.4105
R420 VddA18.n175 VddA18.n174 3.4105
R421 VddA18.n168 VddA18.n167 3.4105
R422 VddA18.n270 VddA18.n269 3.19858
R423 VddA18.n128 VddA18.n126 2.40898
R424 VddA18.n171 VddA18.n170 2.40898
R425 VddA18.n150 VddA18.n147 2.40877
R426 VddA18.n196 VddA18.n184 2.40877
R427 VddA18.n288 VddA18.n18 1.89332
R428 VddA18.n66 VddA18.n65 1.89332
R429 VddA18.n198 VddA18.n197 1.71902
R430 VddA18.n127 VddA18.n121 1.70675
R431 VddA18.n158 VddA18.n141 1.70675
R432 VddA18.n169 VddA18.n163 1.70675
R433 VddA18.n180 VddA18.n163 1.706
R434 VddA18.n146 VddA18.n141 1.706
R435 VddA18.n139 VddA18.n121 1.706
R436 VddA18.n180 VddA18.n179 1.69885
R437 VddA18.n180 VddA18.n162 1.69885
R438 VddA18.n199 VddA18.n182 1.69885
R439 VddA18.n158 VddA18.n140 1.69885
R440 VddA18.n158 VddA18.n157 1.69885
R441 VddA18.n139 VddA18.n138 1.69885
R442 VddA18.n139 VddA18.n122 1.69885
R443 VddA18.n309 VddA18.n308 1.57765
R444 VddA18.n299 VddA18.n298 1.57765
R445 VddA18.n245 VddA18.n244 1.31457
R446 VddA18.n221 VddA18.n219 1.31367
R447 VddA18.n35 VddA18.n34 1.25854
R448 VddA18.n88 VddA18.n87 1.25718
R449 VddA18.n199 VddA18.n198 1.12982
R450 VddA18.n308 VddA18.n307 1.1255
R451 VddA18.n300 VddA18.n299 1.1255
R452 VddA18.n294 VddA18.n291 0.573026
R453 VddA18.n294 VddA18.n16 0.573026
R454 VddA18.n114 VddA18.n112 0.460073
R455 VddA18.n114 VddA18.n113 0.460073
R456 VddA18.n269 VddA18.n268 0.460073
R457 VddA18.n269 VddA18 0.460073
R458 VddA18.n26 VddA18 0.434875
R459 VddA18.n239 VddA18.n238 0.434875
R460 VddA18.n197 VddA18.n5 0.411592
R461 VddA18.n169 VddA18.n5 0.411592
R462 VddA18.n146 VddA18.n10 0.411592
R463 VddA18.n127 VddA18.n10 0.411592
R464 VddA18.n309 VddA18.n4 0.402766
R465 VddA18.n298 VddA18.n13 0.402766
R466 VddA18.n201 VddA18 0.397223
R467 VddA18.n271 VddA18.n270 0.37763
R468 VddA18.n270 VddA18.n267 0.37763
R469 VddA18.n116 VddA18.n115 0.37671
R470 VddA18.n115 VddA18.n78 0.37671
R471 VddA18.n201 VddA18.n159 0.375859
R472 VddA18.n291 VddA18.n288 0.373832
R473 VddA18.n66 VddA18.n16 0.373832
R474 VddA18.n233 VddA18.n232 0.297375
R475 VddA18.n99 VddA18.n98 0.297375
R476 VddA18.n101 VddA18.n100 0.256637
R477 VddA18.n234 VddA18.n231 0.256637
R478 VddA18.n282 VddA18.n281 0.2505
R479 VddA18.n241 VddA18.n240 0.2505
R480 VddA18.n120 VddA18.n119 0.199259
R481 VddA18.n161 VddA18.n160 0.199259
R482 VddA18.n310 VddA18.n309 0.141379
R483 VddA18.n309 VddA18.n1 0.141379
R484 VddA18.n298 VddA18 0.141379
R485 VddA18.n298 VddA18 0.141379
R486 VddA18.n134 VddA18.n133 0.121712
R487 VddA18.n133 VddA18.n126 0.121712
R488 VddA18.n153 VddA18.n151 0.121712
R489 VddA18.n151 VddA18.n150 0.121712
R490 VddA18.n171 VddA18.n166 0.121712
R491 VddA18.n177 VddA18.n166 0.121712
R492 VddA18.n192 VddA18.n184 0.121712
R493 VddA18.n192 VddA18.n191 0.121712
R494 VddA18.n301 VddA18.n300 0.112805
R495 VddA18.n307 VddA18.n306 0.112805
R496 VddA18.n309 VddA18.n0 0.0862552
R497 VddA18.n298 VddA18.n297 0.0862552
R498 VddA18.n201 VddA18.n200 0.0854133
R499 VddA18.n202 VddA18.n201 0.0854133
R500 VddA18.n194 VddA18.n193 0.0615687
R501 VddA18.n149 VddA18.n144 0.0615687
R502 VddA18.n132 VddA18.n131 0.0615687
R503 VddA18.n173 VddA18.n172 0.0615687
R504 VddA18.n196 VddA18.n195 0.0615325
R505 VddA18.n148 VddA18.n147 0.0615325
R506 VddA18.n130 VddA18.n128 0.0615322
R507 VddA18.n170 VddA18.n168 0.0615322
R508 VddA18.n100 VddA18.n99 0.0576777
R509 VddA18.n234 VddA18.n233 0.0576777
R510 VddA18.n282 VddA18.n26 0.0576546
R511 VddA18.n240 VddA18.n239 0.0576546
R512 VddA18.n224 VddA18.n218 0.0574697
R513 VddA18.n212 VddA18.n77 0.0574697
R514 VddA18.n103 VddA18.n82 0.0574697
R515 VddA18.n90 VddA18.n86 0.0574697
R516 VddA18.n250 VddA18.n249 0.0574697
R517 VddA18.n259 VddA18.n258 0.0574697
R518 VddA18.n279 VddA18.n278 0.0574697
R519 VddA18.n38 VddA18.n37 0.0574697
R520 VddA18.n208 VddA18.n206 0.0567576
R521 VddA18.n117 VddA18.n80 0.0567576
R522 VddA18.n266 VddA18.n50 0.0567576
R523 VddA18.n273 VddA18.n47 0.0567576
R524 VddA18.n294 VddA18.n293 0.0549041
R525 VddA18.n296 VddA18.n294 0.0549039
R526 VddA18.n225 VddA18.n74 0.0510606
R527 VddA18.n95 VddA18.n93 0.0510606
R528 VddA18.n253 VddA18.n58 0.0510606
R529 VddA18.n41 VddA18.n32 0.0510606
R530 VddA18.n116 VddA18.n111 0.0505
R531 VddA18.n111 VddA18.n110 0.0505
R532 VddA18.n110 VddA18.n81 0.0505
R533 VddA18.n102 VddA18.n81 0.0505
R534 VddA18.n97 VddA18.n96 0.0505
R535 VddA18.n96 VddA18.n85 0.0505
R536 VddA18.n89 VddA18.n85 0.0505
R537 VddA18.n89 VddA18.n88 0.0505
R538 VddA18.n222 VddA18.n221 0.0505
R539 VddA18.n223 VddA18.n222 0.0505
R540 VddA18.n223 VddA18.n72 0.0505
R541 VddA18.n230 VddA18.n72 0.0505
R542 VddA18.n211 VddA18.n71 0.0505
R543 VddA18.n211 VddA18.n210 0.0505
R544 VddA18.n210 VddA18.n209 0.0505
R545 VddA18.n209 VddA18.n78 0.0505
R546 VddA18.n272 VddA18.n271 0.0505
R547 VddA18.n272 VddA18.n48 0.0505
R548 VddA18.n48 VddA18.n28 0.0505
R549 VddA18.n280 VddA18.n28 0.0505
R550 VddA18.n40 VddA18.n27 0.0505
R551 VddA18.n40 VddA18.n39 0.0505
R552 VddA18.n39 VddA18.n33 0.0505
R553 VddA18.n35 VddA18.n33 0.0505
R554 VddA18.n245 VddA18.n243 0.0505
R555 VddA18.n251 VddA18.n243 0.0505
R556 VddA18.n252 VddA18.n251 0.0505
R557 VddA18.n252 VddA18.n242 0.0505
R558 VddA18.n260 VddA18.n55 0.0505
R559 VddA18.n261 VddA18.n260 0.0505
R560 VddA18.n261 VddA18.n49 0.0505
R561 VddA18.n267 VddA18.n49 0.0505
R562 VddA18.n190 VddA18.n186 0.0501183
R563 VddA18.n155 VddA18.n154 0.0501183
R564 VddA18.n135 VddA18.n125 0.0501183
R565 VddA18.n176 VddA18.n175 0.0501183
R566 VddA18.n229 VddA18.n73 0.0496364
R567 VddA18.n104 VddA18.n84 0.0496364
R568 VddA18.n257 VddA18.n56 0.0496364
R569 VddA18.n42 VddA18.n29 0.0496364
R570 VddA18.n213 VddA18.n76 0.0439394
R571 VddA18.n109 VddA18.n107 0.0439394
R572 VddA18.n262 VddA18.n54 0.0439394
R573 VddA18.n277 VddA18.n30 0.0439394
R574 VddA18.n200 VddA18.n199 0.0398351
R575 VddA18.n200 VddA18.n180 0.0398351
R576 VddA18.n202 VddA18.n158 0.0398351
R577 VddA18.n202 VddA18.n139 0.0398351
R578 VddA18.n204 VddA18.n203 0.0380213
R579 VddA18.n52 VddA18.n51 0.0380213
R580 VddA18.n142 VddA18.n141 0.0370658
R581 VddA18.n129 VddA18.n121 0.0370658
R582 VddA18.n167 VddA18.n163 0.0370658
R583 VddA18.n207 VddA18.n76 0.0353939
R584 VddA18.n109 VddA18.n108 0.0353939
R585 VddA18.n263 VddA18.n262 0.0353939
R586 VddA18.n274 VddA18.n30 0.0353939
R587 VddA18.n189 VddA18.n187 0.0348511
R588 VddA18.n152 VddA18.n145 0.0348511
R589 VddA18.n136 VddA18.n123 0.0348511
R590 VddA18.n178 VddA18.n165 0.0348511
R591 VddA18.n102 VddA18.n101 0.033
R592 VddA18.n231 VddA18.n71 0.033
R593 VddA18.n281 VddA18.n280 0.033
R594 VddA18.n241 VddA18.n55 0.033
R595 VddA18.n205 VddA18.n204 0.0317861
R596 VddA18.n120 VddA18.n118 0.0317861
R597 VddA18.n265 VddA18.n52 0.0317861
R598 VddA18.n161 VddA18.n46 0.0317861
R599 VddA18.n229 VddA18.n228 0.029697
R600 VddA18.n94 VddA18.n84 0.029697
R601 VddA18.n254 VddA18.n56 0.029697
R602 VddA18.n43 VddA18.n42 0.029697
R603 VddA18.n185 VddA18.n183 0.0292023
R604 VddA18.n188 VddA18.n181 0.0292023
R605 VddA18.n156 VddA18.n143 0.0292023
R606 VddA18.n137 VddA18.n124 0.0292023
R607 VddA18.n174 VddA18.n164 0.0292023
R608 VddA18.n228 VddA18.n74 0.0282727
R609 VddA18.n95 VddA18.n94 0.0282727
R610 VddA18.n254 VddA18.n253 0.0282727
R611 VddA18.n43 VddA18.n41 0.0282727
R612 VddA18.n190 VddA18.n189 0.0272176
R613 VddA18.n154 VddA18.n145 0.0272176
R614 VddA18.n136 VddA18.n135 0.0272176
R615 VddA18.n176 VddA18.n165 0.0272176
R616 VddA18.n198 VddA18.n183 0.0255413
R617 VddA18.n297 VddA18.n296 0.0249921
R618 VddA18.n293 VddA18.n0 0.024992
R619 VddA18.n208 VddA18.n207 0.0225758
R620 VddA18.n108 VddA18.n80 0.0225758
R621 VddA18.n263 VddA18.n50 0.0225758
R622 VddA18.n274 VddA18.n273 0.0225758
R623 VddA18.n101 VddA18.n97 0.018
R624 VddA18.n231 VddA18.n230 0.018
R625 VddA18.n281 VddA18.n27 0.018
R626 VddA18.n242 VddA18.n241 0.018
R627 VddA18.n308 VddA18.n5 0.016125
R628 VddA18.n299 VddA18.n10 0.016125
R629 VddA18.n226 VddA18.n217 0.0160723
R630 VddA18.n227 VddA18.n226 0.0160723
R631 VddA18.n227 VddA18.n215 0.0160723
R632 VddA18.n215 VddA18.n214 0.0160723
R633 VddA18.n214 VddA18.n75 0.0160723
R634 VddA18.n205 VddA18.n75 0.0160723
R635 VddA18.n118 VddA18.n79 0.0160723
R636 VddA18.n106 VddA18.n79 0.0160723
R637 VddA18.n106 VddA18.n105 0.0160723
R638 VddA18.n105 VddA18.n83 0.0160723
R639 VddA18.n92 VddA18.n83 0.0160723
R640 VddA18.n247 VddA18.n57 0.0160723
R641 VddA18.n255 VddA18.n57 0.0160723
R642 VddA18.n256 VddA18.n255 0.0160723
R643 VddA18.n256 VddA18.n53 0.0160723
R644 VddA18.n264 VddA18.n53 0.0160723
R645 VddA18.n265 VddA18.n264 0.0160723
R646 VddA18.n275 VddA18.n46 0.0160723
R647 VddA18.n276 VddA18.n275 0.0160723
R648 VddA18.n276 VddA18.n45 0.0160723
R649 VddA18.n45 VddA18.n44 0.0160723
R650 VddA18.n44 VddA18.n31 0.0160723
R651 VddA18.n220 VddA18.n218 0.0154545
R652 VddA18.n91 VddA18.n90 0.0154545
R653 VddA18.n249 VddA18.n248 0.0154545
R654 VddA18.n37 VddA18.n36 0.0154545
R655 VddA18.n167 VddA18.n162 0.015291
R656 VddA18.n188 VddA18.n182 0.015291
R657 VddA18.n185 VddA18.n182 0.015291
R658 VddA18.n157 VddA18.n156 0.015291
R659 VddA18.n143 VddA18.n140 0.015291
R660 VddA18.n157 VddA18.n142 0.015291
R661 VddA18.n124 VddA18.n122 0.015291
R662 VddA18.n138 VddA18.n137 0.015291
R663 VddA18.n129 VddA18.n122 0.015291
R664 VddA18.n174 VddA18.n162 0.015291
R665 VddA18.n179 VddA18.n164 0.015291
R666 VddA18.n213 VddA18.n212 0.0140303
R667 VddA18.n107 VddA18.n82 0.0140303
R668 VddA18.n259 VddA18.n54 0.0140303
R669 VddA18.n278 VddA18.n277 0.0140303
R670 VddA18.n193 VddA18.n186 0.0119504
R671 VddA18.n155 VddA18.n144 0.0119504
R672 VddA18.n132 VddA18.n125 0.0119504
R673 VddA18.n175 VddA18.n173 0.0119504
R674 VddA18.n217 VddA18.n216 0.0108343
R675 VddA18.n247 VddA18.n246 0.0108343
R676 VddA18.n197 VddA18.n196 0.0105559
R677 VddA18.n147 VddA18.n146 0.0105559
R678 VddA18.n128 VddA18.n127 0.00967596
R679 VddA18.n170 VddA18.n169 0.00967596
R680 VddA18.n204 VddA18.n202 0.00934937
R681 VddA18.n202 VddA18.n120 0.00934937
R682 VddA18.n200 VddA18.n52 0.00934937
R683 VddA18.n200 VddA18.n161 0.00934937
R684 VddA18.n77 VddA18.n73 0.00833333
R685 VddA18.n104 VddA18.n103 0.00833333
R686 VddA18.n258 VddA18.n257 0.00833333
R687 VddA18.n279 VddA18.n29 0.00833333
R688 VddA18.n225 VddA18.n224 0.00690909
R689 VddA18.n93 VddA18.n86 0.00690909
R690 VddA18.n250 VddA18.n58 0.00690909
R691 VddA18.n38 VddA18.n32 0.00690909
R692 VddA18.n195 VddA18.n194 0.00431679
R693 VddA18.n149 VddA18.n148 0.00431679
R694 VddA18.n131 VddA18.n130 0.00431679
R695 VddA18.n172 VddA18.n168 0.00431679
R696 vpd[3].n0 vpd[3].t1 254.778
R697 vpd[3].n0 vpd[3].t0 230.966
R698 vpd[3] vpd[3].n1 3.79514
R699 vpd[3].n1 vpd[3].n0 0.0496071
R700 vpd[1].n0 vpd[1].t1 254.778
R701 vpd[1].n0 vpd[1].t0 230.966
R702 vpd[1].n2 vpd[1].n1 3.79514
R703 vpd[1].n2 vpd[1] 0.063
R704 vpd[1] vpd[1].n2 0.050069
R705 vpd[1].n1 vpd[1].n0 0.0496071
R706 vpd[2].n0 vpd[2].t1 254.778
R707 vpd[2].n0 vpd[2].t0 230.966
R708 vpd[2].n1 vpd[2] 3.90721
R709 vpd[2] vpd[2].n0 0.0496071
R710 vpd[2].n1 vpd[2] 0.013431
R711 vpd[0].n0 vpd[0].t1 254.778
R712 vpd[0].n0 vpd[0].t0 230.966
R713 vpd[0].n1 vpd[0] 3.90721
R714 vpd[0] vpd[0].n0 0.0496071
R715 vpd[0].n1 vpd[0] 0.013431
R716 GndA.n1405 GndA.n1404 17208.3
R717 GndA.n748 GndA.n747 17204.2
R718 GndA.n1236 GndA.t39 4592.65
R719 GndA.n914 GndA.t18 4592.65
R720 GndA.n381 GndA.n331 1077.71
R721 GndA.n1023 GndA.n971 1077.71
R722 GndA.n1343 GndA.n1290 1077.71
R723 GndA.n264 GndA.n213 1077.71
R724 GndA.n1237 GndA.n1236 1075.14
R725 GndA.n915 GndA.n914 1075.14
R726 GndA.t26 GndA.n152 1066.12
R727 GndA.t21 GndA.n297 1066.12
R728 GndA.n1246 GndA.n1245 1032.46
R729 GndA.n540 GndA.n286 932.854
R730 GndA.n903 GndA.n894 932.854
R731 GndA.n1257 GndA.n79 932.854
R732 GndA.n565 GndA.n558 932.854
R733 GndA.n1284 GndA.n41 808.97
R734 GndA.n654 GndA.n189 808.97
R735 GndA.n918 GndA.n833 806.928
R736 GndA.n534 GndA.n292 802.393
R737 GndA.n965 GndA.n782 802.393
R738 GndA.t15 GndA.t16 761.944
R739 GndA.t12 GndA.t14 761.944
R740 GndA.t17 GndA.t38 761.944
R741 GndA.t37 GndA.t13 761.944
R742 GndA.n1130 GndA.t25 664.658
R743 GndA.n1131 GndA.t31 664.658
R744 GndA.n1089 GndA.t24 664.658
R745 GndA.n1088 GndA.t36 664.658
R746 GndA.n1189 GndA.n1188 601.348
R747 GndA.n869 GndA.n868 601.348
R748 GndA.n482 GndA.n481 597.657
R749 GndA.n662 GndA.n179 597.657
R750 GndA.n463 GndA.n323 585
R751 GndA.n467 GndA.n322 585
R752 GndA.n460 GndA.n322 585
R753 GndA.n467 GndA.n314 585
R754 GndA.n457 GndA.n314 585
R755 GndA.n467 GndA.n321 585
R756 GndA.n454 GndA.n321 585
R757 GndA.n467 GndA.n315 585
R758 GndA.n451 GndA.n315 585
R759 GndA.n467 GndA.n320 585
R760 GndA.n448 GndA.n320 585
R761 GndA.n467 GndA.n316 585
R762 GndA.n445 GndA.n316 585
R763 GndA.n467 GndA.n319 585
R764 GndA.n443 GndA.n319 585
R765 GndA.n467 GndA.n317 585
R766 GndA.n440 GndA.n317 585
R767 GndA.n467 GndA.n318 585
R768 GndA.n437 GndA.n318 585
R769 GndA.n468 GndA.n467 585
R770 GndA.n468 GndA.n313 585
R771 GndA.n461 GndA.n125 585
R772 GndA.n462 GndA.n461 585
R773 GndA.n458 GndA.n125 585
R774 GndA.n459 GndA.n458 585
R775 GndA.n455 GndA.n125 585
R776 GndA.n456 GndA.n455 585
R777 GndA.n452 GndA.n125 585
R778 GndA.n453 GndA.n452 585
R779 GndA.n449 GndA.n125 585
R780 GndA.n450 GndA.n449 585
R781 GndA.n446 GndA.n125 585
R782 GndA.n447 GndA.n446 585
R783 GndA.n432 GndA.n125 585
R784 GndA.n433 GndA.n432 585
R785 GndA.n441 GndA.n125 585
R786 GndA.n442 GndA.n441 585
R787 GndA.n438 GndA.n125 585
R788 GndA.n439 GndA.n438 585
R789 GndA.n312 GndA.n125 585
R790 GndA.n435 GndA.n312 585
R791 GndA.n469 GndA.n125 585
R792 GndA.n469 GndA.n129 585
R793 GndA.n465 GndA.n464 585
R794 GndA.n324 GndA.n293 585
R795 GndA.n431 GndA.n324 585
R796 GndA.n429 GndA.n428 585
R797 GndA.n430 GndA.n429 585
R798 GndA.n379 GndA.n326 585
R799 GndA.n326 GndA.n325 585
R800 GndA.n378 GndA.n377 585
R801 GndA.n377 GndA.n376 585
R802 GndA.n375 GndA.n333 585
R803 GndA.n374 GndA.n373 585
R804 GndA.n372 GndA.n334 585
R805 GndA.n370 GndA.n369 585
R806 GndA.n368 GndA.n336 585
R807 GndA.n367 GndA.n366 585
R808 GndA.n365 GndA.n337 585
R809 GndA.n363 GndA.n362 585
R810 GndA.n361 GndA.n339 585
R811 GndA.n360 GndA.n359 585
R812 GndA.n358 GndA.n340 585
R813 GndA.n356 GndA.n355 585
R814 GndA.n354 GndA.n342 585
R815 GndA.n353 GndA.n352 585
R816 GndA.n351 GndA.n343 585
R817 GndA.n349 GndA.n348 585
R818 GndA.n347 GndA.n346 585
R819 GndA.n331 GndA.n330 585
R820 GndA.n381 GndA.n380 585
R821 GndA.n382 GndA.n381 585
R822 GndA.n328 GndA.n327 585
R823 GndA.n383 GndA.n328 585
R824 GndA.n427 GndA.n426 585
R825 GndA.n426 GndA.n425 585
R826 GndA.n329 GndA.n292 585
R827 GndA.n424 GndA.n329 585
R828 GndA.n423 GndA.n422 585
R829 GndA.n420 GndA.n384 585
R830 GndA.n419 GndA.n385 585
R831 GndA.n417 GndA.n416 585
R832 GndA.n387 GndA.n386 585
R833 GndA.n412 GndA.n411 585
R834 GndA.n410 GndA.n391 585
R835 GndA.n408 GndA.n407 585
R836 GndA.n394 GndA.n392 585
R837 GndA.n402 GndA.n401 585
R838 GndA.n400 GndA.n399 585
R839 GndA.n398 GndA.n397 585
R840 GndA.n287 GndA.n285 585
R841 GndA.n540 GndA.n539 585
R842 GndA.n291 GndA.n286 585
R843 GndA.n538 GndA.n286 585
R844 GndA.n536 GndA.n535 585
R845 GndA.n537 GndA.n536 585
R846 GndA.n290 GndA.n289 585
R847 GndA.n289 GndA.n288 585
R848 GndA.n520 GndA.n519 585
R849 GndA.n521 GndA.n520 585
R850 GndA.n507 GndA.n499 585
R851 GndA.n524 GndA.n499 585
R852 GndA.n505 GndA.n498 585
R853 GndA.n525 GndA.n498 585
R854 GndA.n504 GndA.n497 585
R855 GndA.n526 GndA.n497 585
R856 GndA.n503 GndA.n300 585
R857 GndA.n302 GndA.n300 585
R858 GndA.n532 GndA.n531 585
R859 GndA.n531 GndA.n530 585
R860 GndA.n299 GndA.n298 585
R861 GndA.n301 GndA.n299 585
R862 GndA.n492 GndA.n491 585
R863 GndA.n493 GndA.n492 585
R864 GndA.n490 GndA.n305 585
R865 GndA.n305 GndA.n304 585
R866 GndA.n489 GndA.n488 585
R867 GndA.n488 GndA.n487 585
R868 GndA.n307 GndA.n306 585
R869 GndA.n308 GndA.n307 585
R870 GndA.n483 GndA.n482 585
R871 GndA.n480 GndA.n311 585
R872 GndA.n311 GndA.n310 585
R873 GndA.n479 GndA.n478 585
R874 GndA.n478 GndA.n477 585
R875 GndA.n473 GndA.n294 585
R876 GndA.n474 GndA.n473 585
R877 GndA.n472 GndA.n295 585
R878 GndA.n472 GndA.n128 585
R879 GndA.n513 GndA.n512 585
R880 GndA.n513 GndA.n506 585
R881 GndA.n513 GndA.n509 585
R882 GndA.n518 GndA.n517 585
R883 GndA.n512 GndA.n500 585
R884 GndA.n515 GndA.n500 585
R885 GndA.n517 GndA.n500 585
R886 GndA.n547 GndA.n546 585
R887 GndA.n548 GndA.n547 585
R888 GndA.n545 GndA.n280 585
R889 GndA.n280 GndA.n279 585
R890 GndA.n555 GndA.n554 585
R891 GndA.n554 GndA.n553 585
R892 GndA.n566 GndA.n565 585
R893 GndA.n565 GndA.n564 585
R894 GndA.n562 GndA.n557 585
R895 GndA.n561 GndA.n560 585
R896 GndA.n566 GndA.n278 585
R897 GndA.n559 GndA.n278 585
R898 GndA.n569 GndA.n568 585
R899 GndA.n276 GndA.n275 585
R900 GndA.n157 GndA.n150 585
R901 GndA.n159 GndA.n157 585
R902 GndA.n689 GndA.n688 585
R903 GndA.n688 GndA.n687 585
R904 GndA.n156 GndA.n155 585
R905 GndA.n158 GndA.n156 585
R906 GndA.n558 GndA.n190 585
R907 GndA.n563 GndA.n558 585
R908 GndA.n694 GndA.n693 585
R909 GndA.n694 GndA.n151 585
R910 GndA.n694 GndA.n154 585
R911 GndA.n690 GndA.n147 585
R912 GndA.n665 GndA.n664 585
R913 GndA.n666 GndA.n665 585
R914 GndA.n173 GndA.n172 585
R915 GndA.n667 GndA.n173 585
R916 GndA.n670 GndA.n669 585
R917 GndA.n669 GndA.n668 585
R918 GndA.n671 GndA.n170 585
R919 GndA.n170 GndA.n169 585
R920 GndA.n673 GndA.n672 585
R921 GndA.n674 GndA.n673 585
R922 GndA.n171 GndA.n163 585
R923 GndA.n675 GndA.n163 585
R924 GndA.n678 GndA.n677 585
R925 GndA.n677 GndA.n676 585
R926 GndA.n679 GndA.n162 585
R927 GndA.n164 GndA.n162 585
R928 GndA.n681 GndA.n680 585
R929 GndA.n681 GndA.n161 585
R930 GndA.n683 GndA.n682 585
R931 GndA.n684 GndA.n683 585
R932 GndA.n693 GndA.n149 585
R933 GndA.n696 GndA.n149 585
R934 GndA.n149 GndA.n147 585
R935 GndA.n601 GndA.n600 585
R936 GndA.n204 GndA.n198 585
R937 GndA.n604 GndA.n204 585
R938 GndA.n205 GndA.n198 585
R939 GndA.n649 GndA.n205 585
R940 GndA.n646 GndA.n198 585
R941 GndA.n647 GndA.n646 585
R942 GndA.n643 GndA.n198 585
R943 GndA.n644 GndA.n643 585
R944 GndA.n640 GndA.n198 585
R945 GndA.n641 GndA.n640 585
R946 GndA.n637 GndA.n198 585
R947 GndA.n638 GndA.n637 585
R948 GndA.n605 GndA.n198 585
R949 GndA.n606 GndA.n605 585
R950 GndA.n632 GndA.n198 585
R951 GndA.n633 GndA.n632 585
R952 GndA.n629 GndA.n198 585
R953 GndA.n630 GndA.n629 585
R954 GndA.n626 GndA.n198 585
R955 GndA.n627 GndA.n626 585
R956 GndA.n623 GndA.n198 585
R957 GndA.n624 GndA.n623 585
R958 GndA.n653 GndA.n188 585
R959 GndA.n188 GndA.n187 585
R960 GndA.n656 GndA.n655 585
R961 GndA.n657 GndA.n656 585
R962 GndA.n182 GndA.n181 585
R963 GndA.n658 GndA.n182 585
R964 GndA.n661 GndA.n660 585
R965 GndA.n660 GndA.n659 585
R966 GndA.n179 GndA.n178 585
R967 GndA.n652 GndA.n197 585
R968 GndA.n625 GndA.n197 585
R969 GndA.n652 GndA.n200 585
R970 GndA.n628 GndA.n200 585
R971 GndA.n652 GndA.n196 585
R972 GndA.n631 GndA.n196 585
R973 GndA.n652 GndA.n201 585
R974 GndA.n634 GndA.n201 585
R975 GndA.n652 GndA.n195 585
R976 GndA.n636 GndA.n195 585
R977 GndA.n652 GndA.n202 585
R978 GndA.n639 GndA.n202 585
R979 GndA.n652 GndA.n194 585
R980 GndA.n642 GndA.n194 585
R981 GndA.n652 GndA.n203 585
R982 GndA.n645 GndA.n203 585
R983 GndA.n652 GndA.n193 585
R984 GndA.n648 GndA.n193 585
R985 GndA.n652 GndA.n651 585
R986 GndA.n651 GndA.n650 585
R987 GndA.n603 GndA.n602 585
R988 GndA.n1231 GndA.n1189 585
R989 GndA.n1229 GndA.n1228 585
R990 GndA.n1230 GndA.n1229 585
R991 GndA.n1227 GndA.n1225 585
R992 GndA.n1225 GndA.n1224 585
R993 GndA.n1226 GndA.n39 585
R994 GndA.n39 GndA.n37 585
R995 GndA.n1391 GndA.n1390 585
R996 GndA.n1392 GndA.n1391 585
R997 GndA.n56 GndA.n34 585
R998 GndA.n57 GndA.n56 585
R999 GndA.n1382 GndA.n34 585
R1000 GndA.n1383 GndA.n1382 585
R1001 GndA.n1379 GndA.n34 585
R1002 GndA.n1380 GndA.n1379 585
R1003 GndA.n1376 GndA.n34 585
R1004 GndA.n1377 GndA.n1376 585
R1005 GndA.n1373 GndA.n34 585
R1006 GndA.n1374 GndA.n1373 585
R1007 GndA.n1370 GndA.n34 585
R1008 GndA.n1371 GndA.n1370 585
R1009 GndA.n1367 GndA.n34 585
R1010 GndA.n1368 GndA.n1367 585
R1011 GndA.n1364 GndA.n34 585
R1012 GndA.n1365 GndA.n1364 585
R1013 GndA.n1361 GndA.n34 585
R1014 GndA.n1362 GndA.n1361 585
R1015 GndA.n1358 GndA.n34 585
R1016 GndA.n1359 GndA.n1358 585
R1017 GndA.n1355 GndA.n34 585
R1018 GndA.n1356 GndA.n1355 585
R1019 GndA.n1352 GndA.n1351 585
R1020 GndA.n1354 GndA.n1353 585
R1021 GndA.n1389 GndA.n48 585
R1022 GndA.n1357 GndA.n48 585
R1023 GndA.n1389 GndA.n46 585
R1024 GndA.n1360 GndA.n46 585
R1025 GndA.n1389 GndA.n49 585
R1026 GndA.n1363 GndA.n49 585
R1027 GndA.n1389 GndA.n45 585
R1028 GndA.n1366 GndA.n45 585
R1029 GndA.n1389 GndA.n50 585
R1030 GndA.n1369 GndA.n50 585
R1031 GndA.n1389 GndA.n44 585
R1032 GndA.n1372 GndA.n44 585
R1033 GndA.n1389 GndA.n51 585
R1034 GndA.n1375 GndA.n51 585
R1035 GndA.n1389 GndA.n43 585
R1036 GndA.n1378 GndA.n43 585
R1037 GndA.n1389 GndA.n52 585
R1038 GndA.n1381 GndA.n52 585
R1039 GndA.n1389 GndA.n42 585
R1040 GndA.n1384 GndA.n42 585
R1041 GndA.n1195 GndA.n1194 585
R1042 GndA.n1202 GndA.n1201 585
R1043 GndA.n1204 GndA.n1203 585
R1044 GndA.n1207 GndA.n1206 585
R1045 GndA.n1205 GndA.n1192 585
R1046 GndA.n1212 GndA.n1211 585
R1047 GndA.n1214 GndA.n1213 585
R1048 GndA.n1216 GndA.n1215 585
R1049 GndA.n1190 GndA.n1187 585
R1050 GndA.n1233 GndA.n1232 585
R1051 GndA.n1245 GndA.n1244 585
R1052 GndA.n1243 GndA.n1242 585
R1053 GndA.n1239 GndA.n1238 585
R1054 GndA.n1237 GndA.n1182 585
R1055 GndA.n1182 GndA.n1181 585
R1056 GndA.n1247 GndA.n1246 585
R1057 GndA.n930 GndA.n800 585
R1058 GndA.n800 GndA.n799 585
R1059 GndA.n939 GndA.n938 585
R1060 GndA.n938 GndA.n937 585
R1061 GndA.n932 GndA.n931 585
R1062 GndA.n933 GndA.n932 585
R1063 GndA.n845 GndA.n834 585
R1064 GndA.n909 GndA.n845 585
R1065 GndA.n906 GndA.n836 585
R1066 GndA.n907 GndA.n906 585
R1067 GndA.n905 GndA.n904 585
R1068 GndA.n905 GndA.n893 585
R1069 GndA.n903 GndA.n902 585
R1070 GndA.n903 GndA.n901 585
R1071 GndA.n900 GndA.n894 585
R1072 GndA.n899 GndA.n898 585
R1073 GndA.n897 GndA.n896 585
R1074 GndA.n895 GndA.n796 585
R1075 GndA.n943 GndA.n942 585
R1076 GndA.n944 GndA.n791 585
R1077 GndA.n920 GndA.n919 585
R1078 GndA.n920 GndA.n835 585
R1079 GndA.n921 GndA.n920 585
R1080 GndA.n919 GndA.n917 585
R1081 GndA.n917 GndA.n832 585
R1082 GndA.n917 GndA.n916 585
R1083 GndA.n1259 GndA.n71 585
R1084 GndA.n1263 GndA.n71 585
R1085 GndA.n1262 GndA.n1261 585
R1086 GndA.n1253 GndA.n75 585
R1087 GndA.n1259 GndA.n76 585
R1088 GndA.n1254 GndA.n76 585
R1089 GndA.n1255 GndA.n77 585
R1090 GndA.n1257 GndA.n1256 585
R1091 GndA.n79 GndA.n78 585
R1092 GndA.n1252 GndA.n79 585
R1093 GndA.n1250 GndA.n1249 585
R1094 GndA.n1251 GndA.n1250 585
R1095 GndA.n1248 GndA.n81 585
R1096 GndA.n81 GndA.n80 585
R1097 GndA.n1196 GndA.n84 585
R1098 GndA.n1197 GndA.n1196 585
R1099 GndA.n854 GndA.n850 585
R1100 GndA.n875 GndA.n874 585
R1101 GndA.n877 GndA.n876 585
R1102 GndA.n880 GndA.n879 585
R1103 GndA.n878 GndA.n848 585
R1104 GndA.n885 GndA.n884 585
R1105 GndA.n887 GndA.n886 585
R1106 GndA.n889 GndA.n888 585
R1107 GndA.n846 GndA.n844 585
R1108 GndA.n911 GndA.n910 585
R1109 GndA.n921 GndA.n833 585
R1110 GndA.n839 GndA.n832 585
R1111 GndA.n916 GndA.n915 585
R1112 GndA.n770 GndA.n759 585
R1113 GndA.n1060 GndA.n770 585
R1114 GndA.n774 GndA.n759 585
R1115 GndA.n1057 GndA.n774 585
R1116 GndA.n775 GndA.n759 585
R1117 GndA.n1055 GndA.n775 585
R1118 GndA.n776 GndA.n759 585
R1119 GndA.n1053 GndA.n776 585
R1120 GndA.n778 GndA.n759 585
R1121 GndA.n1051 GndA.n778 585
R1122 GndA.n1048 GndA.n759 585
R1123 GndA.n1049 GndA.n1048 585
R1124 GndA.n1045 GndA.n759 585
R1125 GndA.n1046 GndA.n1045 585
R1126 GndA.n1042 GndA.n759 585
R1127 GndA.n1043 GndA.n1042 585
R1128 GndA.n1039 GndA.n759 585
R1129 GndA.n1040 GndA.n1039 585
R1130 GndA.n1036 GndA.n759 585
R1131 GndA.n1037 GndA.n1036 585
R1132 GndA.n1034 GndA.n1033 585
R1133 GndA.n1066 GndA.n753 585
R1134 GndA.n1061 GndA.n753 585
R1135 GndA.n1066 GndA.n764 585
R1136 GndA.n771 GndA.n764 585
R1137 GndA.n1066 GndA.n754 585
R1138 GndA.n1056 GndA.n754 585
R1139 GndA.n1066 GndA.n763 585
R1140 GndA.n1054 GndA.n763 585
R1141 GndA.n1066 GndA.n755 585
R1142 GndA.n777 GndA.n755 585
R1143 GndA.n1066 GndA.n762 585
R1144 GndA.n1050 GndA.n762 585
R1145 GndA.n1066 GndA.n756 585
R1146 GndA.n1047 GndA.n756 585
R1147 GndA.n1066 GndA.n761 585
R1148 GndA.n1044 GndA.n761 585
R1149 GndA.n1066 GndA.n757 585
R1150 GndA.n1041 GndA.n757 585
R1151 GndA.n1066 GndA.n760 585
R1152 GndA.n1038 GndA.n760 585
R1153 GndA.n1066 GndA.n758 585
R1154 GndA.n1035 GndA.n758 585
R1155 GndA.n857 GndA.n856 585
R1156 GndA.n857 GndA.n766 585
R1157 GndA.n858 GndA.n855 585
R1158 GndA.n859 GndA.n858 585
R1159 GndA.n866 GndA.n865 585
R1160 GndA.n865 GndA.n864 585
R1161 GndA.n867 GndA.n853 585
R1162 GndA.n853 GndA.n852 585
R1163 GndA.n870 GndA.n869 585
R1164 GndA.n965 GndA.n964 585
R1165 GndA.n964 GndA.n963 585
R1166 GndA.n794 GndA.n792 585
R1167 GndA.n958 GndA.n957 585
R1168 GndA.n956 GndA.n955 585
R1169 GndA.n953 GndA.n952 585
R1170 GndA.n951 GndA.n950 585
R1171 GndA.n787 GndA.n786 585
R1172 GndA.n968 GndA.n967 585
R1173 GndA.n969 GndA.n784 585
R1174 GndA.n1028 GndA.n1027 585
R1175 GndA.n1027 GndA.n1026 585
R1176 GndA.n972 GndA.n785 585
R1177 GndA.n1025 GndA.n785 585
R1178 GndA.n1023 GndA.n1022 585
R1179 GndA.n1024 GndA.n1023 585
R1180 GndA.n974 GndA.n971 585
R1181 GndA.n971 GndA.n970 585
R1182 GndA.n989 GndA.n988 585
R1183 GndA.n991 GndA.n987 585
R1184 GndA.n992 GndA.n986 585
R1185 GndA.n995 GndA.n994 585
R1186 GndA.n985 GndA.n974 585
R1187 GndA.n996 GndA.n985 585
R1188 GndA.n998 GndA.n997 585
R1189 GndA.n1000 GndA.n984 585
R1190 GndA.n1001 GndA.n974 585
R1191 GndA.n1001 GndA.n983 585
R1192 GndA.n1003 GndA.n1002 585
R1193 GndA.n1005 GndA.n1004 585
R1194 GndA.n1006 GndA.n981 585
R1195 GndA.n1009 GndA.n1008 585
R1196 GndA.n980 GndA.n974 585
R1197 GndA.n1010 GndA.n980 585
R1198 GndA.n1012 GndA.n1011 585
R1199 GndA.n1014 GndA.n979 585
R1200 GndA.n1017 GndA.n1016 585
R1201 GndA.n1018 GndA.n976 585
R1202 GndA.n1021 GndA.n1020 585
R1203 GndA.n1020 GndA.n1019 585
R1204 GndA.n975 GndA.n973 585
R1205 GndA.n978 GndA.n975 585
R1206 GndA.n783 GndA.n780 585
R1207 GndA.n977 GndA.n780 585
R1208 GndA.n1030 GndA.n1029 585
R1209 GndA.n1030 GndA.n781 585
R1210 GndA.n1031 GndA.n779 585
R1211 GndA.n1288 GndA.n63 585
R1212 GndA.n1287 GndA.n1286 585
R1213 GndA.n66 GndA.n65 585
R1214 GndA.n1269 GndA.n1268 585
R1215 GndA.n1271 GndA.n1270 585
R1216 GndA.n1274 GndA.n1273 585
R1217 GndA.n1284 GndA.n69 585
R1218 GndA.n1276 GndA.n69 585
R1219 GndA.n73 GndA.n70 585
R1220 GndA.n1282 GndA.n1281 585
R1221 GndA.n1343 GndA.n1342 585
R1222 GndA.n1344 GndA.n1343 585
R1223 GndA.n1291 GndA.n64 585
R1224 GndA.n1345 GndA.n64 585
R1225 GndA.n1348 GndA.n1347 585
R1226 GndA.n1347 GndA.n1346 585
R1227 GndA.n1350 GndA.n1349 585
R1228 GndA.n1350 GndA.n60 585
R1229 GndA.n62 GndA.n61 585
R1230 GndA.n1296 GndA.n61 585
R1231 GndA.n1294 GndA.n1292 585
R1232 GndA.n1297 GndA.n1294 585
R1233 GndA.n1341 GndA.n1340 585
R1234 GndA.n1340 GndA.n1339 585
R1235 GndA.n1295 GndA.n1293 585
R1236 GndA.n1338 GndA.n1295 585
R1237 GndA.n1337 GndA.n1336 585
R1238 GndA.n1334 GndA.n1298 585
R1239 GndA.n1333 GndA.n1332 585
R1240 GndA.n1331 GndA.n1330 585
R1241 GndA.n1329 GndA.n1300 585
R1242 GndA.n1327 GndA.n1326 585
R1243 GndA.n1325 GndA.n1301 585
R1244 GndA.n1324 GndA.n1323 585
R1245 GndA.n1321 GndA.n1293 585
R1246 GndA.n1321 GndA.n1302 585
R1247 GndA.n1320 GndA.n1319 585
R1248 GndA.n1318 GndA.n1317 585
R1249 GndA.n1316 GndA.n1304 585
R1250 GndA.n1314 GndA.n1313 585
R1251 GndA.n1312 GndA.n1305 585
R1252 GndA.n1311 GndA.n1310 585
R1253 GndA.n1308 GndA.n1306 585
R1254 GndA.n1290 GndA.n1289 585
R1255 GndA.n261 GndA.n260 585
R1256 GndA.n260 GndA.n259 585
R1257 GndA.n262 GndA.n207 585
R1258 GndA.n258 GndA.n207 585
R1259 GndA.n598 GndA.n597 585
R1260 GndA.n598 GndA.n208 585
R1261 GndA.n599 GndA.n191 585
R1262 GndA.n599 GndA.n206 585
R1263 GndA.n256 GndA.n255 585
R1264 GndA.n257 GndA.n215 585
R1265 GndA.n213 GndA.n212 585
R1266 GndA.n225 GndA.n224 585
R1267 GndA.n227 GndA.n226 585
R1268 GndA.n229 GndA.n222 585
R1269 GndA.n232 GndA.n231 585
R1270 GndA.n233 GndA.n221 585
R1271 GndA.n235 GndA.n234 585
R1272 GndA.n237 GndA.n220 585
R1273 GndA.n240 GndA.n239 585
R1274 GndA.n241 GndA.n219 585
R1275 GndA.n243 GndA.n242 585
R1276 GndA.n245 GndA.n218 585
R1277 GndA.n248 GndA.n247 585
R1278 GndA.n249 GndA.n217 585
R1279 GndA.n251 GndA.n250 585
R1280 GndA.n253 GndA.n216 585
R1281 GndA.n575 GndA.n574 585
R1282 GndA.n578 GndA.n577 585
R1283 GndA.n274 GndA.n271 585
R1284 GndA.n584 GndA.n583 585
R1285 GndA.n586 GndA.n585 585
R1286 GndA.n588 GndA.n587 585
R1287 GndA.n589 GndA.n189 585
R1288 GndA.n589 GndA.n267 585
R1289 GndA.n592 GndA.n591 585
R1290 GndA.n593 GndA.n211 585
R1291 GndA.n596 GndA.n595 585
R1292 GndA.n595 GndA.n594 585
R1293 GndA.n210 GndA.n209 585
R1294 GndA.n266 GndA.n210 585
R1295 GndA.n264 GndA.n263 585
R1296 GndA.n265 GndA.n264 585
R1297 GndA.n472 GndA.n471 502.93
R1298 GndA.n857 GndA.n765 502.93
R1299 GndA.n1391 GndA.n40 502.93
R1300 GndA.n621 GndA.n188 502.93
R1301 GndA.n377 GndA.n333 486.707
R1302 GndA.n1020 GndA.n976 486.707
R1303 GndA.n1340 GndA.n1295 486.707
R1304 GndA.n260 GndA.n215 486.707
R1305 GndA.n1238 GndA.n1237 447.459
R1306 GndA.n1245 GndA.n1243 447.459
R1307 GndA.n915 GndA.n839 447.459
R1308 GndA.n426 GndA.n329 422.971
R1309 GndA.n381 GndA.n328 422.971
R1310 GndA.n429 GndA.n324 422.971
R1311 GndA.n377 GndA.n326 422.971
R1312 GndA.n1020 GndA.n975 422.971
R1313 GndA.n1030 GndA.n780 422.971
R1314 GndA.n989 GndA.n971 422.971
R1315 GndA.n992 GndA.n991 422.971
R1316 GndA.n994 GndA.n985 422.971
R1317 GndA.n1002 GndA.n1001 422.971
R1318 GndA.n1006 GndA.n1005 422.971
R1319 GndA.n1008 GndA.n980 422.971
R1320 GndA.n1023 GndA.n785 422.971
R1321 GndA.n1027 GndA.n784 422.971
R1322 GndA.n967 GndA.n787 422.971
R1323 GndA.n952 GndA.n951 422.971
R1324 GndA.n957 GndA.n956 422.971
R1325 GndA.n964 GndA.n792 422.971
R1326 GndA.n1336 GndA.n1295 422.971
R1327 GndA.n1330 GndA.n1329 422.971
R1328 GndA.n1327 GndA.n1301 422.971
R1329 GndA.n1323 GndA.n1321 422.971
R1330 GndA.n1340 GndA.n1294 422.971
R1331 GndA.n1350 GndA.n61 422.971
R1332 GndA.n1343 GndA.n64 422.971
R1333 GndA.n1347 GndA.n63 422.971
R1334 GndA.n1286 GndA.n66 422.971
R1335 GndA.n1270 GndA.n1269 422.971
R1336 GndA.n1273 GndA.n69 422.971
R1337 GndA.n1261 GndA.n71 422.971
R1338 GndA.n565 GndA.n557 422.971
R1339 GndA.n591 GndA.n589 422.971
R1340 GndA.n595 GndA.n211 422.971
R1341 GndA.n264 GndA.n210 422.971
R1342 GndA.n599 GndA.n598 422.971
R1343 GndA.n260 GndA.n207 422.971
R1344 GndA.n536 GndA.n286 417.176
R1345 GndA.n536 GndA.n289 417.176
R1346 GndA.n520 GndA.n289 417.176
R1347 GndA.n520 GndA.n499 417.176
R1348 GndA.n499 GndA.n498 417.176
R1349 GndA.n498 GndA.n497 417.176
R1350 GndA.n497 GndA.n300 417.176
R1351 GndA.n531 GndA.n300 417.176
R1352 GndA.n531 GndA.n299 417.176
R1353 GndA.n492 GndA.n299 417.176
R1354 GndA.n492 GndA.n305 417.176
R1355 GndA.n488 GndA.n305 417.176
R1356 GndA.n488 GndA.n307 417.176
R1357 GndA.n482 GndA.n307 417.176
R1358 GndA.n482 GndA.n311 417.176
R1359 GndA.n478 GndA.n311 417.176
R1360 GndA.n478 GndA.n473 417.176
R1361 GndA.n473 GndA.n472 417.176
R1362 GndA.n397 GndA.n285 417.176
R1363 GndA.n401 GndA.n400 417.176
R1364 GndA.n408 GndA.n392 417.176
R1365 GndA.n411 GndA.n410 417.176
R1366 GndA.n417 GndA.n386 417.176
R1367 GndA.n420 GndA.n419 417.176
R1368 GndA.n422 GndA.n329 417.176
R1369 GndA.n426 GndA.n328 417.176
R1370 GndA.n349 GndA.n346 417.176
R1371 GndA.n352 GndA.n351 417.176
R1372 GndA.n356 GndA.n342 417.176
R1373 GndA.n359 GndA.n358 417.176
R1374 GndA.n363 GndA.n339 417.176
R1375 GndA.n366 GndA.n365 417.176
R1376 GndA.n370 GndA.n336 417.176
R1377 GndA.n373 GndA.n372 417.176
R1378 GndA.n465 GndA.n324 417.176
R1379 GndA.n429 GndA.n326 417.176
R1380 GndA.n975 GndA.n780 417.176
R1381 GndA.n1031 GndA.n1030 417.176
R1382 GndA.n998 GndA.n985 417.176
R1383 GndA.n1001 GndA.n1000 417.176
R1384 GndA.n1012 GndA.n980 417.176
R1385 GndA.n1016 GndA.n1014 417.176
R1386 GndA.n1027 GndA.n785 417.176
R1387 GndA.n964 GndA.n791 417.176
R1388 GndA.n942 GndA.n796 417.176
R1389 GndA.n898 GndA.n897 417.176
R1390 GndA.n905 GndA.n903 417.176
R1391 GndA.n906 GndA.n905 417.176
R1392 GndA.n906 GndA.n845 417.176
R1393 GndA.n911 GndA.n845 417.176
R1394 GndA.n888 GndA.n844 417.176
R1395 GndA.n886 GndA.n885 417.176
R1396 GndA.n879 GndA.n878 417.176
R1397 GndA.n876 GndA.n875 417.176
R1398 GndA.n869 GndA.n854 417.176
R1399 GndA.n869 GndA.n853 417.176
R1400 GndA.n865 GndA.n853 417.176
R1401 GndA.n865 GndA.n858 417.176
R1402 GndA.n858 GndA.n857 417.176
R1403 GndA.n1334 GndA.n1333 417.176
R1404 GndA.n1321 GndA.n1320 417.176
R1405 GndA.n1317 GndA.n1316 417.176
R1406 GndA.n1314 GndA.n1305 417.176
R1407 GndA.n1310 GndA.n1308 417.176
R1408 GndA.n1294 GndA.n61 417.176
R1409 GndA.n1351 GndA.n1350 417.176
R1410 GndA.n1391 GndA.n39 417.176
R1411 GndA.n1225 GndA.n39 417.176
R1412 GndA.n1229 GndA.n1225 417.176
R1413 GndA.n1229 GndA.n1189 417.176
R1414 GndA.n1233 GndA.n1189 417.176
R1415 GndA.n1215 GndA.n1187 417.176
R1416 GndA.n1213 GndA.n1212 417.176
R1417 GndA.n1206 GndA.n1205 417.176
R1418 GndA.n1203 GndA.n1202 417.176
R1419 GndA.n1196 GndA.n1195 417.176
R1420 GndA.n1196 GndA.n81 417.176
R1421 GndA.n1250 GndA.n81 417.176
R1422 GndA.n1250 GndA.n79 417.176
R1423 GndA.n1347 GndA.n64 417.176
R1424 GndA.n70 GndA.n69 417.176
R1425 GndA.n1282 GndA.n71 417.176
R1426 GndA.n76 GndA.n75 417.176
R1427 GndA.n77 GndA.n76 417.176
R1428 GndA.n560 GndA.n278 417.176
R1429 GndA.n568 GndA.n278 417.176
R1430 GndA.n575 GndA.n275 417.176
R1431 GndA.n577 GndA.n274 417.176
R1432 GndA.n585 GndA.n584 417.176
R1433 GndA.n589 GndA.n588 417.176
R1434 GndA.n595 GndA.n210 417.176
R1435 GndA.n255 GndA.n253 417.176
R1436 GndA.n251 GndA.n217 417.176
R1437 GndA.n247 GndA.n245 417.176
R1438 GndA.n243 GndA.n219 417.176
R1439 GndA.n239 GndA.n237 417.176
R1440 GndA.n235 GndA.n221 417.176
R1441 GndA.n231 GndA.n229 417.176
R1442 GndA.n227 GndA.n224 417.176
R1443 GndA.n600 GndA.n599 417.176
R1444 GndA.n598 GndA.n207 417.176
R1445 GndA.n656 GndA.n188 417.176
R1446 GndA.n656 GndA.n182 417.176
R1447 GndA.n660 GndA.n182 417.176
R1448 GndA.n660 GndA.n179 417.176
R1449 GndA.n665 GndA.n179 417.176
R1450 GndA.n665 GndA.n173 417.176
R1451 GndA.n669 GndA.n173 417.176
R1452 GndA.n669 GndA.n170 417.176
R1453 GndA.n673 GndA.n170 417.176
R1454 GndA.n673 GndA.n163 417.176
R1455 GndA.n677 GndA.n163 417.176
R1456 GndA.n677 GndA.n162 417.176
R1457 GndA.n681 GndA.n162 417.176
R1458 GndA.n683 GndA.n681 417.176
R1459 GndA.n683 GndA.n157 417.176
R1460 GndA.n688 GndA.n157 417.176
R1461 GndA.n688 GndA.n156 417.176
R1462 GndA.n558 GndA.n156 417.176
R1463 GndA.n928 GndA.n800 404.301
R1464 GndA.n543 GndA.n280 404.301
R1465 GndA.n281 GndA.n280 292.5
R1466 GndA.n801 GndA.n800 292.5
R1467 GndA.n180 GndA.t26 288.798
R1468 GndA.n533 GndA.t21 288.791
R1469 GndA.t16 GndA.n555 286.106
R1470 GndA.n546 GndA.t12 286.106
R1471 GndA.n931 GndA.t17 286.106
R1472 GndA.t13 GndA.n939 286.106
R1473 GndA.n514 GndA.n513 277.61
R1474 GndA.n518 GndA.n501 277.61
R1475 GndA.n518 GndA.n502 277.61
R1476 GndA.n508 GndA.n500 277.61
R1477 GndA.n695 GndA.n694 277.61
R1478 GndA.n691 GndA.n690 277.61
R1479 GndA.n690 GndA.n148 277.61
R1480 GndA.n153 GndA.n149 277.61
R1481 GndA.n1181 GndA.n85 277.61
R1482 GndA.n1181 GndA.n88 277.61
R1483 GndA.n1247 GndA.n82 277.61
R1484 GndA.n1247 GndA.n83 277.61
R1485 GndA.n920 GndA.n837 277.61
R1486 GndA.n917 GndA.n831 277.61
R1487 GndA.n467 GndA.n466 256.123
R1488 GndA.n652 GndA.n192 256.123
R1489 GndA.n1389 GndA.n47 256.123
R1490 GndA.n1032 GndA.n759 256.123
R1491 GndA GndA.t23 237.516
R1492 GndA GndA.t28 237.512
R1493 GndA.n925 GndA.t11 237.178
R1494 GndA.n720 GndA.t9 237.178
R1495 GndA.n718 GndA.t53 237.178
R1496 GndA.n89 GndA.t51 237.178
R1497 GndA.n115 GndA.t20 237.171
R1498 GndA GndA.t41 237.167
R1499 GndA.n505 GndA.n504 228.903
R1500 GndA.n504 GndA.n503 228.903
R1501 GndA.n491 GndA.n298 228.903
R1502 GndA.n491 GndA.n490 228.903
R1503 GndA.n490 GndA.n489 228.903
R1504 GndA.n489 GndA.n306 228.903
R1505 GndA.n664 GndA.n172 228.903
R1506 GndA.n670 GndA.n172 228.903
R1507 GndA.n671 GndA.n670 228.903
R1508 GndA.n672 GndA.n671 228.903
R1509 GndA.n679 GndA.n678 228.903
R1510 GndA.n680 GndA.n679 228.903
R1511 GndA.n467 GndA.n125 225.165
R1512 GndA.n652 GndA.n198 225.165
R1513 GndA.n1389 GndA.n34 225.165
R1514 GndA.n1066 GndA.n759 225.165
R1515 GndA.n1238 GndA.t2 223.73
R1516 GndA.t0 GndA.n839 223.73
R1517 GndA.n749 GndA.n748 222.375
R1518 GndA.n747 GndA.n746 222.375
R1519 GndA.n1404 GndA.n1403 222.375
R1520 GndA.n1405 GndA.n26 222.375
R1521 GndA.t39 GndA.n1235 222.131
R1522 GndA.t18 GndA.n913 222.125
R1523 GndA.n689 GndA.n155 216.839
R1524 GndA.n555 GndA.n279 216.839
R1525 GndA.n546 GndA.n545 216.839
R1526 GndA.n535 GndA.n290 216.839
R1527 GndA.n1249 GndA.n1248 216.839
R1528 GndA.n931 GndA.n930 216.839
R1529 GndA.n939 GndA.n799 216.839
R1530 GndA.n904 GndA.n836 216.839
R1531 GndA.n371 GndA.n332 215.619
R1532 GndA.n542 GndA.n284 215.619
R1533 GndA.n566 GndA.n556 215.619
R1534 GndA.n1236 GndA.n1183 215.619
R1535 GndA.n1236 GndA.n1184 215.619
R1536 GndA.n1236 GndA.n1185 215.619
R1537 GndA.n1236 GndA.n1186 215.619
R1538 GndA.n1236 GndA.n1234 215.619
R1539 GndA.n940 GndA.n798 215.619
R1540 GndA.n1260 GndA.n1259 215.619
R1541 GndA.n914 GndA.n840 215.619
R1542 GndA.n914 GndA.n841 215.619
R1543 GndA.n914 GndA.n842 215.619
R1544 GndA.n914 GndA.n843 215.619
R1545 GndA.n914 GndA.n912 215.619
R1546 GndA.n965 GndA.n790 215.619
R1547 GndA.n965 GndA.n789 215.619
R1548 GndA.n965 GndA.n788 215.619
R1549 GndA.n966 GndA.n965 215.619
R1550 GndA.n990 GndA.n974 215.619
R1551 GndA.n993 GndA.n974 215.619
R1552 GndA.n982 GndA.n974 215.619
R1553 GndA.n1007 GndA.n974 215.619
R1554 GndA.n1013 GndA.n974 215.619
R1555 GndA.n1285 GndA.n1284 215.619
R1556 GndA.n1284 GndA.n68 215.619
R1557 GndA.n1284 GndA.n67 215.619
R1558 GndA.n1335 GndA.n1293 215.619
R1559 GndA.n1299 GndA.n1293 215.619
R1560 GndA.n1328 GndA.n1293 215.619
R1561 GndA.n1322 GndA.n1293 215.619
R1562 GndA.n252 GndA.n214 215.619
R1563 GndA.n590 GndA.n189 215.619
R1564 GndA.n335 GndA.n332 214.835
R1565 GndA.n338 GndA.n332 214.835
R1566 GndA.n364 GndA.n332 214.835
R1567 GndA.n341 GndA.n332 214.835
R1568 GndA.n357 GndA.n332 214.835
R1569 GndA.n344 GndA.n332 214.835
R1570 GndA.n350 GndA.n332 214.835
R1571 GndA.n345 GndA.n332 214.835
R1572 GndA.n421 GndA.n292 214.835
R1573 GndA.n418 GndA.n292 214.835
R1574 GndA.n390 GndA.n292 214.835
R1575 GndA.n409 GndA.n292 214.835
R1576 GndA.n542 GndA.n283 214.835
R1577 GndA.n542 GndA.n541 214.835
R1578 GndA.n567 GndA.n566 214.835
R1579 GndA.n940 GndA.n797 214.835
R1580 GndA.n941 GndA.n940 214.835
R1581 GndA.n1259 GndA.n1258 214.835
R1582 GndA.n999 GndA.n974 214.835
R1583 GndA.n1015 GndA.n974 214.835
R1584 GndA.n1284 GndA.n1283 214.835
R1585 GndA.n1303 GndA.n1293 214.835
R1586 GndA.n1315 GndA.n1293 214.835
R1587 GndA.n1309 GndA.n1293 214.835
R1588 GndA.n1307 GndA.n1293 214.835
R1589 GndA.n254 GndA.n214 214.835
R1590 GndA.n223 GndA.n214 214.835
R1591 GndA.n228 GndA.n214 214.835
R1592 GndA.n230 GndA.n214 214.835
R1593 GndA.n236 GndA.n214 214.835
R1594 GndA.n238 GndA.n214 214.835
R1595 GndA.n244 GndA.n214 214.835
R1596 GndA.n246 GndA.n214 214.835
R1597 GndA.n576 GndA.n189 214.835
R1598 GndA.n270 GndA.n189 214.835
R1599 GndA.n268 GndA.n189 214.835
R1600 GndA.n566 GndA.t52 207.804
R1601 GndA.n542 GndA.t8 207.804
R1602 GndA.n1259 GndA.t50 207.804
R1603 GndA.n940 GndA.t10 207.804
R1604 GndA.n513 GndA.n505 206.648
R1605 GndA.n680 GndA.n149 206.648
R1606 GndA.n916 GndA.n830 199.827
R1607 GndA.n512 GndA.n511 199.827
R1608 GndA.n693 GndA.n692 199.827
R1609 GndA.n1240 GndA.n1182 199.827
R1610 GndA.n1246 GndA.n86 199.369
R1611 GndA.n919 GndA.n829 199.369
R1612 GndA.n517 GndA.n516 199.369
R1613 GndA.n697 GndA.n147 199.369
R1614 GndA.n690 GndA.n150 195.756
R1615 GndA.n519 GndA.n518 195.756
R1616 GndA.n1247 GndA.n84 195.756
R1617 GndA.n920 GndA.n834 195.756
R1618 GndA.n467 GndA.n130 195
R1619 GndA.n735 GndA.n130 195
R1620 GndA.n738 GndA.n126 195
R1621 GndA.n126 GndA.n125 195
R1622 GndA.n741 GndA.n740 195
R1623 GndA.n740 GndA.n739 195
R1624 GndA.n742 GndA.n124 195
R1625 GndA.n127 GndA.n124 195
R1626 GndA.n744 GndA.n743 195
R1627 GndA.n745 GndA.n744 195
R1628 GndA.n122 GndA.n121 195
R1629 GndA.n511 GndA.n506 195
R1630 GndA.n510 GndA.n509 195
R1631 GndA.n516 GndA.n515 195
R1632 GndA.n692 GndA.n151 195
R1633 GndA.n154 GndA.n146 195
R1634 GndA.n697 GndA.n696 195
R1635 GndA.n1406 GndA.n28 195
R1636 GndA.n1408 GndA.n1407 195
R1637 GndA.n1409 GndA.n1408 195
R1638 GndA.n29 GndA.n27 195
R1639 GndA.n27 GndA.n25 195
R1640 GndA.n616 GndA.n615 195
R1641 GndA.n618 GndA.n616 195
R1642 GndA.n620 GndA.n198 195
R1643 GndA.n620 GndA.n619 195
R1644 GndA.n652 GndA.n199 195
R1645 GndA.n613 GndA.n199 195
R1646 GndA.n31 GndA.n30 195
R1647 GndA.n1401 GndA.n1400 195
R1648 GndA.n1402 GndA.n1401 195
R1649 GndA.n1399 GndA.n33 195
R1650 GndA.n1395 GndA.n33 195
R1651 GndA.n1398 GndA.n1397 195
R1652 GndA.n1397 GndA.n1396 195
R1653 GndA.n35 GndA.n34 195
R1654 GndA.n1394 GndA.n35 195
R1655 GndA.n1388 GndA.n1387 195
R1656 GndA.n1389 GndA.n1388 195
R1657 GndA.n1244 GndA.n86 195
R1658 GndA.n1242 GndA.n1241 195
R1659 GndA.n1240 GndA.n1239 195
R1660 GndA.n835 GndA.n829 195
R1661 GndA.n922 GndA.n921 195
R1662 GndA.n832 GndA.n830 195
R1663 GndA.n769 GndA.n768 195
R1664 GndA.n768 GndA.n759 195
R1665 GndA.n1066 GndA.n1065 195
R1666 GndA.n1065 GndA.n1064 195
R1667 GndA.n1067 GndA.n120 195
R1668 GndA.n120 GndA.n118 195
R1669 GndA.n1069 GndA.n1068 195
R1670 GndA.n1070 GndA.n1069 195
R1671 GndA.n752 GndA.n119 195
R1672 GndA.n119 GndA.n117 195
R1673 GndA.n751 GndA.n750 195
R1674 GndA.n825 GndA.t46 189.877
R1675 GndA.t43 GndA.n708 189.877
R1676 GndA.n728 GndA.t45 189.877
R1677 GndA.t47 GndA.n1170 189.877
R1678 GndA.n932 GndA.n800 185.412
R1679 GndA.n554 GndA.n280 185.412
R1680 GndA.n810 GndA.t1 184.483
R1681 GndA.t1 GndA.n809 184.483
R1682 GndA.t46 GndA.n824 184.483
R1683 GndA.n817 GndA.t49 184.483
R1684 GndA.t49 GndA.n816 184.483
R1685 GndA.n711 GndA.t43 184.483
R1686 GndA.n142 GndA.t7 184.483
R1687 GndA.t7 GndA.n141 184.483
R1688 GndA.t45 GndA.n727 184.483
R1689 GndA.t5 GndA.n704 184.483
R1690 GndA.n705 GndA.t5 184.483
R1691 GndA.n1164 GndA.t30 184.483
R1692 GndA.t30 GndA.n1161 184.483
R1693 GndA.n1173 GndA.t47 184.483
R1694 GndA.t3 GndA.n95 184.483
R1695 GndA.n96 GndA.t3 184.483
R1696 GndA.n566 GndA.t15 183.71
R1697 GndA.t14 GndA.n542 183.71
R1698 GndA.n1259 GndA.t38 183.71
R1699 GndA.n940 GndA.t37 183.71
R1700 GndA.n938 GndA.n800 179.619
R1701 GndA.n547 GndA.n280 179.619
R1702 GndA.t21 GndA.n298 171.677
R1703 GndA.n672 GndA.t26 171.677
R1704 GndA.n335 GndA.n333 155.333
R1705 GndA.n338 GndA.n336 155.333
R1706 GndA.n365 GndA.n364 155.333
R1707 GndA.n341 GndA.n339 155.333
R1708 GndA.n358 GndA.n357 155.333
R1709 GndA.n344 GndA.n342 155.333
R1710 GndA.n351 GndA.n350 155.333
R1711 GndA.n346 GndA.n345 155.333
R1712 GndA.n422 GndA.n421 155.333
R1713 GndA.n419 GndA.n418 155.333
R1714 GndA.n390 GndA.n386 155.333
R1715 GndA.n410 GndA.n409 155.333
R1716 GndA.n392 GndA.n283 155.333
R1717 GndA.n541 GndA.n285 155.333
R1718 GndA.n541 GndA.n540 155.333
R1719 GndA.n401 GndA.n283 155.333
R1720 GndA.n409 GndA.n408 155.333
R1721 GndA.n411 GndA.n390 155.333
R1722 GndA.n418 GndA.n417 155.333
R1723 GndA.n421 GndA.n420 155.333
R1724 GndA.n345 GndA.n331 155.333
R1725 GndA.n350 GndA.n349 155.333
R1726 GndA.n352 GndA.n344 155.333
R1727 GndA.n357 GndA.n356 155.333
R1728 GndA.n359 GndA.n341 155.333
R1729 GndA.n364 GndA.n363 155.333
R1730 GndA.n366 GndA.n338 155.333
R1731 GndA.n373 GndA.n335 155.333
R1732 GndA.n568 GndA.n567 155.333
R1733 GndA.n894 GndA.n797 155.333
R1734 GndA.n942 GndA.n941 155.333
R1735 GndA.n1258 GndA.n77 155.333
R1736 GndA.n1000 GndA.n999 155.333
R1737 GndA.n1016 GndA.n1015 155.333
R1738 GndA.n999 GndA.n998 155.333
R1739 GndA.n1015 GndA.n976 155.333
R1740 GndA.n941 GndA.n791 155.333
R1741 GndA.n898 GndA.n797 155.333
R1742 GndA.n1283 GndA.n70 155.333
R1743 GndA.n1317 GndA.n1303 155.333
R1744 GndA.n1316 GndA.n1315 155.333
R1745 GndA.n1310 GndA.n1309 155.333
R1746 GndA.n1308 GndA.n1307 155.333
R1747 GndA.n1320 GndA.n1303 155.333
R1748 GndA.n1315 GndA.n1314 155.333
R1749 GndA.n1309 GndA.n1305 155.333
R1750 GndA.n1307 GndA.n1290 155.333
R1751 GndA.n1283 GndA.n1282 155.333
R1752 GndA.n1258 GndA.n1257 155.333
R1753 GndA.n254 GndA.n215 155.333
R1754 GndA.n223 GndA.n213 155.333
R1755 GndA.n228 GndA.n227 155.333
R1756 GndA.n231 GndA.n230 155.333
R1757 GndA.n236 GndA.n235 155.333
R1758 GndA.n239 GndA.n238 155.333
R1759 GndA.n244 GndA.n243 155.333
R1760 GndA.n247 GndA.n246 155.333
R1761 GndA.n576 GndA.n575 155.333
R1762 GndA.n274 GndA.n270 155.333
R1763 GndA.n585 GndA.n268 155.333
R1764 GndA.n567 GndA.n275 155.333
R1765 GndA.n577 GndA.n576 155.333
R1766 GndA.n584 GndA.n270 155.333
R1767 GndA.n588 GndA.n268 155.333
R1768 GndA.n255 GndA.n254 155.333
R1769 GndA.n246 GndA.n217 155.333
R1770 GndA.n245 GndA.n244 155.333
R1771 GndA.n238 GndA.n219 155.333
R1772 GndA.n237 GndA.n236 155.333
R1773 GndA.n230 GndA.n221 155.333
R1774 GndA.n229 GndA.n228 155.333
R1775 GndA.n224 GndA.n223 155.333
R1776 GndA.n372 GndA.n371 153.763
R1777 GndA.n400 GndA.n284 153.763
R1778 GndA.n397 GndA.n284 153.763
R1779 GndA.n371 GndA.n370 153.763
R1780 GndA.n557 GndA.n556 153.763
R1781 GndA.n1195 GndA.n1183 153.763
R1782 GndA.n1203 GndA.n1184 153.763
R1783 GndA.n1205 GndA.n1185 153.763
R1784 GndA.n1213 GndA.n1186 153.763
R1785 GndA.n1234 GndA.n1187 153.763
R1786 GndA.n897 GndA.n798 153.763
R1787 GndA.n1261 GndA.n1260 153.763
R1788 GndA.n854 GndA.n840 153.763
R1789 GndA.n876 GndA.n841 153.763
R1790 GndA.n878 GndA.n842 153.763
R1791 GndA.n886 GndA.n843 153.763
R1792 GndA.n912 GndA.n844 153.763
R1793 GndA.n792 GndA.n790 153.763
R1794 GndA.n956 GndA.n789 153.763
R1795 GndA.n951 GndA.n788 153.763
R1796 GndA.n967 GndA.n966 153.763
R1797 GndA.n991 GndA.n990 153.763
R1798 GndA.n994 GndA.n993 153.763
R1799 GndA.n1002 GndA.n982 153.763
R1800 GndA.n1008 GndA.n1007 153.763
R1801 GndA.n1013 GndA.n1012 153.763
R1802 GndA.n990 GndA.n989 153.763
R1803 GndA.n993 GndA.n992 153.763
R1804 GndA.n1005 GndA.n982 153.763
R1805 GndA.n1007 GndA.n1006 153.763
R1806 GndA.n1014 GndA.n1013 153.763
R1807 GndA.n966 GndA.n784 153.763
R1808 GndA.n788 GndA.n787 153.763
R1809 GndA.n952 GndA.n789 153.763
R1810 GndA.n957 GndA.n790 153.763
R1811 GndA.n798 GndA.n796 153.763
R1812 GndA.n912 GndA.n911 153.763
R1813 GndA.n888 GndA.n843 153.763
R1814 GndA.n885 GndA.n842 153.763
R1815 GndA.n879 GndA.n841 153.763
R1816 GndA.n875 GndA.n840 153.763
R1817 GndA.n1285 GndA.n63 153.763
R1818 GndA.n68 GndA.n66 153.763
R1819 GndA.n1270 GndA.n67 153.763
R1820 GndA.n1335 GndA.n1334 153.763
R1821 GndA.n1330 GndA.n1299 153.763
R1822 GndA.n1328 GndA.n1327 153.763
R1823 GndA.n1323 GndA.n1322 153.763
R1824 GndA.n1336 GndA.n1335 153.763
R1825 GndA.n1333 GndA.n1299 153.763
R1826 GndA.n1329 GndA.n1328 153.763
R1827 GndA.n1322 GndA.n1301 153.763
R1828 GndA.n1234 GndA.n1233 153.763
R1829 GndA.n1215 GndA.n1186 153.763
R1830 GndA.n1212 GndA.n1185 153.763
R1831 GndA.n1206 GndA.n1184 153.763
R1832 GndA.n1202 GndA.n1183 153.763
R1833 GndA.n1286 GndA.n1285 153.763
R1834 GndA.n1269 GndA.n68 153.763
R1835 GndA.n1273 GndA.n67 153.763
R1836 GndA.n1260 GndA.n75 153.763
R1837 GndA.n252 GndA.n251 153.763
R1838 GndA.n591 GndA.n590 153.763
R1839 GndA.n560 GndA.n556 153.763
R1840 GndA.n590 GndA.n211 153.763
R1841 GndA.n253 GndA.n252 153.763
R1842 GndA.n507 GndA.n297 152.601
R1843 GndA.n682 GndA.n152 152.601
R1844 GndA.n480 GndA.n479 148.732
R1845 GndA.n479 GndA.n294 148.732
R1846 GndA.n741 GndA.n125 148.732
R1847 GndA.n743 GndA.n742 148.732
R1848 GndA.n747 GndA.n121 148.732
R1849 GndA.n1406 GndA.n1405 148.732
R1850 GndA.n1407 GndA.n29 148.732
R1851 GndA.n615 GndA.n198 148.732
R1852 GndA.n655 GndA.n181 148.732
R1853 GndA.n661 GndA.n181 148.732
R1854 GndA.n1404 GndA.n30 148.732
R1855 GndA.n1400 GndA.n1399 148.732
R1856 GndA.n1398 GndA.n34 148.732
R1857 GndA.n1227 GndA.n1226 148.732
R1858 GndA.n1228 GndA.n1227 148.732
R1859 GndA.n867 GndA.n866 148.732
R1860 GndA.n866 GndA.n855 148.732
R1861 GndA.n1067 GndA.n1066 148.732
R1862 GndA.n1068 GndA.n752 148.732
R1863 GndA.n751 GndA.n748 148.732
R1864 GndA.n428 GndA.n427 143.757
R1865 GndA.n379 GndA.n327 143.757
R1866 GndA.n380 GndA.n378 143.757
R1867 GndA.n1022 GndA.n1021 143.757
R1868 GndA.n973 GndA.n972 143.757
R1869 GndA.n1028 GndA.n783 143.757
R1870 GndA.n1342 GndA.n1341 143.757
R1871 GndA.n1292 GndA.n1291 143.757
R1872 GndA.n1348 GndA.n62 143.757
R1873 GndA.n597 GndA.n596 143.757
R1874 GndA.n262 GndA.n209 143.757
R1875 GndA.n263 GndA.n261 143.757
R1876 GndA.n742 GndA.t54 126.01
R1877 GndA.t56 GndA.n29 126.01
R1878 GndA.n1399 GndA.t29 126.01
R1879 GndA.n1068 GndA.t48 126.01
R1880 GndA.n503 GndA.t6 117.63
R1881 GndA.n678 GndA.t4 117.63
R1882 GndA.n535 GndA.n534 117.454
R1883 GndA.n904 GndA.n782 117.454
R1884 GndA.n654 GndA.n155 114.442
R1885 GndA.n1249 GndA.n41 114.442
R1886 GndA.n544 GndA.n279 111.431
R1887 GndA.n930 GndA.n929 111.431
R1888 GndA.n532 GndA.t6 111.272
R1889 GndA.n171 GndA.t4 111.272
R1890 GndA.n534 GndA.n295 107.418
R1891 GndA.n856 GndA.n782 107.418
R1892 GndA.n545 GndA.n544 105.407
R1893 GndA.n929 GndA.n799 105.407
R1894 GndA.t44 GndA.n480 105.353
R1895 GndA.n654 GndA.n653 105.353
R1896 GndA.t42 GndA.n661 105.353
R1897 GndA.n1390 GndA.n41 105.353
R1898 GndA.n1228 GndA.t2 105.353
R1899 GndA.t0 GndA.n867 105.353
R1900 GndA.n654 GndA.n190 102.397
R1901 GndA.n78 GndA.n41 102.397
R1902 GndA.n534 GndA.n291 99.3845
R1903 GndA.n902 GndA.n782 99.3845
R1904 GndA.n731 GndA.t55 98.4793
R1905 GndA.n707 GndA.t57 98.4792
R1906 GndA.t22 GndA.n121 97.0897
R1907 GndA.t27 GndA.n1406 97.0897
R1908 GndA.t40 GndA.n30 97.0897
R1909 GndA.t19 GndA.n751 97.0897
R1910 GndA.n749 GndA.n117 89.4404
R1911 GndA.n746 GndA.n745 89.44
R1912 GndA.n1403 GndA.n1402 89.44
R1913 GndA.n1409 GndA.n26 89.44
R1914 GndA.n378 GndA.n332 84.7146
R1915 GndA.n1021 GndA.n974 84.7146
R1916 GndA.n1341 GndA.n1293 84.7146
R1917 GndA.n261 GndA.n214 84.7146
R1918 GndA.n927 GndA.n926 81.2833
R1919 GndA.n719 GndA.n145 81.2833
R1920 GndA.n926 GndA.n89 78.5552
R1921 GndA.n926 GndA.n925 78.5552
R1922 GndA.n719 GndA.n718 78.5552
R1923 GndA.n720 GndA.n719 78.5552
R1924 GndA.n913 GndA.n782 76.4218
R1925 GndA.n1235 GndA.n41 76.3945
R1926 GndA.n481 GndA.n296 75.1291
R1927 GndA.n663 GndA.n662 75.1291
R1928 GndA.n468 GndA.n312 74.933
R1929 GndA.n438 GndA.n318 74.933
R1930 GndA.n441 GndA.n317 74.933
R1931 GndA.n775 GndA.n763 74.933
R1932 GndA.n774 GndA.n754 74.933
R1933 GndA.n770 GndA.n764 74.933
R1934 GndA.n1376 GndA.n43 74.933
R1935 GndA.n1379 GndA.n52 74.933
R1936 GndA.n1382 GndA.n42 74.933
R1937 GndA.n626 GndA.n197 74.933
R1938 GndA.n629 GndA.n200 74.933
R1939 GndA.n632 GndA.n196 74.933
R1940 GndA.n432 GndA.n319 73.7244
R1941 GndA.n446 GndA.n316 73.7244
R1942 GndA.n778 GndA.n762 73.7244
R1943 GndA.n776 GndA.n755 73.7244
R1944 GndA.n1370 GndA.n44 73.7244
R1945 GndA.n1373 GndA.n51 73.7244
R1946 GndA.n605 GndA.n201 73.7244
R1947 GndA.n637 GndA.n195 73.7244
R1948 GndA.n466 GndA.n323 72.7575
R1949 GndA.n466 GndA.n465 72.7575
R1950 GndA.n600 GndA.n192 72.7575
R1951 GndA.n1351 GndA.n47 72.7575
R1952 GndA.n1032 GndA.n1031 72.7575
R1953 GndA.n1033 GndA.n1032 72.7575
R1954 GndA.n1354 GndA.n47 72.7575
R1955 GndA.n602 GndA.n192 72.7575
R1956 GndA.n449 GndA.n320 72.5158
R1957 GndA.n452 GndA.n315 72.5158
R1958 GndA.n1045 GndA.n761 72.5158
R1959 GndA.n1048 GndA.n756 72.5158
R1960 GndA.n1364 GndA.n45 72.5158
R1961 GndA.n1367 GndA.n50 72.5158
R1962 GndA.n640 GndA.n202 72.5158
R1963 GndA.n643 GndA.n194 72.5158
R1964 GndA.n534 GndA.n293 71.8791
R1965 GndA.n1029 GndA.n782 71.8791
R1966 GndA.n1349 GndA.n41 71.8791
R1967 GndA.n654 GndA.n191 71.8791
R1968 GndA.n455 GndA.n321 71.3072
R1969 GndA.n458 GndA.n314 71.3072
R1970 GndA.n1039 GndA.n760 71.3072
R1971 GndA.n1042 GndA.n757 71.3072
R1972 GndA.n1358 GndA.n46 71.3072
R1973 GndA.n1361 GndA.n49 71.3072
R1974 GndA.n646 GndA.n203 71.3072
R1975 GndA.n205 GndA.n193 71.3072
R1976 GndA.n461 GndA.n322 70.0987
R1977 GndA.n1036 GndA.n758 70.0987
R1978 GndA.n1355 GndA.n48 70.0987
R1979 GndA.n651 GndA.n204 70.0987
R1980 GndA.n382 GndA.n330 70.024
R1981 GndA.n1024 GndA.n970 70.024
R1982 GndA.n1344 GndA.n1289 70.024
R1983 GndA.n265 GndA.n212 70.024
R1984 GndA.n534 GndA.n533 69.9251
R1985 GndA.n654 GndA.n180 69.8991
R1986 GndA.n740 GndA.n126 62.7616
R1987 GndA.n740 GndA.n124 62.7616
R1988 GndA.n744 GndA.n124 62.7616
R1989 GndA.n744 GndA.n122 62.7616
R1990 GndA.n921 GndA.n832 62.7616
R1991 GndA.n1065 GndA.n120 62.7616
R1992 GndA.n1069 GndA.n120 62.7616
R1993 GndA.n1069 GndA.n119 62.7616
R1994 GndA.n750 GndA.n119 62.7616
R1995 GndA.n1401 GndA.n31 62.7616
R1996 GndA.n1401 GndA.n33 62.7616
R1997 GndA.n1397 GndA.n33 62.7616
R1998 GndA.n1397 GndA.n35 62.7616
R1999 GndA.n1408 GndA.n28 62.7616
R2000 GndA.n1408 GndA.n27 62.7616
R2001 GndA.n616 GndA.n27 62.7616
R2002 GndA.n620 GndA.n616 62.7616
R2003 GndA.n1243 GndA.n87 62.1474
R2004 GndA.n838 GndA.n833 62.1474
R2005 GndA.n1188 GndA.n87 60.8909
R2006 GndA.n868 GndA.n838 60.8909
R2007 GndA.n539 GndA.n538 60.6123
R2008 GndA.n901 GndA.n900 60.6123
R2009 GndA.n1256 GndA.n1252 60.6123
R2010 GndA.n564 GndA.n563 60.6123
R2011 GndA.t52 GndA.n190 60.2332
R2012 GndA.n291 GndA.t8 60.2332
R2013 GndA.n78 GndA.t50 60.2332
R2014 GndA.n902 GndA.t10 60.2332
R2015 GndA.n467 GndA.n295 59.9066
R2016 GndA.n653 GndA.n652 59.9066
R2017 GndA.n1390 GndA.n1389 59.9066
R2018 GndA.n856 GndA.n759 59.9066
R2019 GndA.t21 GndA.n532 57.2259
R2020 GndA.t26 GndA.n171 57.2259
R2021 GndA.n1388 GndA.n53 56.6598
R2022 GndA.n622 GndA.n199 56.6598
R2023 GndA.n470 GndA.n130 55.7881
R2024 GndA.n768 GndA.n767 55.7881
R2025 GndA.n694 GndA.n152 51.1983
R2026 GndA.n500 GndA.n297 51.1983
R2027 GndA.n1181 GndA.n87 51.1983
R2028 GndA.n917 GndA.n838 51.1983
R2029 GndA.n427 GndA.n293 43.6411
R2030 GndA.n380 GndA.n379 43.6411
R2031 GndA.n1022 GndA.n973 43.6411
R2032 GndA.n1029 GndA.n1028 43.6411
R2033 GndA.n1342 GndA.n1292 43.6411
R2034 GndA.n1349 GndA.n1348 43.6411
R2035 GndA.n596 GndA.n191 43.6411
R2036 GndA.n263 GndA.n262 43.6411
R2037 GndA.n655 GndA.n654 43.3808
R2038 GndA.n1226 GndA.n41 43.3808
R2039 GndA.n534 GndA.n294 41.3151
R2040 GndA.n855 GndA.n782 41.3151
R2041 GndA.n428 GndA.n327 41.074
R2042 GndA.n972 GndA.n783 41.074
R2043 GndA.n1291 GndA.n62 41.074
R2044 GndA.n597 GndA.n209 41.074
R2045 GndA.n919 GndA.n918 38.5663
R2046 GndA.n306 GndA.n296 38.1508
R2047 GndA.n664 GndA.n663 38.1508
R2048 GndA.n470 GndA.n469 37.4668
R2049 GndA.n767 GndA.n753 37.4668
R2050 GndA.n56 GndA.n53 37.4668
R2051 GndA.n623 GndA.n622 37.4668
R2052 GndA.n544 GndA.n543 36.563
R2053 GndA.n543 GndA.n145 36.563
R2054 GndA.n929 GndA.n928 36.563
R2055 GndA.n928 GndA.n927 36.563
R2056 GndA.n743 GndA.t35 35.1179
R2057 GndA.n1407 GndA.t32 35.1179
R2058 GndA.n1400 GndA.t33 35.1179
R2059 GndA.n752 GndA.t34 35.1179
R2060 GndA.n471 GndA.n126 33.1244
R2061 GndA.n1065 GndA.n765 33.1244
R2062 GndA.n40 GndA.n35 33.1244
R2063 GndA.n621 GndA.n620 33.1244
R2064 GndA.n376 GndA.n375 31.624
R2065 GndA.n1019 GndA.n1018 31.624
R2066 GndA.n1339 GndA.n1338 31.624
R2067 GndA.n259 GndA.n257 31.624
R2068 GndA.n533 GndA.n296 31.1832
R2069 GndA.n663 GndA.n180 31.1717
R2070 GndA.n515 GndA.n514 29.7839
R2071 GndA.n512 GndA.n501 29.7839
R2072 GndA.n509 GndA.n502 29.7839
R2073 GndA.n509 GndA.n508 29.7839
R2074 GndA.n696 GndA.n695 29.7839
R2075 GndA.n693 GndA.n691 29.7839
R2076 GndA.n154 GndA.n148 29.7839
R2077 GndA.n154 GndA.n153 29.7839
R2078 GndA.n1182 GndA.n83 29.7839
R2079 GndA.n1246 GndA.n85 29.7839
R2080 GndA.n1242 GndA.n88 29.7839
R2081 GndA.n1242 GndA.n82 29.7839
R2082 GndA.n1239 GndA.n83 29.7839
R2083 GndA.n1239 GndA.n88 29.7839
R2084 GndA.n1244 GndA.n82 29.7839
R2085 GndA.n1244 GndA.n85 29.7839
R2086 GndA.n837 GndA.n832 29.7839
R2087 GndA.n921 GndA.n831 29.7839
R2088 GndA.n916 GndA.n837 29.7839
R2089 GndA.n835 GndA.n831 29.7839
R2090 GndA.n695 GndA.n147 29.7839
R2091 GndA.n696 GndA.n148 29.7839
R2092 GndA.n153 GndA.n151 29.7839
R2093 GndA.n691 GndA.n151 29.7839
R2094 GndA.n517 GndA.n514 29.7839
R2095 GndA.n515 GndA.n502 29.7839
R2096 GndA.n508 GndA.n506 29.7839
R2097 GndA.n506 GndA.n501 29.7839
R2098 GndA.n825 GndA.n821 29.0473
R2099 GndA.n712 GndA.n708 29.0473
R2100 GndA.n728 GndA.n724 29.0473
R2101 GndA.n1174 GndA.n1170 29.0473
R2102 GndA.n737 GndA.n128 27.9848
R2103 GndA.n1063 GndA.n766 27.9848
R2104 GndA.n1393 GndA.n1392 27.9848
R2105 GndA.n617 GndA.n187 27.9848
R2106 GndA.n431 GndA.n430 27.4829
R2107 GndA.n376 GndA.n325 27.4829
R2108 GndA.n375 GndA.n374 27.4829
R2109 GndA.n347 GndA.n330 27.4829
R2110 GndA.n348 GndA.n343 27.4829
R2111 GndA.n354 GndA.n353 27.4829
R2112 GndA.n355 GndA.n340 27.4829
R2113 GndA.n361 GndA.n360 27.4829
R2114 GndA.n362 GndA.n337 27.4829
R2115 GndA.n368 GndA.n367 27.4829
R2116 GndA.n539 GndA.n287 27.4829
R2117 GndA.n416 GndA.n385 27.4829
R2118 GndA.n423 GndA.n384 27.4829
R2119 GndA.n425 GndA.n424 27.4829
R2120 GndA.n383 GndA.n382 27.4829
R2121 GndA.n1025 GndA.n1024 27.4829
R2122 GndA.n1026 GndA.n969 27.4829
R2123 GndA.n968 GndA.n786 27.4829
R2124 GndA.n953 GndA.n950 27.4829
R2125 GndA.n900 GndA.n899 27.4829
R2126 GndA.n988 GndA.n970 27.4829
R2127 GndA.n987 GndA.n986 27.4829
R2128 GndA.n996 GndA.n995 27.4829
R2129 GndA.n997 GndA.n984 27.4829
R2130 GndA.n1003 GndA.n983 27.4829
R2131 GndA.n1004 GndA.n981 27.4829
R2132 GndA.n1010 GndA.n1009 27.4829
R2133 GndA.n1018 GndA.n1017 27.4829
R2134 GndA.n1019 GndA.n978 27.4829
R2135 GndA.n977 GndA.n781 27.4829
R2136 GndA.n1345 GndA.n1344 27.4829
R2137 GndA.n1346 GndA.n1288 27.4829
R2138 GndA.n1287 GndA.n65 27.4829
R2139 GndA.n1271 GndA.n1268 27.4829
R2140 GndA.n1256 GndA.n1255 27.4829
R2141 GndA.n1339 GndA.n1297 27.4829
R2142 GndA.n1296 GndA.n60 27.4829
R2143 GndA.n1338 GndA.n1337 27.4829
R2144 GndA.n1331 GndA.n1300 27.4829
R2145 GndA.n1326 GndA.n1325 27.4829
R2146 GndA.n1324 GndA.n1302 27.4829
R2147 GndA.n1319 GndA.n1318 27.4829
R2148 GndA.n1313 GndA.n1304 27.4829
R2149 GndA.n1312 GndA.n1311 27.4829
R2150 GndA.n1306 GndA.n1289 27.4829
R2151 GndA.n208 GndA.n206 27.4829
R2152 GndA.n259 GndA.n258 27.4829
R2153 GndA.n257 GndA.n256 27.4829
R2154 GndA.n249 GndA.n248 27.4829
R2155 GndA.n242 GndA.n218 27.4829
R2156 GndA.n241 GndA.n240 27.4829
R2157 GndA.n234 GndA.n220 27.4829
R2158 GndA.n233 GndA.n232 27.4829
R2159 GndA.n226 GndA.n222 27.4829
R2160 GndA.n225 GndA.n212 27.4829
R2161 GndA.n564 GndA.n562 27.4829
R2162 GndA.n587 GndA.n586 27.4829
R2163 GndA.n592 GndA.n267 27.4829
R2164 GndA.n594 GndA.n593 27.4829
R2165 GndA.n266 GndA.n265 27.4829
R2166 GndA.n464 GndA.n431 27.1064
R2167 GndA.n430 GndA.n325 27.1064
R2168 GndA.n348 GndA.n347 27.1064
R2169 GndA.n353 GndA.n343 27.1064
R2170 GndA.n355 GndA.n354 27.1064
R2171 GndA.n360 GndA.n340 27.1064
R2172 GndA.n362 GndA.n361 27.1064
R2173 GndA.n367 GndA.n337 27.1064
R2174 GndA.n369 GndA.n368 27.1064
R2175 GndA.n369 GndA.n334 27.1064
R2176 GndA.n398 GndA.n287 27.1064
R2177 GndA.n399 GndA.n398 27.1064
R2178 GndA.n385 GndA.n384 27.1064
R2179 GndA.n424 GndA.n423 27.1064
R2180 GndA.n425 GndA.n383 27.1064
R2181 GndA.n538 GndA.n537 27.1064
R2182 GndA.n537 GndA.n288 27.1064
R2183 GndA.n524 GndA.n521 27.1064
R2184 GndA.n525 GndA.n524 27.1064
R2185 GndA.n526 GndA.n525 27.1064
R2186 GndA.n526 GndA.n302 27.1064
R2187 GndA.n530 GndA.n302 27.1064
R2188 GndA.n530 GndA.n301 27.1064
R2189 GndA.n493 GndA.n301 27.1064
R2190 GndA.n493 GndA.n304 27.1064
R2191 GndA.n487 GndA.n304 27.1064
R2192 GndA.n487 GndA.n308 27.1064
R2193 GndA.n483 GndA.n308 27.1064
R2194 GndA.n483 GndA.n310 27.1064
R2195 GndA.n477 GndA.n310 27.1064
R2196 GndA.n477 GndA.n474 27.1064
R2197 GndA.n474 GndA.n128 27.1064
R2198 GndA.n808 GndA.n805 27.1064
R2199 GndA.n901 GndA.n893 27.1064
R2200 GndA.n907 GndA.n893 27.1064
R2201 GndA.n910 GndA.n909 27.1064
R2202 GndA.n910 GndA.n846 27.1064
R2203 GndA.n889 GndA.n846 27.1064
R2204 GndA.n889 GndA.n887 27.1064
R2205 GndA.n887 GndA.n884 27.1064
R2206 GndA.n884 GndA.n848 27.1064
R2207 GndA.n880 GndA.n848 27.1064
R2208 GndA.n880 GndA.n877 27.1064
R2209 GndA.n877 GndA.n874 27.1064
R2210 GndA.n874 GndA.n850 27.1064
R2211 GndA.n870 GndA.n850 27.1064
R2212 GndA.n870 GndA.n852 27.1064
R2213 GndA.n864 GndA.n852 27.1064
R2214 GndA.n864 GndA.n859 27.1064
R2215 GndA.n859 GndA.n766 27.1064
R2216 GndA.n1026 GndA.n1025 27.1064
R2217 GndA.n969 GndA.n968 27.1064
R2218 GndA.n950 GndA.n786 27.1064
R2219 GndA.n896 GndA.n895 27.1064
R2220 GndA.n899 GndA.n896 27.1064
R2221 GndA.n988 GndA.n987 27.1064
R2222 GndA.n995 GndA.n986 27.1064
R2223 GndA.n997 GndA.n996 27.1064
R2224 GndA.n984 GndA.n983 27.1064
R2225 GndA.n1004 GndA.n1003 27.1064
R2226 GndA.n1009 GndA.n981 27.1064
R2227 GndA.n1011 GndA.n1010 27.1064
R2228 GndA.n1011 GndA.n979 27.1064
R2229 GndA.n978 GndA.n977 27.1064
R2230 GndA.n781 GndA.n779 27.1064
R2231 GndA.n815 GndA.n813 27.1064
R2232 GndA.n1346 GndA.n1345 27.1064
R2233 GndA.n1288 GndA.n1287 27.1064
R2234 GndA.n1268 GndA.n65 27.1064
R2235 GndA.n1254 GndA.n1253 27.1064
R2236 GndA.n1255 GndA.n1254 27.1064
R2237 GndA.n1392 GndA.n37 27.1064
R2238 GndA.n1224 GndA.n37 27.1064
R2239 GndA.n1230 GndA.n1224 27.1064
R2240 GndA.n1231 GndA.n1230 27.1064
R2241 GndA.n1232 GndA.n1231 27.1064
R2242 GndA.n1232 GndA.n1190 27.1064
R2243 GndA.n1216 GndA.n1190 27.1064
R2244 GndA.n1216 GndA.n1214 27.1064
R2245 GndA.n1214 GndA.n1211 27.1064
R2246 GndA.n1211 GndA.n1192 27.1064
R2247 GndA.n1207 GndA.n1192 27.1064
R2248 GndA.n1207 GndA.n1204 27.1064
R2249 GndA.n1204 GndA.n1201 27.1064
R2250 GndA.n1201 GndA.n1194 27.1064
R2251 GndA.n1197 GndA.n1194 27.1064
R2252 GndA.n1251 GndA.n80 27.1064
R2253 GndA.n1252 GndA.n1251 27.1064
R2254 GndA.n1297 GndA.n1296 27.1064
R2255 GndA.n1352 GndA.n60 27.1064
R2256 GndA.n1332 GndA.n1298 27.1064
R2257 GndA.n1332 GndA.n1331 27.1064
R2258 GndA.n1326 GndA.n1300 27.1064
R2259 GndA.n1325 GndA.n1324 27.1064
R2260 GndA.n1319 GndA.n1302 27.1064
R2261 GndA.n1318 GndA.n1304 27.1064
R2262 GndA.n1313 GndA.n1312 27.1064
R2263 GndA.n1311 GndA.n1306 27.1064
R2264 GndA.n601 GndA.n206 27.1064
R2265 GndA.n258 GndA.n208 27.1064
R2266 GndA.n250 GndA.n216 27.1064
R2267 GndA.n250 GndA.n249 27.1064
R2268 GndA.n248 GndA.n218 27.1064
R2269 GndA.n242 GndA.n241 27.1064
R2270 GndA.n240 GndA.n220 27.1064
R2271 GndA.n234 GndA.n233 27.1064
R2272 GndA.n232 GndA.n222 27.1064
R2273 GndA.n226 GndA.n225 27.1064
R2274 GndA.n562 GndA.n561 27.1064
R2275 GndA.n561 GndA.n559 27.1064
R2276 GndA.n587 GndA.n267 27.1064
R2277 GndA.n593 GndA.n592 27.1064
R2278 GndA.n594 GndA.n266 27.1064
R2279 GndA.n657 GndA.n187 27.1064
R2280 GndA.n658 GndA.n657 27.1064
R2281 GndA.n659 GndA.n658 27.1064
R2282 GndA.n659 GndA.n178 27.1064
R2283 GndA.n666 GndA.n178 27.1064
R2284 GndA.n667 GndA.n666 27.1064
R2285 GndA.n668 GndA.n667 27.1064
R2286 GndA.n668 GndA.n169 27.1064
R2287 GndA.n674 GndA.n169 27.1064
R2288 GndA.n675 GndA.n674 27.1064
R2289 GndA.n676 GndA.n675 27.1064
R2290 GndA.n676 GndA.n164 27.1064
R2291 GndA.n164 GndA.n161 27.1064
R2292 GndA.n684 GndA.n161 27.1064
R2293 GndA.n684 GndA.n159 27.1064
R2294 GndA.n687 GndA.n158 27.1064
R2295 GndA.n563 GndA.n158 27.1064
R2296 GndA.n140 GndA.n137 27.1064
R2297 GndA.n703 GndA.n700 27.1064
R2298 GndA.n1166 GndA.n1165 27.1064
R2299 GndA.n94 GndA.n91 27.1064
R2300 GndA.n750 GndA.n749 26.7727
R2301 GndA.n746 GndA.n122 26.7721
R2302 GndA.n28 GndA.n26 26.7721
R2303 GndA.n1403 GndA.n31 26.7721
R2304 GndA.n481 GndA.t44 26.2958
R2305 GndA.n662 GndA.t42 26.2958
R2306 GndA.n927 GndA.n801 26.2698
R2307 GndA.n281 GndA.n145 26.2698
R2308 GndA.n816 GndA 25.9611
R2309 GndA.n1164 GndA.n1163 25.9611
R2310 GndA.n809 GndA.n806 25.79
R2311 GndA.n141 GndA.n138 25.79
R2312 GndA.n704 GndA.n701 25.79
R2313 GndA.n95 GndA.n92 25.79
R2314 GndA.n818 GndA.n817 25.7847
R2315 GndA.n1168 GndA.n1161 25.7847
R2316 GndA.n811 GndA.n810 25.7818
R2317 GndA.n824 GndA.n823 25.7818
R2318 GndA.n711 GndA.n710 25.7818
R2319 GndA.n143 GndA.n142 25.7818
R2320 GndA.n727 GndA.n726 25.7818
R2321 GndA.n706 GndA.n705 25.7818
R2322 GndA.n1173 GndA.n1172 25.7818
R2323 GndA.n97 GndA.n96 25.7818
R2324 GndA.n913 GndA.n838 23.9849
R2325 GndA.n1235 GndA.n87 23.9763
R2326 GndA.t54 GndA.n741 22.7235
R2327 GndA.n615 GndA.t56 22.7235
R2328 GndA.t29 GndA.n1398 22.7235
R2329 GndA.t48 GndA.n1067 22.7235
R2330 GndA.n513 GndA.n507 22.2548
R2331 GndA.n682 GndA.n149 22.2548
R2332 GndA.n918 GndA.n835 21.8525
R2333 GndA.n1188 GndA.t2 21.3125
R2334 GndA.n868 GndA.t0 21.3125
R2335 GndA.n399 GndA.n396 21.0829
R2336 GndA.n403 GndA.n402 21.0829
R2337 GndA.n406 GndA.n394 21.0829
R2338 GndA.n407 GndA.n393 21.0829
R2339 GndA.n413 GndA.n412 21.0829
R2340 GndA.n958 GndA.n949 21.0829
R2341 GndA.n963 GndA.n962 21.0829
R2342 GndA.n944 GndA.n793 21.0829
R2343 GndA.n945 GndA.n943 21.0829
R2344 GndA.n895 GndA.n795 21.0829
R2345 GndA.n1276 GndA.n1275 21.0829
R2346 GndA.n1281 GndA.n1280 21.0829
R2347 GndA.n1263 GndA.n72 21.0829
R2348 GndA.n1264 GndA.n1262 21.0829
R2349 GndA.n1253 GndA.n74 21.0829
R2350 GndA.n559 GndA.n277 21.0829
R2351 GndA.n570 GndA.n569 21.0829
R2352 GndA.n573 GndA.n276 21.0829
R2353 GndA.n574 GndA.n273 21.0829
R2354 GndA.n582 GndA.n271 21.0829
R2355 GndA.n694 GndA.n150 21.082
R2356 GndA.n690 GndA.n689 21.082
R2357 GndA.n518 GndA.n290 21.082
R2358 GndA.n519 GndA.n500 21.082
R2359 GndA.n1181 GndA.n84 21.082
R2360 GndA.n1248 GndA.n1247 21.082
R2361 GndA.n920 GndA.n836 21.082
R2362 GndA.n917 GndA.n834 21.082
R2363 GndA.n391 GndA.n389 20.7064
R2364 GndA.n415 GndA.n387 20.7064
R2365 GndA.n955 GndA.n954 20.7064
R2366 GndA.n959 GndA.n794 20.7064
R2367 GndA.n1274 GndA.n1272 20.7064
R2368 GndA.n1277 GndA.n73 20.7064
R2369 GndA.n579 GndA.n578 20.7064
R2370 GndA.n583 GndA.n269 20.7064
R2371 GndA.n458 GndA.n322 16.9207
R2372 GndA.n461 GndA.n323 16.9207
R2373 GndA.n1033 GndA.n758 16.9207
R2374 GndA.n1036 GndA.n760 16.9207
R2375 GndA.n1355 GndA.n1354 16.9207
R2376 GndA.n1358 GndA.n48 16.9207
R2377 GndA.n651 GndA.n205 16.9207
R2378 GndA.n602 GndA.n204 16.9207
R2379 GndA.t35 GndA.t22 16.5263
R2380 GndA.t32 GndA.t27 16.5263
R2381 GndA.t33 GndA.t40 16.5263
R2382 GndA.t34 GndA.t19 16.5263
R2383 GndA.n452 GndA.n321 15.7122
R2384 GndA.n455 GndA.n314 15.7122
R2385 GndA.n1039 GndA.n757 15.7122
R2386 GndA.n1042 GndA.n761 15.7122
R2387 GndA.n1361 GndA.n46 15.7122
R2388 GndA.n1364 GndA.n49 15.7122
R2389 GndA.n643 GndA.n203 15.7122
R2390 GndA.n646 GndA.n193 15.7122
R2391 GndA.n446 GndA.n320 14.5036
R2392 GndA.n449 GndA.n315 14.5036
R2393 GndA.n1045 GndA.n756 14.5036
R2394 GndA.n1048 GndA.n762 14.5036
R2395 GndA.n1367 GndA.n45 14.5036
R2396 GndA.n1370 GndA.n50 14.5036
R2397 GndA.n637 GndA.n202 14.5036
R2398 GndA.n640 GndA.n194 14.5036
R2399 GndA.n374 GndA.n334 14.3064
R2400 GndA.n1017 GndA.n979 14.3064
R2401 GndA.n1337 GndA.n1298 14.3064
R2402 GndA.n256 GndA.n216 14.3064
R2403 GndA.n1132 GndA.n1131 13.3171
R2404 GndA.n1130 GndA.n1129 13.3171
R2405 GndA.n441 GndA.n319 13.295
R2406 GndA.n432 GndA.n316 13.295
R2407 GndA.n778 GndA.n755 13.295
R2408 GndA.n776 GndA.n763 13.295
R2409 GndA.n1373 GndA.n44 13.295
R2410 GndA.n1376 GndA.n51 13.295
R2411 GndA.n632 GndA.n201 13.295
R2412 GndA.n605 GndA.n195 13.295
R2413 GndA.n1090 GndA.n1089 12.8637
R2414 GndA.n1088 GndA.n1087 12.8637
R2415 GndA.n469 GndA.n468 12.0864
R2416 GndA.n318 GndA.n312 12.0864
R2417 GndA.n438 GndA.n317 12.0864
R2418 GndA.n775 GndA.n754 12.0864
R2419 GndA.n774 GndA.n764 12.0864
R2420 GndA.n770 GndA.n753 12.0864
R2421 GndA.n1379 GndA.n43 12.0864
R2422 GndA.n1382 GndA.n52 12.0864
R2423 GndA.n56 GndA.n42 12.0864
R2424 GndA.n623 GndA.n197 12.0864
R2425 GndA.n626 GndA.n200 12.0864
R2426 GndA.n629 GndA.n196 12.0864
R2427 GndA.n933 GndA.n801 12.0476
R2428 GndA.n553 GndA.n281 12.0476
R2429 GndA.n937 GndA.n801 11.6711
R2430 GndA.n548 GndA.n281 11.6711
R2431 GndA.n464 GndA.n463 10.798
R2432 GndA.n1034 GndA.n779 10.798
R2433 GndA.n1353 GndA.n1352 10.798
R2434 GndA.n603 GndA.n601 10.798
R2435 GndA.n445 GndA.n444 9.49615
R2436 GndA.n1052 GndA.n1051 9.49615
R2437 GndA.n954 GndA.n948 9.49615
R2438 GndA.n946 GndA.n795 9.49615
R2439 GndA.n1372 GndA.n59 9.49615
R2440 GndA.n636 GndA.n635 9.49615
R2441 GndA.n571 GndA.n277 9.49615
R2442 GndA.n581 GndA.n269 9.49615
R2443 GndA.n1272 GndA.n1267 9.49615
R2444 GndA.n1265 GndA.n74 9.49615
R2445 GndA.n404 GndA.n396 9.49615
R2446 GndA.n415 GndA.n414 9.49615
R2447 GndA.n444 GndA.n443 9.3005
R2448 GndA.n440 GndA.n434 9.3005
R2449 GndA.n437 GndA.n436 9.3005
R2450 GndA.n313 GndA.n131 9.3005
R2451 GndA.n414 GndA.n413 9.3005
R2452 GndA.n389 GndA.n388 9.3005
R2453 GndA.n395 GndA.n393 9.3005
R2454 GndA.n406 GndA.n405 9.3005
R2455 GndA.n404 GndA.n403 9.3005
R2456 GndA.n132 GndA.n128 9.3005
R2457 GndA.n475 GndA.n474 9.3005
R2458 GndA.n477 GndA.n476 9.3005
R2459 GndA.n310 GndA.n309 9.3005
R2460 GndA.n484 GndA.n483 9.3005
R2461 GndA.n485 GndA.n308 9.3005
R2462 GndA.n487 GndA.n486 9.3005
R2463 GndA.n304 GndA.n303 9.3005
R2464 GndA.n494 GndA.n493 9.3005
R2465 GndA.n495 GndA.n301 9.3005
R2466 GndA.n530 GndA.n529 9.3005
R2467 GndA.n528 GndA.n302 9.3005
R2468 GndA.n527 GndA.n526 9.3005
R2469 GndA.n525 GndA.n496 9.3005
R2470 GndA.n524 GndA.n523 9.3005
R2471 GndA.n94 GndA.n93 9.3005
R2472 GndA.n91 GndA.n90 9.3005
R2473 GndA.n934 GndA.n933 9.3005
R2474 GndA.n937 GndA.n936 9.3005
R2475 GndA.n805 GndA.n804 9.3005
R2476 GndA.n808 GndA.n807 9.3005
R2477 GndA.n1060 GndA.n1059 9.3005
R2478 GndA.n1058 GndA.n1057 9.3005
R2479 GndA.n1055 GndA.n773 9.3005
R2480 GndA.n1053 GndA.n1052 9.3005
R2481 GndA.n861 GndA.n766 9.3005
R2482 GndA.n862 GndA.n859 9.3005
R2483 GndA.n864 GndA.n863 9.3005
R2484 GndA.n852 GndA.n851 9.3005
R2485 GndA.n871 GndA.n870 9.3005
R2486 GndA.n872 GndA.n850 9.3005
R2487 GndA.n874 GndA.n873 9.3005
R2488 GndA.n877 GndA.n849 9.3005
R2489 GndA.n881 GndA.n880 9.3005
R2490 GndA.n882 GndA.n848 9.3005
R2491 GndA.n884 GndA.n883 9.3005
R2492 GndA.n887 GndA.n847 9.3005
R2493 GndA.n890 GndA.n889 9.3005
R2494 GndA.n891 GndA.n846 9.3005
R2495 GndA.n910 GndA.n892 9.3005
R2496 GndA.n949 GndA.n948 9.3005
R2497 GndA.n960 GndA.n959 9.3005
R2498 GndA.n962 GndA.n961 9.3005
R2499 GndA.n947 GndA.n793 9.3005
R2500 GndA.n946 GndA.n945 9.3005
R2501 GndA.n821 GndA.n820 9.3005
R2502 GndA.n813 GndA.n812 9.3005
R2503 GndA.n815 GndA.n814 9.3005
R2504 GndA.n1275 GndA.n1267 9.3005
R2505 GndA.n1278 GndA.n1277 9.3005
R2506 GndA.n1280 GndA.n1279 9.3005
R2507 GndA.n1266 GndA.n72 9.3005
R2508 GndA.n1265 GndA.n1264 9.3005
R2509 GndA.n1199 GndA.n1194 9.3005
R2510 GndA.n1201 GndA.n1200 9.3005
R2511 GndA.n1204 GndA.n1193 9.3005
R2512 GndA.n1208 GndA.n1207 9.3005
R2513 GndA.n1209 GndA.n1192 9.3005
R2514 GndA.n1211 GndA.n1210 9.3005
R2515 GndA.n1214 GndA.n1191 9.3005
R2516 GndA.n1217 GndA.n1216 9.3005
R2517 GndA.n1218 GndA.n1190 9.3005
R2518 GndA.n1232 GndA.n1219 9.3005
R2519 GndA.n1231 GndA.n1220 9.3005
R2520 GndA.n1230 GndA.n1221 9.3005
R2521 GndA.n1224 GndA.n1223 9.3005
R2522 GndA.n1222 GndA.n37 9.3005
R2523 GndA.n1392 GndA.n38 9.3005
R2524 GndA.n1375 GndA.n59 9.3005
R2525 GndA.n1378 GndA.n58 9.3005
R2526 GndA.n1381 GndA.n55 9.3005
R2527 GndA.n1385 GndA.n1384 9.3005
R2528 GndA.n625 GndA.n609 9.3005
R2529 GndA.n628 GndA.n608 9.3005
R2530 GndA.n631 GndA.n607 9.3005
R2531 GndA.n635 GndA.n634 9.3005
R2532 GndA.n571 GndA.n570 9.3005
R2533 GndA.n573 GndA.n572 9.3005
R2534 GndA.n273 GndA.n272 9.3005
R2535 GndA.n580 GndA.n579 9.3005
R2536 GndA.n582 GndA.n581 9.3005
R2537 GndA.n610 GndA.n187 9.3005
R2538 GndA.n657 GndA.n186 9.3005
R2539 GndA.n658 GndA.n185 9.3005
R2540 GndA.n659 GndA.n184 9.3005
R2541 GndA.n183 GndA.n178 9.3005
R2542 GndA.n666 GndA.n177 9.3005
R2543 GndA.n667 GndA.n176 9.3005
R2544 GndA.n668 GndA.n175 9.3005
R2545 GndA.n174 GndA.n169 9.3005
R2546 GndA.n674 GndA.n168 9.3005
R2547 GndA.n675 GndA.n167 9.3005
R2548 GndA.n676 GndA.n166 9.3005
R2549 GndA.n165 GndA.n164 9.3005
R2550 GndA.n161 GndA.n160 9.3005
R2551 GndA.n685 GndA.n684 9.3005
R2552 GndA.n713 GndA.n712 9.3005
R2553 GndA.n703 GndA.n702 9.3005
R2554 GndA.n700 GndA.n699 9.3005
R2555 GndA.n549 GndA.n548 9.3005
R2556 GndA.n553 GndA.n552 9.3005
R2557 GndA.n137 GndA.n136 9.3005
R2558 GndA.n140 GndA.n139 9.3005
R2559 GndA.n724 GndA.n723 9.3005
R2560 GndA.n1167 GndA.n1166 9.3005
R2561 GndA.n1165 GndA.n1162 9.3005
R2562 GndA.n1175 GndA.n1174 9.3005
R2563 GndA.n810 GndA.n805 9.2683
R2564 GndA.n809 GndA.n808 9.2683
R2565 GndA.n824 GndA.n821 9.2683
R2566 GndA.n817 GndA.n813 9.2683
R2567 GndA.n816 GndA.n815 9.2683
R2568 GndA.n712 GndA.n711 9.2683
R2569 GndA.n142 GndA.n137 9.2683
R2570 GndA.n141 GndA.n140 9.2683
R2571 GndA.n727 GndA.n724 9.2683
R2572 GndA.n704 GndA.n703 9.2683
R2573 GndA.n705 GndA.n700 9.2683
R2574 GndA.n1165 GndA.n1164 9.2683
R2575 GndA.n1166 GndA.n1161 9.2683
R2576 GndA.n1174 GndA.n1173 9.2683
R2577 GndA.n95 GndA.n94 9.2683
R2578 GndA.n96 GndA.n91 9.2683
R2579 GndA.n403 GndA.n394 6.4005
R2580 GndA.n393 GndA.n391 6.4005
R2581 GndA.n412 GndA.n389 6.4005
R2582 GndA.n413 GndA.n387 6.4005
R2583 GndA.n416 GndA.n415 6.4005
R2584 GndA.n954 GndA.n953 6.4005
R2585 GndA.n955 GndA.n949 6.4005
R2586 GndA.n959 GndA.n958 6.4005
R2587 GndA.n962 GndA.n794 6.4005
R2588 GndA.n945 GndA.n944 6.4005
R2589 GndA.n1272 GndA.n1271 6.4005
R2590 GndA.n1275 GndA.n1274 6.4005
R2591 GndA.n1277 GndA.n1276 6.4005
R2592 GndA.n1280 GndA.n73 6.4005
R2593 GndA.n1264 GndA.n1263 6.4005
R2594 GndA.n570 GndA.n276 6.4005
R2595 GndA.n578 GndA.n273 6.4005
R2596 GndA.n579 GndA.n271 6.4005
R2597 GndA.n583 GndA.n582 6.4005
R2598 GndA.n586 GndA.n269 6.4005
R2599 GndA.n471 GndA.n470 6.10227
R2600 GndA.n767 GndA.n765 6.10227
R2601 GndA.n402 GndA.n396 6.02403
R2602 GndA.n407 GndA.n406 6.02403
R2603 GndA.n963 GndA.n793 6.02403
R2604 GndA.n943 GndA.n795 6.02403
R2605 GndA.n1281 GndA.n72 6.02403
R2606 GndA.n1262 GndA.n74 6.02403
R2607 GndA.n569 GndA.n277 6.02403
R2608 GndA.n574 GndA.n573 6.02403
R2609 GndA.n522 GndA.n288 5.60299
R2610 GndA.n908 GndA.n907 5.60299
R2611 GndA.n1198 GndA.n80 5.60299
R2612 GndA.n687 GndA.n686 5.60299
R2613 GndA.n522 GndA.n521 5.49424
R2614 GndA.n909 GndA.n908 5.49424
R2615 GndA.n1198 GndA.n1197 5.49424
R2616 GndA.n686 GndA.n159 5.49424
R2617 GndA.n826 GndA.n825 5.44963
R2618 GndA.n714 GndA.n708 5.44963
R2619 GndA.n729 GndA.n728 5.44963
R2620 GndA.n1176 GndA.n1170 5.44963
R2621 GndA.n53 GndA.n40 5.23059
R2622 GndA.n622 GndA.n621 5.23059
R2623 GndA.n435 GndA.n313 4.86921
R2624 GndA.n439 GndA.n437 4.86921
R2625 GndA.n442 GndA.n440 4.86921
R2626 GndA.n1055 GndA.n1054 4.86921
R2627 GndA.n1057 GndA.n1056 4.86921
R2628 GndA.n1060 GndA.n771 4.86921
R2629 GndA.n1378 GndA.n1377 4.86921
R2630 GndA.n1381 GndA.n1380 4.86921
R2631 GndA.n1384 GndA.n1383 4.86921
R2632 GndA.n627 GndA.n625 4.86921
R2633 GndA.n630 GndA.n628 4.86921
R2634 GndA.n633 GndA.n631 4.86921
R2635 GndA.n443 GndA.n433 4.79068
R2636 GndA.n447 GndA.n445 4.79068
R2637 GndA.n1051 GndA.n1050 4.79068
R2638 GndA.n1053 GndA.n777 4.79068
R2639 GndA.n1372 GndA.n1371 4.79068
R2640 GndA.n1375 GndA.n1374 4.79068
R2641 GndA.n634 GndA.n606 4.79068
R2642 GndA.n638 GndA.n636 4.79068
R2643 GndA.n450 GndA.n448 4.71216
R2644 GndA.n453 GndA.n451 4.71216
R2645 GndA.n1046 GndA.n1044 4.71216
R2646 GndA.n1049 GndA.n1047 4.71216
R2647 GndA.n1366 GndA.n1365 4.71216
R2648 GndA.n1369 GndA.n1368 4.71216
R2649 GndA.n641 GndA.n639 4.71216
R2650 GndA.n644 GndA.n642 4.71216
R2651 GndA.n456 GndA.n454 4.63363
R2652 GndA.n459 GndA.n457 4.63363
R2653 GndA.n1040 GndA.n1038 4.63363
R2654 GndA.n1043 GndA.n1041 4.63363
R2655 GndA.n1360 GndA.n1359 4.63363
R2656 GndA.n1363 GndA.n1362 4.63363
R2657 GndA.n647 GndA.n645 4.63363
R2658 GndA.n649 GndA.n648 4.63363
R2659 GndA.n935 GndA.n801 4.6026
R2660 GndA.n550 GndA.n281 4.6026
R2661 GndA.n462 GndA.n460 4.5551
R2662 GndA.n1037 GndA.n1035 4.5551
R2663 GndA.n1357 GndA.n1356 4.5551
R2664 GndA.n650 GndA.n604 4.5551
R2665 GndA.n739 GndA.n738 4.38907
R2666 GndA.n739 GndA.n127 4.38907
R2667 GndA.n1064 GndA.n118 4.38907
R2668 GndA.n1070 GndA.n118 4.38907
R2669 GndA.n1396 GndA.n1395 4.38907
R2670 GndA.n1396 GndA.n1394 4.38907
R2671 GndA.n618 GndA.n25 4.38907
R2672 GndA.n619 GndA.n618 4.38907
R2673 GndA.n1241 GndA.n1240 4.36827
R2674 GndA.n922 GndA.n830 4.36827
R2675 GndA.n511 GndA.n510 4.36827
R2676 GndA.n692 GndA.n146 4.36827
R2677 GndA.n1387 GndA.n36 3.9624
R2678 GndA.n614 GndA.n613 3.9624
R2679 GndA.n736 GndA.n735 3.90145
R2680 GndA.n1062 GndA.n769 3.90145
R2681 GndA.n1091 GndA.n1084 3.44112
R2682 GndA.n1086 GndA.n2 3.44112
R2683 GndA.n1133 GndA.n1125 3.44112
R2684 GndA.n1145 GndA.n105 3.44112
R2685 GndA.n113 GndA.n108 3.42261
R2686 GndA.n1435 GndA.n15 3.42261
R2687 GndA.n1427 GndA.n1426 3.42261
R2688 GndA.n1116 GndA.n1111 3.42261
R2689 GndA.n1084 GndA.n1082 3.4126
R2690 GndA.n1452 GndA.n2 3.4126
R2691 GndA.n1140 GndA.n1125 3.4126
R2692 GndA.n1145 GndA.n1144 3.4126
R2693 GndA.n1108 GndA.n108 3.4112
R2694 GndA.n1435 GndA.n1434 3.4112
R2695 GndA.n1428 GndA.n1427 3.4112
R2696 GndA.n1122 GndA.n1111 3.4112
R2697 GndA.n1095 GndA.n1094 3.4105
R2698 GndA.n1097 GndA.n1096 3.4105
R2699 GndA.n1079 GndA.n1075 3.4105
R2700 GndA.n111 GndA.n109 3.4105
R2701 GndA.n1107 GndA.n1106 3.4105
R2702 GndA.n1093 GndA.n1092 3.4105
R2703 GndA.n1085 GndA.n1083 3.4105
R2704 GndA.n1077 GndA.n1076 3.4105
R2705 GndA.n1099 GndA.n1098 3.4105
R2706 GndA.n1101 GndA.n1100 3.4105
R2707 GndA.n1103 GndA.n1102 3.4105
R2708 GndA.n1105 GndA.n1104 3.4105
R2709 GndA.n114 GndA.n110 3.4105
R2710 GndA.n1437 GndA.n1436 3.4105
R2711 GndA.n1439 GndA.n1438 3.4105
R2712 GndA.n13 GndA.n11 3.4105
R2713 GndA.n9 GndA.n7 3.4105
R2714 GndA.n1446 GndA.n1445 3.4105
R2715 GndA.n1447 GndA.n5 3.4105
R2716 GndA.n1449 GndA.n1448 3.4105
R2717 GndA.n6 GndA.n4 3.4105
R2718 GndA.n12 GndA.n10 3.4105
R2719 GndA.n1441 GndA.n1440 3.4105
R2720 GndA.n1444 GndA.n1443 3.4105
R2721 GndA.n8 GndA.n3 3.4105
R2722 GndA.n1451 GndA.n1450 3.4105
R2723 GndA.n1147 GndA.n1146 3.4105
R2724 GndA.n1148 GndA.n104 3.4105
R2725 GndA.n1150 GndA.n1149 3.4105
R2726 GndA.n101 GndA.n99 3.4105
R2727 GndA.n1156 GndA.n1155 3.4105
R2728 GndA.n100 GndA.n98 3.4105
R2729 GndA.n1119 GndA.n1118 3.4105
R2730 GndA.n1117 GndA.n1113 3.4105
R2731 GndA.n1424 GndA.n18 3.4105
R2732 GndA.n1423 GndA.n1422 3.4105
R2733 GndA.n20 GndA.n19 3.4105
R2734 GndA.n1415 GndA.n1414 3.4105
R2735 GndA.n23 GndA.n22 3.4105
R2736 GndA.n1135 GndA.n1128 3.4105
R2737 GndA.n1137 GndA.n1136 3.4105
R2738 GndA.n1134 GndA.n1126 3.4105
R2739 GndA.n1421 GndA.n17 3.4105
R2740 GndA.n1420 GndA.n1419 3.4105
R2741 GndA.n1417 GndA.n1416 3.4105
R2742 GndA.n1127 GndA.n21 3.4105
R2743 GndA.n1139 GndA.n1138 3.4105
R2744 GndA.n106 GndA.n103 3.4105
R2745 GndA.n1152 GndA.n1151 3.4105
R2746 GndA.n1154 GndA.n1153 3.4105
R2747 GndA.n1114 GndA.n1112 3.4105
R2748 GndA.n1121 GndA.n1120 3.4105
R2749 GndA.n736 GndA.n129 3.06308
R2750 GndA.n1062 GndA.n1061 3.06308
R2751 GndA.n57 GndA.n36 3.06308
R2752 GndA.n624 GndA.n614 3.06308
R2753 GndA.n735 GndA.n734 3.01552
R2754 GndA.n772 GndA.n769 3.01552
R2755 GndA.n613 GndA.n612 3.01552
R2756 GndA.n1387 GndA.n1386 3.01552
R2757 GndA.n738 GndA.n737 2.31669
R2758 GndA.n1064 GndA.n1063 2.31669
R2759 GndA.n1394 GndA.n1393 2.31669
R2760 GndA.n619 GndA.n617 2.31669
R2761 GndA.n127 GndA.n123 2.19479
R2762 GndA.n745 GndA.n123 2.19479
R2763 GndA.n1071 GndA.n1070 2.19479
R2764 GndA.n1071 GndA.n117 2.19479
R2765 GndA.n1402 GndA.n32 2.19479
R2766 GndA.n1395 GndA.n32 2.19479
R2767 GndA.n1410 GndA.n1409 2.19479
R2768 GndA.n1410 GndA.n25 2.19479
R2769 GndA.n1241 GndA.n1180 2.18439
R2770 GndA.n1180 GndA.n86 2.18439
R2771 GndA.n923 GndA.n922 2.18439
R2772 GndA.n923 GndA.n829 2.18439
R2773 GndA.n516 GndA.n144 2.18439
R2774 GndA.n510 GndA.n144 2.18439
R2775 GndA.n698 GndA.n697 2.18439
R2776 GndA.n698 GndA.n146 2.18439
R2777 GndA.n908 GndA.n892 2.11869
R2778 GndA.n1199 GndA.n1198 2.11869
R2779 GndA.n686 GndA.n685 2.11869
R2780 GndA.n523 GndA.n522 2.11869
R2781 GndA.n1180 GndA.n1179 1.17454
R2782 GndA.n924 GndA.n923 1.17454
R2783 GndA.n721 GndA.n144 1.17454
R2784 GndA.n717 GndA.n698 1.17454
R2785 GndA.n460 GndA.n459 1.09989
R2786 GndA.n463 GndA.n462 1.09989
R2787 GndA.n1035 GndA.n1034 1.09989
R2788 GndA.n1038 GndA.n1037 1.09989
R2789 GndA.n1356 GndA.n1353 1.09989
R2790 GndA.n1359 GndA.n1357 1.09989
R2791 GndA.n650 GndA.n649 1.09989
R2792 GndA.n604 GndA.n603 1.09989
R2793 GndA.n454 GndA.n453 1.02136
R2794 GndA.n457 GndA.n456 1.02136
R2795 GndA.n1041 GndA.n1040 1.02136
R2796 GndA.n1044 GndA.n1043 1.02136
R2797 GndA.n1362 GndA.n1360 1.02136
R2798 GndA.n1365 GndA.n1363 1.02136
R2799 GndA.n645 GndA.n644 1.02136
R2800 GndA.n648 GndA.n647 1.02136
R2801 GndA.n819 GndA.n116 1.01394
R2802 GndA.n707 GndA.n24 1.01394
R2803 GndA.n732 GndA.n731 1.01394
R2804 GndA.n1169 GndA.n1160 1.01394
R2805 GndA.n1090 GndA.n1087 0.990802
R2806 GndA.n1132 GndA.n1129 0.990802
R2807 GndA.n448 GndA.n447 0.942831
R2808 GndA.n451 GndA.n450 0.942831
R2809 GndA.n1047 GndA.n1046 0.942831
R2810 GndA.n1050 GndA.n1049 0.942831
R2811 GndA.n1368 GndA.n1366 0.942831
R2812 GndA.n1371 GndA.n1369 0.942831
R2813 GndA.n639 GndA.n638 0.942831
R2814 GndA.n642 GndA.n641 0.942831
R2815 GndA.n828 GndA.n827 0.919889
R2816 GndA.n716 GndA.n715 0.919889
R2817 GndA.n730 GndA.n722 0.919889
R2818 GndA.n1178 GndA.n1177 0.919889
R2819 GndA.n1087 GndA.n1086 0.88078
R2820 GndA.n1133 GndA.n1132 0.88078
R2821 GndA.n1091 GndA.n1090 0.879703
R2822 GndA.n1129 GndA.n105 0.879703
R2823 GndA.n443 GndA.n442 0.864304
R2824 GndA.n445 GndA.n433 0.864304
R2825 GndA.n1051 GndA.n777 0.864304
R2826 GndA.n1054 GndA.n1053 0.864304
R2827 GndA.n1374 GndA.n1372 0.864304
R2828 GndA.n1377 GndA.n1375 0.864304
R2829 GndA.n634 GndA.n633 0.864304
R2830 GndA.n636 GndA.n606 0.864304
R2831 GndA.n313 GndA.n129 0.785776
R2832 GndA.n437 GndA.n435 0.785776
R2833 GndA.n440 GndA.n439 0.785776
R2834 GndA.n1056 GndA.n1055 0.785776
R2835 GndA.n1057 GndA.n771 0.785776
R2836 GndA.n1061 GndA.n1060 0.785776
R2837 GndA.n1380 GndA.n1378 0.785776
R2838 GndA.n1383 GndA.n1381 0.785776
R2839 GndA.n1384 GndA.n57 0.785776
R2840 GndA.n625 GndA.n624 0.785776
R2841 GndA.n628 GndA.n627 0.785776
R2842 GndA.n631 GndA.n630 0.785776
R2843 GndA.n819 GndA.n818 0.7505
R2844 GndA.n1169 GndA.n1168 0.7505
R2845 GndA.n827 GndA.n826 0.563
R2846 GndA.n715 GndA.n714 0.563
R2847 GndA.n730 GndA.n729 0.563
R2848 GndA.n1177 GndA.n1176 0.563
R2849 GndA.n135 GndA.n123 0.517167
R2850 GndA.n1072 GndA.n1071 0.517167
R2851 GndA.n1159 GndA.n32 0.517167
R2852 GndA.n1411 GndA.n1410 0.517167
R2853 GndA.n737 GndA.n736 0.427167
R2854 GndA.n1063 GndA.n1062 0.427167
R2855 GndA.n1386 GndA.n54 0.392519
R2856 GndA.n15 GndA.n14 0.392504
R2857 GndA.n1426 GndA.n1425 0.392504
R2858 GndA.n734 GndA.n733 0.392167
R2859 GndA.n860 GndA.n772 0.392167
R2860 GndA.n612 GndA.n611 0.392167
R2861 GndA.n734 GndA.n131 0.390682
R2862 GndA.n1059 GndA.n772 0.390682
R2863 GndA.n612 GndA.n609 0.390682
R2864 GndA.n1386 GndA.n1385 0.39033
R2865 GndA.n1434 GndA.n1433 0.3805
R2866 GndA.n1442 GndA.n1 0.3805
R2867 GndA.n1453 GndA.n1452 0.3805
R2868 GndA.n1082 GndA.n1081 0.3805
R2869 GndA.n1078 GndA.n107 0.3805
R2870 GndA.n1109 GndA.n1108 0.3805
R2871 GndA.n1429 GndA.n1428 0.3805
R2872 GndA.n1418 GndA.n16 0.3805
R2873 GndA.n1141 GndA.n1140 0.3805
R2874 GndA.n1144 GndA.n1143 0.3805
R2875 GndA.n1124 GndA.n102 0.3805
R2876 GndA.n1123 GndA.n1122 0.3805
R2877 GndA.n827 GndA.n819 0.373547
R2878 GndA.n715 GndA.n707 0.373547
R2879 GndA.n731 GndA.n730 0.373547
R2880 GndA.n1177 GndA.n1169 0.373547
R2881 GndA.n1393 GndA.n36 0.366214
R2882 GndA.n617 GndA.n614 0.366214
R2883 GndA.n113 GndA.n112 0.33647
R2884 GndA.n1116 GndA.n1115 0.33647
R2885 GndA.n1074 GndA.n1073 0.321929
R2886 GndA.n134 GndA.n133 0.321929
R2887 GndA.n1158 GndA.n1157 0.321929
R2888 GndA.n1413 GndA.n1412 0.321929
R2889 GndA.n935 GndA.n934 0.29346
R2890 GndA.n936 GndA.n935 0.29346
R2891 GndA.n552 GndA.n550 0.29346
R2892 GndA.n550 GndA.n549 0.29346
R2893 GndA.n1131 GndA.n1130 0.268357
R2894 GndA.n1089 GndA.n1088 0.268357
R2895 GndA.n1179 GndA.n89 0.214916
R2896 GndA.n925 GndA.n924 0.214916
R2897 GndA.n718 GndA.n717 0.214916
R2898 GndA.n721 GndA.n720 0.214916
R2899 GndA.n444 GndA.n434 0.19887
R2900 GndA.n1052 GndA.n773 0.19887
R2901 GndA.n960 GndA.n948 0.19887
R2902 GndA.n947 GndA.n946 0.19887
R2903 GndA.n59 GndA.n58 0.19887
R2904 GndA.n635 GndA.n607 0.19887
R2905 GndA.n572 GndA.n571 0.19887
R2906 GndA.n581 GndA.n580 0.19887
R2907 GndA.n1278 GndA.n1267 0.19887
R2908 GndA.n1266 GndA.n1265 0.19887
R2909 GndA.n405 GndA.n404 0.19887
R2910 GndA.n414 GndA.n388 0.19887
R2911 GndA.n436 GndA.n131 0.196152
R2912 GndA.n436 GndA.n434 0.196152
R2913 GndA.n1058 GndA.n773 0.196152
R2914 GndA.n1059 GndA.n1058 0.196152
R2915 GndA.n961 GndA.n960 0.196152
R2916 GndA.n961 GndA.n947 0.196152
R2917 GndA.n892 GndA.n891 0.196152
R2918 GndA.n891 GndA.n890 0.196152
R2919 GndA.n890 GndA.n847 0.196152
R2920 GndA.n883 GndA.n847 0.196152
R2921 GndA.n883 GndA.n882 0.196152
R2922 GndA.n882 GndA.n881 0.196152
R2923 GndA.n881 GndA.n849 0.196152
R2924 GndA.n873 GndA.n849 0.196152
R2925 GndA.n873 GndA.n872 0.196152
R2926 GndA.n872 GndA.n871 0.196152
R2927 GndA.n871 GndA.n851 0.196152
R2928 GndA.n863 GndA.n851 0.196152
R2929 GndA.n863 GndA.n862 0.196152
R2930 GndA.n862 GndA.n861 0.196152
R2931 GndA.n58 GndA.n55 0.196152
R2932 GndA.n1385 GndA.n55 0.196152
R2933 GndA.n1222 GndA.n38 0.196152
R2934 GndA.n1223 GndA.n1222 0.196152
R2935 GndA.n1223 GndA.n1221 0.196152
R2936 GndA.n1221 GndA.n1220 0.196152
R2937 GndA.n1220 GndA.n1219 0.196152
R2938 GndA.n1219 GndA.n1218 0.196152
R2939 GndA.n1218 GndA.n1217 0.196152
R2940 GndA.n1217 GndA.n1191 0.196152
R2941 GndA.n1210 GndA.n1191 0.196152
R2942 GndA.n1210 GndA.n1209 0.196152
R2943 GndA.n1209 GndA.n1208 0.196152
R2944 GndA.n1208 GndA.n1193 0.196152
R2945 GndA.n1200 GndA.n1193 0.196152
R2946 GndA.n1200 GndA.n1199 0.196152
R2947 GndA.n609 GndA.n608 0.196152
R2948 GndA.n608 GndA.n607 0.196152
R2949 GndA.n610 GndA.n186 0.196152
R2950 GndA.n186 GndA.n185 0.196152
R2951 GndA.n185 GndA.n184 0.196152
R2952 GndA.n184 GndA.n183 0.196152
R2953 GndA.n183 GndA.n177 0.196152
R2954 GndA.n177 GndA.n176 0.196152
R2955 GndA.n176 GndA.n175 0.196152
R2956 GndA.n175 GndA.n174 0.196152
R2957 GndA.n174 GndA.n168 0.196152
R2958 GndA.n168 GndA.n167 0.196152
R2959 GndA.n167 GndA.n166 0.196152
R2960 GndA.n166 GndA.n165 0.196152
R2961 GndA.n165 GndA.n160 0.196152
R2962 GndA.n685 GndA.n160 0.196152
R2963 GndA.n572 GndA.n272 0.196152
R2964 GndA.n580 GndA.n272 0.196152
R2965 GndA.n1279 GndA.n1278 0.196152
R2966 GndA.n1279 GndA.n1266 0.196152
R2967 GndA.n523 GndA.n496 0.196152
R2968 GndA.n527 GndA.n496 0.196152
R2969 GndA.n528 GndA.n527 0.196152
R2970 GndA.n529 GndA.n528 0.196152
R2971 GndA.n529 GndA.n495 0.196152
R2972 GndA.n495 GndA.n494 0.196152
R2973 GndA.n494 GndA.n303 0.196152
R2974 GndA.n486 GndA.n303 0.196152
R2975 GndA.n486 GndA.n485 0.196152
R2976 GndA.n485 GndA.n484 0.196152
R2977 GndA.n484 GndA.n309 0.196152
R2978 GndA.n476 GndA.n309 0.196152
R2979 GndA.n476 GndA.n475 0.196152
R2980 GndA.n475 GndA.n132 0.196152
R2981 GndA.n405 GndA.n395 0.196152
R2982 GndA.n395 GndA.n388 0.196152
R2983 GndA.n733 GndA.n732 0.16137
R2984 GndA.n860 GndA.n116 0.16137
R2985 GndA.n1160 GndA.n54 0.16137
R2986 GndA.n611 GndA.n24 0.16137
R2987 GndA.n814 GndA.n812 0.14915
R2988 GndA.n1167 GndA.n1162 0.14915
R2989 GndA.n1178 GndA.n97 0.123675
R2990 GndA.n828 GndA.n811 0.123675
R2991 GndA.n716 GndA.n706 0.123675
R2992 GndA.n722 GndA.n143 0.123675
R2993 GndA.n1080 GndA 0.089089
R2994 GndA.n1158 GndA 0.0768037
R2995 GndA.n1412 GndA 0.0768037
R2996 GndA.n1073 GndA.n115 0.0758528
R2997 GndA.n134 GndA 0.0758528
R2998 GndA.n823 GndA.n820 0.0708125
R2999 GndA.n713 GndA.n710 0.0708125
R3000 GndA.n726 GndA.n723 0.0708125
R3001 GndA.n1175 GndA.n1172 0.0708125
R3002 GndA.n818 GndA.n812 0.0678828
R3003 GndA.n1168 GndA.n1167 0.0678828
R3004 GndA.n93 GndA.n90 0.0661934
R3005 GndA.n97 GndA.n90 0.0661934
R3006 GndA.n811 GndA.n804 0.0661934
R3007 GndA.n807 GndA.n804 0.0661934
R3008 GndA.n702 GndA.n699 0.0661934
R3009 GndA.n706 GndA.n699 0.0661934
R3010 GndA.n143 GndA.n136 0.0661934
R3011 GndA.n139 GndA.n136 0.0661934
R3012 GndA.n934 GndA.n803 0.0657174
R3013 GndA.n936 GndA.n802 0.0657174
R3014 GndA.n552 GndA.n551 0.0657174
R3015 GndA.n549 GndA.n282 0.0657174
R3016 GndA.n732 GndA.n135 0.059875
R3017 GndA.n1072 GndA.n116 0.059875
R3018 GndA.n1160 GndA.n1159 0.059875
R3019 GndA.n1411 GndA.n24 0.059875
R3020 GndA.n93 GndA.n92 0.0579818
R3021 GndA.n807 GndA.n806 0.0579818
R3022 GndA.n702 GndA.n701 0.0579818
R3023 GndA.n139 GndA.n138 0.0579818
R3024 GndA.n1083 GndA.n1077 0.0574697
R3025 GndA.n1102 GndA.n1101 0.0574697
R3026 GndA.n11 GndA.n9 0.0574697
R3027 GndA.n1449 GndA.n5 0.0574697
R3028 GndA.n1415 GndA.n20 0.0574697
R3029 GndA.n1137 GndA.n1128 0.0574697
R3030 GndA.n1150 GndA.n104 0.0574697
R3031 GndA.n1155 GndA.n100 0.0574697
R3032 GndA.n1105 GndA.n111 0.0553333
R3033 GndA.n1440 GndA.n1439 0.0553333
R3034 GndA.n1422 GndA.n1420 0.0553333
R3035 GndA.n1119 GndA.n1114 0.0553333
R3036 GndA.n1430 GndA.n0 0.0546794
R3037 GndA.n1110 GndA.n0 0.0546794
R3038 GndA.n1094 GndA.n1093 0.0524848
R3039 GndA.n1450 GndA.n4 0.0524848
R3040 GndA.n1138 GndA.n1126 0.0524848
R3041 GndA.n1146 GndA.n106 0.0524848
R3042 GndA.n1092 GndA.n1091 0.0505
R3043 GndA.n1092 GndA.n1085 0.0505
R3044 GndA.n1085 GndA.n1076 0.0505
R3045 GndA.n1099 GndA.n1076 0.0505
R3046 GndA.n1100 GndA.n1099 0.0505
R3047 GndA.n1104 GndA.n1103 0.0505
R3048 GndA.n1104 GndA.n114 0.0505
R3049 GndA.n114 GndA.n113 0.0505
R3050 GndA.n1437 GndA.n15 0.0505
R3051 GndA.n1438 GndA.n1437 0.0505
R3052 GndA.n1438 GndA.n13 0.0505
R3053 GndA.n1446 GndA.n7 0.0505
R3054 GndA.n1447 GndA.n1446 0.0505
R3055 GndA.n1448 GndA.n1447 0.0505
R3056 GndA.n1448 GndA.n6 0.0505
R3057 GndA.n1086 GndA.n6 0.0505
R3058 GndA.n1147 GndA.n105 0.0505
R3059 GndA.n1148 GndA.n1147 0.0505
R3060 GndA.n1149 GndA.n1148 0.0505
R3061 GndA.n1149 GndA.n99 0.0505
R3062 GndA.n1156 GndA.n99 0.0505
R3063 GndA.n1118 GndA.n98 0.0505
R3064 GndA.n1118 GndA.n1117 0.0505
R3065 GndA.n1117 GndA.n1116 0.0505
R3066 GndA.n1426 GndA.n1424 0.0505
R3067 GndA.n1424 GndA.n1423 0.0505
R3068 GndA.n1423 GndA.n19 0.0505
R3069 GndA.n1414 GndA.n23 0.0505
R3070 GndA.n1135 GndA.n23 0.0505
R3071 GndA.n1136 GndA.n1135 0.0505
R3072 GndA.n1136 GndA.n1134 0.0505
R3073 GndA.n1134 GndA.n1133 0.0505
R3074 GndA.n110 GndA.n108 0.0453636
R3075 GndA.n1436 GndA.n1435 0.0453636
R3076 GndA.n1427 GndA.n18 0.0453636
R3077 GndA.n1113 GndA.n1111 0.0453636
R3078 GndA.n1098 GndA.n1097 0.0410909
R3079 GndA.n1445 GndA.n8 0.0410909
R3080 GndA.n1127 GndA.n22 0.0410909
R3081 GndA.n1151 GndA.n101 0.0410909
R3082 GndA.n1142 GndA.n0 0.0401794
R3083 GndA.n1098 GndA.n1075 0.0382424
R3084 GndA.n1445 GndA.n1444 0.0382424
R3085 GndA.n1416 GndA.n22 0.0382424
R3086 GndA.n1154 GndA.n101 0.0382424
R3087 GndA.n1110 GndA.n1109 0.0376687
R3088 GndA.n1430 GndA.n1429 0.0376687
R3089 GndA.n1123 GndA.n1110 0.0376687
R3090 GndA.n1159 GndA.n1158 0.0375399
R3091 GndA.n1412 GndA.n1411 0.0375399
R3092 GndA.n1179 GndA.n1178 0.0351715
R3093 GndA.n924 GndA.n828 0.0351715
R3094 GndA.n717 GndA.n716 0.0351715
R3095 GndA.n722 GndA.n721 0.0351715
R3096 GndA.n826 GndA.n820 0.0346797
R3097 GndA.n714 GndA.n713 0.0346797
R3098 GndA.n729 GndA.n723 0.0346797
R3099 GndA.n1176 GndA.n1175 0.0346797
R3100 GndA.n1106 GndA.n110 0.0339697
R3101 GndA.n1436 GndA.n12 0.0339697
R3102 GndA.n1421 GndA.n18 0.0339697
R3103 GndA.n1120 GndA.n1113 0.0339697
R3104 GndA.n1455 GndA.n1454 0.0295
R3105 GndA.n1432 GndA.n1430 0.0288048
R3106 GndA.n1100 GndA.n1074 0.027375
R3107 GndA.n133 GndA.n7 0.027375
R3108 GndA.n1157 GndA.n1156 0.027375
R3109 GndA.n1414 GndA.n1413 0.027375
R3110 GndA.n1093 GndA.n1084 0.0268485
R3111 GndA.n4 GndA.n2 0.0268485
R3112 GndA.n1126 GndA.n1125 0.0268485
R3113 GndA.n1146 GndA.n1145 0.0268485
R3114 GndA.n135 GndA.n134 0.0262812
R3115 GndA.n1073 GndA.n1072 0.0262812
R3116 GndA.n1106 GndA.n1105 0.024
R3117 GndA.n1439 GndA.n12 0.024
R3118 GndA.n1422 GndA.n1421 0.024
R3119 GndA.n1120 GndA.n1119 0.024
R3120 GndA.n1103 GndA.n1074 0.023625
R3121 GndA.n133 GndA.n13 0.023625
R3122 GndA.n1157 GndA.n98 0.023625
R3123 GndA.n1413 GndA.n19 0.023625
R3124 GndA.n1101 GndA.n1075 0.0197273
R3125 GndA.n1444 GndA.n9 0.0197273
R3126 GndA.n1416 GndA.n1415 0.0197273
R3127 GndA.n1155 GndA.n1154 0.0197273
R3128 GndA.n1454 GndA.n1453 0.0185505
R3129 GndA.n1081 GndA.n1080 0.0185505
R3130 GndA.n1142 GndA.n1141 0.0185505
R3131 GndA.n1143 GndA.n1142 0.0185505
R3132 GndA.n1097 GndA.n1077 0.0168788
R3133 GndA.n8 GndA.n5 0.0168788
R3134 GndA.n1128 GndA.n1127 0.0168788
R3135 GndA.n1151 GndA.n1150 0.0168788
R3136 GndA.n861 GndA.n860 0.0168043
R3137 GndA.n814 GndA 0.0168043
R3138 GndA.n54 GndA.n38 0.0168043
R3139 GndA.n611 GndA.n610 0.0168043
R3140 GndA.n1163 GndA.n1162 0.0168043
R3141 GndA.n733 GndA.n132 0.0168043
R3142 GndA.n1096 GndA.n1095 0.0158869
R3143 GndA.n1096 GndA.n1079 0.0158869
R3144 GndA.n1107 GndA.n109 0.0158869
R3145 GndA.n1441 GndA.n10 0.0158869
R3146 GndA.n1443 GndA.n3 0.0158869
R3147 GndA.n1451 GndA.n3 0.0158869
R3148 GndA.n1419 GndA.n17 0.0158869
R3149 GndA.n1417 GndA.n21 0.0158869
R3150 GndA.n1139 GndA.n21 0.0158869
R3151 GndA.n1152 GndA.n103 0.0158869
R3152 GndA.n1153 GndA.n1152 0.0158869
R3153 GndA.n1121 GndA.n1112 0.0158869
R3154 GndA.n1078 GndA.n109 0.0151875
R3155 GndA.n1108 GndA.n1107 0.0151875
R3156 GndA.n1434 GndA.n10 0.0151875
R3157 GndA.n1442 GndA.n1441 0.0151875
R3158 GndA.n1428 GndA.n17 0.0151875
R3159 GndA.n1419 GndA.n1418 0.0151875
R3160 GndA.n1112 GndA.n102 0.0151875
R3161 GndA.n1122 GndA.n1121 0.0151875
R3162 GndA.n1432 GndA.n1431 0.015
R3163 GndA.n1095 GndA.n1082 0.0137887
R3164 GndA.n1452 GndA.n1451 0.0137887
R3165 GndA.n1140 GndA.n1139 0.0137887
R3166 GndA.n1144 GndA.n103 0.0137887
R3167 GndA.n823 GndA.n822 0.0122188
R3168 GndA.n710 GndA.n709 0.0122188
R3169 GndA.n726 GndA.n725 0.0122188
R3170 GndA.n1172 GndA.n1171 0.0122188
R3171 GndA.n1433 GndA.n1432 0.00936387
R3172 GndA.n1433 GndA.n1 0.00844521
R3173 GndA.n1453 GndA.n1 0.00844521
R3174 GndA.n1081 GndA.n107 0.00844521
R3175 GndA.n1109 GndA.n107 0.00844521
R3176 GndA.n1429 GndA.n16 0.00844521
R3177 GndA.n1141 GndA.n16 0.00844521
R3178 GndA.n1143 GndA.n1124 0.00844521
R3179 GndA.n1124 GndA.n1123 0.00844521
R3180 GndA.n1454 GndA.n0 0.00841594
R3181 GndA.n1080 GndA.n0 0.00841594
R3182 GndA.n1094 GndA.n1083 0.00548485
R3183 GndA.n1450 GndA.n1449 0.00548485
R3184 GndA.n1138 GndA.n1137 0.00548485
R3185 GndA.n106 GndA.n104 0.00548485
R3186 GndA.n1102 GndA.n111 0.00263636
R3187 GndA.n1440 GndA.n11 0.00263636
R3188 GndA.n1420 GndA.n20 0.00263636
R3189 GndA.n1114 GndA.n100 0.00263636
R3190 GndA.n1079 GndA.n1078 0.0011994
R3191 GndA.n1443 GndA.n1442 0.0011994
R3192 GndA.n1418 GndA.n1417 0.0011994
R3193 GndA.n1153 GndA.n102 0.0011994
R3194 openDVS_pixel_1.DiffBn openDVS_pixel_1.DiffBn.t0 75.4171
R3195 openDVS_pixel_1.vpr.n0 openDVS_pixel_1.vpr.t1 242.743
R3196 openDVS_pixel_1.vpr openDVS_pixel_1.vpr.n0 9.46888
R3197 openDVS_pixel_1.vpr openDVS_pixel_1.vpr.n1 0.00496429
R3198 openDVS_pixel_1.vpr.n1 openDVS_pixel_1.vpr.t3 270.712
R3199 openDVS_pixel_1.vpr.n1 openDVS_pixel_1.vpr.t0 653.798
R3200 openDVS_pixel_1.vpr.n0 openDVS_pixel_1.vpr.t2 264.62
R3201 openDVS_pixel_2.vpr.t0 openDVS_pixel_2.vpr 918.417
R3202 openDVS_pixel_1.vsf openDVS_pixel_1.vsf.n0 665.364
R3203 openDVS_pixel_1.vsf.n0 openDVS_pixel_1.vsf.t1 665.678
R3204 openDVS_pixel_1.vsf.n0 openDVS_pixel_1.vsf.t2 8.80807
R3205 openDVS_pixel_1.vsf.t2 openDVS_pixel_1.vsf.t0 0.728122
R3206 openDVS_pixel_2.vsf openDVS_pixel_2.vsf.n0 665.364
R3207 openDVS_pixel_2.vsf.n0 openDVS_pixel_2.vsf.t1 665.673
R3208 openDVS_pixel_2.vsf.n0 openDVS_pixel_2.vsf.t0 8.80807
R3209 openDVS_pixel_2.vsf.t0 openDVS_pixel_2.vsf.t2 0.728122
R3210 a_1070_n607# a_1070_n607.t0 142.857
R3211 openDVS_pixel_1.nRst.t0 openDVS_pixel_1.nRst.n4 665.591
R3212 openDVS_pixel_1.nRst.n3 openDVS_pixel_1.nRst.n4 0.129964
R3213 openDVS_pixel_1.nRst.n4 openDVS_pixel_1.nRst.n0 0.244939
R3214 openDVS_pixel_1.nRst.n0 openDVS_pixel_1.nRst.n2 0.898761
R3215 openDVS_pixel_1.nRst.n2 openDVS_pixel_1.nRst.n1 17.7439
R3216 openDVS_pixel_1.nRst.n1 openDVS_pixel_1.nRst 0.0586897
R3217 openDVS_pixel_1.nRst.n1 openDVS_pixel_1.nRst.t1 237.157
R3218 openDVS_pixel_1.nRst.n2 openDVS_pixel_1.nRst.t2 798.135
R3219 openDVS_pixel_1.nRst.n0 openDVS_pixel_1.nRst.t3 127.233
R3220 a_n3520_n607# a_n3520_n607.t0 142.857
R3221 openDVS_pixel_2.nRst.n4 openDVS_pixel_2.nRst.t0 665.591
R3222 openDVS_pixel_2.nRst.n3 openDVS_pixel_2.nRst.n4 0.129964
R3223 openDVS_pixel_2.nRst.n4 openDVS_pixel_2.nRst.n0 0.249403
R3224 openDVS_pixel_2.nRst.n0 openDVS_pixel_2.nRst.n2 0.898761
R3225 openDVS_pixel_2.nRst.n2 openDVS_pixel_2.nRst.n1 17.7439
R3226 openDVS_pixel_2.nRst.n1 openDVS_pixel_2.nRst 0.0586897
R3227 openDVS_pixel_2.nRst.n1 openDVS_pixel_2.nRst.t1 237.157
R3228 openDVS_pixel_2.nRst.n2 openDVS_pixel_2.nRst.t2 798.135
R3229 openDVS_pixel_2.nRst.n0 openDVS_pixel_2.nRst.t3 127.233
R3230 a_788_n281# a_788_n281.t0 142.857
R3231 a_528_n281# a_528_n281.t0 142.857
R3232 openDVS_pixel_1.ON openDVS_pixel_1.ON.t0 235.186
R3233 openDVS_pixel_1.ON openDVS_pixel_1.ON.n0 3.84612
R3234 openDVS_pixel_1.ON.n0 openDVS_pixel_1.ON.t2 322.777
R3235 openDVS_pixel_1.ON.n0 openDVS_pixel_1.ON.t1 111.662
R3236 openDVS_pixel_1.nOFF.t0 openDVS_pixel_1.nOFF.n0 102.117
R3237 openDVS_pixel_1.nOFF.n1 openDVS_pixel_1.nOFF.n0 4.30407
R3238 openDVS_pixel_1.nOFF openDVS_pixel_1.nOFF.n1 0.0249565
R3239 openDVS_pixel_1.nOFF.n1 openDVS_pixel_1.nOFF.t1 235.626
R3240 openDVS_pixel_1.nOFF.n0 openDVS_pixel_1.nOFF.t2 376.247
R3241 a_n2994_n281# a_n2994_n281.t0 142.857
R3242 a_n3254_n281# a_n3254_n281.t0 142.857
R3243 openDVS_pixel_1.vdiff.t0 openDVS_pixel_1.vdiff 801.992
R3244 openDVS_pixel_1.vd.t0 openDVS_pixel_1.vd.n5 670.802
R3245 openDVS_pixel_1.vd.n4 openDVS_pixel_1.vd.n5 0.0263621
R3246 openDVS_pixel_1.vd.n5 openDVS_pixel_1.vd.n0 16.0278
R3247 openDVS_pixel_1.vd.n0 openDVS_pixel_1.vd.t1 1.1255
R3248 openDVS_pixel_1.vd.n1 openDVS_pixel_1.vd.t3 1.1255
R3249 openDVS_pixel_1.vd.n2 openDVS_pixel_1.vd.t2 1.1255
R3250 openDVS_pixel_1.vd.n2 openDVS_pixel_1.vd.n1 0.152681
R3251 openDVS_pixel_1.vd.n0 openDVS_pixel_1.vd.n2 1.41423
R3252 openDVS_pixel_1.vd openDVS_pixel_1.vd.n3 0.0551875
R3253 openDVS_pixel_1.vd.n1 openDVS_pixel_1.vd.n3 13.5676
R3254 openDVS_pixel_1.vd.n3 openDVS_pixel_1.vd.t4 107.385
R3255 openDVS_pixel_2.vd.n5 openDVS_pixel_2.vd.t0 670.802
R3256 openDVS_pixel_2.vd.n4 openDVS_pixel_2.vd.n5 0.0263621
R3257 openDVS_pixel_2.vd.n5 openDVS_pixel_2.vd.n0 16.0278
R3258 openDVS_pixel_2.vd.n0 openDVS_pixel_2.vd.t1 1.1255
R3259 openDVS_pixel_2.vd.n1 openDVS_pixel_2.vd.t3 1.1255
R3260 openDVS_pixel_2.vd.n2 openDVS_pixel_2.vd.t2 1.1255
R3261 openDVS_pixel_2.vd.n0 openDVS_pixel_2.vd.n1 1.41423
R3262 openDVS_pixel_2.vd.n1 openDVS_pixel_2.vd.n2 0.152681
R3263 openDVS_pixel_2.vd.n2 openDVS_pixel_2.vd.n3 13.5676
R3264 openDVS_pixel_2.vd.n3 openDVS_pixel_2.vd 0.0551875
R3265 openDVS_pixel_2.vd.n3 openDVS_pixel_2.vd.t4 107.385
R3266 openDVS_pixel_2.vdiff.t0 openDVS_pixel_2.vdiff.n5 687.573
R3267 openDVS_pixel_2.vdiff.n4 openDVS_pixel_2.vdiff.n5 4.5005
R3268 openDVS_pixel_2.vdiff.n5 openDVS_pixel_2.vdiff.n6 1.43379
R3269 openDVS_pixel_2.vdiff.n6 openDVS_pixel_2.vdiff.t3 114.45
R3270 openDVS_pixel_2.vdiff.n6 openDVS_pixel_2.vdiff.t1 3.47592
R3271 openDVS_pixel_2.vdiff openDVS_pixel_2.vdiff.n4 0.157047
R3272 openDVS_pixel_2.vdiff openDVS_pixel_2.vdiff.t2 235.643
R3273 openDVS_pixel_2.vdiff.n2 openDVS_pixel_2.vdiff.n3 0.00530769
R3274 openDVS_pixel_2.vdiff.n3 openDVS_pixel_2.vdiff.n0 0.111077
R3275 openDVS_pixel_2.vdiff.n4 openDVS_pixel_2.vdiff.n0 1.51126
R3276 openDVS_pixel_2.vdiff.n2 openDVS_pixel_2.vdiff.t5 87.4114
R3277 openDVS_pixel_2.vdiff.n0 openDVS_pixel_2.vdiff.n1 15.6111
R3278 openDVS_pixel_2.vdiff.n1 openDVS_pixel_2.vdiff.n2 27.537
R3279 openDVS_pixel_2.vdiff.n1 openDVS_pixel_2.vdiff.t4 76.2275
R3280 a_788_125# a_788_125.t0 142.857
R3281 a_528_125# a_528_125.t0 142.857
R3282 openDVS_pixel_2.nOFF.t0 openDVS_pixel_2.nOFF.n0 102.117
R3283 openDVS_pixel_2.nOFF.n1 openDVS_pixel_2.nOFF.n0 4.30407
R3284 openDVS_pixel_2.nOFF openDVS_pixel_2.nOFF.n1 0.0249565
R3285 openDVS_pixel_2.nOFF.n1 openDVS_pixel_2.nOFF.t1 235.626
R3286 openDVS_pixel_2.nOFF.n0 openDVS_pixel_2.nOFF.t2 376.247
R3287 openDVS_pixel_2.ON.n0 openDVS_pixel_2.ON.t0 111.662
R3288 openDVS_pixel_2.ON openDVS_pixel_2.ON.n0 3.84613
R3289 openDVS_pixel_2.ON openDVS_pixel_2.ON.t1 235.186
R3290 openDVS_pixel_2.ON.n0 openDVS_pixel_2.ON.t2 322.777
R3291 a_n2994_125# a_n2994_125.t0 142.857
R3292 a_n3254_125# a_n3254_125.t0 142.857
R3293 a_1070_435# a_1070_435.t0 142.857
R3294 openDVS_pixel_3.nOFF.n0 openDVS_pixel_3.nOFF.t0 102.117
R3295 openDVS_pixel_3.nOFF.n1 openDVS_pixel_3.nOFF.n0 4.30407
R3296 openDVS_pixel_3.nOFF.n1 openDVS_pixel_3.nOFF.t1 235.626
R3297 openDVS_pixel_3.nOFF openDVS_pixel_3.nOFF.n1 0.0249565
R3298 openDVS_pixel_3.nOFF.n0 openDVS_pixel_3.nOFF.t2 376.247
R3299 openDVS_pixel_3.ON.t0 openDVS_pixel_3.ON 235.186
R3300 openDVS_pixel_3.ON openDVS_pixel_3.ON.n0 3.84612
R3301 openDVS_pixel_3.ON.n0 openDVS_pixel_3.ON.t1 111.662
R3302 openDVS_pixel_3.ON.n0 openDVS_pixel_3.ON.t2 322.777
R3303 a_n3520_435# a_n3520_435.t0 142.857
R3304 openDVS_pixel_3.vsf openDVS_pixel_3.vsf.n0 665.364
R3305 openDVS_pixel_3.vsf.n0 openDVS_pixel_3.vsf.t0 665.678
R3306 openDVS_pixel_3.vsf.n0 openDVS_pixel_3.vsf.t1 8.80807
R3307 openDVS_pixel_3.vsf.t1 openDVS_pixel_3.vsf.t2 0.728122
R3308 openDVS_pixel_0.vsf openDVS_pixel_0.vsf.n0 665.364
R3309 openDVS_pixel_0.vsf.n0 openDVS_pixel_0.vsf.t0 665.673
R3310 openDVS_pixel_0.vsf.n0 openDVS_pixel_0.vsf.t1 8.80807
R3311 openDVS_pixel_0.vsf.t1 openDVS_pixel_0.vsf.t2 0.728122
R3312 openDVS_pixel_0.nOFF.n0 openDVS_pixel_0.nOFF.t0 102.117
R3313 openDVS_pixel_0.nOFF.n1 openDVS_pixel_0.nOFF.n0 4.30407
R3314 openDVS_pixel_0.nOFF.n1 openDVS_pixel_0.nOFF.t1 235.626
R3315 openDVS_pixel_0.nOFF openDVS_pixel_0.nOFF.n1 0.0249565
R3316 openDVS_pixel_0.nOFF.n0 openDVS_pixel_0.nOFF.t2 376.247
R3317 openDVS_pixel_0.ON.t0 openDVS_pixel_0.ON 235.186
R3318 openDVS_pixel_0.ON openDVS_pixel_0.ON.n0 3.84612
R3319 openDVS_pixel_0.ON.n0 openDVS_pixel_0.ON.t1 111.662
R3320 openDVS_pixel_0.ON.n0 openDVS_pixel_0.ON.t2 322.777
R3321 DiffBn DiffBn.t0 204.851
R3322 openDVS_pixel_3.vpr.n0 openDVS_pixel_3.vpr.t1 242.743
R3323 openDVS_pixel_3.vpr openDVS_pixel_3.vpr.n1 0.00496429
R3324 openDVS_pixel_3.vpr openDVS_pixel_3.vpr.n0 9.46888
R3325 openDVS_pixel_3.vpr.n1 openDVS_pixel_3.vpr.t2 270.712
R3326 openDVS_pixel_3.vpr.n1 openDVS_pixel_3.vpr.t0 653.798
R3327 openDVS_pixel_3.vpr.n0 openDVS_pixel_3.vpr.t3 264.62
R3328 openDVS_pixel_3.vd.t0 openDVS_pixel_3.vd.n5 670.802
R3329 openDVS_pixel_3.vd.n4 openDVS_pixel_3.vd.n5 0.0263621
R3330 openDVS_pixel_3.vd.n5 openDVS_pixel_3.vd.n0 16.0278
R3331 openDVS_pixel_3.vd.n0 openDVS_pixel_3.vd.t3 1.1255
R3332 openDVS_pixel_3.vd.n1 openDVS_pixel_3.vd.t2 1.1255
R3333 openDVS_pixel_3.vd.n2 openDVS_pixel_3.vd.t1 1.1255
R3334 openDVS_pixel_3.vd.n2 openDVS_pixel_3.vd.n1 0.152681
R3335 openDVS_pixel_3.vd.n0 openDVS_pixel_3.vd.n2 1.41423
R3336 openDVS_pixel_3.vd openDVS_pixel_3.vd.n3 0.0551875
R3337 openDVS_pixel_3.vd.n1 openDVS_pixel_3.vd.n3 13.5676
R3338 openDVS_pixel_3.vd.n3 openDVS_pixel_3.vd.t4 107.385
R3339 openDVS_pixel_3.vdiff.t0 openDVS_pixel_3.vdiff 801.992
R3340 openDVS_pixel_0.vd.n5 openDVS_pixel_0.vd.t0 670.802
R3341 openDVS_pixel_0.vd.n4 openDVS_pixel_0.vd.n5 0.0263621
R3342 openDVS_pixel_0.vd.n5 openDVS_pixel_0.vd.n0 16.0278
R3343 openDVS_pixel_0.vd.n0 openDVS_pixel_0.vd.t3 1.1255
R3344 openDVS_pixel_0.vd.n1 openDVS_pixel_0.vd.t2 1.1255
R3345 openDVS_pixel_0.vd.n2 openDVS_pixel_0.vd.t1 1.1255
R3346 openDVS_pixel_0.vd.n0 openDVS_pixel_0.vd.n1 1.41423
R3347 openDVS_pixel_0.vd.n1 openDVS_pixel_0.vd.n2 0.152681
R3348 openDVS_pixel_0.vd.n2 openDVS_pixel_0.vd.n3 13.5676
R3349 openDVS_pixel_0.vd.n3 openDVS_pixel_0.vd 0.0551875
R3350 openDVS_pixel_0.vd.n3 openDVS_pixel_0.vd.t4 107.385
R3351 openDVS_pixel_3.nRst.t0 openDVS_pixel_3.nRst.n4 665.591
R3352 openDVS_pixel_3.nRst openDVS_pixel_3.nRst.n4 0.129964
R3353 openDVS_pixel_3.nRst.n4 openDVS_pixel_3.nRst.n0 0.244939
R3354 openDVS_pixel_3.nRst.n0 openDVS_pixel_3.nRst.n3 0.898761
R3355 openDVS_pixel_3.nRst.n3 openDVS_pixel_3.nRst.t3 798.135
R3356 openDVS_pixel_3.nRst.n3 openDVS_pixel_3.nRst.n1 17.7439
R3357 openDVS_pixel_3.nRst.n2 openDVS_pixel_3.nRst.n1 0.0586897
R3358 openDVS_pixel_3.nRst.n1 openDVS_pixel_3.nRst.t1 237.157
R3359 openDVS_pixel_3.nRst.n0 openDVS_pixel_3.nRst.t2 127.233
R3360 openDVS_pixel_0.nRst.n4 openDVS_pixel_0.nRst.t0 665.591
R3361 openDVS_pixel_0.nRst openDVS_pixel_0.nRst.n4 0.129964
R3362 openDVS_pixel_0.nRst.n4 openDVS_pixel_0.nRst.n0 0.249403
R3363 openDVS_pixel_0.nRst.n0 openDVS_pixel_0.nRst.n3 0.898761
R3364 openDVS_pixel_0.nRst.n3 openDVS_pixel_0.nRst.t3 798.135
R3365 openDVS_pixel_0.nRst.n3 openDVS_pixel_0.nRst.n1 17.7439
R3366 openDVS_pixel_0.nRst.n2 openDVS_pixel_0.nRst.n1 0.0586897
R3367 openDVS_pixel_0.nRst.n1 openDVS_pixel_0.nRst.t1 237.157
R3368 openDVS_pixel_0.nRst.n0 openDVS_pixel_0.nRst.t2 127.233
R3369 openDVS_pixel_0.vdiff.t0 openDVS_pixel_0.vdiff.n5 687.573
R3370 openDVS_pixel_0.vdiff.n4 openDVS_pixel_0.vdiff.n5 4.5005
R3371 openDVS_pixel_0.vdiff.n5 openDVS_pixel_0.vdiff.n6 1.43379
R3372 openDVS_pixel_0.vdiff.n6 openDVS_pixel_0.vdiff.t3 114.45
R3373 openDVS_pixel_0.vdiff.n6 openDVS_pixel_0.vdiff.t1 3.47592
R3374 openDVS_pixel_0.vdiff.n3 openDVS_pixel_0.vdiff.t2 235.643
R3375 openDVS_pixel_0.vdiff.n3 openDVS_pixel_0.vdiff.n4 0.157047
R3376 openDVS_pixel_0.vdiff.n2 openDVS_pixel_0.vdiff 0.00530769
R3377 openDVS_pixel_0.vdiff openDVS_pixel_0.vdiff.n0 0.111077
R3378 openDVS_pixel_0.vdiff.n4 openDVS_pixel_0.vdiff.n0 1.51126
R3379 openDVS_pixel_0.vdiff.n2 openDVS_pixel_0.vdiff.t5 87.4111
R3380 openDVS_pixel_0.vdiff.n0 openDVS_pixel_0.vdiff.n1 15.6111
R3381 openDVS_pixel_0.vdiff.n1 openDVS_pixel_0.vdiff.n2 27.537
R3382 openDVS_pixel_0.vdiff.n1 openDVS_pixel_0.vdiff.t4 76.2275
R3383 openDVS_pixel_0.vpr.t0 openDVS_pixel_0.vpr 918.417
C857 readLine[1] GndA 4.42849f
C858 rowReadOFF[1] GndA 0.44155f
C859 rowReadON[1] GndA 1.20283f
C860 readLine[0] GndA 4.42845f
C861 GndD GndA 2.07899f
C862 rowReadOFF[0] GndA 0.44255f
C863 pixRst[1] GndA 2.91729f
C864 pixRst[0] GndA 2.91715f
C865 rowReadON[0] GndA 1.2038f
C866 RefrBp GndA 0.30426f
C867 PrSFBp GndA 0.27325f
C868 OffBn GndA 7.81139f
C869 PrBp GndA 0.3188f
C870 OnBn GndA 6.22983f
C871 DiffBn_uq1 GndA 4.30264f
C872 VddA18 GndA 57.24969f
C873 vpd[3] GndA 2.32669f
C874 vpd[1] GndA 2.32795f
C875 vpd[2] GndA 2.38781f
C876 vpd[0] GndA 2.38656f
C877 m2_637_n1876# GndA 0.01099f
C878 m2_379_n1876# GndA 0.00787f
C879 m2_121_n1876# GndA 0.0171f
C880 m2_n2545_n1876# GndA 0.0171f
C881 m2_n2803_n1876# GndA 0.00787f
C882 m2_n3061_n1876# GndA 0.01099f
C883 m2_637_1746# GndA 0.01099f
C884 m2_379_1746# GndA 0.00787f
C885 m2_121_1746# GndA 0.0171f
C886 m2_n2545_1746# GndA 0.0171f
C887 m2_n2803_1746# GndA 0.00787f
C888 m2_n3061_1746# GndA 0.01099f
C889 m1_637_n1876# GndA 0.06644f
C890 m1_379_n1876# GndA 0.03794f
C891 m1_121_n1876# GndA 0.03589f
C892 m1_637_n1618# GndA 0.04661f
C893 m1_379_n1618# GndA 0.00275f
C894 m1_121_n1618# GndA 0.00146f
C895 m1_637_n1360# GndA 0.0492f
C896 m1_379_n1360# GndA 0.00262f
C897 m1_n137_n1618# GndA 0.00147f
C898 m1_n395_n1618# GndA 0.00287f
C899 m1_n395_n1360# GndA 0.00274f
C900 m1_637_n1102# GndA 0.04942f
C901 m1_379_n1102# GndA 0.00264f
C902 m1_n395_n1102# GndA 0.00277f
C903 m1_n2029_n1618# GndA 0.00287f
C904 m1_n2287_n1618# GndA 0.00147f
C905 m1_n2029_n1360# GndA 0.00274f
C906 m1_n2545_n1876# GndA 0.03589f
C907 m1_n2803_n1876# GndA 0.03794f
C908 m1_n3061_n1876# GndA 0.06644f
C909 m1_n2545_n1618# GndA 0.00146f
C910 m1_n2803_n1618# GndA 0.00275f
C911 m1_n3061_n1618# GndA 0.04661f
C912 m1_n2803_n1360# GndA 0.00262f
C913 m1_n3061_n1360# GndA 0.0492f
C914 m1_n2029_n1102# GndA 0.00277f
C915 m1_n2803_n1102# GndA 0.00264f
C916 m1_n3061_n1102# GndA 0.04942f
C917 m1_637_n844# GndA 0.05421f
C918 m1_379_n844# GndA 0.00299f
C919 m1_121_n844# GndA 0.00282f
C920 m1_n137_n844# GndA 0.00284f
C921 m1_n395_n844# GndA 0.00311f
C922 m1_n2029_n844# GndA 0.00311f
C923 m1_n2287_n844# GndA 0.00284f
C924 m1_n2545_n844# GndA 0.00282f
C925 m1_n2803_n844# GndA 0.00299f
C926 m1_n3061_n844# GndA 0.05421f
C927 m1_637_714# GndA 0.05421f
C928 m1_379_714# GndA 0.00299f
C929 m1_121_714# GndA 0.00282f
C930 m1_n137_714# GndA 0.00284f
C931 m1_n395_714# GndA 0.00311f
C932 m1_n2029_714# GndA 0.00311f
C933 m1_n2287_714# GndA 0.00284f
C934 m1_n2545_714# GndA 0.00282f
C935 m1_n2803_714# GndA 0.00299f
C936 m1_n3061_714# GndA 0.05421f
C937 m1_637_972# GndA 0.04942f
C938 m1_379_972# GndA 0.00264f
C939 m1_n395_972# GndA 0.00277f
C940 m1_637_1230# GndA 0.0492f
C941 m1_379_1230# GndA 0.00262f
C942 m1_637_1488# GndA 0.04661f
C943 m1_379_1488# GndA 0.00275f
C944 m1_121_1488# GndA 0.00146f
C945 m1_637_1746# GndA 0.06644f
C946 m1_379_1746# GndA 0.03794f
C947 m1_121_1746# GndA 0.03589f
C948 m1_n395_1230# GndA 0.00274f
C949 m1_n137_1488# GndA 0.00147f
C950 m1_n395_1488# GndA 0.00287f
C951 m1_n2029_972# GndA 0.00277f
C952 m1_n2803_972# GndA 0.00264f
C953 m1_n3061_972# GndA 0.04942f
C954 m1_n2029_1230# GndA 0.00274f
C955 m1_n2029_1488# GndA 0.00287f
C956 m1_n2287_1488# GndA 0.00147f
C957 m1_n2803_1230# GndA 0.00262f
C958 m1_n3061_1230# GndA 0.0492f
C959 m1_n2545_1488# GndA 0.00146f
C960 m1_n2803_1488# GndA 0.00275f
C961 m1_n3061_1488# GndA 0.04661f
C962 m1_n2545_1746# GndA 0.03589f
C963 m1_n2803_1746# GndA 0.03794f
C964 m1_n3061_1746# GndA 0.06644f
C965 openDVS_pixel_1.DiffBn GndA 1.47702f $ **FLOATING
C966 openDVS_pixel_1.vpr GndA 0.8825f $ **FLOATING
C967 openDVS_pixel_2.vpr GndA 0.88274f $ **FLOATING
C968 openDVS_pixel_1.vsf GndA 2.46093f $ **FLOATING
C969 openDVS_pixel_2.vsf GndA 2.46092f $ **FLOATING
C970 a_1070_n607# GndA 0.01126f $ **FLOATING
C971 openDVS_pixel_1.nRst GndA 2.23638f $ **FLOATING
C972 a_n3520_n607# GndA 0.01126f $ **FLOATING
C973 openDVS_pixel_2.nRst GndA 2.23684f $ **FLOATING
C974 a_788_n281# GndA 0.0047f $ **FLOATING
C975 a_528_n281# GndA 0.00573f $ **FLOATING
C976 openDVS_pixel_1.ON GndA 1.51927f $ **FLOATING
C977 openDVS_pixel_1.nOFF GndA 1.32993f $ **FLOATING
C978 a_n2994_n281# GndA 0.00573f $ **FLOATING
C979 a_n3254_n281# GndA 0.0047f $ **FLOATING
C980 openDVS_pixel_1.vdiff GndA 1.95261f $ **FLOATING
C981 openDVS_pixel_1.vd GndA 4.64908f $ **FLOATING
C982 openDVS_pixel_2.vd GndA 4.66595f $ **FLOATING
C983 openDVS_pixel_2.vdiff GndA 1.95397f $ **FLOATING
C984 a_788_125# GndA 0.00472f $ **FLOATING
C985 a_528_125# GndA 0.00575f $ **FLOATING
C986 openDVS_pixel_2.nOFF GndA 1.32993f $ **FLOATING
C987 openDVS_pixel_2.ON GndA 1.51927f $ **FLOATING
C988 a_n2994_125# GndA 0.00575f $ **FLOATING
C989 a_n3254_125# GndA 0.00472f $ **FLOATING
C990 a_1070_435# GndA 0.01126f $ **FLOATING
C991 openDVS_pixel_3.nOFF GndA 1.32999f $ **FLOATING
C992 openDVS_pixel_3.ON GndA 1.51934f $ **FLOATING
C993 a_n3520_435# GndA 0.01126f $ **FLOATING
C994 openDVS_pixel_3.vsf GndA 2.57556f $ **FLOATING
C995 openDVS_pixel_0.vsf GndA 2.57558f $ **FLOATING
C996 openDVS_pixel_0.nOFF GndA 1.32999f $ **FLOATING
C997 openDVS_pixel_0.ON GndA 1.51934f $ **FLOATING
C998 DiffBn GndA 2.17565f $ **FLOATING
C999 openDVS_pixel_3.vpr GndA 1.63425f $ **FLOATING
C1000 openDVS_pixel_3.vd GndA 4.75874f $ **FLOATING
C1001 openDVS_pixel_3.vdiff GndA 2.02796f $ **FLOATING
C1002 openDVS_pixel_0.vd GndA 4.74188f $ **FLOATING
C1003 openDVS_pixel_3.nRst GndA 2.24675f $ **FLOATING
C1004 openDVS_pixel_0.nRst GndA 2.24626f $ **FLOATING
C1005 openDVS_pixel_0.vdiff GndA 2.02623f $ **FLOATING
C1006 openDVS_pixel_0.vpr GndA 1.63401f $ **FLOATING
* fill shunts: 168 floating capacitor-only nodes of openDVS_pixel2x2__diffbn_physical_core tied to ground with 1e15 ohm (dummy fill)
Rfs0 m1_121_1230# 0 1e15
Rfs1 m1_121_1488# 0 1e15
Rfs2 m1_121_1746# 0 1e15
Rfs3 m1_121_714# 0 1e15
Rfs4 m1_121_972# 0 1e15
Rfs5 m1_121_n1102# 0 1e15
Rfs6 m1_121_n1360# 0 1e15
Rfs7 m1_121_n1618# 0 1e15
Rfs8 m1_121_n1876# 0 1e15
Rfs9 m1_121_n844# 0 1e15
Rfs10 m1_379_1230# 0 1e15
Rfs11 m1_379_1488# 0 1e15
Rfs12 m1_379_1746# 0 1e15
Rfs13 m1_379_714# 0 1e15
Rfs14 m1_379_972# 0 1e15
Rfs15 m1_379_n1102# 0 1e15
Rfs16 m1_379_n1360# 0 1e15
Rfs17 m1_379_n1618# 0 1e15
Rfs18 m1_379_n1876# 0 1e15
Rfs19 m1_379_n844# 0 1e15
Rfs20 m1_637_1230# 0 1e15
Rfs21 m1_637_1488# 0 1e15
Rfs22 m1_637_1746# 0 1e15
Rfs23 m1_637_714# 0 1e15
Rfs24 m1_637_972# 0 1e15
Rfs25 m1_637_n1102# 0 1e15
Rfs26 m1_637_n1360# 0 1e15
Rfs27 m1_637_n1618# 0 1e15
Rfs28 m1_637_n1876# 0 1e15
Rfs29 m1_637_n844# 0 1e15
Rfs30 m1_n137_1230# 0 1e15
Rfs31 m1_n137_1488# 0 1e15
Rfs32 m1_n137_714# 0 1e15
Rfs33 m1_n137_972# 0 1e15
Rfs34 m1_n137_n1102# 0 1e15
Rfs35 m1_n137_n1360# 0 1e15
Rfs36 m1_n137_n1618# 0 1e15
Rfs37 m1_n137_n844# 0 1e15
Rfs38 m1_n2029_1230# 0 1e15
Rfs39 m1_n2029_1488# 0 1e15
Rfs40 m1_n2029_714# 0 1e15
Rfs41 m1_n2029_972# 0 1e15
Rfs42 m1_n2029_n1102# 0 1e15
Rfs43 m1_n2029_n1360# 0 1e15
Rfs44 m1_n2029_n1618# 0 1e15
Rfs45 m1_n2029_n844# 0 1e15
Rfs46 m1_n2287_1230# 0 1e15
Rfs47 m1_n2287_1488# 0 1e15
Rfs48 m1_n2287_714# 0 1e15
Rfs49 m1_n2287_972# 0 1e15
Rfs50 m1_n2287_n1102# 0 1e15
Rfs51 m1_n2287_n1360# 0 1e15
Rfs52 m1_n2287_n1618# 0 1e15
Rfs53 m1_n2287_n844# 0 1e15
Rfs54 m1_n2545_1230# 0 1e15
Rfs55 m1_n2545_1488# 0 1e15
Rfs56 m1_n2545_1746# 0 1e15
Rfs57 m1_n2545_714# 0 1e15
Rfs58 m1_n2545_972# 0 1e15
Rfs59 m1_n2545_n1102# 0 1e15
Rfs60 m1_n2545_n1360# 0 1e15
Rfs61 m1_n2545_n1618# 0 1e15
Rfs62 m1_n2545_n1876# 0 1e15
Rfs63 m1_n2545_n844# 0 1e15
Rfs64 m1_n2803_1230# 0 1e15
Rfs65 m1_n2803_1488# 0 1e15
Rfs66 m1_n2803_1746# 0 1e15
Rfs67 m1_n2803_714# 0 1e15
Rfs68 m1_n2803_972# 0 1e15
Rfs69 m1_n2803_n1102# 0 1e15
Rfs70 m1_n2803_n1360# 0 1e15
Rfs71 m1_n2803_n1618# 0 1e15
Rfs72 m1_n2803_n1876# 0 1e15
Rfs73 m1_n2803_n844# 0 1e15
Rfs74 m1_n3061_1230# 0 1e15
Rfs75 m1_n3061_1488# 0 1e15
Rfs76 m1_n3061_1746# 0 1e15
Rfs77 m1_n3061_714# 0 1e15
Rfs78 m1_n3061_972# 0 1e15
Rfs79 m1_n3061_n1102# 0 1e15
Rfs80 m1_n3061_n1360# 0 1e15
Rfs81 m1_n3061_n1618# 0 1e15
Rfs82 m1_n3061_n1876# 0 1e15
Rfs83 m1_n3061_n844# 0 1e15
Rfs84 m1_n395_1230# 0 1e15
Rfs85 m1_n395_1488# 0 1e15
Rfs86 m1_n395_714# 0 1e15
Rfs87 m1_n395_972# 0 1e15
Rfs88 m1_n395_n1102# 0 1e15
Rfs89 m1_n395_n1360# 0 1e15
Rfs90 m1_n395_n1618# 0 1e15
Rfs91 m1_n395_n844# 0 1e15
Rfs92 m2_121_1230# 0 1e15
Rfs93 m2_121_1488# 0 1e15
Rfs94 m2_121_1746# 0 1e15
Rfs95 m2_121_714# 0 1e15
Rfs96 m2_121_972# 0 1e15
Rfs97 m2_121_n1102# 0 1e15
Rfs98 m2_121_n1360# 0 1e15
Rfs99 m2_121_n1618# 0 1e15
Rfs100 m2_121_n1876# 0 1e15
Rfs101 m2_121_n844# 0 1e15
Rfs102 m2_379_1230# 0 1e15
Rfs103 m2_379_1488# 0 1e15
Rfs104 m2_379_1746# 0 1e15
Rfs105 m2_379_714# 0 1e15
Rfs106 m2_379_972# 0 1e15
Rfs107 m2_379_n1102# 0 1e15
Rfs108 m2_379_n1360# 0 1e15
Rfs109 m2_379_n1618# 0 1e15
Rfs110 m2_379_n1876# 0 1e15
Rfs111 m2_379_n844# 0 1e15
Rfs112 m2_637_1746# 0 1e15
Rfs113 m2_637_n1876# 0 1e15
Rfs114 m2_n137_1230# 0 1e15
Rfs115 m2_n137_1488# 0 1e15
Rfs116 m2_n137_714# 0 1e15
Rfs117 m2_n137_972# 0 1e15
Rfs118 m2_n137_n1102# 0 1e15
Rfs119 m2_n137_n1360# 0 1e15
Rfs120 m2_n137_n1618# 0 1e15
Rfs121 m2_n137_n844# 0 1e15
Rfs122 m2_n2029_1230# 0 1e15
Rfs123 m2_n2029_1488# 0 1e15
Rfs124 m2_n2029_714# 0 1e15
Rfs125 m2_n2029_972# 0 1e15
Rfs126 m2_n2029_n1102# 0 1e15
Rfs127 m2_n2029_n1360# 0 1e15
Rfs128 m2_n2029_n1618# 0 1e15
Rfs129 m2_n2029_n844# 0 1e15
Rfs130 m2_n2287_1230# 0 1e15
Rfs131 m2_n2287_1488# 0 1e15
Rfs132 m2_n2287_714# 0 1e15
Rfs133 m2_n2287_972# 0 1e15
Rfs134 m2_n2287_n1102# 0 1e15
Rfs135 m2_n2287_n1360# 0 1e15
Rfs136 m2_n2287_n1618# 0 1e15
Rfs137 m2_n2287_n844# 0 1e15
Rfs138 m2_n2545_1230# 0 1e15
Rfs139 m2_n2545_1488# 0 1e15
Rfs140 m2_n2545_1746# 0 1e15
Rfs141 m2_n2545_714# 0 1e15
Rfs142 m2_n2545_972# 0 1e15
Rfs143 m2_n2545_n1102# 0 1e15
Rfs144 m2_n2545_n1360# 0 1e15
Rfs145 m2_n2545_n1618# 0 1e15
Rfs146 m2_n2545_n1876# 0 1e15
Rfs147 m2_n2545_n844# 0 1e15
Rfs148 m2_n2803_1230# 0 1e15
Rfs149 m2_n2803_1488# 0 1e15
Rfs150 m2_n2803_1746# 0 1e15
Rfs151 m2_n2803_714# 0 1e15
Rfs152 m2_n2803_972# 0 1e15
Rfs153 m2_n2803_n1102# 0 1e15
Rfs154 m2_n2803_n1360# 0 1e15
Rfs155 m2_n2803_n1618# 0 1e15
Rfs156 m2_n2803_n1876# 0 1e15
Rfs157 m2_n2803_n844# 0 1e15
Rfs158 m2_n3061_1746# 0 1e15
Rfs159 m2_n3061_n1876# 0 1e15
Rfs160 m2_n395_1230# 0 1e15
Rfs161 m2_n395_1488# 0 1e15
Rfs162 m2_n395_714# 0 1e15
Rfs163 m2_n395_972# 0 1e15
Rfs164 m2_n395_n1102# 0 1e15
Rfs165 m2_n395_n1360# 0 1e15
Rfs166 m2_n395_n1618# 0 1e15
Rfs167 m2_n395_n844# 0 1e15
.ends
.subckt openDVS_pixel2x2 pixRst[1] pixRst[0] rowReadON[1] rowReadON[0] rowReadOFF[1]
+ rowReadOFF[0] readLine[1] readLine[0] vpd[3] vpd[2] vpd[1] vpd[0] VddA18 GndA GndD OnBn OffBn
+ DiffBn PrSFBp RefrBp PrBp
Xdiffbn_physical_core pixRst[1] pixRst[0] rowReadON[1] rowReadON[0] rowReadOFF[1] rowReadOFF[0]
+ readLine[1] readLine[0] vpd[3] vpd[2] vpd[1] vpd[0] VddA18 GndA GndD OnBn OffBn DiffBn DiffBn
+ DiffBn PrSFBp RefrBp PrBp openDVS_pixel2x2__diffbn_physical_core
.ends openDVS_pixel2x2
