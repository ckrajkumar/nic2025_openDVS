* PEX netlist: openDVS_pixel2x2 (mode=rcc, extracted by Calibre)
* Converted from Calibre RCC extraction to sky130/ngspice format
.subckt openDVS_pixel2x2 pixRst[1] pixRst[0] rowReadON[1] rowReadON[0] rowReadOFF[1] rowReadOFF[0] readLine[1] readLine[0] vpd[3] vpd[2] vpd[1] vpd[0] VddA18 GndA GndD OnBn OffBn DiffBn PrSFBp RefrBp PrBp

* SPICE netlist converted from spectre by scs2spice.py
* Source: openDVS_pixel2x2_rcc_.scs
* Generated for: spectre
* Generated on: May 22 15:09:28 2026
* Design library name: openDVS_pixel_4x4_klay_5_22_26
* Design cell name: openDVS_pixel2x2
* Design view name: calibre
* .lib "models.all.scs" tt  ** removed: Spectre model library

* Library name: openDVS_pixel_4x4_klay_5_22_26
* Cell name: openDVS_pixel2x2
* View name: calibre
vshort_vpd xPix[0].vpd xPix[0].DD1.pos 0
xPix[3].CC3 xPix[3].CC3.pos xPix[3].CC3.neg sky130_fd_pr__cap_mim_m3_1 w=2.27 l=3.985 m=1
xPix[3].CC1b xPix[3].CC1b.pos xPix[3].CC1b.neg sky130_fd_pr__cap_mim_m3_1 w=6.47 l=1.05 m=1
xPix[3].CC1 xPix[3].CC1.pos xPix[3].CC1.neg sky130_fd_pr__cap_mim_m3_1 w=1 l=1 m=1
xPix[1].CC3 xPix[1].CC3.pos xPix[1].CC3.neg sky130_fd_pr__cap_mim_m3_1 w=2.27 l=3.985 m=1
xPix[1].CC1b xPix[1].CC1b.pos xPix[1].CC1b.neg sky130_fd_pr__cap_mim_m3_1 w=6.47 l=1.05 m=1
xPix[1].CC1 xPix[1].CC1.pos xPix[1].CC1.neg sky130_fd_pr__cap_mim_m3_1 w=1 l=1 m=1
xPix[2].CC3 xPix[2].CC3.pos xPix[2].CC3.neg sky130_fd_pr__cap_mim_m3_1 w=2.27 l=3.985 m=1
xPix[2].CC1b xPix[2].CC1b.pos xPix[2].CC1b.neg sky130_fd_pr__cap_mim_m3_1 w=6.47 l=1.05 m=1
xPix[2].CC1 xPix[2].CC1.pos xPix[2].CC1.neg sky130_fd_pr__cap_mim_m3_1 w=1 l=1 m=1
xPix[0].CC3 xPix[0].CC3.pos xPix[0].CC3.neg sky130_fd_pr__cap_mim_m3_1 w=2.27 l=3.985 m=1
xPix[0].CC1b xPix[0].CC1b.pos xPix[0].CC1b.neg sky130_fd_pr__cap_mim_m3_1 w=6.47 l=1.05 m=1
xPix[0].CC1 xPix[0].CC1.pos xPix[0].CC1.neg sky130_fd_pr__cap_mim_m3_1 w=1 l=1 m=1
xPix[3].MMPDrefrCol xPix[3].MMPDrefrCol.d xPix[3].MMPDrefrCol.g xPix[3].net48 xPix[3].MMPDrefrCol.b
+ sky130_fd_pr__nfet_01v8 nf=1 w=0.42 l=0.15 m=1 as=0.1113 ad=0.1113 ps=0.95 pd=0.95 nrd=0.333333
+ nrs=0.333333 sa=0.265 sb=0.265 sd=0.28
xPix[3].MMPDRefrRow xPix[3].net48 xPix[3].MMPDRefrRow.g xPix[3].MMPDRefrRow.s xPix[3].MMPDRefrRow.b
+ sky130_fd_pr__nfet_01v8 nf=1 w=0.42 l=0.15 m=1 as=0.1113 ad=0.1113 ps=0.95 pd=0.95 nrd=0.333333
+ nrs=0.333333 sa=0.265 sb=0.265 sd=0.28
xPix[3].MMN8 xPix[3].net47 xPix[3].MMN8.g xPix[3].MMN8.s xPix[3].MMN8.b sky130_fd_pr__nfet_01v8 nf=1 w=0.42 l=0.15 m=1
+ as=0.1113 ad=0.1113 ps=0.95 pd=0.95 nrd=0.333333 nrs=0.333333 sa=0.265
+ sb=0.265 sd=0.28
xPix[3].MMN7 xPix[3].net46 xPix[3].MMN7.g xPix[3].MMN7.s xPix[3].MMN7.b sky130_fd_pr__nfet_01v8 nf=1 w=0.42 l=0.15 m=1
+ as=0.1113 ad=0.1113 ps=0.95 pd=0.95 nrd=0.333333 nrs=0.333333 sa=0.265
+ sb=0.265 sd=0.28
xPix[3].MMN11 xPix[3].MMN11.d xPix[3].MMN11.g xPix[3].net47 xPix[3].MMN11.b sky130_fd_pr__nfet_01v8 nf=1 w=0.42 l=0.15
+ m=1 as=0.1113 ad=0.1113 ps=0.95 pd=0.95 nrd=0.333333 nrs=0.333333 sa=0.265
+ sb=0.265 sd=0.28
xPix[3].MMN10 xPix[3].MMN10.d xPix[3].MMN10.g xPix[3].net46 xPix[3].MMN10.b sky130_fd_pr__nfet_01v8 nf=1 w=0.42 l=0.15
+ m=1 as=0.1113 ad=0.1113 ps=0.95 pd=0.95 nrd=0.333333 nrs=0.333333 sa=0.265
+ sb=0.265 sd=0.28
xPix[1].MMPDrefrCol xPix[1].MMPDrefrCol.d xPix[1].MMPDrefrCol.g xPix[1].net48 xPix[1].MMPDrefrCol.b
+ sky130_fd_pr__nfet_01v8 nf=1 w=0.42 l=0.15 m=1 as=0.1113 ad=0.1113 ps=0.95 pd=0.95 nrd=0.333333
+ nrs=0.333333 sa=0.265 sb=0.265 sd=0.28
xPix[1].MMPDRefrRow xPix[1].net48 xPix[1].MMPDRefrRow.g xPix[1].MMPDRefrRow.s xPix[1].MMPDRefrRow.b
+ sky130_fd_pr__nfet_01v8 nf=1 w=0.42 l=0.15 m=1 as=0.1113 ad=0.1113 ps=0.95 pd=0.95 nrd=0.333333
+ nrs=0.333333 sa=0.265 sb=0.265 sd=0.28
xPix[1].MMN8 xPix[1].net47 xPix[1].MMN8.g xPix[1].MMN8.s xPix[1].MMN8.b sky130_fd_pr__nfet_01v8 nf=1 w=0.42 l=0.15 m=1
+ as=0.1113 ad=0.1113 ps=0.95 pd=0.95 nrd=0.333333 nrs=0.333333 sa=0.265
+ sb=0.265 sd=0.28
xPix[1].MMN7 xPix[1].net46 xPix[1].MMN7.g xPix[1].MMN7.s xPix[1].MMN7.b sky130_fd_pr__nfet_01v8 nf=1 w=0.42 l=0.15 m=1
+ as=0.1113 ad=0.1113 ps=0.95 pd=0.95 nrd=0.333333 nrs=0.333333 sa=0.265
+ sb=0.265 sd=0.28
xPix[1].MMN11 xPix[1].MMN11.d xPix[1].MMN11.g xPix[1].net47 xPix[1].MMN11.b sky130_fd_pr__nfet_01v8 nf=1 w=0.42 l=0.15
+ m=1 as=0.1113 ad=0.1113 ps=0.95 pd=0.95 nrd=0.333333 nrs=0.333333 sa=0.265
+ sb=0.265 sd=0.28
xPix[1].MMN10 xPix[1].MMN10.d xPix[1].MMN10.g xPix[1].net46 xPix[1].MMN10.b sky130_fd_pr__nfet_01v8 nf=1 w=0.42 l=0.15
+ m=1 as=0.1113 ad=0.1113 ps=0.95 pd=0.95 nrd=0.333333 nrs=0.333333 sa=0.265
+ sb=0.265 sd=0.28
xPix[2].MMPDrefrCol xPix[2].MMPDrefrCol.d xPix[2].MMPDrefrCol.g xPix[2].net48 xPix[2].MMPDrefrCol.b
+ sky130_fd_pr__nfet_01v8 nf=1 w=0.42 l=0.15 m=1 as=0.1113 ad=0.1113 ps=0.95 pd=0.95 nrd=0.333333
+ nrs=0.333333 sa=0.265 sb=0.265 sd=0.28
xPix[2].MMPDRefrRow xPix[2].net48 xPix[2].MMPDRefrRow.g xPix[2].MMPDRefrRow.s xPix[2].MMPDRefrRow.b
+ sky130_fd_pr__nfet_01v8 nf=1 w=0.42 l=0.15 m=1 as=0.1113 ad=0.1113 ps=0.95 pd=0.95 nrd=0.333333
+ nrs=0.333333 sa=0.265 sb=0.265 sd=0.28
xPix[2].MMN8 xPix[2].net47 xPix[2].MMN8.g xPix[2].MMN8.s xPix[2].MMN8.b sky130_fd_pr__nfet_01v8 nf=1 w=0.42 l=0.15 m=1
+ as=0.1113 ad=0.1113 ps=0.95 pd=0.95 nrd=0.333333 nrs=0.333333 sa=0.265
+ sb=0.265 sd=0.28
xPix[2].MMN7 xPix[2].net46 xPix[2].MMN7.g xPix[2].MMN7.s xPix[2].MMN7.b sky130_fd_pr__nfet_01v8 nf=1 w=0.42 l=0.15 m=1
+ as=0.1113 ad=0.1113 ps=0.95 pd=0.95 nrd=0.333333 nrs=0.333333 sa=0.265
+ sb=0.265 sd=0.28
xPix[2].MMN11 xPix[2].MMN11.d xPix[2].MMN11.g xPix[2].net47 xPix[2].MMN11.b sky130_fd_pr__nfet_01v8 nf=1 w=0.42 l=0.15
+ m=1 as=0.1113 ad=0.1113 ps=0.95 pd=0.95 nrd=0.333333 nrs=0.333333 sa=0.265
+ sb=0.265 sd=0.28
xPix[2].MMN10 xPix[2].MMN10.d xPix[2].MMN10.g xPix[2].net46 xPix[2].MMN10.b sky130_fd_pr__nfet_01v8 nf=1 w=0.42 l=0.15
+ m=1 as=0.1113 ad=0.1113 ps=0.95 pd=0.95 nrd=0.333333 nrs=0.333333 sa=0.265
+ sb=0.265 sd=0.28
xPix[0].MMPDrefrCol xPix[0].MMPDrefrCol.d xPix[0].MMPDrefrCol.g xPix[0].net48 xPix[0].MMPDrefrCol.b
+ sky130_fd_pr__nfet_01v8 nf=1 w=0.42 l=0.15 m=1 as=0.1113 ad=0.1113 ps=0.95 pd=0.95 nrd=0.333333
+ nrs=0.333333 sa=0.265 sb=0.265 sd=0.28
xPix[0].MMPDRefrRow xPix[0].net48 xPix[0].MMPDRefrRow.g xPix[0].MMPDRefrRow.s xPix[0].MMPDRefrRow.b
+ sky130_fd_pr__nfet_01v8 nf=1 w=0.42 l=0.15 m=1 as=0.1113 ad=0.1113 ps=0.95 pd=0.95 nrd=0.333333
+ nrs=0.333333 sa=0.265 sb=0.265 sd=0.28
xPix[0].MMN8 xPix[0].net47 xPix[0].MMN8.g xPix[0].MMN8.s xPix[0].MMN8.b sky130_fd_pr__nfet_01v8 nf=1 w=0.42 l=0.15 m=1
+ as=0.1113 ad=0.1113 ps=0.95 pd=0.95 nrd=0.333333 nrs=0.333333 sa=0.265
+ sb=0.265 sd=0.28
xPix[0].MMN7 xPix[0].net46 xPix[0].MMN7.g xPix[0].MMN7.s xPix[0].MMN7.b sky130_fd_pr__nfet_01v8 nf=1 w=0.42 l=0.15 m=1
+ as=0.1113 ad=0.1113 ps=0.95 pd=0.95 nrd=0.333333 nrs=0.333333 sa=0.265
+ sb=0.265 sd=0.28
xPix[0].MMN11 xPix[0].MMN11.d xPix[0].MMN11.g xPix[0].net47 xPix[0].MMN11.b sky130_fd_pr__nfet_01v8 nf=1 w=0.42 l=0.15
+ m=1 as=0.1113 ad=0.1113 ps=0.95 pd=0.95 nrd=0.333333 nrs=0.333333 sa=0.265
+ sb=0.265 sd=0.28
xPix[0].MMN10 xPix[0].MMN10.d xPix[0].MMN10.g xPix[0].net46 xPix[0].MMN10.b sky130_fd_pr__nfet_01v8 nf=1 w=0.42 l=0.15
+ m=1 as=0.1113 ad=0.1113 ps=0.95 pd=0.95 nrd=0.333333 nrs=0.333333 sa=0.265
+ sb=0.265 sd=0.28
xPix[3].MMP0 xPix[3].MMP0.d xPix[3].MMP0.g xPix[3].MMP0.s xPix[3].MMP0.b sky130_fd_pr__pfet_01v8_hvt nf=1 w=0.42 l=1.5
+ m=1 as=0.126 ad=0.126 ps=1.02 pd=1.02 nrd=0 nrs=0 sa=0.265 sb=0.265 sd=0.28
xPix[1].MMP0 xPix[1].MMP0.d xPix[1].MMP0.g xPix[1].MMP0.s xPix[1].MMP0.b sky130_fd_pr__pfet_01v8_hvt nf=1 w=0.42 l=1.5
+ m=1 as=0.126 ad=0.126 ps=1.02 pd=1.02 nrd=0 nrs=0 sa=0.265 sb=0.265 sd=0.28
xPix[2].MMP0 xPix[2].MMP0.d xPix[2].MMP0.g xPix[2].MMP0.s xPix[2].MMP0.b sky130_fd_pr__pfet_01v8_hvt nf=1 w=0.42 l=1.5
+ m=1 as=0.126 ad=0.126 ps=1.02 pd=1.02 nrd=0 nrs=0 sa=0.265 sb=0.265 sd=0.28
xPix[0].MMP0 xPix[0].MMP0.d xPix[0].MMP0.g xPix[0].MMP0.s xPix[0].MMP0.b sky130_fd_pr__pfet_01v8_hvt nf=1 w=0.42 l=1.5
+ m=1 as=0.126 ad=0.126 ps=1.02 pd=1.02 nrd=0 nrs=0 sa=0.265 sb=0.265 sd=0.28
* DD1 parasitic diodes replaced with 1T-ohm resistors (diode model causes transient convergence failure)
rDD1_2 xPix[2].DD1.pos xPix[2].DD1.neg 1e12
rDD1_3 xPix[3].DD1.pos xPix[3].DD1.neg 1e12
rDD1_0 xPix[0].DD1.pos xPix[0].DD1.neg 1e12
rDD1_1 xPix[1].DD1.pos xPix[1].DD1.neg 1e12
* CC3.pos (vd node) DC stabilizers: floating in DC when reset switch is OFF
rCC3stab_0 xPix[0].CC3.pos GndA 1e12
rCC3stab_1 xPix[1].CC3.pos GndA 1e12
rCC3stab_2 xPix[2].CC3.pos GndA 1e12
rCC3stab_3 xPix[3].CC3.pos GndA 1e12
xPix[3].MMon xPix[3].MMon.d xPix[3].MMon.g xPix[3].MMon.s xPix[3].MMon.b sky130_fd_pr__pfet_01v8 nf=1 w=1.5 l=1.5 m=1
+ as=0.45 ad=0.45 ps=2.1 pd=2.1 nrd=0 nrs=0 sa=0.265 sb=0.265 sd=0.28
xPix[3].MMchAmp xPix[3].MMchAmp.d xPix[3].MMchAmp.g xPix[3].MMchAmp.s xPix[3].MMchAmp.b sky130_fd_pr__pfet_01v8 nf=1
+ w=1.5 l=1.5 m=1 as=0.45 ad=0.45 ps=2.1 pd=2.1 nrd=0 nrs=0 sa=0.265 sb=0.265
+ sd=0.28
xPix[3].MMcapRef xPix[3].MMcapRef.d xPix[3].MMcapRef.g xPix[3].MMcapRef.s xPix[3].MMcapRef.b sky130_fd_pr__pfet_01v8
+ nf=1 w=1.5 l=1.5 m=1 as=0.45 ad=0.45 ps=2.1 pd=2.1 nrd=0 nrs=0 sa=0.265
+ sb=0.265 sd=0.28
xPix[3].MMP2 xPix[3].MMP2.d xPix[3].MMP2.g xPix[3].MMP2.s xPix[3].MMP2.b sky130_fd_pr__pfet_01v8 nf=1 w=1.5 l=1.5 m=1
+ as=0.45 ad=0.45 ps=2.1 pd=2.1 nrd=0 nrs=0 sa=0.265 sb=0.265 sd=0.28
xPix[1].MMon xPix[1].MMon.d xPix[1].MMon.g xPix[1].MMon.s xPix[1].MMon.b sky130_fd_pr__pfet_01v8 nf=1 w=1.5 l=1.5 m=1
+ as=0.45 ad=0.45 ps=2.1 pd=2.1 nrd=0 nrs=0 sa=0.265 sb=0.265 sd=0.28
xPix[1].MMchAmp xPix[1].MMchAmp.d xPix[1].MMchAmp.g xPix[1].MMchAmp.s xPix[1].MMchAmp.b sky130_fd_pr__pfet_01v8 nf=1
+ w=1.5 l=1.5 m=1 as=0.45 ad=0.45 ps=2.1 pd=2.1 nrd=0 nrs=0 sa=0.265 sb=0.265
+ sd=0.28
xPix[1].MMcapRef xPix[1].MMcapRef.d xPix[1].MMcapRef.g xPix[1].MMcapRef.s xPix[1].MMcapRef.b sky130_fd_pr__pfet_01v8
+ nf=1 w=1.5 l=1.5 m=1 as=0.45 ad=0.45 ps=2.1 pd=2.1 nrd=0 nrs=0 sa=0.265
+ sb=0.265 sd=0.28
xPix[1].MMP2 xPix[1].MMP2.d xPix[1].MMP2.g xPix[1].MMP2.s xPix[1].MMP2.b sky130_fd_pr__pfet_01v8 nf=1 w=1.5 l=1.5 m=1
+ as=0.45 ad=0.45 ps=2.1 pd=2.1 nrd=0 nrs=0 sa=0.265 sb=0.265 sd=0.28
xPix[2].MMon xPix[2].MMon.d xPix[2].MMon.g xPix[2].MMon.s xPix[2].MMon.b sky130_fd_pr__pfet_01v8 nf=1 w=1.5 l=1.5 m=1
+ as=0.45 ad=0.45 ps=2.1 pd=2.1 nrd=0 nrs=0 sa=0.265 sb=0.265 sd=0.28
xPix[2].MMchAmp xPix[2].MMchAmp.d xPix[2].MMchAmp.g xPix[2].MMchAmp.s xPix[2].MMchAmp.b sky130_fd_pr__pfet_01v8 nf=1
+ w=1.5 l=1.5 m=1 as=0.45 ad=0.45 ps=2.1 pd=2.1 nrd=0 nrs=0 sa=0.265 sb=0.265
+ sd=0.28
xPix[2].MMcapRef xPix[2].MMcapRef.d xPix[2].MMcapRef.g xPix[2].MMcapRef.s xPix[2].MMcapRef.b sky130_fd_pr__pfet_01v8
+ nf=1 w=1.5 l=1.5 m=1 as=0.45 ad=0.45 ps=2.1 pd=2.1 nrd=0 nrs=0 sa=0.265
+ sb=0.265 sd=0.28
xPix[2].MMP2 xPix[2].MMP2.d xPix[2].MMP2.g xPix[2].MMP2.s xPix[2].MMP2.b sky130_fd_pr__pfet_01v8 nf=1 w=1.5 l=1.5 m=1
+ as=0.45 ad=0.45 ps=2.1 pd=2.1 nrd=0 nrs=0 sa=0.265 sb=0.265 sd=0.28
xPix[0].MMon xPix[0].MMon.d xPix[0].MMon.g xPix[0].MMon.s xPix[0].MMon.b sky130_fd_pr__pfet_01v8 nf=1 w=1.5 l=1.5 m=1
+ as=0.45 ad=0.45 ps=2.1 pd=2.1 nrd=0 nrs=0 sa=0.265 sb=0.265 sd=0.28
xPix[0].MMchAmp xPix[0].MMchAmp.d xPix[0].MMchAmp.g xPix[0].MMchAmp.s xPix[0].MMchAmp.b sky130_fd_pr__pfet_01v8 nf=1
+ w=1.5 l=1.5 m=1 as=0.45 ad=0.45 ps=2.1 pd=2.1 nrd=0 nrs=0 sa=0.265 sb=0.265
+ sd=0.28
xPix[0].MMcapRef xPix[0].MMcapRef.d xPix[0].MMcapRef.g xPix[0].MMcapRef.s xPix[0].MMcapRef.b sky130_fd_pr__pfet_01v8
+ nf=1 w=1.5 l=1.5 m=1 as=0.45 ad=0.45 ps=2.1 pd=2.1 nrd=0 nrs=0 sa=0.265
+ sb=0.265 sd=0.28
xPix[0].MMP2 xPix[0].MMP2.d xPix[0].MMP2.g xPix[0].MMP2.s xPix[0].MMP2.b sky130_fd_pr__pfet_01v8 nf=1 w=1.5 l=1.5 m=1
+ as=0.45 ad=0.45 ps=2.1 pd=2.1 nrd=0 nrs=0 sa=0.265 sb=0.265 sd=0.28
xPix[3].MMonBias xPix[3].MMonBias.d xPix[3].MMonBias.g xPix[3].MMonBias.s xPix[3].MMonBias.b sky130_fd_pr__nfet_01v8
+ nf=1 w=1.5 l=1.5 m=1 as=0.3975 ad=0.3975 ps=2.03 pd=2.03 nrd=0.093333
+ nrs=0.093333 sa=0.265 sb=0.265 sd=0.28
xPix[3].MMoffBias xPix[3].MMoffBias.d xPix[3].MMoffBias.g xPix[3].MMoffBias.s xPix[3].MMoffBias.b
+ sky130_fd_pr__nfet_01v8 nf=1 w=1.5 l=1.5 m=1 as=0.3975 ad=0.3975 ps=2.03 pd=2.03 nrd=0.093333
+ nrs=0.093333 sa=0.265 sb=0.265 sd=0.28
xPix[3].MMchAmpBias xPix[3].MMchAmpBias.d xPix[3].MMchAmpBias.g xPix[3].MMchAmpBias.s
+ xPix[3].MMchAmpBias.b sky130_fd_pr__nfet_01v8 nf=1 w=1.5 l=1.5 m=1 as=0.3975 ad=0.3975 ps=2.03
+ pd=2.03 nrd=0.093333 nrs=0.093333 sa=0.265 sb=0.265 sd=0.28
xPix[1].MMonBias xPix[1].MMonBias.d xPix[1].MMonBias.g xPix[1].MMonBias.s xPix[1].MMonBias.b sky130_fd_pr__nfet_01v8
+ nf=1 w=1.5 l=1.5 m=1 as=0.3975 ad=0.3975 ps=2.03 pd=2.03 nrd=0.093333
+ nrs=0.093333 sa=0.265 sb=0.265 sd=0.28
xPix[1].MMoffBias xPix[1].MMoffBias.d xPix[1].MMoffBias.g xPix[1].MMoffBias.s xPix[1].MMoffBias.b
+ sky130_fd_pr__nfet_01v8 nf=1 w=1.5 l=1.5 m=1 as=0.3975 ad=0.3975 ps=2.03 pd=2.03 nrd=0.093333
+ nrs=0.093333 sa=0.265 sb=0.265 sd=0.28
xPix[1].MMchAmpBias xPix[1].MMchAmpBias.d xPix[1].MMchAmpBias.g xPix[1].MMchAmpBias.s
+ xPix[1].MMchAmpBias.b sky130_fd_pr__nfet_01v8 nf=1 w=1.5 l=1.5 m=1 as=0.3975 ad=0.3975 ps=2.03
+ pd=2.03 nrd=0.093333 nrs=0.093333 sa=0.265 sb=0.265 sd=0.28
xPix[2].MMonBias xPix[2].MMonBias.d xPix[2].MMonBias.g xPix[2].MMonBias.s xPix[2].MMonBias.b sky130_fd_pr__nfet_01v8
+ nf=1 w=1.5 l=1.5 m=1 as=0.3975 ad=0.3975 ps=2.03 pd=2.03 nrd=0.093333
+ nrs=0.093333 sa=0.265 sb=0.265 sd=0.28
xPix[2].MMoffBias xPix[2].MMoffBias.d xPix[2].MMoffBias.g xPix[2].MMoffBias.s xPix[2].MMoffBias.b
+ sky130_fd_pr__nfet_01v8 nf=1 w=1.5 l=1.5 m=1 as=0.3975 ad=0.3975 ps=2.03 pd=2.03 nrd=0.093333
+ nrs=0.093333 sa=0.265 sb=0.265 sd=0.28
xPix[2].MMchAmpBias xPix[2].MMchAmpBias.d xPix[2].MMchAmpBias.g xPix[2].MMchAmpBias.s
+ xPix[2].MMchAmpBias.b sky130_fd_pr__nfet_01v8 nf=1 w=1.5 l=1.5 m=1 as=0.3975 ad=0.3975 ps=2.03
+ pd=2.03 nrd=0.093333 nrs=0.093333 sa=0.265 sb=0.265 sd=0.28
xPix[0].MMonBias xPix[0].MMonBias.d xPix[0].MMonBias.g xPix[0].MMonBias.s xPix[0].MMonBias.b sky130_fd_pr__nfet_01v8
+ nf=1 w=1.5 l=1.5 m=1 as=0.3975 ad=0.3975 ps=2.03 pd=2.03 nrd=0.093333
+ nrs=0.093333 sa=0.265 sb=0.265 sd=0.28
xPix[0].MMoffBias xPix[0].MMoffBias.d xPix[0].MMoffBias.g xPix[0].MMoffBias.s xPix[0].MMoffBias.b
+ sky130_fd_pr__nfet_01v8 nf=1 w=1.5 l=1.5 m=1 as=0.3975 ad=0.3975 ps=2.03 pd=2.03 nrd=0.093333
+ nrs=0.093333 sa=0.265 sb=0.265 sd=0.28
xPix[0].MMchAmpBias xPix[0].MMchAmpBias.d xPix[0].MMchAmpBias.g xPix[0].MMchAmpBias.s
+ xPix[0].MMchAmpBias.b sky130_fd_pr__nfet_01v8 nf=1 w=1.5 l=1.5 m=1 as=0.3975 ad=0.3975 ps=2.03
+ pd=2.03 nrd=0.093333 nrs=0.093333 sa=0.265 sb=0.265 sd=0.28
xPix[3].MMpd xPix[3].MMpd.d xPix[3].MMpd.g xPix[3].MMpd.s xPix[3].MMpd.b sky130_fd_pr__nfet_01v8 nf=1 w=0.5 l=0.3 m=1
+ as=0.1325 ad=0.1325 ps=1.03 pd=1.03 nrd=0.28 nrs=0.28 sa=0.265 sb=0.265
+ sd=0.28
xPix[1].MMpd xPix[1].MMpd.d xPix[1].MMpd.g xPix[1].MMpd.s xPix[1].MMpd.b sky130_fd_pr__nfet_01v8 nf=1 w=0.5 l=0.3 m=1
+ as=0.1325 ad=0.1325 ps=1.03 pd=1.03 nrd=0.28 nrs=0.28 sa=0.265 sb=0.265
+ sd=0.28
xPix[2].MMpd xPix[2].MMpd.d xPix[2].MMpd.g xPix[2].MMpd.s xPix[2].MMpd.b sky130_fd_pr__nfet_01v8 nf=1 w=0.5 l=0.3 m=1
+ as=0.1325 ad=0.1325 ps=1.03 pd=1.03 nrd=0.28 nrs=0.28 sa=0.265 sb=0.265
+ sd=0.28
xPix[0].MMpd xPix[0].MMpd.d xPix[0].MMpd.g xPix[0].MMpd.s xPix[0].MMpd.b sky130_fd_pr__nfet_01v8 nf=1 w=0.5 l=0.3 m=1
+ as=0.1325 ad=0.1325 ps=1.03 pd=1.03 nrd=0.28 nrs=0.28 sa=0.265 sb=0.265
+ sd=0.28
xPix[3].MMprBias xPix[3].MMprBias.d xPix[3].MMprBias.g xPix[3].MMprBias.s xPix[3].MMprBias.b sky130_fd_pr__pfet_01v8
+ nf=1 w=0.5 l=0.15 m=1 as=0.15 ad=0.15 ps=1.1 pd=1.1 nrd=0 nrs=0 sa=0.265
+ sb=0.265 sd=0.28
xPix[1].MMprBias xPix[1].MMprBias.d xPix[1].MMprBias.g xPix[1].MMprBias.s xPix[1].MMprBias.b sky130_fd_pr__pfet_01v8
+ nf=1 w=0.5 l=0.15 m=1 as=0.15 ad=0.15 ps=1.1 pd=1.1 nrd=0 nrs=0 sa=0.265
+ sb=0.265 sd=0.28
xPix[2].MMprBias xPix[2].MMprBias.d xPix[2].MMprBias.g xPix[2].MMprBias.s xPix[2].MMprBias.b sky130_fd_pr__pfet_01v8
+ nf=1 w=0.5 l=0.15 m=1 as=0.15 ad=0.15 ps=1.1 pd=1.1 nrd=0 nrs=0 sa=0.265
+ sb=0.265 sd=0.28
xPix[0].MMprBias xPix[0].MMprBias.d xPix[0].MMprBias.g xPix[0].MMprBias.s xPix[0].MMprBias.b sky130_fd_pr__pfet_01v8
+ nf=1 w=0.5 l=0.15 m=1 as=0.15 ad=0.15 ps=1.1 pd=1.1 nrd=0 nrs=0 sa=0.265
+ sb=0.265 sd=0.28
xPix[3].MMpr.amp xPix[3].MMpr.amp.d xPix[3].MMpr.amp.g xPix[3].MMpr.amp.s xPix[3].MMpr.amp.b sky130_fd_pr__nfet_01v8
+ nf=1 w=0.42 l=0.3 m=1 as=0.1113 ad=0.1113 ps=0.95 pd=0.95 nrd=0.333333
+ nrs=0.333333 sa=0.265 sb=0.265 sd=0.28
xPix[1].MMpr.amp xPix[1].MMpr.amp.d xPix[1].MMpr.amp.g xPix[1].MMpr.amp.s xPix[1].MMpr.amp.b sky130_fd_pr__nfet_01v8
+ nf=1 w=0.42 l=0.3 m=1 as=0.1113 ad=0.1113 ps=0.95 pd=0.95 nrd=0.333333
+ nrs=0.333333 sa=0.265 sb=0.265 sd=0.28
xPix[2].MMpr.amp xPix[2].MMpr.amp.d xPix[2].MMpr.amp.g xPix[2].MMpr.amp.s xPix[2].MMpr.amp.b sky130_fd_pr__nfet_01v8
+ nf=1 w=0.42 l=0.3 m=1 as=0.1113 ad=0.1113 ps=0.95 pd=0.95 nrd=0.333333
+ nrs=0.333333 sa=0.265 sb=0.265 sd=0.28
xPix[0].MMpr.amp xPix[0].MMpr.amp.d xPix[0].MMpr.amp.g xPix[0].MMpr.amp.s xPix[0].MMpr.amp.b sky130_fd_pr__nfet_01v8
+ nf=1 w=0.42 l=0.3 m=1 as=0.1113 ad=0.1113 ps=0.95 pd=0.95 nrd=0.333333
+ nrs=0.333333 sa=0.265 sb=0.265 sd=0.28
xPix[3].MMrefrBias xPix[3].MMrefrBias.d xPix[3].MMrefrBias.g xPix[3].MMrefrBias.s
+ xPix[3].MMrefrBias.b sky130_fd_pr__pfet_01v8 nf=1 w=0.42 l=1.5 m=1 as=0.126 ad=0.126 ps=1.02 pd=1.02
+ nrd=0 nrs=0 sa=0.265 sb=0.265 sd=0.28
xPix[1].MMrefrBias xPix[1].MMrefrBias.d xPix[1].MMrefrBias.g xPix[1].MMrefrBias.s
+ xPix[1].MMrefrBias.b sky130_fd_pr__pfet_01v8 nf=1 w=0.42 l=1.5 m=1 as=0.126 ad=0.126 ps=1.02 pd=1.02
+ nrd=0 nrs=0 sa=0.265 sb=0.265 sd=0.28
xPix[2].MMrefrBias xPix[2].MMrefrBias.d xPix[2].MMrefrBias.g xPix[2].MMrefrBias.s
+ xPix[2].MMrefrBias.b sky130_fd_pr__pfet_01v8 nf=1 w=0.42 l=1.5 m=1 as=0.126 ad=0.126 ps=1.02 pd=1.02
+ nrd=0 nrs=0 sa=0.265 sb=0.265 sd=0.28
xPix[0].MMrefrBias xPix[0].MMrefrBias.d xPix[0].MMrefrBias.g xPix[0].MMrefrBias.s
+ xPix[0].MMrefrBias.b sky130_fd_pr__pfet_01v8 nf=1 w=0.42 l=1.5 m=1 as=0.126 ad=0.126 ps=1.02 pd=1.02
+ nrd=0 nrs=0 sa=0.265 sb=0.265 sd=0.28
xPix[3].MMrst xPix[3].MMrst.d xPix[3].MMrst.g xPix[3].MMrst.s xPix[3].MMrst.b sky130_fd_pr__pfet_01v8_hvt nf=1 w=0.42
+ l=0.42 m=1 as=0.126 ad=0.126 ps=1.02 pd=1.02 nrd=0 nrs=0 sa=0.265 sb=0.265
+ sd=0.28
xPix[1].MMrst xPix[1].MMrst.d xPix[1].MMrst.g xPix[1].MMrst.s xPix[1].MMrst.b sky130_fd_pr__pfet_01v8_hvt nf=1 w=0.42
+ l=0.42 m=1 as=0.126 ad=0.126 ps=1.02 pd=1.02 nrd=0 nrs=0 sa=0.265 sb=0.265
+ sd=0.28
xPix[2].MMrst xPix[2].MMrst.d xPix[2].MMrst.g xPix[2].MMrst.s xPix[2].MMrst.b sky130_fd_pr__pfet_01v8_hvt nf=1 w=0.42
+ l=0.42 m=1 as=0.126 ad=0.126 ps=1.02 pd=1.02 nrd=0 nrs=0 sa=0.265 sb=0.265
+ sd=0.28
xPix[0].MMrst xPix[0].MMrst.d xPix[0].MMrst.g xPix[0].MMrst.s xPix[0].MMrst.b sky130_fd_pr__pfet_01v8_hvt nf=1 w=0.42
+ l=0.42 m=1 as=0.126 ad=0.126 ps=1.02 pd=1.02 nrd=0 nrs=0 sa=0.265 sb=0.265
+ sd=0.28
xPix[3].MMsf xPix[3].MMsf.d xPix[3].MMsf.g xPix[3].MMsf.s xPix[3].MMsf.b sky130_fd_pr__pfet_01v8 nf=1 w=0.42 l=0.25 m=1
+ as=0.126 ad=0.126 ps=1.02 pd=1.02 nrd=0 nrs=0 sa=0.265 sb=0.265 sd=0.28
xPix[1].MMsf xPix[1].MMsf.d xPix[1].MMsf.g xPix[1].MMsf.s xPix[1].MMsf.b sky130_fd_pr__pfet_01v8 nf=1 w=0.42 l=0.25 m=1
+ as=0.126 ad=0.126 ps=1.02 pd=1.02 nrd=0 nrs=0 sa=0.265 sb=0.265 sd=0.28
xPix[2].MMsf xPix[2].MMsf.d xPix[2].MMsf.g xPix[2].MMsf.s xPix[2].MMsf.b sky130_fd_pr__pfet_01v8 nf=1 w=0.42 l=0.25 m=1
+ as=0.126 ad=0.126 ps=1.02 pd=1.02 nrd=0 nrs=0 sa=0.265 sb=0.265 sd=0.28
xPix[0].MMsf xPix[0].MMsf.d xPix[0].MMsf.g xPix[0].MMsf.s xPix[0].MMsf.b sky130_fd_pr__pfet_01v8 nf=1 w=0.42 l=0.25 m=1
+ as=0.126 ad=0.126 ps=1.02 pd=1.02 nrd=0 nrs=0 sa=0.265 sb=0.265 sd=0.28
civpd[2]_13 xPix[2].DD1.neg GndA 3.83364e-17
civpd[2]_12 vpd[2]_8 GndA 1.49211e-17
civpd[2]_11 vpd[2]_9 GndA 1.36564e-16
civpd[2]_10 vpd[2]_10 GndA 1.72257e-17
civpd[2]_9 vpd[2]_12 GndA 1.90938e-16
civpd[2]_8 vpd[2]_14 GndA 1.26938e-16
civpd[2]_7 vpd[2]_20 GndA 9.49871e-17
civpd[2]_6 vpd[2]_24 GndA 4.3778e-17
civpd[2]_5 vpd[2]_26 GndA 7.99059e-18
civpd[2]_4 vpd[2]_30 GndA 1.02859e-16
civpd[2]_3 vpd[2]_32 GndA 2.68099e-16
civpd[2]_2 vpd[2]_34 GndA 1.85579e-17
civpd[2]_1 vpd[2]_49 GndA 2.35338e-16
civpd[2]_0 xPix[2].MMpd.s GndA 3.9824e-17
civpd[3]_14 xPix[3].DD1.neg GndA 3.83364e-17
civpd[3]_13 vpd[3]_8 GndA 2.16003e-17
civpd[3]_12 vpd[3]_9 GndA 1.36564e-16
civpd[3]_11 vpd[3]_10 GndA 1.04731e-17
civpd[3]_10 vpd[3]_12 GndA 1.38216e-16
civpd[3]_9 vpd[3]_14 GndA 1.79252e-16
civpd[3]_8 vpd[3]_16 GndA 2.27921e-16
civpd[3]_7 vpd[3]_20 GndA 9.43177e-17
civpd[3]_6 vpd[3]_24 GndA 4.3778e-17
civpd[3]_5 vpd[3]_26 GndA 7.99059e-18
civpd[3]_4 vpd[3]_30 GndA 9.57841e-17
civpd[3]_3 vpd[3]_32 GndA 4.01777e-17
civpd[3]_2 vpd[3]_34 GndA 1.83595e-17
civpd[3]_1 vpd[3]_49 GndA 2.34475e-16
civpd[3]_0 xPix[3].MMpd.s GndA 4.12057e-17
civpd[0]_13 xPix[0].DD1.neg GndA 3.83364e-17
civpd[0]_12 vpd[0]_8 GndA 1.49211e-17
civpd[0]_11 vpd[0]_9 GndA 7.69432e-17
civpd[0]_10 vpd[0]_10 GndA 7.68517e-17
civpd[0]_9 vpd[0]_12 GndA 1.90938e-16
civpd[0]_8 vpd[0]_14 GndA 1.26938e-16
civpd[0]_7 vpd[0]_20 GndA 9.4999e-17
civpd[0]_6 vpd[0]_24 GndA 4.3778e-17
civpd[0]_5 vpd[0]_26 GndA 7.99059e-18
civpd[0]_4 vpd[0]_30 GndA 1.0284e-16
civpd[0]_3 vpd[0]_34 GndA 1.85579e-17
civpd[0]_2 vpd[0]_49 GndA 2.35402e-16
civpd[0]_1 xPix[0].MMpd.s GndA 3.9824e-17
civpd[0]_0 vpd[0] GndA 2.68099e-16
civpd[1]_14 xPix[1].DD1.neg GndA 3.83364e-17
civpd[1]_13 vpd[1]_8 GndA 2.16003e-17
civpd[1]_12 vpd[1]_9 GndA 7.69432e-17
civpd[1]_11 vpd[1]_10 GndA 7.00991e-17
civpd[1]_10 vpd[1]_12 GndA 1.38216e-16
civpd[1]_9 vpd[1]_14 GndA 1.79252e-16
civpd[1]_8 vpd[1]_16 GndA 2.27921e-16
civpd[1]_7 vpd[1]_20 GndA 9.43297e-17
civpd[1]_6 vpd[1]_24 GndA 4.3778e-17
civpd[1]_5 vpd[1]_26 GndA 7.99059e-18
civpd[1]_4 vpd[1]_30 GndA 9.57841e-17
civpd[1]_3 vpd[1]_32 GndA 4.01777e-17
civpd[1]_2 vpd[1]_34 GndA 1.83595e-17
civpd[1]_1 vpd[1]_49 GndA 2.34482e-16
civpd[1]_0 xPix[1].MMpd.s GndA 4.12057e-17
cirowReadOFF[0]_10 rowReadOFF[0]_1 GndA 1.37067e-16
cirowReadOFF[0]_9 rowReadOFF[0]_3 GndA 5.23421e-17
cirowReadOFF[0]_8 rowReadOFF[0]_9 GndA 2.81579e-17
cirowReadOFF[0]_7 xPix[0].MMN11.g GndA 1.20732e-16
cirowReadOFF[0]_6 rowReadOFF[0]_18 GndA 9.65303e-17
cirowReadOFF[0]_5 rowReadOFF[0]_21 GndA 1.37065e-16
cirowReadOFF[0]_4 rowReadOFF[0]_23 GndA 5.23421e-17
cirowReadOFF[0]_3 rowReadOFF[0]_29 GndA 2.81579e-17
cirowReadOFF[0]_2 xPix[2].MMN11.g GndA 1.20732e-16
cirowReadOFF[0]_1 rowReadOFF[0]_38 GndA 9.65303e-17
cirowReadOFF[0]_0 rowReadOFF[0] GndA 5.79515e-15
cirowReadON[0]_32 rowReadON[0]_9 GndA 1.09662e-16
cirowReadON[0]_31 rowReadON[0]_12 GndA 1.03435e-16
cirowReadON[0]_30 rowReadON[0]_15 GndA 7.62299e-17
cirowReadON[0]_29 rowReadON[0]_16 GndA 1.52337e-17
cirowReadON[0]_28 rowReadON[0]_18 GndA 6.38173e-17
cirowReadON[0]_27 rowReadON[0]_21 GndA 6.49454e-17
cirowReadON[0]_26 rowReadON[0]_22 GndA 6.06339e-17
cirowReadON[0]_25 rowReadON[0]_23 GndA 5.19178e-17
cirowReadON[0]_24 rowReadON[0]_24 GndA 2.35392e-17
cirowReadON[0]_23 rowReadON[0]_25 GndA 1.75034e-17
cirowReadON[0]_22 rowReadON[0]_26 GndA 3.94212e-17
cirowReadON[0]_21 rowReadON[0]_29 GndA 1.44601e-16
cirowReadON[0]_20 rowReadON[0]_35 GndA 1.31821e-16
cirowReadON[0]_19 xPix[0].MMN10.g GndA 1.15801e-16
cirowReadON[0]_18 rowReadON[0]_44 GndA 7.82112e-17
cirowReadON[0]_17 rowReadON[0]_47 GndA 9.9056e-17
cirowReadON[0]_16 rowReadON[0]_58 GndA 1.09662e-16
cirowReadON[0]_15 rowReadON[0]_61 GndA 1.03459e-16
cirowReadON[0]_14 rowReadON[0]_64 GndA 7.62299e-17
cirowReadON[0]_13 rowReadON[0]_65 GndA 1.52337e-17
cirowReadON[0]_12 rowReadON[0]_67 GndA 6.60393e-17
cirowReadON[0]_11 rowReadON[0]_70 GndA 6.49454e-17
cirowReadON[0]_10 rowReadON[0]_71 GndA 7.5426e-17
cirowReadON[0]_9 rowReadON[0]_72 GndA 3.49992e-17
cirowReadON[0]_8 rowReadON[0]_73 GndA 2.35392e-17
cirowReadON[0]_7 rowReadON[0]_74 GndA 1.75034e-17
cirowReadON[0]_6 rowReadON[0]_75 GndA 3.7385e-17
cirowReadON[0]_5 rowReadON[0]_78 GndA 1.44624e-16
cirowReadON[0]_4 rowReadON[0]_84 GndA 1.31821e-16
cirowReadON[0]_3 xPix[2].MMN10.g GndA 1.15801e-16
cirowReadON[0]_2 rowReadON[0]_93 GndA 7.82112e-17
cirowReadON[0]_1 rowReadON[0]_96 GndA 9.9056e-17
cirowReadON[0]_0 rowReadON[0] GndA 6.63715e-15
cirowReadOFF[1]_10 rowReadOFF[1]_1 GndA 7.71634e-17
cirowReadOFF[1]_9 rowReadOFF[1]_3 GndA 1.12246e-16
cirowReadOFF[1]_8 rowReadOFF[1]_9 GndA 2.96687e-17
cirowReadOFF[1]_7 xPix[1].MMN11.g GndA 1.18414e-16
cirowReadOFF[1]_6 rowReadOFF[1]_18 GndA 9.72427e-17
cirowReadOFF[1]_5 rowReadOFF[1]_21 GndA 7.71609e-17
cirowReadOFF[1]_4 rowReadOFF[1]_23 GndA 1.12246e-16
cirowReadOFF[1]_3 rowReadOFF[1]_29 GndA 2.863e-17
cirowReadOFF[1]_2 xPix[3].MMN11.g GndA 1.18414e-16
cirowReadOFF[1]_1 rowReadOFF[1]_38 GndA 9.88483e-17
cirowReadOFF[1]_0 rowReadOFF[1] GndA 5.79679e-15
cirowReadON[1]_32 rowReadON[1]_9 GndA 1.12978e-16
cirowReadON[1]_31 rowReadON[1]_12 GndA 6.92947e-17
cirowReadON[1]_30 rowReadON[1]_15 GndA 1.03552e-16
cirowReadON[1]_29 rowReadON[1]_16 GndA 1.78626e-17
cirowReadON[1]_28 rowReadON[1]_18 GndA 6.38173e-17
cirowReadON[1]_27 rowReadON[1]_21 GndA 7.77338e-17
cirowReadON[1]_26 rowReadON[1]_22 GndA 6.06339e-17
cirowReadON[1]_25 rowReadON[1]_23 GndA 3.91294e-17
cirowReadON[1]_24 rowReadON[1]_24 GndA 2.45841e-17
cirowReadON[1]_23 rowReadON[1]_25 GndA 1.75034e-17
cirowReadON[1]_22 rowReadON[1]_26 GndA 3.94212e-17
cirowReadON[1]_21 rowReadON[1]_29 GndA 1.44603e-16
cirowReadON[1]_20 rowReadON[1]_35 GndA 1.31821e-16
cirowReadON[1]_19 xPix[1].MMN10.g GndA 1.13482e-16
cirowReadON[1]_18 rowReadON[1]_44 GndA 7.82112e-17
cirowReadON[1]_17 rowReadON[1]_47 GndA 9.97696e-17
cirowReadON[1]_16 rowReadON[1]_58 GndA 1.12978e-16
cirowReadON[1]_15 rowReadON[1]_61 GndA 6.9318e-17
cirowReadON[1]_14 rowReadON[1]_64 GndA 1.03552e-16
cirowReadON[1]_13 rowReadON[1]_65 GndA 1.78626e-17
cirowReadON[1]_12 rowReadON[1]_67 GndA 6.60393e-17
cirowReadON[1]_11 rowReadON[1]_70 GndA 7.77338e-17
cirowReadON[1]_10 rowReadON[1]_71 GndA 7.5426e-17
cirowReadON[1]_9 rowReadON[1]_72 GndA 2.22109e-17
cirowReadON[1]_8 rowReadON[1]_73 GndA 2.35454e-17
cirowReadON[1]_7 rowReadON[1]_74 GndA 1.75034e-17
cirowReadON[1]_6 rowReadON[1]_75 GndA 3.7385e-17
cirowReadON[1]_5 rowReadON[1]_78 GndA 1.44626e-16
cirowReadON[1]_4 rowReadON[1]_84 GndA 1.31821e-16
cirowReadON[1]_3 xPix[3].MMN10.g GndA 1.13482e-16
cirowReadON[1]_2 rowReadON[1]_93 GndA 7.82112e-17
cirowReadON[1]_1 rowReadON[1]_96 GndA 1.01375e-16
cirowReadON[1]_0 rowReadON[1] GndA 6.63715e-15
ciGndD_32 GndD_3 GndA 1.46041e-16
ciGndD_31 GndD_5 GndA 1.2698e-16
ciGndD_30 GndD_7 GndA 7.49039e-17
ciGndD_29 GndD_9 GndA 1.61852e-16
ciGndD_28 GndD_15 GndA 1.71299e-16
ciGndD_27 xPix[1].MMN7.s GndA 3.57355e-17
ciGndD_26 xPix[1].MMN8.s GndA 3.52529e-17
ciGndD_25 GndD_35 GndA 1.46121e-16
ciGndD_24 GndD_37 GndA 1.2698e-16
ciGndD_23 GndD_39 GndA 7.49039e-17
ciGndD_22 GndD_41 GndA 2.00119e-16
ciGndD_21 GndD_47 GndA 1.33031e-16
ciGndD_20 xPix[0].MMN7.s GndA 3.57355e-17
ciGndD_19 xPix[0].MMN8.s GndA 3.52529e-17
ciGndD_18 GndD_67 GndA 1.46041e-16
ciGndD_17 GndD_69 GndA 3.71014e-17
ciGndD_16 GndD_71 GndA 1.64804e-16
ciGndD_15 GndD_73 GndA 1.61849e-16
ciGndD_14 GndD_79 GndA 1.71299e-16
ciGndD_13 xPix[3].MMN7.s GndA 3.57355e-17
ciGndD_12 xPix[3].MMN8.s GndA 3.52529e-17
ciGndD_11 GndD_99 GndA 1.46121e-16
ciGndD_10 GndD_101 GndA 3.71014e-17
ciGndD_9 GndD_103 GndA 1.64804e-16
ciGndD_8 GndD_105 GndA 2.00117e-16
ciGndD_7 GndD_111 GndA 1.33031e-16
ciGndD_6 xPix[2].MMN7.s GndA 3.57355e-17
ciGndD_5 xPix[2].MMN8.s GndA 3.52529e-17
ciGndD_4 GndD_138 GndA 2.53285e-16
ciGndD_3 GndD_144 GndA 2.53229e-16
ciGndD_2 GndD_149 GndA 5.57962e-15
ciGndD_1 GndD_150 GndA 4.93284e-15
ciGndD_0 GndD_161 GndA 1.79269e-16
cipixRst[1]_12 pixRst[1]_3 GndA 1.80625e-16
cipixRst[1]_11 pixRst[1]_6 GndA 1.00652e-16
cipixRst[1]_10 pixRst[1]_13 GndA 2.02866e-16
cipixRst[1]_9 pixRst[1]_15 GndA 6.16259e-15
cipixRst[1]_8 pixRst[1]_17 GndA 4.06825e-17
cipixRst[1]_7 pixRst[1]_21 GndA 1.26146e-16
cipixRst[1]_6 pixRst[1]_26 GndA 8.28098e-17
cipixRst[1]_5 pixRst[1]_30 GndA 1.80625e-16
cipixRst[1]_4 pixRst[1]_33 GndA 1.00652e-16
cipixRst[1]_3 pixRst[1]_40 GndA 2.03041e-16
cipixRst[1]_2 pixRst[1]_44 GndA 4.06825e-17
cipixRst[1]_1 pixRst[1]_48 GndA 1.26146e-16
cipixRst[1]_0 pixRst[1]_53 GndA 8.28098e-17
cireadLine[1]_24 readLine[1]_6 GndA 7.63144e-17
cireadLine[1]_23 readLine[1]_8 GndA 9.49693e-17
cireadLine[1]_22 readLine[1]_11 GndA 1.35234e-16
cireadLine[1]_21 readLine[1]_14 GndA 1.6023e-17
cireadLine[1]_20 readLine[1]_15 GndA 1.88161e-16
cireadLine[1]_19 readLine[1]_16 GndA 7.16414e-17
cireadLine[1]_18 readLine[1]_18 GndA 5.04859e-17
cireadLine[1]_17 readLine[1]_20 GndA 1.11661e-17
cireadLine[1]_16 readLine[1]_24 GndA 3.12212e-16
cireadLine[1]_15 readLine[1]_27 GndA 1.39815e-16
cireadLine[1]_14 readLine[1]_28 GndA 1.30133e-16
cireadLine[1]_13 readLine[1]_30 GndA 5.90792e-15
cireadLine[1]_12 xPix[3].MMN10.d GndA 3.78807e-17
cireadLine[1]_11 readLine[1]_43 GndA 7.63144e-17
cireadLine[1]_10 readLine[1]_45 GndA 9.49693e-17
cireadLine[1]_9 readLine[1]_48 GndA 1.35234e-16
cireadLine[1]_8 readLine[1]_51 GndA 2.05103e-17
cireadLine[1]_7 readLine[1]_52 GndA 1.79044e-16
cireadLine[1]_6 readLine[1]_53 GndA 6.43633e-17
cireadLine[1]_5 readLine[1]_55 GndA 3.63712e-17
cireadLine[1]_4 readLine[1]_57 GndA 3.38044e-17
cireadLine[1]_3 readLine[1]_61 GndA 3.15335e-16
cireadLine[1]_2 readLine[1]_64 GndA 1.39815e-16
cireadLine[1]_1 readLine[1]_65 GndA 1.30133e-16
cireadLine[1]_0 xPix[2].MMN10.d GndA 3.78807e-17
ciOnBn_74 OnBn_5 GndA 5.77071e-17
ciOnBn_73 OnBn_6 GndA 5.98029e-16
ciOnBn_72 OnBn_7 GndA 5.51467e-16
ciOnBn_71 OnBn_12 GndA 3.13572e-16
ciOnBn_70 OnBn_14 GndA 4.74417e-17
ciOnBn_69 OnBn_15 GndA 7.67018e-17
ciOnBn_68 OnBn_17 GndA 1.49393e-16
ciOnBn_67 OnBn_18 GndA 9.13449e-17
ciOnBn_66 OnBn_27 GndA 4.95352e-17
ciOnBn_65 xPix[1].MMonBias.g GndA 1.30689e-15
ciOnBn_64 OnBn_41 GndA 5.75018e-17
ciOnBn_63 OnBn_42 GndA 5.97951e-16
ciOnBn_62 OnBn_43 GndA 5.51467e-16
ciOnBn_61 OnBn_48 GndA 3.04135e-16
ciOnBn_60 OnBn_50 GndA 1.65343e-16
ciOnBn_59 OnBn_51 GndA 5.02755e-17
ciOnBn_58 OnBn_53 GndA 1.4761e-16
ciOnBn_57 OnBn_54 GndA 9.15157e-17
ciOnBn_56 OnBn_63 GndA 4.95377e-17
ciOnBn_55 xPix[0].MMonBias.g GndA 1.30689e-15
ciOnBn_54 OnBn_77 GndA 5.77071e-17
ciOnBn_53 OnBn_78 GndA 5.98029e-16
ciOnBn_52 OnBn_79 GndA 2.01285e-17
ciOnBn_51 OnBn_84 GndA 3.13623e-16
ciOnBn_50 OnBn_86 GndA 6.73065e-17
ciOnBn_49 OnBn_87 GndA 3.04107e-17
ciOnBn_48 OnBn_89 GndA 1.49393e-16
ciOnBn_47 OnBn_90 GndA 5.79082e-16
ciOnBn_46 OnBn_99 GndA 4.96055e-17
ciOnBn_45 xPix[3].MMonBias.g GndA 1.3071e-15
ciOnBn_44 OnBn_113 GndA 5.75018e-17
ciOnBn_43 OnBn_114 GndA 5.97951e-16
ciOnBn_42 OnBn_115 GndA 2.01285e-17
ciOnBn_41 OnBn_120 GndA 3.04186e-16
ciOnBn_40 OnBn_122 GndA 1.85147e-16
ciOnBn_39 OnBn_123 GndA 3.04107e-17
ciOnBn_38 OnBn_125 GndA 1.47616e-16
ciOnBn_37 OnBn_126 GndA 5.79082e-16
ciOnBn_36 OnBn_135 GndA 4.9608e-17
ciOnBn_35 xPix[2].MMonBias.g GndA 1.3071e-15
ciOnBn_34 OnBn_178 GndA 2.24662e-16
ciOnBn_33 OnBn_180 GndA 6.3649e-17
ciOnBn_32 OnBn_183 GndA 2.24772e-16
ciOnBn_31 OnBn_185 GndA 6.37847e-17
ciOnBn_30 OnBn_191 GndA 2.94639e-16
ciOnBn_29 OnBn_196 GndA 2.94848e-16
ciOnBn_28 OnBn_197 GndA 3.47018e-16
ciOnBn_27 OnBn_198 GndA 3.47015e-16
ciOnBn_26 OnBn_201 GndA 2.46862e-16
ciOnBn_25 OnBn_202 GndA 1.25201e-16
ciOnBn_24 OnBn_203 GndA 1.38613e-16
ciOnBn_23 OnBn_204 GndA 2.25491e-17
ciOnBn_22 OnBn_205 GndA 3.8049e-16
ciOnBn_21 OnBn_206 GndA 3.89927e-16
ciOnBn_20 OnBn_207 GndA 2.45197e-17
ciOnBn_19 OnBn_208 GndA 2.45197e-17
ciOnBn_18 OnBn_209 GndA 9.35156e-17
ciOnBn_17 OnBn_210 GndA 9.35156e-17
ciOnBn_16 OnBn_211 GndA 2.26945e-16
ciOnBn_15 OnBn_212 GndA 2.26945e-16
ciOnBn_14 OnBn_215 GndA 3.31047e-17
ciOnBn_13 OnBn_219 GndA 8.55527e-17
ciOnBn_12 OnBn_221 GndA 3.14201e-16
ciOnBn_11 OnBn_222 GndA 2.61608e-16
ciOnBn_10 OnBn_227 GndA 6.40015e-16
ciOnBn_9 OnBn_228 GndA 5.87551e-16
ciOnBn_8 OnBn_231 GndA 3.3312e-17
ciOnBn_7 OnBn_235 GndA 8.57601e-17
ciOnBn_6 OnBn_238 GndA 1.92035e-16
ciOnBn_5 OnBn_240 GndA 1.92035e-16
ciOnBn_4 OnBn_243 GndA 1.90488e-16
ciOnBn_3 OnBn_247 GndA 1.90488e-16
ciOnBn_2 OnBn_253 GndA 6.29365e-15
ciOnBn_1 OnBn_199 GndA 8.39206e-17
ciOnBn_0 OnBn_200 GndA 1.19784e-16
ciRefrBp_14 RefrBp_8 GndA 5.14841e-17
ciRefrBp_13 RefrBp_17 GndA 6.40928e-16
ciRefrBp_12 RefrBp_26 GndA 5.0072e-17
ciRefrBp_11 RefrBp_35 GndA 6.34606e-16
ciRefrBp_10 RefrBp_38 GndA 1.39794e-16
ciRefrBp_9 RefrBp_44 GndA 5.24204e-17
ciRefrBp_8 RefrBp_53 GndA 6.34552e-16
ciRefrBp_7 RefrBp_56 GndA 1.41728e-16
ciRefrBp_6 RefrBp_62 GndA 5.10084e-17
ciRefrBp_5 RefrBp_71 GndA 6.2836e-16
ciRefrBp_4 RefrBp_97 GndA 4.56533e-16
ciRefrBp_3 RefrBp_102 GndA 4.57977e-16
ciRefrBp_2 RefrBp_106 GndA 6.69609e-17
ciRefrBp_1 RefrBp_112 GndA 6.65141e-17
ciRefrBp_0 RefrBp_121 GndA 6.85051e-15
ciPrBp_15 xPix[3].MMprBias.g GndA 1.44456e-16
ciPrBp_14 xPix[2].MMprBias.g GndA 1.44666e-16
ciPrBp_13 PrBp_10 GndA 1.32425e-16
ciPrBp_12 PrBp_13 GndA 1.32462e-16
ciPrBp_11 PrBp_16 GndA 4.09841e-16
ciPrBp_10 PrBp_17 GndA 1.70513e-16
ciPrBp_9 PrBp_18 GndA 2.39328e-16
ciPrBp_8 PrBp_35 GndA 6.80664e-15
ciPrBp_7 PrBp_42 GndA 3.44713e-17
ciPrBp_6 PrBp_47 GndA 3.4473e-17
ciPrBp_5 PrBp_51 GndA 1.44423e-16
ciPrBp_4 PrBp_54 GndA 1.44624e-16
ciPrBp_3 PrBp_57 GndA 4.91792e-17
ciPrBp_2 PrBp_60 GndA 5.03778e-17
ciPrBp_1 PrBp_20 GndA 7.91827e-17
ciPrBp_0 PrBp_23 GndA 7.9222e-17
ciPrSFBp_16 PrSFBp_8 GndA 7.96245e-17
ciPrSFBp_15 PrSFBp_17 GndA 6.0801e-16
ciPrSFBp_14 PrSFBp_26 GndA 7.96245e-17
ciPrSFBp_13 PrSFBp_35 GndA 6.0801e-16
ciPrSFBp_12 PrSFBp_38 GndA 3.52086e-16
ciPrSFBp_11 PrSFBp_44 GndA 7.75121e-17
ciPrSFBp_10 PrSFBp_53 GndA 6.10897e-16
ciPrSFBp_9 PrSFBp_56 GndA 3.4384e-16
ciPrSFBp_8 PrSFBp_62 GndA 7.75121e-17
ciPrSFBp_7 PrSFBp_71 GndA 6.10897e-16
ciPrSFBp_6 PrSFBp_96 GndA 1.99891e-16
ciPrSFBp_5 PrSFBp_99 GndA 9.66447e-17
ciPrSFBp_4 PrSFBp_101 GndA 1.99891e-16
ciPrSFBp_3 PrSFBp_104 GndA 1.04904e-16
ciPrSFBp_2 PrSFBp_106 GndA 9.91833e-17
ciPrSFBp_1 PrSFBp_112 GndA 9.91869e-17
ciPrSFBp_0 PrSFBp_121 GndA 6.84281e-15
ciOffBn_74 OffBn_1 GndA 9.06352e-17
ciOffBn_73 OffBn_2 GndA 1.09835e-16
ciOffBn_72 OffBn_5 GndA 2.10951e-16
ciOffBn_71 OffBn_6 GndA 5.83284e-16
ciOffBn_70 OffBn_7 GndA 2.11497e-16
ciOffBn_69 OffBn_9 GndA 4.10206e-17
ciOffBn_68 OffBn_10 GndA 1.30885e-15
ciOffBn_67 OffBn_11 GndA 8.24905e-17
ciOffBn_66 OffBn_17 GndA 1.4869e-16
ciOffBn_65 OffBn_19 GndA 5.86344e-17
ciOffBn_64 OffBn_28 GndA 5.17943e-17
ciOffBn_63 xPix[1].MMoffBias.g GndA 1.20185e-15
ciOffBn_62 OffBn_38 GndA 9.06352e-17
ciOffBn_61 OffBn_39 GndA 1.09835e-16
ciOffBn_60 OffBn_42 GndA 2.33903e-16
ciOffBn_59 OffBn_43 GndA 5.79999e-16
ciOffBn_58 OffBn_44 GndA 1.4785e-16
ciOffBn_57 OffBn_46 GndA 8.08661e-17
ciOffBn_56 OffBn_47 GndA 1.30876e-15
ciOffBn_55 OffBn_48 GndA 4.34251e-17
ciOffBn_54 OffBn_54 GndA 9.26818e-17
ciOffBn_53 OffBn_56 GndA 5.86344e-17
ciOffBn_52 OffBn_65 GndA 5.17905e-17
ciOffBn_51 xPix[0].MMoffBias.g GndA 1.20192e-15
ciOffBn_50 OffBn_76 GndA 1.33435e-16
ciOffBn_49 OffBn_79 GndA 2.09714e-16
ciOffBn_48 OffBn_80 GndA 5.83412e-16
ciOffBn_47 OffBn_81 GndA 2.11105e-16
ciOffBn_46 OffBn_83 GndA 4.10206e-17
ciOffBn_45 OffBn_84 GndA 1.12448e-15
ciOffBn_44 OffBn_85 GndA 4.65821e-17
ciOffBn_43 OffBn_91 GndA 1.48682e-16
ciOffBn_42 OffBn_93 GndA 2.52559e-16
ciOffBn_41 OffBn_102 GndA 5.1962e-17
ciOffBn_40 xPix[3].MMoffBias.g GndA 1.20374e-15
ciOffBn_39 OffBn_113 GndA 1.33435e-16
ciOffBn_38 OffBn_116 GndA 2.31792e-16
ciOffBn_37 OffBn_117 GndA 5.83158e-16
ciOffBn_36 OffBn_118 GndA 1.48027e-16
ciOffBn_35 OffBn_120 GndA 8.08661e-17
ciOffBn_34 OffBn_121 GndA 1.12516e-15
ciOffBn_33 OffBn_122 GndA 6.73651e-18
ciOffBn_32 OffBn_128 GndA 9.31557e-17
ciOffBn_31 OffBn_130 GndA 2.54241e-16
ciOffBn_30 OffBn_139 GndA 5.19582e-17
ciOffBn_29 xPix[2].MMoffBias.g GndA 1.20374e-15
ciOffBn_28 OffBn_177 GndA 2.05277e-17
ciOffBn_27 OffBn_180 GndA 2.05277e-17
ciOffBn_26 OffBn_183 GndA 9.32537e-17
ciOffBn_25 OffBn_186 GndA 9.32537e-17
ciOffBn_24 OffBn_210 GndA 1.00988e-16
ciOffBn_23 OffBn_213 GndA 1.78858e-16
ciOffBn_22 OffBn_215 GndA 1.1028e-16
ciOffBn_21 OffBn_216 GndA 1.70969e-16
ciOffBn_20 OffBn_217 GndA 2.04974e-16
ciOffBn_19 OffBn_218 GndA 2.04974e-16
ciOffBn_18 OffBn_223 GndA 1.77549e-16
ciOffBn_17 OffBn_224 GndA 1.7689e-16
ciOffBn_16 OffBn_225 GndA 1.06928e-16
ciOffBn_15 OffBn_227 GndA 1.06877e-16
ciOffBn_14 OffBn_229 GndA 1.70482e-16
ciOffBn_13 OffBn_230 GndA 1.7646e-16
ciOffBn_12 OffBn_236 GndA 1.18361e-16
ciOffBn_11 OffBn_241 GndA 1.18361e-16
ciOffBn_10 OffBn_244 GndA 1.78815e-16
ciOffBn_9 OffBn_247 GndA 1.73159e-16
ciOffBn_8 OffBn_254 GndA 1.18361e-16
ciOffBn_7 OffBn_259 GndA 1.18361e-16
ciOffBn_6 OffBn_265 GndA 6.82407e-15
ciOffBn_5 OffBn_206 GndA 2.21719e-16
ciOffBn_4 OffBn_212 GndA 2.0081e-16
ciOffBn_3 OffBn_220 GndA 2.21814e-16
ciOffBn_2 OffBn_221 GndA 1.25214e-16
ciOffBn_1 OffBn_231 GndA 1.25308e-16
ciOffBn_0 OffBn_211 GndA 2.0081e-16
ciDiffBn_48 DiffBn_1 GndA 9.66932e-17
ciDiffBn_47 DiffBn_2 GndA 1.41729e-16
ciDiffBn_46 DiffBn_5 GndA 3.05141e-17
ciDiffBn_45 DiffBn_6 GndA 2.35943e-16
ciDiffBn_44 DiffBn_7 GndA 1.92544e-16
ciDiffBn_43 DiffBn_9 GndA 4.22933e-16
ciDiffBn_42 DiffBn_18 GndA 2.01534e-17
ciDiffBn_41 xPix[1].MMchAmpBias.g GndA 9.49826e-16
ciDiffBn_40 DiffBn_26 GndA 2.46961e-16
ciDiffBn_39 DiffBn_30 GndA 1.0404e-16
ciDiffBn_38 DiffBn_31 GndA 1.41729e-16
ciDiffBn_37 DiffBn_34 GndA 6.27252e-17
ciDiffBn_36 DiffBn_35 GndA 2.36901e-16
ciDiffBn_35 DiffBn_38 GndA 4.22496e-16
ciDiffBn_34 DiffBn_47 GndA 1.99392e-17
ciDiffBn_33 xPix[0].MMchAmpBias.g GndA 9.78155e-16
ciDiffBn_32 DiffBn_55 GndA 2.22903e-16
ciDiffBn_31 DiffBn_60 GndA 9.72415e-17
ciDiffBn_30 DiffBn_76 GndA 2.01534e-17
ciDiffBn_29 xPix[3].MMchAmpBias.g GndA 9.49878e-16
ciDiffBn_28 DiffBn_84 GndA 2.46973e-16
ciDiffBn_27 DiffBn_89 GndA 9.72415e-17
ciDiffBn_26 DiffBn_105 GndA 1.99392e-17
ciDiffBn_25 xPix[2].MMchAmpBias.g GndA 9.79272e-16
ciDiffBn_24 DiffBn_113 GndA 2.23079e-16
ciDiffBn_23 DiffBn_139 GndA 1.28904e-16
ciDiffBn_22 DiffBn_143 GndA 1.28904e-16
ciDiffBn_21 DiffBn_151 GndA 1.41266e-16
ciDiffBn_20 DiffBn_154 GndA 1.48531e-16
ciDiffBn_19 DiffBn_159 GndA 1.29309e-16
ciDiffBn_18 DiffBn_163 GndA 1.29309e-16
ciDiffBn_17 DiffBn_173 GndA 4.99017e-16
ciDiffBn_16 DiffBn_174 GndA 6.89744e-16
ciDiffBn_15 DiffBn_187 GndA 4.94459e-16
ciDiffBn_14 DiffBn_188 GndA 4.94459e-16
ciDiffBn_13 DiffBn GndA 7.37752e-17
ciDiffBn_12 DiffBn GndA 2.01857e-16
ciDiffBn_11 DiffBn_202 GndA 5.83579e-16
ciDiffBn_10 DiffBn_204 GndA 6.33513e-17
ciDiffBn_9 DiffBn_206 GndA 2.44745e-16
ciDiffBn_8 DiffBn_208 GndA 2.33385e-16
ciDiffBn_7 DiffBn_210 GndA 1.21756e-16
ciDiffBn_6 DiffBn_214 GndA 1.26585e-16
ciDiffBn_5 DiffBn_222 GndA 2.52029e-15
ciDiffBn_4 DiffBn_224 GndA 6.32277e-17
ciDiffBn_3 DiffBn_226 GndA 2.32972e-15
ciDiffBn_2 DiffBn_228 GndA 1.9131e-16
ciDiffBn_1 DiffBn_233 GndA 6.31467e-15
ciDiffBn_0 DiffBn_36 GndA 1.95587e-16
cipixRst[0]_12 pixRst[0]_3 GndA 1.80625e-16
cipixRst[0]_11 pixRst[0]_6 GndA 1.00652e-16
cipixRst[0]_10 pixRst[0]_13 GndA 2.02866e-16
cipixRst[0]_9 pixRst[0]_15 GndA 6.16203e-15
cipixRst[0]_8 pixRst[0]_17 GndA 4.07171e-17
cipixRst[0]_7 pixRst[0]_21 GndA 1.26146e-16
cipixRst[0]_6 pixRst[0]_26 GndA 8.28098e-17
cipixRst[0]_5 pixRst[0]_30 GndA 1.80625e-16
cipixRst[0]_4 pixRst[0]_33 GndA 1.00652e-16
cipixRst[0]_3 pixRst[0]_40 GndA 2.03041e-16
cipixRst[0]_2 pixRst[0]_44 GndA 4.07171e-17
cipixRst[0]_1 pixRst[0]_48 GndA 1.26146e-16
cipixRst[0]_0 pixRst[0]_53 GndA 8.28098e-17
cireadLine[0]_24 readLine[0]_6 GndA 7.63144e-17
cireadLine[0]_23 readLine[0]_8 GndA 9.49693e-17
cireadLine[0]_22 readLine[0]_11 GndA 1.35234e-16
cireadLine[0]_21 readLine[0]_14 GndA 1.6023e-17
cireadLine[0]_20 readLine[0]_15 GndA 1.88066e-16
cireadLine[0]_19 readLine[0]_16 GndA 7.15469e-17
cireadLine[0]_18 readLine[0]_18 GndA 5.04859e-17
cireadLine[0]_17 readLine[0]_20 GndA 8.56023e-17
cireadLine[0]_16 readLine[0]_24 GndA 3.12183e-16
cireadLine[0]_15 readLine[0]_27 GndA 9.35083e-17
cireadLine[0]_14 readLine[0]_28 GndA 1.02003e-16
cireadLine[0]_13 readLine[0]_30 GndA 5.90787e-15
cireadLine[0]_12 xPix[1].MMN10.d GndA 3.78807e-17
cireadLine[0]_11 readLine[0]_43 GndA 7.63144e-17
cireadLine[0]_10 readLine[0]_45 GndA 9.49693e-17
cireadLine[0]_9 readLine[0]_48 GndA 1.35234e-16
cireadLine[0]_8 readLine[0]_51 GndA 2.05103e-17
cireadLine[0]_7 readLine[0]_52 GndA 1.7895e-16
cireadLine[0]_6 readLine[0]_53 GndA 6.42689e-17
cireadLine[0]_5 readLine[0]_55 GndA 3.63712e-17
cireadLine[0]_4 readLine[0]_57 GndA 1.08241e-16
cireadLine[0]_3 readLine[0]_61 GndA 3.15306e-16
cireadLine[0]_2 readLine[0]_64 GndA 9.35083e-17
cireadLine[0]_1 readLine[0]_65 GndA 1.02003e-16
cireadLine[0]_0 xPix[0].MMN10.d GndA 3.78807e-17
ciVddA18_135 xPix[1].MMon.b GndA 2.16955e-16
ciVddA18_134 VddA18_9 GndA 5.73209e-16
ciVddA18_133 VddA18_22 GndA 1.23048e-16
ciVddA18_132 VddA18_31 GndA 2.07321e-16
ciVddA18_131 VddA18_33 GndA 3.00826e-16
ciVddA18_130 VddA18_57 GndA 3.49937e-16
ciVddA18_129 VddA18_60 GndA 4.34493e-16
ciVddA18_128 xPix[1].MMpd.d GndA 3.53459e-17
ciVddA18_127 xPix[1].MMon.s GndA 1.31762e-16
ciVddA18_126 xPix[1].MMcapRef.s GndA 4.36789e-16
ciVddA18_125 xPix[1].MMprBias.s GndA 4.94535e-17
ciVddA18_124 xPix[1].MMrefrBias.s GndA 2.79469e-17
ciVddA18_123 xPix[1].MMP0.s GndA 3.69136e-17
ciVddA18_122 xPix[0].MMon.b GndA 2.18739e-16
ciVddA18_121 VddA18_124 GndA 1.32035e-16
ciVddA18_120 VddA18_127 GndA 5.73347e-16
ciVddA18_119 VddA18_135 GndA 2.67452e-16
ciVddA18_118 VddA18_137 GndA 2.31267e-15
ciVddA18_117 VddA18_140 GndA 1.24196e-16
ciVddA18_116 VddA18_149 GndA 2.16175e-16
ciVddA18_115 VddA18_151 GndA 2.9128e-16
ciVddA18_114 VddA18_175 GndA 3.29719e-16
ciVddA18_113 VddA18_178 GndA 4.37819e-16
ciVddA18_112 xPix[0].MMpd.d GndA 3.52355e-17
ciVddA18_111 xPix[0].MMon.s GndA 1.31762e-16
ciVddA18_110 xPix[0].MMcapRef.s GndA 4.36789e-16
ciVddA18_109 xPix[0].MMprBias.s GndA 4.94564e-17
ciVddA18_108 xPix[0].MMchAmp.s GndA 1.10465e-16
ciVddA18_107 xPix[0].MMrefrBias.s GndA 2.79469e-17
ciVddA18_106 xPix[0].MMP0.s GndA 3.69136e-17
ciVddA18_105 xPix[3].MMon.b GndA 2.16955e-16
ciVddA18_104 VddA18_245 GndA 5.73211e-16
ciVddA18_103 VddA18_258 GndA 1.2421e-16
ciVddA18_102 VddA18_262 GndA 1.86793e-15
ciVddA18_101 VddA18_267 GndA 2.0736e-16
ciVddA18_100 VddA18_269 GndA 3.00727e-16
ciVddA18_99 VddA18_293 GndA 3.50187e-16
ciVddA18_98 VddA18_296 GndA 4.34492e-16
ciVddA18_97 VddA18_305 GndA 1.53063e-15
ciVddA18_96 VddA18_306 GndA 2.85379e-15
ciVddA18_95 xPix[3].MMpd.d GndA 3.53459e-17
ciVddA18_94 xPix[3].MMon.s GndA 1.31762e-16
ciVddA18_93 xPix[3].MMprBias.s GndA 4.94564e-17
ciVddA18_92 xPix[2].MMon.b GndA 2.18739e-16
ciVddA18_91 VddA18_360 GndA 1.32035e-16
ciVddA18_90 VddA18_363 GndA 5.73349e-16
ciVddA18_89 VddA18_371 GndA 2.67452e-16
ciVddA18_88 VddA18_376 GndA 1.24196e-16
ciVddA18_87 VddA18_380 GndA 1.86793e-15
ciVddA18_86 VddA18_385 GndA 2.16397e-16
ciVddA18_85 VddA18_387 GndA 2.91066e-16
ciVddA18_84 VddA18_411 GndA 3.34008e-16
ciVddA18_83 VddA18_414 GndA 4.37819e-16
ciVddA18_82 VddA18_423 GndA 1.5191e-15
ciVddA18_81 VddA18_425 GndA 2.84762e-15
ciVddA18_80 xPix[2].MMpd.d GndA 3.52355e-17
ciVddA18_79 xPix[2].MMon.s GndA 1.31762e-16
ciVddA18_78 xPix[2].MMprBias.s GndA 4.94564e-17
ciVddA18_77 VddA18_586 GndA 7.39208e-17
ciVddA18_76 VddA18_587 GndA 7.62353e-17
ciVddA18_75 VddA18_592 GndA 1.76989e-16
ciVddA18_74 VddA18_594 GndA 1.14286e-16
ciVddA18_73 VddA18_595 GndA 2.93936e-15
ciVddA18_72 VddA18_600 GndA 1.16912e-16
ciVddA18_71 VddA18_602 GndA 9.94754e-17
ciVddA18_70 VddA18_606 GndA 7.2037e-17
ciVddA18_69 VddA18_610 GndA 1.72346e-16
ciVddA18_68 VddA18_612 GndA 1.3047e-16
ciVddA18_67 VddA18_615 GndA 3.8107e-16
ciVddA18_66 VddA18_617 GndA 3.8107e-16
ciVddA18_65 VddA18_618 GndA 1.18841e-16
ciVddA18_64 VddA18_619 GndA 1.22365e-16
ciVddA18_63 VddA18_622 GndA 2.49292e-16
ciVddA18_62 VddA18_628 GndA 2.49292e-16
ciVddA18_61 VddA18_634 GndA 1.58824e-16
ciVddA18_60 VddA18_638 GndA 1.58824e-16
ciVddA18_59 VddA18_641 GndA 3.37435e-16
ciVddA18_58 VddA18_643 GndA 4.0505e-16
ciVddA18_57 VddA18_650 GndA 1.16494e-16
ciVddA18_56 VddA18_658 GndA 1.14286e-16
ciVddA18_55 VddA18_660 GndA 1.76989e-16
ciVddA18_54 VddA18_661 GndA 2.93936e-15
ciVddA18_53 VddA18_680 GndA 2.0358e-15
ciVddA18_52 VddA18_698 GndA 1.06548e-15
ciVddA18_51 VddA18_717 GndA 5.06708e-17
ciVddA18_50 VddA18_718 GndA 9.37176e-17
ciVddA18_49 VddA18_725 GndA 1.44264e-16
ciVddA18_48 VddA18_727 GndA 1.44264e-16
ciVddA18_47 VddA18_728 GndA 2.36225e-17
ciVddA18_46 VddA18_729 GndA 3.03674e-18
ciVddA18_45 VddA18_730 GndA 3.03836e-18
ciVddA18_44 VddA18_731 GndA 4.33827e-18
ciVddA18_43 VddA18_733 GndA 1.51614e-16
ciVddA18_42 VddA18_734 GndA 2.13975e-16
ciVddA18_41 VddA18_736 GndA 8.36437e-17
ciVddA18_40 VddA18_737 GndA 1.66728e-16
ciVddA18_39 VddA18_739 GndA 1.06548e-15
ciVddA18_38 VddA18_755 GndA 2.0358e-15
ciVddA18_37 VddA18_771 GndA 2.31273e-15
ciVddA18_36 VddA18_776 GndA 4.46177e-16
ciVddA18_35 VddA18_777 GndA 4.46177e-16
ciVddA18_34 VddA18_786 GndA 6.40103e-17
ciVddA18_33 VddA18_787 GndA 5.0898e-16
ciVddA18_32 VddA18_805 GndA 1.57531e-16
ciVddA18_31 VddA18_806 GndA 6.73942e-16
ciVddA18_30 VddA18_822 GndA 4.46988e-16
ciVddA18_29 VddA18_823 GndA 4.46988e-16
ciVddA18_28 VddA18_824 GndA 8.68363e-16
ciVddA18_27 VddA18_825 GndA 4.90859e-16
ciVddA18_26 VddA18_826 GndA 3.368e-16
ciVddA18_25 VddA18_827 GndA 2.44927e-16
ciVddA18_24 VddA18_830 GndA 7.18751e-16
ciVddA18_23 VddA18_834 GndA 7.17264e-16
ciVddA18_22 VddA18_840 GndA 1.5753e-16
ciVddA18_21 VddA18_841 GndA 8.47206e-16
ciVddA18_20 VddA18_859 GndA 6.41088e-17
ciVddA18_19 VddA18_860 GndA 6.07777e-16
ciVddA18_18 VddA18 GndA 2.00951e-15
ciVddA18_17 VddA18 GndA 1.30898e-15
ciVddA18_16 VddA18_886 GndA 1.31164e-15
ciVddA18_15 VddA18_887 GndA 2.16425e-15
ciVddA18_14 VddA18_895 GndA 1.20192e-16
ciVddA18_13 VddA18_896 GndA 1.20192e-16
ciVddA18_12 VddA18_903 GndA 3.16804e-16
ciVddA18_11 VddA18_904 GndA 1.42004e-16
ciVddA18_10 VddA18_911 GndA 1.53057e-15
ciVddA18_9 VddA18_916 GndA 1.51555e-15
ciVddA18_8 VddA18_922 GndA 2.37705e-15
ciVddA18_7 VddA18_924 GndA 1.88204e-15
ciVddA18_6 VddA18_926 GndA 1.89063e-15
ciVddA18_5 VddA18_928 GndA 2.37569e-15
ciVddA18_4 VddA18 GndA 6.45537e-16
ciVddA18_3 VddA18_958 GndA 3.12772e-14
ciVddA18_2 VddA18 GndA 6.24618e-16
ciVddA18_1 VddA18_995 GndA 1.10465e-16
ciVddA18_0 VddA18_720 GndA 3.00802e-15
ciGndA_228 GndA_17 GndA 1.54803e-15
ciGndA_227 GndA_48 GndA 2.91571e-16
ciGndA_226 GndA_49 GndA 1.46097e-16
ciGndA_225 GndA_52 GndA 5.9392e-17
ciGndA_224 GndA_56 GndA 1.37767e-16
ciGndA_223 GndA_61 GndA 6.40845e-17
ciGndA_222 GndA_64 GndA 5.88271e-17
ciGndA_221 GndA_69 GndA 1.35003e-16
ciGndA_220 GndA_74 GndA 1.22954e-16
ciGndA_219 GndA_79 GndA 9.64111e-16
ciGndA_218 GndA_93 GndA 6.45863e-17
ciGndA_217 GndA_95 GndA 7.59825e-17
ciGndA_216 GndA_102 GndA 4.04318e-16
ciGndA_215 GndA_104 GndA 6.35315e-17
ciGndA_214 GndA_110 GndA 4.37558e-16
ciGndA_213 GndA_116 GndA 2.62973e-16
ciGndA_212 GndA_119 GndA 2.87198e-17
ciGndA_211 GndA_122 GndA 1.56142e-16
ciGndA_210 GndA_130 GndA 1.24096e-16
ciGndA_209 GndA_136 GndA 8.80053e-17
ciGndA_208 GndA_143 GndA 1.23763e-17
ciGndA_207 GndA_147 GndA 8.60895e-16
ciGndA_206 GndA_152 GndA 1.67972e-16
ciGndA_205 GndA_157 GndA 1.05272e-16
ciGndA_204 GndA_159 GndA 1.16905e-15
ciGndA_203 GndA_185 GndA 3.32801e-16
ciGndA_202 GndA_189 GndA 1.20031e-16
ciGndA_201 GndA_191 GndA 3.27777e-16
ciGndA_200 GndA_195 GndA 7.36315e-17
ciGndA_199 GndA_201 GndA 4.83768e-16
ciGndA_198 GndA_207 GndA 1.58191e-16
ciGndA_197 GndA_222 GndA 3.02896e-16
ciGndA_196 GndA_224 GndA 8.13836e-16
ciGndA_195 GndA_279 GndA 7.33352e-16
ciGndA_194 GndA_280 GndA 5.54867e-17
ciGndA_193 GndA_307 GndA 5.4928e-16
ciGndA_192 GndA_355 GndA 3.45878e-16
ciGndA_191 xPix[1].MMoffBias.s GndA 1.02724e-16
ciGndA_190 xPix[1].MMonBias.s GndA 1.0303e-16
ciGndA_189 xPix[1].MMchAmpBias.s GndA 1.11764e-16
ciGndA_188 xPix[1].MMPDRefrRow.s GndA 3.2049e-17
ciGndA_187 xPix[1].MMpr.amp.s GndA 3.31389e-17
ciGndA_186 xPix[1].MMsf.d GndA 4.66244e-17
ciGndA_185 GndA_381 GndA 3.16148e-14
ciGndA_184 GndA_397 GndA 1.4935e-15
ciGndA_183 GndA_411 GndA 1.4196e-16
ciGndA_182 GndA_428 GndA 2.91571e-16
ciGndA_181 GndA_429 GndA 1.42544e-16
ciGndA_180 GndA_432 GndA 5.9392e-17
ciGndA_179 GndA_436 GndA 1.63447e-16
ciGndA_178 GndA_441 GndA 8.08815e-17
ciGndA_177 GndA_444 GndA 6.52682e-17
ciGndA_176 GndA_449 GndA 1.19327e-16
ciGndA_175 GndA_454 GndA 1.22954e-16
ciGndA_174 GndA_459 GndA 8.26914e-16
ciGndA_173 GndA_473 GndA 1.82778e-17
ciGndA_172 GndA_475 GndA 2.56342e-16
ciGndA_171 GndA_482 GndA 4.0319e-16
ciGndA_170 GndA_484 GndA 6.35315e-17
ciGndA_169 GndA_490 GndA 4.37558e-16
ciGndA_168 GndA_496 GndA 2.58545e-16
ciGndA_167 GndA_499 GndA 2.87198e-17
ciGndA_166 GndA_502 GndA 1.60044e-16
ciGndA_165 GndA_510 GndA 9.45316e-17
ciGndA_164 GndA_516 GndA 6.47893e-17
ciGndA_163 GndA_523 GndA 1.24745e-17
ciGndA_162 GndA_532 GndA 1.67972e-16
ciGndA_161 GndA_537 GndA 1.13844e-16
ciGndA_160 GndA_539 GndA 1.17586e-15
ciGndA_159 GndA_565 GndA 3.32376e-16
ciGndA_158 GndA_569 GndA 1.18252e-16
ciGndA_157 GndA_571 GndA 2.58021e-16
ciGndA_156 GndA_575 GndA 1.43388e-16
ciGndA_155 GndA_581 GndA 4.8359e-16
ciGndA_154 GndA_587 GndA 1.58191e-16
ciGndA_153 GndA_602 GndA 3.68767e-16
ciGndA_152 GndA_604 GndA 8.26282e-16
ciGndA_151 GndA_659 GndA 7.8645e-16
ciGndA_150 GndA_660 GndA 5.54867e-17
ciGndA_149 GndA_687 GndA 5.4928e-16
ciGndA_148 GndA_735 GndA 3.45894e-16
ciGndA_147 xPix[0].MMoffBias.s GndA 1.02724e-16
ciGndA_146 xPix[0].MMonBias.s GndA 1.0303e-16
ciGndA_145 xPix[0].MMchAmpBias.s GndA 1.11764e-16
ciGndA_144 xPix[0].MMPDRefrRow.s GndA 3.2049e-17
ciGndA_143 xPix[0].MMpr.amp.s GndA 3.44749e-17
ciGndA_142 xPix[0].MMsf.d GndA 4.65789e-17
ciGndA_141 GndA_777 GndA 1.54816e-15
ciGndA_140 GndA_808 GndA 2.91571e-16
ciGndA_139 GndA_809 GndA 1.4604e-16
ciGndA_138 GndA_812 GndA 5.9392e-17
ciGndA_137 GndA_816 GndA 1.32525e-16
ciGndA_136 GndA_821 GndA 6.07787e-17
ciGndA_135 GndA_824 GndA 5.67793e-17
ciGndA_134 GndA_829 GndA 1.35421e-16
ciGndA_133 GndA_834 GndA 1.22977e-16
ciGndA_132 GndA_839 GndA 1.09617e-15
ciGndA_131 GndA_853 GndA 6.70425e-17
ciGndA_130 GndA_855 GndA 6.58146e-17
ciGndA_129 GndA_862 GndA 4.04318e-16
ciGndA_128 GndA_864 GndA 3.01571e-17
ciGndA_127 GndA_870 GndA 4.72685e-16
ciGndA_126 GndA_876 GndA 2.62974e-16
ciGndA_125 GndA_879 GndA 2.87198e-17
ciGndA_124 GndA_882 GndA 1.56123e-16
ciGndA_123 GndA_890 GndA 1.22223e-16
ciGndA_122 GndA_896 GndA 8.81006e-17
ciGndA_121 GndA_903 GndA 1.23269e-17
ciGndA_120 GndA_905 GndA 8.60914e-16
ciGndA_119 GndA_912 GndA 1.7814e-16
ciGndA_118 GndA_916 GndA 2.30604e-16
ciGndA_117 GndA_917 GndA 6.47851e-17
ciGndA_116 GndA_919 GndA 1.17706e-15
ciGndA_115 GndA_945 GndA 1.98858e-16
ciGndA_114 GndA_949 GndA 3.90743e-16
ciGndA_113 GndA_951 GndA 4.28505e-16
ciGndA_112 GndA_955 GndA 7.36315e-17
ciGndA_111 GndA_961 GndA 3.87657e-16
ciGndA_110 GndA_967 GndA 6.32676e-17
ciGndA_109 GndA_982 GndA 2.9993e-16
ciGndA_108 GndA_986 GndA 8.15295e-16
ciGndA_107 GndA_1039 GndA 7.52665e-16
ciGndA_106 GndA_1040 GndA 3.53147e-17
ciGndA_105 GndA_1067 GndA 5.49245e-16
ciGndA_104 GndA_1115 GndA 3.45861e-16
ciGndA_103 xPix[3].MMoffBias.s GndA 1.02773e-16
ciGndA_102 xPix[3].MMonBias.s GndA 1.03141e-16
ciGndA_101 xPix[3].MMchAmpBias.s GndA 1.11803e-16
ciGndA_100 xPix[3].MMPDRefrRow.s GndA 3.2049e-17
ciGndA_99 xPix[3].MMpr.amp.s GndA 3.31389e-17
ciGndA_98 xPix[3].MMsf.d GndA 4.65859e-17
ciGndA_97 GndA_1157 GndA 1.49362e-15
ciGndA_96 GndA_1171 GndA 1.4196e-16
ciGndA_95 GndA_1188 GndA 2.91571e-16
ciGndA_94 GndA_1189 GndA 1.42486e-16
ciGndA_93 GndA_1192 GndA 5.9392e-17
ciGndA_92 GndA_1196 GndA 1.65094e-16
ciGndA_91 GndA_1201 GndA 8.03196e-17
ciGndA_90 GndA_1204 GndA 6.32203e-17
ciGndA_89 GndA_1209 GndA 1.19805e-16
ciGndA_88 GndA_1214 GndA 1.22977e-16
ciGndA_87 GndA_1219 GndA 9.46851e-16
ciGndA_86 GndA_1233 GndA 2.23217e-17
ciGndA_85 GndA_1235 GndA 2.59855e-16
ciGndA_84 GndA_1242 GndA 4.0319e-16
ciGndA_83 GndA_1244 GndA 3.01571e-17
ciGndA_82 GndA_1250 GndA 4.72685e-16
ciGndA_81 GndA_1256 GndA 2.58545e-16
ciGndA_80 GndA_1259 GndA 2.87198e-17
ciGndA_79 GndA_1262 GndA 1.56123e-16
ciGndA_78 GndA_1270 GndA 9.31717e-17
ciGndA_77 GndA_1276 GndA 6.21186e-17
ciGndA_76 GndA_1283 GndA 1.23269e-17
ciGndA_75 GndA_1287 GndA 7.01391e-16
ciGndA_74 GndA_1292 GndA 1.7814e-16
ciGndA_73 GndA_1296 GndA 2.30622e-16
ciGndA_72 GndA_1297 GndA 7.33572e-17
ciGndA_71 GndA_1299 GndA 1.18327e-15
ciGndA_70 GndA_1329 GndA 3.89652e-16
ciGndA_69 GndA_1331 GndA 3.58748e-16
ciGndA_68 GndA_1335 GndA 1.43388e-16
ciGndA_67 GndA_1341 GndA 3.90116e-16
ciGndA_66 GndA_1347 GndA 6.32676e-17
ciGndA_65 GndA_1362 GndA 3.68563e-16
ciGndA_64 GndA_1366 GndA 8.25933e-16
ciGndA_63 GndA_1419 GndA 8.04517e-16
ciGndA_62 GndA_1420 GndA 3.53147e-17
ciGndA_61 GndA_1447 GndA 5.49245e-16
ciGndA_60 GndA_1495 GndA 3.45894e-16
ciGndA_59 xPix[2].MMoffBias.s GndA 1.02773e-16
ciGndA_58 xPix[2].MMonBias.s GndA 1.03141e-16
ciGndA_57 xPix[2].MMchAmpBias.s GndA 1.11803e-16
ciGndA_56 xPix[2].MMPDRefrRow.s GndA 3.2049e-17
ciGndA_55 xPix[2].MMpr.amp.s GndA 3.44749e-17
ciGndA_54 xPix[2].MMsf.d GndA 4.65859e-17
ciGndA_53 GndA_1674 GndA 9.46372e-17
ciGndA_52 GndA_1675 GndA 1.57386e-16
ciGndA_51 GndA_1676 GndA 4.83417e-16
ciGndA_50 GndA_1677 GndA 1.57386e-16
ciGndA_49 GndA_1678 GndA 4.83417e-16
ciGndA_48 GndA_1680 GndA 9.46372e-17
ciGndA_47 GndA_1681 GndA 1.94881e-16
ciGndA_46 GndA_1683 GndA 7.52272e-16
ciGndA_45 GndA_1685 GndA 1.34044e-16
ciGndA_44 GndA_1687 GndA 1.27502e-16
ciGndA_43 GndA_1690 GndA 8.4143e-16
ciGndA_42 GndA_1693 GndA 4.76091e-16
ciGndA_41 GndA_1695 GndA 2.23106e-16
ciGndA_40 GndA_1696 GndA 2.77521e-16
ciGndA_39 GndA_1697 GndA 1.77004e-16
ciGndA_38 GndA_1698 GndA 3.2369e-16
ciGndA_37 GndA_1700 GndA 8.41625e-16
ciGndA_36 GndA_1703 GndA 4.76069e-16
ciGndA_35 GndA_1705 GndA 1.34044e-16
ciGndA_34 GndA_1707 GndA 1.27502e-16
ciGndA_33 GndA_1709 GndA 7.52272e-16
ciGndA_32 GndA_1711 GndA 1.94881e-16
ciGndA_31 GndA_1713 GndA 1.32816e-17
ciGndA_30 GndA_1714 GndA 3.6274e-17
ciGndA_29 GndA_1743 GndA 7.0302e-16
ciGndA_28 GndA_1753 GndA 3.6274e-17
ciGndA_27 GndA_1782 GndA 1.32816e-17
ciGndA_26 GndA_1791 GndA 8.98898e-17
ciGndA_25 GndA_1792 GndA 5.12192e-16
ciGndA_24 GndA_1801 GndA 4.7602e-16
ciGndA_23 GndA_1802 GndA 6.82429e-16
ciGndA_22 GndA_1823 GndA 5.88236e-17
ciGndA_21 GndA_1824 GndA 5.82626e-16
ciGndA_20 GndA_1838 GndA 1.40199e-16
ciGndA_19 GndA_1839 GndA 1.05342e-15
ciGndA_18 GndA GndA 2.994e-16
ciGndA_17 GndA GndA 5.025e-16
ciGndA_16 GndA_1862 GndA 2.99405e-16
ciGndA_15 GndA_1868 GndA 5.44192e-16
ciGndA_14 GndA_1874 GndA 1.52628e-16
ciGndA_13 GndA_1876 GndA 3.49858e-16
ciGndA_12 GndA_1878 GndA 2.78824e-15
ciGndA_11 GndA_1880 GndA 3.84304e-15
ciGndA_10 GndA_1881 GndA 1.14288e-16
ciGndA_9 GndA_1882 GndA 2.57275e-16
ciGndA_8 GndA_1925 GndA 2.16522e-15
ciGndA_7 GndA_1928 GndA 2.16559e-15
ciGndA_6 GndA_1931 GndA 2.94931e-15
ciGndA_5 GndA_1934 GndA 2.95049e-15
ciGndA_4 GndA_1937 GndA 2.17853e-15
ciGndA_3 GndA_1940 GndA 2.1778e-15
ciGndA_2 GndA_1950 GndA 9.17258e-15
ciGndA_1 GndA_1955 GndA 9.31246e-15
ciGndA_0 GndA_1325 GndA 1.97495e-16
cixPix[2].nOFF.18 xPix[2].nOFF.1 GndA 2.31506e-16
cixPix[2].nOFF.17 xPix[2].nOFF.3 GndA 6.60379e-17
cixPix[2].nOFF.16 xPix[2].nOFF.9 GndA 2.57643e-16
cixPix[2].nOFF.15 xPix[2].nOFF.10 GndA 1.52969e-16
cixPix[2].nOFF.14 xPix[2].nOFF.15 GndA 1.14834e-16
cixPix[2].nOFF.13 xPix[2].nOFF.17 GndA 3.19186e-16
cixPix[2].nOFF.12 xPix[2].nOFF.19 GndA 7.61759e-16
cixPix[2].nOFF.11 xPix[2].nOFF.23 GndA 3.73859e-16
cixPix[2].nOFF.10 xPix[2].nOFF.25 GndA 4.75419e-16
cixPix[2].nOFF.9 xPix[2].nOFF.26 GndA 8.94425e-17
cixPix[2].nOFF.8 xPix[2].nOFF.32 GndA 9.16284e-17
cixPix[2].nOFF.7 xPix[2].nOFF.34 GndA 8.04211e-17
cixPix[2].nOFF.6 xPix[2].nOFF.46 GndA 4.71047e-17
cixPix[2].nOFF.5 xPix[2].nOFF.57 GndA 1.92061e-16
cixPix[2].nOFF.4 xPix[2].nOFF.60 GndA 5.86653e-17
cixPix[2].nOFF.3 xPix[2].MMN8.g GndA 1.34765e-16
cixPix[2].nOFF.2 xPix[2].nOFF.70 GndA 8.01573e-17
cixPix[2].nOFF.1 xPix[2].MMoffBias.d GndA 2.02098e-16
cixPix[2].nOFF.0 xPix[2].nOFF GndA 1.63732e-16
cixPix[2].VPR.22 xPix[2].VPR.2 GndA 3.22e-17
cixPix[2].VPR.21 xPix[2].VPR.4 GndA 1.65178e-16
cixPix[2].VPR.20 xPix[2].VPR.7 GndA 6.20053e-17
cixPix[2].VPR.19 xPix[2].VPR.8 GndA 3.13302e-17
cixPix[2].VPR.18 xPix[2].VPR.12 GndA 1.01638e-16
cixPix[2].VPR.17 xPix[2].VPR.17 GndA 1.01248e-16
cixPix[2].VPR.16 xPix[2].VPR.20 GndA 1.61543e-16
cixPix[2].VPR.15 xPix[2].VPR.26 GndA 1.84505e-16
cixPix[2].VPR.14 xPix[2].VPR.30 GndA 8.08283e-17
cixPix[2].VPR.13 xPix[2].VPR.31 GndA 1.68946e-16
cixPix[2].VPR.12 xPix[2].VPR.34 GndA 1.27071e-16
cixPix[2].VPR.11 xPix[2].VPR.40 GndA 9.71517e-16
cixPix[2].VPR.10 xPix[2].VPR.44 GndA 1.29004e-16
cixPix[2].VPR.9 xPix[2].VPR.52 GndA 3.92824e-16
cixPix[2].VPR.8 xPix[2].VPR.53 GndA 5.29161e-17
cixPix[2].VPR.7 xPix[2].VPR.60 GndA 2.14328e-17
cixPix[2].VPR.6 xPix[2].VPR.65 GndA 1.9619e-17
cixPix[2].VPR.5 xPix[2].VPR.75 GndA 2.32875e-16
cixPix[2].VPR.4 xPix[2].VPR.80 GndA 5.66419e-17
cixPix[2].VPR.3 xPix[2].MMsf.g GndA 1.93932e-16
cixPix[2].VPR.2 xPix[2].MMpr.amp.d GndA 4.04305e-17
cixPix[2].VPR.1 xPix[2].VPR GndA 5.63415e-17
cixPix[2].VPR.0 xPix[2].VPR.49 GndA 8.37701e-17
cixPix[2].nRst.27 xPix[2].nRst.3 GndA 8.73807e-17
cixPix[2].nRst.26 xPix[2].nRst.5 GndA 2.33554e-16
cixPix[2].nRst.25 xPix[2].nRst.7 GndA 2.70228e-16
cixPix[2].nRst.24 xPix[2].nRst.10 GndA 8.26701e-16
cixPix[2].nRst.23 xPix[2].nRst.12 GndA 3.67745e-16
cixPix[2].nRst.22 xPix[2].nRst.13 GndA 1.90167e-16
cixPix[2].nRst.21 xPix[2].nRst.14 GndA 4.32266e-17
cixPix[2].nRst.20 xPix[2].nRst.16 GndA 1.02367e-16
cixPix[2].nRst.19 xPix[2].nRst.18 GndA 3.16664e-17
cixPix[2].nRst.18 xPix[2].nRst.20 GndA 3.88369e-16
cixPix[2].nRst.17 xPix[2].nRst.21 GndA 2.16067e-16
cixPix[2].nRst.16 xPix[2].nRst.22 GndA 1.52091e-16
cixPix[2].nRst.15 xPix[2].nRst.28 GndA 1.95685e-16
cixPix[2].nRst.14 xPix[2].nRst.32 GndA 1.17056e-16
cixPix[2].nRst.13 xPix[2].nRst.36 GndA 9.86152e-17
cixPix[2].nRst.12 xPix[2].nRst.41 GndA 7.70097e-17
cixPix[2].nRst.11 xPix[2].nRst.44 GndA 4.11932e-17
cixPix[2].nRst.10 xPix[2].nRst.49 GndA 1.19534e-16
cixPix[2].nRst.9 xPix[2].nRst.55 GndA 7.03576e-17
cixPix[2].nRst.8 xPix[2].nRst.56 GndA 1.25802e-15
cixPix[2].nRst.7 xPix[2].nRst.74 GndA 1.03672e-16
cixPix[2].nRst.6 xPix[2].nRst.77 GndA 1.66805e-17
cixPix[2].nRst.5 xPix[2].MMcapRef.g GndA 1.29045e-15
cixPix[2].nRst.4 xPix[2].nRst.89 GndA 2.68969e-16
cixPix[2].nRst.3 xPix[2].MMPDrefrCol.d GndA 4.01105e-17
cixPix[2].nRst.2 xPix[2].nRst GndA 3.92213e-17
cixPix[2].nRst.1 xPix[2].nRst.25 GndA 1.16441e-16
cixPix[2].nRst.0 xPix[2].nRst.23 GndA 3.37434e-18
cixPix[2].ON.20 xPix[2].ON.2 GndA 8.43357e-17
cixPix[2].ON.19 xPix[2].ON.5 GndA 2.88302e-16
cixPix[2].ON.18 xPix[2].ON.9 GndA 1.9307e-16
cixPix[2].ON.17 xPix[2].ON.13 GndA 1.54758e-16
cixPix[2].ON.16 xPix[2].ON.16 GndA 4.40345e-17
cixPix[2].ON.15 xPix[2].ON.17 GndA 3.48965e-16
cixPix[2].ON.14 xPix[2].ON.18 GndA 4.73079e-17
cixPix[2].ON.13 xPix[2].ON.21 GndA 2.72034e-16
cixPix[2].ON.12 xPix[2].ON.24 GndA 1.21061e-16
cixPix[2].ON.11 xPix[2].ON.25 GndA 2.35078e-16
cixPix[2].ON.10 xPix[2].ON.30 GndA 1.19486e-16
cixPix[2].ON.9 xPix[2].ON.32 GndA 1.45856e-17
cixPix[2].ON.8 xPix[2].ON.34 GndA 1.52998e-16
cixPix[2].ON.7 xPix[2].ON.37 GndA 9.72471e-17
cixPix[2].ON.6 xPix[2].ON.42 GndA 6.53351e-16
cixPix[2].ON.5 xPix[2].ON.44 GndA 2.18656e-16
cixPix[2].ON.4 xPix[2].ON.51 GndA 3.46621e-17
cixPix[2].ON.3 xPix[2].MMN7.g GndA 1.37177e-16
cixPix[2].ON.2 xPix[2].ON.76 GndA 8.29958e-17
cixPix[2].ON.1 xPix[2].MMonBias.d GndA 2.03009e-16
cixPix[2].ON.0 xPix[2].ON GndA 1.72241e-16
cixPix[2].VSF.15 xPix[2].VSF.2 GndA 1.6162e-16
cixPix[2].VSF.14 xPix[2].VSF.3 GndA 2.98184e-16
cixPix[2].VSF.13 xPix[2].VSF.4 GndA 7.01456e-17
cixPix[2].VSF.12 xPix[2].VSF.7 GndA 9.08888e-17
cixPix[2].VSF.11 xPix[2].VSF.10 GndA 9.27067e-17
cixPix[2].VSF.10 xPix[2].VSF.16 GndA 2.90803e-16
cixPix[2].VSF.9 xPix[2].VSF.22 GndA 1.31778e-16
cixPix[2].VSF.8 xPix[2].VSF.25 GndA 9.71047e-16
cixPix[2].VSF.7 xPix[2].VSF.26 GndA 3.22832e-15
cixPix[2].VSF.6 xPix[2].VSF.29 GndA 2.08088e-15
cixPix[2].VSF.5 xPix[2].VSF.30 GndA 3.87848e-16
cixPix[2].VSF.4 xPix[2].VSF.33 GndA 2.2387e-16
cixPix[2].VSF.3 xPix[2].VSF.37 GndA 1.7705e-16
cixPix[2].VSF.2 xPix[2].VSF.39 GndA 5.46955e-16
cixPix[2].VSF.1 xPix[2].MMP0.d GndA 4.56777e-17
cixPix[2].VSF.0 xPix[2].VSF GndA 5.0044e-17
cixPix[2].vdiff.50 xPix[2].vdiff.1 GndA 1.72754e-16
cixPix[2].vdiff.49 xPix[2].vdiff.3 GndA 1.53369e-16
cixPix[2].vdiff.48 xPix[2].vdiff.9 GndA 5.40458e-17
cixPix[2].vdiff.47 xPix[2].vdiff.15 GndA 4.76455e-16
cixPix[2].vdiff.46 xPix[2].vdiff.19 GndA 3.87708e-16
cixPix[2].vdiff.45 xPix[2].vdiff.22 GndA 2.26872e-16
cixPix[2].vdiff.44 xPix[2].vdiff.25 GndA 1.3837e-16
cixPix[2].vdiff.43 xPix[2].vdiff.27 GndA 1.48381e-16
cixPix[2].vdiff.42 xPix[2].vdiff.36 GndA 1.14339e-16
cixPix[2].vdiff.41 xPix[2].vdiff.37 GndA 8.34243e-17
cixPix[2].vdiff.40 xPix[2].vdiff.38 GndA 7.44648e-17
cixPix[2].vdiff.39 xPix[2].vdiff.42 GndA 1.0382e-16
cixPix[2].vdiff.38 xPix[2].vdiff.47 GndA 8.56189e-17
cixPix[2].vdiff.37 xPix[2].vdiff.50 GndA 7.6118e-17
cixPix[2].vdiff.36 xPix[2].vdiff.51 GndA 8.26982e-17
cixPix[2].vdiff.35 xPix[2].vdiff.54 GndA 1.91786e-16
cixPix[2].vdiff.34 xPix[2].vdiff.58 GndA 2.59537e-16
cixPix[2].vdiff.33 xPix[2].vdiff.60 GndA 2.03078e-17
cixPix[2].vdiff.32 xPix[2].vdiff.62 GndA 5.35861e-16
cixPix[2].vdiff.31 xPix[2].vdiff.63 GndA 1.54896e-16
cixPix[2].vdiff.30 xPix[2].vdiff.64 GndA 9.03597e-17
cixPix[2].vdiff.29 xPix[2].vdiff.67 GndA 4.19393e-17
cixPix[2].vdiff.28 xPix[2].vdiff.70 GndA 4.0173e-17
cixPix[2].vdiff.27 xPix[2].vdiff.71 GndA 3.48706e-18
cixPix[2].vdiff.26 xPix[2].vdiff.72 GndA 9.97684e-18
cixPix[2].vdiff.25 xPix[2].vdiff.73 GndA 1.76024e-16
cixPix[2].vdiff.24 xPix[2].vdiff.76 GndA 3.5679e-16
cixPix[2].vdiff.23 xPix[2].vdiff.79 GndA 1.11002e-16
cixPix[2].vdiff.22 xPix[2].vdiff.80 GndA 1.53986e-16
cixPix[2].vdiff.21 xPix[2].vdiff.81 GndA 5.42161e-18
cixPix[2].vdiff.20 xPix[2].vdiff.83 GndA 6.96087e-16
cixPix[2].vdiff.19 xPix[2].vdiff.88 GndA 1.71865e-16
cixPix[2].vdiff.18 xPix[2].vdiff.91 GndA 9.25962e-17
cixPix[2].vdiff.17 xPix[2].vdiff.92 GndA 1.14544e-16
cixPix[2].vdiff.16 xPix[2].vdiff.96 GndA 1.48558e-15
cixPix[2].vdiff.15 xPix[2].vdiff.97 GndA 6.22584e-17
cixPix[2].vdiff.14 xPix[2].vdiff.98 GndA 1.33673e-17
cixPix[2].vdiff.13 xPix[2].vdiff.102 GndA 6.57267e-17
cixPix[2].vdiff.12 xPix[2].vdiff.111 GndA 3.2985e-16
cixPix[2].vdiff.11 xPix[2].vdiff.115 GndA 1.07239e-16
cixPix[2].vdiff.10 xPix[2].vdiff.120 GndA 6.92614e-16
cixPix[2].vdiff.9 xPix[2].vdiff.136 GndA 1.19472e-16
cixPix[2].vdiff.8 xPix[2].vdiff.144 GndA 9.74359e-17
cixPix[2].vdiff.7 xPix[2].MMon.g GndA 1.08094e-15
cixPix[2].vdiff.6 xPix[2].MMP2.g GndA 1.04319e-15
cixPix[2].vdiff.5 xPix[2].MMchAmpBias.d GndA 1.76514e-16
cixPix[2].vdiff.4 xPix[2].MMchAmp.d GndA 1.68135e-16
cixPix[2].vdiff.3 xPix[2].vdiff GndA 4.22115e-17
cixPix[2].vdiff.2 xPix[2].vdiff.30 GndA 9.9798e-17
cixPix[2].vdiff.1 xPix[2].vdiff.110 GndA 8.8234e-17
cixPix[2].vdiff.0 xPix[2].vdiff.107 GndA 2.13402e-16
cixPix[2].vd.29 xPix[2].vd.2 GndA 1.10806e-16
cixPix[2].vd.28 xPix[2].vd.3 GndA 2.11433e-16
cixPix[2].vd.27 xPix[2].vd.4 GndA 1.6562e-17
cixPix[2].vd.26 xPix[2].vd.6 GndA 4.26631e-16
cixPix[2].vd.25 xPix[2].vd.7 GndA 9.56958e-17
cixPix[2].vd.24 xPix[2].vd.8 GndA 1.40199e-16
cixPix[2].vd.23 xPix[2].vd.14 GndA 7.66488e-17
cixPix[2].vd.22 xPix[2].vd.18 GndA 1.0569e-16
cixPix[2].vd.21 xPix[2].vd.19 GndA 6.15832e-17
cixPix[2].vd.20 xPix[2].vd.21 GndA 1.0814e-16
cixPix[2].vd.19 xPix[2].vd.27 GndA 1.20457e-16
cixPix[2].vd.18 xPix[2].vd.32 GndA 1.99641e-16
cixPix[2].vd.17 xPix[2].vd.35 GndA 1.62608e-16
cixPix[2].vd.16 xPix[2].vd.39 GndA 6.75481e-17
cixPix[2].vd.15 xPix[2].vd.41 GndA 1.35654e-16
cixPix[2].vd.14 xPix[2].vd.48 GndA 1.64821e-16
cixPix[2].vd.13 xPix[2].vd.51 GndA 2.93626e-16
cixPix[2].vd.12 xPix[2].vd.57 GndA 1.5924e-15
cixPix[2].vd.11 xPix[2].vd.59 GndA 1.01617e-15
cixPix[2].vd.10 xPix[2].vd.62 GndA 2.16071e-15
cixPix[2].vd.9 xPix[2].vd.63 GndA 1.5093e-16
cixPix[2].vd.8 xPix[2].vd.66 GndA 7.21943e-16
cixPix[2].vd.7 xPix[2].vd.70 GndA 4.9292e-16
cixPix[2].vd.6 xPix[2].vd.74 GndA 2.54384e-16
cixPix[2].vd.5 xPix[2].vd.76 GndA 7.49539e-16
cixPix[2].vd.4 xPix[2].vd.77 GndA 2.2074e-16
cixPix[2].vd.3 xPix[2].CC1.pos GndA 1.24645e-15
cixPix[2].vd.2 xPix[2].vd.87 GndA 1.33927e-16
cixPix[2].vd.1 xPix[2].MMchAmp.g GndA 1.28612e-15
cixPix[2].vd.0 xPix[2].vd GndA 3.76212e-17
cixPix[3].nOFF.18 xPix[3].nOFF.1 GndA 1.72397e-17
cixPix[3].nOFF.17 xPix[3].nOFF.3 GndA 2.80304e-16
cixPix[3].nOFF.16 xPix[3].nOFF.9 GndA 2.57643e-16
cixPix[3].nOFF.15 xPix[3].nOFF.10 GndA 1.52969e-16
cixPix[3].nOFF.14 xPix[3].nOFF.15 GndA 1.14834e-16
cixPix[3].nOFF.13 xPix[3].nOFF.17 GndA 3.19186e-16
cixPix[3].nOFF.12 xPix[3].nOFF.19 GndA 9.14062e-16
cixPix[3].nOFF.11 xPix[3].nOFF.23 GndA 2.21555e-16
cixPix[3].nOFF.10 xPix[3].nOFF.25 GndA 4.74963e-16
cixPix[3].nOFF.9 xPix[3].nOFF.26 GndA 8.94425e-17
cixPix[3].nOFF.8 xPix[3].nOFF.32 GndA 9.16284e-17
cixPix[3].nOFF.7 xPix[3].nOFF.34 GndA 8.04211e-17
cixPix[3].nOFF.6 xPix[3].nOFF.46 GndA 4.71047e-17
cixPix[3].nOFF.5 xPix[3].nOFF.57 GndA 1.91353e-16
cixPix[3].nOFF.4 xPix[3].nOFF.60 GndA 5.86984e-17
cixPix[3].nOFF.3 xPix[3].MMN8.g GndA 1.34765e-16
cixPix[3].nOFF.2 xPix[3].nOFF.70 GndA 8.13374e-17
cixPix[3].nOFF.1 xPix[3].MMoffBias.d GndA 2.02098e-16
cixPix[3].nOFF.0 xPix[3].nOFF GndA 1.63732e-16
cixPix[3].VPR.22 xPix[3].VPR.2 GndA 3.85799e-17
cixPix[3].VPR.21 xPix[3].VPR.4 GndA 1.65161e-16
cixPix[3].VPR.20 xPix[3].VPR.7 GndA 6.20053e-17
cixPix[3].VPR.19 xPix[3].VPR.8 GndA 9.325e-17
cixPix[3].VPR.18 xPix[3].VPR.12 GndA 1.04163e-16
cixPix[3].VPR.17 xPix[3].VPR.17 GndA 9.34821e-17
cixPix[3].VPR.16 xPix[3].VPR.20 GndA 1.61399e-16
cixPix[3].VPR.15 xPix[3].VPR.26 GndA 1.22585e-16
cixPix[3].VPR.14 xPix[3].VPR.30 GndA 8.08681e-17
cixPix[3].VPR.13 xPix[3].VPR.31 GndA 1.69196e-16
cixPix[3].VPR.12 xPix[3].VPR.34 GndA 1.27074e-16
cixPix[3].VPR.11 xPix[3].VPR.40 GndA 8.37576e-16
cixPix[3].VPR.10 xPix[3].VPR.44 GndA 1.25027e-16
cixPix[3].VPR.9 xPix[3].VPR.49 GndA 2.29889e-16
cixPix[3].VPR.8 xPix[3].VPR.52 GndA 2.33158e-16
cixPix[3].VPR.7 xPix[3].VPR.53 GndA 2.05487e-16
cixPix[3].VPR.6 xPix[3].VPR.60 GndA 2.14934e-17
cixPix[3].VPR.5 xPix[3].VPR.65 GndA 1.9619e-17
cixPix[3].VPR.4 xPix[3].VPR.75 GndA 2.31021e-16
cixPix[3].VPR.3 xPix[3].VPR.80 GndA 5.66419e-17
cixPix[3].VPR.2 xPix[3].MMsf.g GndA 1.93932e-16
cixPix[3].VPR.1 xPix[3].MMpr.amp.d GndA 4.04016e-17
cixPix[3].VPR.0 xPix[3].VPR GndA 5.63445e-17
cixPix[3].nRst.27 xPix[3].nRst.3 GndA 1.63443e-16
cixPix[3].nRst.26 xPix[3].nRst.5 GndA 2.33553e-16
cixPix[3].nRst.25 xPix[3].nRst.7 GndA 2.69122e-16
cixPix[3].nRst.24 xPix[3].nRst.10 GndA 5.27134e-16
cixPix[3].nRst.23 xPix[3].nRst.12 GndA 6.6828e-16
cixPix[3].nRst.22 xPix[3].nRst.13 GndA 1.90167e-16
cixPix[3].nRst.21 xPix[3].nRst.14 GndA 4.32266e-17
cixPix[3].nRst.20 xPix[3].nRst.16 GndA 1.01673e-16
cixPix[3].nRst.19 xPix[3].nRst.18 GndA 4.9187e-18
cixPix[3].nRst.18 xPix[3].nRst.20 GndA 3.88369e-16
cixPix[3].nRst.17 xPix[3].nRst.21 GndA 2.00091e-16
cixPix[3].nRst.16 xPix[3].nRst.22 GndA 1.66015e-16
cixPix[3].nRst.15 xPix[3].nRst.28 GndA 1.19622e-16
cixPix[3].nRst.14 xPix[3].nRst.32 GndA 1.17496e-16
cixPix[3].nRst.13 xPix[3].nRst.36 GndA 9.86152e-17
cixPix[3].nRst.12 xPix[3].nRst.41 GndA 1.04673e-16
cixPix[3].nRst.11 xPix[3].nRst.44 GndA 4.11932e-17
cixPix[3].nRst.10 xPix[3].nRst.49 GndA 1.19534e-16
cixPix[3].nRst.9 xPix[3].nRst.55 GndA 7.23218e-17
cixPix[3].nRst.8 xPix[3].nRst.56 GndA 1.25968e-15
cixPix[3].nRst.7 xPix[3].nRst.74 GndA 1.04684e-16
cixPix[3].nRst.6 xPix[3].nRst.77 GndA 1.70929e-17
cixPix[3].nRst.5 xPix[3].MMcapRef.g GndA 1.29628e-15
cixPix[3].nRst.4 xPix[3].nRst.89 GndA 2.68715e-16
cixPix[3].nRst.3 xPix[3].MMPDrefrCol.d GndA 4.01105e-17
cixPix[3].nRst.2 xPix[3].nRst GndA 3.92213e-17
cixPix[3].nRst.1 xPix[3].nRst.25 GndA 1.15858e-16
cixPix[3].nRst.0 xPix[3].nRst.23 GndA 3.46241e-18
cixPix[3].ON.20 xPix[3].ON.2 GndA 6.66745e-17
cixPix[3].ON.19 xPix[3].ON.5 GndA 2.88302e-16
cixPix[3].ON.18 xPix[3].ON.9 GndA 3.07455e-16
cixPix[3].ON.17 xPix[3].ON.13 GndA 1.77334e-16
cixPix[3].ON.16 xPix[3].ON.16 GndA 5.62247e-17
cixPix[3].ON.15 xPix[3].ON.17 GndA 3.72846e-16
cixPix[3].ON.14 xPix[3].ON.18 GndA 1.25749e-17
cixPix[3].ON.13 xPix[3].ON.21 GndA 2.48153e-16
cixPix[3].ON.12 xPix[3].ON.24 GndA 1.21057e-16
cixPix[3].ON.11 xPix[3].ON.25 GndA 2.95923e-16
cixPix[3].ON.10 xPix[3].ON.30 GndA 7.6311e-17
cixPix[3].ON.9 xPix[3].ON.32 GndA 1.45856e-17
cixPix[3].ON.8 xPix[3].ON.34 GndA 3.86133e-17
cixPix[3].ON.7 xPix[3].ON.37 GndA 9.72471e-17
cixPix[3].ON.6 xPix[3].ON.42 GndA 7.83466e-16
cixPix[3].ON.5 xPix[3].ON.44 GndA 7.91811e-17
cixPix[3].ON.4 xPix[3].ON.51 GndA 3.46683e-17
cixPix[3].ON.3 xPix[3].MMN7.g GndA 1.37177e-16
cixPix[3].ON.2 xPix[3].ON.76 GndA 8.29958e-17
cixPix[3].ON.1 xPix[3].MMonBias.d GndA 2.03009e-16
cixPix[3].ON.0 xPix[3].ON GndA 1.72241e-16
cixPix[3].VSF.15 xPix[3].VSF.2 GndA 8.94721e-17
cixPix[3].VSF.14 xPix[3].VSF.3 GndA 2.98184e-16
cixPix[3].VSF.13 xPix[3].VSF.4 GndA 1.42293e-16
cixPix[3].VSF.12 xPix[3].VSF.7 GndA 9.08888e-17
cixPix[3].VSF.11 xPix[3].VSF.10 GndA 9.27067e-17
cixPix[3].VSF.10 xPix[3].VSF.16 GndA 2.90801e-16
cixPix[3].VSF.9 xPix[3].VSF.22 GndA 1.31778e-16
cixPix[3].VSF.8 xPix[3].VSF.25 GndA 9.66337e-16
cixPix[3].VSF.7 xPix[3].VSF.26 GndA 1.22612e-14
cixPix[3].VSF.6 xPix[3].VSF.29 GndA 1.99284e-15
cixPix[3].VSF.5 xPix[3].VSF.30 GndA 7.13287e-16
cixPix[3].VSF.4 xPix[3].VSF.33 GndA 3.28628e-16
cixPix[3].VSF.3 xPix[3].VSF.37 GndA 6.98658e-17
cixPix[3].VSF.2 xPix[3].VSF.39 GndA 5.29719e-16
cixPix[3].VSF.1 xPix[3].MMP0.d GndA 4.56777e-17
cixPix[3].VSF.0 xPix[3].VSF GndA 5.0044e-17
cixPix[3].vdiff.50 xPix[3].vdiff.1 GndA 2.48598e-17
cixPix[3].vdiff.49 xPix[3].vdiff.3 GndA 2.99798e-16
cixPix[3].vdiff.48 xPix[3].vdiff.9 GndA 5.40458e-17
cixPix[3].vdiff.47 xPix[3].vdiff.15 GndA 4.76453e-16
cixPix[3].vdiff.46 xPix[3].vdiff.19 GndA 1.10417e-16
cixPix[3].vdiff.45 xPix[3].vdiff.22 GndA 2.20483e-16
cixPix[3].vdiff.44 xPix[3].vdiff.25 GndA 1.3837e-16
cixPix[3].vdiff.43 xPix[3].vdiff.27 GndA 1.48172e-16
cixPix[3].vdiff.42 xPix[3].vdiff.36 GndA 1.14339e-16
cixPix[3].vdiff.41 xPix[3].vdiff.37 GndA 8.33774e-17
cixPix[3].vdiff.40 xPix[3].vdiff.38 GndA 3.51753e-16
cixPix[3].vdiff.39 xPix[3].vdiff.42 GndA 1.0382e-16
cixPix[3].vdiff.38 xPix[3].vdiff.47 GndA 9.20082e-17
cixPix[3].vdiff.37 xPix[3].vdiff.50 GndA 2.2463e-16
cixPix[3].vdiff.36 xPix[3].vdiff.51 GndA 8.26982e-17
cixPix[3].vdiff.35 xPix[3].vdiff.54 GndA 5.68948e-17
cixPix[3].vdiff.34 xPix[3].vdiff.58 GndA 1.87413e-16
cixPix[3].vdiff.33 xPix[3].vdiff.60 GndA 1.47377e-17
cixPix[3].vdiff.32 xPix[3].vdiff.62 GndA 5.32869e-16
cixPix[3].vdiff.31 xPix[3].vdiff.63 GndA 1.28908e-16
cixPix[3].vdiff.30 xPix[3].vdiff.64 GndA 9.03597e-17
cixPix[3].vdiff.29 xPix[3].vdiff.67 GndA 4.88795e-17
cixPix[3].vdiff.28 xPix[3].vdiff.70 GndA 3.42043e-17
cixPix[3].vdiff.27 xPix[3].vdiff.71 GndA 3.48706e-18
cixPix[3].vdiff.26 xPix[3].vdiff.72 GndA 9.97684e-18
cixPix[3].vdiff.25 xPix[3].vdiff.73 GndA 1.78318e-16
cixPix[3].vdiff.24 xPix[3].vdiff.76 GndA 2.9351e-16
cixPix[3].vdiff.23 xPix[3].vdiff.79 GndA 1.11002e-16
cixPix[3].vdiff.22 xPix[3].vdiff.80 GndA 6.97131e-17
cixPix[3].vdiff.21 xPix[3].vdiff.81 GndA 1.53222e-16
cixPix[3].vdiff.20 xPix[3].vdiff.83 GndA 4.75141e-16
cixPix[3].vdiff.19 xPix[3].vdiff.88 GndA 2.46605e-16
cixPix[3].vdiff.18 xPix[3].vdiff.91 GndA 9.25962e-17
cixPix[3].vdiff.17 xPix[3].vdiff.92 GndA 1.40532e-16
cixPix[3].vdiff.16 xPix[3].vdiff.96 GndA 1.4914e-15
cixPix[3].vdiff.15 xPix[3].vdiff.97 GndA 6.22584e-17
cixPix[3].vdiff.14 xPix[3].vdiff.98 GndA 1.33673e-17
cixPix[3].vdiff.13 xPix[3].vdiff.102 GndA 3.49934e-16
cixPix[3].vdiff.12 xPix[3].vdiff.111 GndA 4.14123e-16
cixPix[3].vdiff.11 xPix[3].vdiff.115 GndA 1.64747e-16
cixPix[3].vdiff.10 xPix[3].vdiff.120 GndA 6.36319e-16
cixPix[3].vdiff.9 xPix[3].vdiff.136 GndA 1.19472e-16
cixPix[3].vdiff.8 xPix[3].vdiff.144 GndA 9.74359e-17
cixPix[3].vdiff.7 xPix[3].MMon.g GndA 1.08094e-15
cixPix[3].vdiff.6 xPix[3].MMP2.g GndA 1.04319e-15
cixPix[3].vdiff.5 xPix[3].MMchAmpBias.d GndA 1.76511e-16
cixPix[3].vdiff.4 xPix[3].MMchAmp.d GndA 1.68135e-16
cixPix[3].vdiff.3 xPix[3].vdiff GndA 4.53955e-17
cixPix[3].vdiff.2 xPix[3].vdiff.30 GndA 9.9798e-17
cixPix[3].vdiff.1 xPix[3].vdiff.110 GndA 8.8234e-17
cixPix[3].vdiff.0 xPix[3].vdiff.107 GndA 6.56012e-17
cixPix[3].vd.29 xPix[3].vd.2 GndA 7.65048e-17
cixPix[3].vd.28 xPix[3].vd.3 GndA 2.1143e-16
cixPix[3].vd.27 xPix[3].vd.4 GndA 5.08721e-17
cixPix[3].vd.26 xPix[3].vd.6 GndA 4.26837e-16
cixPix[3].vd.25 xPix[3].vd.7 GndA 1.14789e-16
cixPix[3].vd.24 xPix[3].vd.8 GndA 1.58038e-16
cixPix[3].vd.23 xPix[3].vd.14 GndA 7.66488e-17
cixPix[3].vd.22 xPix[3].vd.18 GndA 1.0569e-16
cixPix[3].vd.21 xPix[3].vd.19 GndA 6.15832e-17
cixPix[3].vd.20 xPix[3].vd.21 GndA 1.22496e-16
cixPix[3].vd.19 xPix[3].vd.27 GndA 1.20462e-16
cixPix[3].vd.18 xPix[3].vd.32 GndA 2.6689e-16
cixPix[3].vd.17 xPix[3].vd.35 GndA 1.5031e-16
cixPix[3].vd.16 xPix[3].vd.39 GndA 6.75481e-17
cixPix[3].vd.15 xPix[3].vd.41 GndA 8.26555e-17
cixPix[3].vd.14 xPix[3].vd.48 GndA 1.64821e-16
cixPix[3].vd.13 xPix[3].vd.51 GndA 2.93626e-16
cixPix[3].vd.12 xPix[3].vd.57 GndA 1.59039e-15
cixPix[3].vd.11 xPix[3].vd.59 GndA 1.89453e-16
cixPix[3].vd.10 xPix[3].vd.62 GndA 2.19655e-15
cixPix[3].vd.9 xPix[3].vd.63 GndA 9.80949e-16
cixPix[3].vd.8 xPix[3].vd.66 GndA 7.28387e-16
cixPix[3].vd.7 xPix[3].vd.70 GndA 4.58363e-16
cixPix[3].vd.6 xPix[3].vd.74 GndA 3.87157e-16
cixPix[3].vd.5 xPix[3].vd.76 GndA 7.49539e-16
cixPix[3].vd.4 xPix[3].vd.77 GndA 2.2074e-16
cixPix[3].vd.3 xPix[3].CC1.pos GndA 1.1119e-15
cixPix[3].vd.2 xPix[3].vd.87 GndA 1.33927e-16
cixPix[3].vd.1 xPix[3].MMchAmp.g GndA 1.28612e-15
cixPix[3].vd.0 xPix[3].vd GndA 4.08255e-17
cixPix[0].nOFF.18 xPix[0].nOFF.1 GndA 1.97546e-16
cixPix[0].nOFF.17 xPix[0].nOFF.3 GndA 2.98421e-17
cixPix[0].nOFF.16 xPix[0].nOFF.9 GndA 2.43997e-16
cixPix[0].nOFF.15 xPix[0].nOFF.10 GndA 1.66615e-16
cixPix[0].nOFF.14 xPix[0].nOFF.15 GndA 7.42698e-17
cixPix[0].nOFF.13 xPix[0].nOFF.17 GndA 1.92064e-16
cixPix[0].nOFF.12 xPix[0].nOFF.19 GndA 4.50945e-16
cixPix[0].nOFF.11 xPix[0].nOFF.23 GndA 3.73859e-16
cixPix[0].nOFF.10 xPix[0].nOFF.25 GndA 4.61738e-16
cixPix[0].nOFF.9 xPix[0].nOFF.26 GndA 1.43608e-16
cixPix[0].nOFF.8 xPix[0].nOFF.32 GndA 2.49181e-16
cixPix[0].nOFF.7 xPix[0].nOFF.34 GndA 3.47204e-16
cixPix[0].nOFF.6 xPix[0].nOFF.46 GndA 3.57734e-17
cixPix[0].nOFF.5 xPix[0].nOFF.57 GndA 2.07226e-16
cixPix[0].nOFF.4 xPix[0].nOFF.60 GndA 5.46131e-17
cixPix[0].nOFF.3 xPix[0].MMN8.g GndA 1.34765e-16
cixPix[0].nOFF.2 xPix[0].nOFF.70 GndA 8.0615e-17
cixPix[0].nOFF.1 xPix[0].MMoffBias.d GndA 2.01217e-16
cixPix[0].nOFF.0 xPix[0].nOFF GndA 1.63724e-16
cixPix[0].VPR.22 xPix[0].VPR.2 GndA 3.22e-17
cixPix[0].VPR.21 xPix[0].VPR.4 GndA 1.65178e-16
cixPix[0].VPR.20 xPix[0].VPR.7 GndA 4.9382e-17
cixPix[0].VPR.19 xPix[0].VPR.8 GndA 5.3636e-17
cixPix[0].VPR.18 xPix[0].VPR.12 GndA 1.01638e-16
cixPix[0].VPR.17 xPix[0].VPR.17 GndA 1.01227e-16
cixPix[0].VPR.16 xPix[0].VPR.20 GndA 1.61543e-16
cixPix[0].VPR.15 xPix[0].VPR.26 GndA 1.84505e-16
cixPix[0].VPR.14 xPix[0].VPR.30 GndA 8.08283e-17
cixPix[0].VPR.13 xPix[0].VPR.31 GndA 1.68351e-16
cixPix[0].VPR.12 xPix[0].VPR.34 GndA 1.17389e-16
cixPix[0].VPR.11 xPix[0].VPR.40 GndA 6.71215e-16
cixPix[0].VPR.10 xPix[0].VPR.44 GndA 1.39901e-16
cixPix[0].VPR.9 xPix[0].VPR.52 GndA 2.91417e-16
cixPix[0].VPR.8 xPix[0].VPR.53 GndA 2.55672e-16
cixPix[0].VPR.7 xPix[0].VPR.60 GndA 2.14328e-17
cixPix[0].VPR.6 xPix[0].VPR.65 GndA 1.99673e-17
cixPix[0].VPR.5 xPix[0].VPR.75 GndA 2.32875e-16
cixPix[0].VPR.4 xPix[0].VPR.80 GndA 5.66004e-17
cixPix[0].VPR.3 xPix[0].MMsf.g GndA 1.92509e-16
cixPix[0].VPR.2 xPix[0].MMpr.amp.d GndA 4.04305e-17
cixPix[0].VPR.1 xPix[0].VPR GndA 5.63275e-17
cixPix[0].VPR.0 xPix[0].VPR.49 GndA 2.86526e-16
cixPix[0].nRst.27 xPix[0].nRst.3 GndA 8.74381e-17
cixPix[0].nRst.26 xPix[0].nRst.5 GndA 2.33853e-16
cixPix[0].nRst.25 xPix[0].nRst.7 GndA 1.63323e-16
cixPix[0].nRst.24 xPix[0].nRst.10 GndA 8.2671e-16
cixPix[0].nRst.23 xPix[0].nRst.12 GndA 3.67706e-16
cixPix[0].nRst.22 xPix[0].nRst.13 GndA 1.35378e-16
cixPix[0].nRst.21 xPix[0].nRst.14 GndA 9.80149e-17
cixPix[0].nRst.20 xPix[0].nRst.16 GndA 1.0381e-16
cixPix[0].nRst.19 xPix[0].nRst.18 GndA 6.36316e-17
cixPix[0].nRst.18 xPix[0].nRst.20 GndA 3.88369e-16
cixPix[0].nRst.17 xPix[0].nRst.21 GndA 1.83161e-16
cixPix[0].nRst.16 xPix[0].nRst.22 GndA 1.85237e-16
cixPix[0].nRst.15 xPix[0].nRst.28 GndA 1.95685e-16
cixPix[0].nRst.14 xPix[0].nRst.32 GndA 1.94864e-16
cixPix[0].nRst.13 xPix[0].nRst.36 GndA 1.27712e-16
cixPix[0].nRst.12 xPix[0].nRst.41 GndA 7.70137e-17
cixPix[0].nRst.11 xPix[0].nRst.44 GndA 1.69382e-17
cixPix[0].nRst.10 xPix[0].nRst.49 GndA 1.1944e-16
cixPix[0].nRst.9 xPix[0].nRst.55 GndA 7.20755e-17
cixPix[0].nRst.8 xPix[0].nRst.56 GndA 1.25912e-15
cixPix[0].nRst.7 xPix[0].nRst.74 GndA 1.04169e-16
cixPix[0].nRst.6 xPix[0].nRst.77 GndA 1.67281e-17
cixPix[0].nRst.5 xPix[0].MMcapRef.g GndA 1.29002e-15
cixPix[0].nRst.4 xPix[0].nRst.89 GndA 2.68969e-16
cixPix[0].nRst.3 xPix[0].MMPDrefrCol.d GndA 4.01105e-17
cixPix[0].nRst.2 xPix[0].nRst GndA 3.92214e-17
cixPix[0].nRst.1 xPix[0].nRst.23 GndA 8.51218e-17
cixPix[0].nRst.0 xPix[0].nRst.25 GndA 2.02187e-17
cixPix[0].ON.20 xPix[0].ON.2 GndA 8.43357e-17
cixPix[0].ON.19 xPix[0].ON.5 GndA 2.88302e-16
cixPix[0].ON.18 xPix[0].ON.9 GndA 1.58623e-16
cixPix[0].ON.17 xPix[0].ON.13 GndA 1.48921e-16
cixPix[0].ON.16 xPix[0].ON.16 GndA 4.40345e-17
cixPix[0].ON.15 xPix[0].ON.17 GndA 2.91172e-16
cixPix[0].ON.14 xPix[0].ON.18 GndA 1.05101e-16
cixPix[0].ON.13 xPix[0].ON.21 GndA 2.72034e-16
cixPix[0].ON.12 xPix[0].ON.24 GndA 1.21061e-16
cixPix[0].ON.11 xPix[0].ON.25 GndA 2.35078e-16
cixPix[0].ON.10 xPix[0].ON.30 GndA 1.19488e-16
cixPix[0].ON.9 xPix[0].ON.32 GndA 1.45856e-17
cixPix[0].ON.8 xPix[0].ON.34 GndA 1.27525e-16
cixPix[0].ON.7 xPix[0].ON.37 GndA 1.03084e-16
cixPix[0].ON.6 xPix[0].ON.42 GndA 6.47989e-16
cixPix[0].ON.5 xPix[0].ON.44 GndA 2.18656e-16
cixPix[0].ON.4 xPix[0].ON.51 GndA 3.47491e-17
cixPix[0].ON.3 xPix[0].MMN7.g GndA 1.37177e-16
cixPix[0].ON.2 xPix[0].ON.76 GndA 8.48399e-17
cixPix[0].ON.1 xPix[0].MMonBias.d GndA 2.01994e-16
cixPix[0].ON.0 xPix[0].ON GndA 1.72241e-16
cixPix[0].VSF.15 xPix[0].VSF.2 GndA 1.61497e-16
cixPix[0].VSF.14 xPix[0].VSF.3 GndA 1.95026e-16
cixPix[0].VSF.13 xPix[0].VSF.4 GndA 1.78737e-16
cixPix[0].VSF.12 xPix[0].VSF.7 GndA 8.72582e-17
cixPix[0].VSF.11 xPix[0].VSF.10 GndA 9.27067e-17
cixPix[0].VSF.10 xPix[0].VSF.16 GndA 2.90803e-16
cixPix[0].VSF.9 xPix[0].VSF.22 GndA 1.31778e-16
cixPix[0].VSF.8 xPix[0].VSF.25 GndA 9.55613e-16
cixPix[0].VSF.7 xPix[0].VSF.26 GndA 3.22832e-15
cixPix[0].VSF.6 xPix[0].VSF.29 GndA 2.03918e-15
cixPix[0].VSF.5 xPix[0].VSF.30 GndA 5.58793e-16
cixPix[0].VSF.4 xPix[0].VSF.33 GndA 2.23014e-16
cixPix[0].VSF.3 xPix[0].VSF.37 GndA 1.7705e-16
cixPix[0].VSF.2 xPix[0].VSF.39 GndA 3.9984e-16
cixPix[0].VSF.1 xPix[0].MMP0.d GndA 4.56818e-17
cixPix[0].VSF.0 xPix[0].VSF GndA 5.03308e-17
cixPix[0].vdiff.50 xPix[0].vdiff.1 GndA 1.67098e-16
cixPix[0].vdiff.49 xPix[0].vdiff.3 GndA 1.52089e-16
cixPix[0].vdiff.48 xPix[0].vdiff.9 GndA 1.36917e-16
cixPix[0].vdiff.47 xPix[0].vdiff.15 GndA 1.69811e-16
cixPix[0].vdiff.46 xPix[0].vdiff.19 GndA 3.87917e-16
cixPix[0].vdiff.45 xPix[0].vdiff.22 GndA 2.26872e-16
cixPix[0].vdiff.44 xPix[0].vdiff.25 GndA 1.24776e-16
cixPix[0].vdiff.43 xPix[0].vdiff.27 GndA 1.45393e-16
cixPix[0].vdiff.42 xPix[0].vdiff.36 GndA 1.14339e-16
cixPix[0].vdiff.41 xPix[0].vdiff.37 GndA 8.34243e-17
cixPix[0].vdiff.40 xPix[0].vdiff.38 GndA 7.44973e-17
cixPix[0].vdiff.39 xPix[0].vdiff.42 GndA 1.03808e-16
cixPix[0].vdiff.38 xPix[0].vdiff.47 GndA 9.12374e-17
cixPix[0].vdiff.37 xPix[0].vdiff.50 GndA 7.6118e-17
cixPix[0].vdiff.36 xPix[0].vdiff.51 GndA 8.26982e-17
cixPix[0].vdiff.35 xPix[0].vdiff.54 GndA 1.91786e-16
cixPix[0].vdiff.34 xPix[0].vdiff.58 GndA 2.59537e-16
cixPix[0].vdiff.33 xPix[0].vdiff.60 GndA 5.90226e-16
cixPix[0].vdiff.32 xPix[0].vdiff.62 GndA 5.36094e-16
cixPix[0].vdiff.31 xPix[0].vdiff.63 GndA 1.50373e-16
cixPix[0].vdiff.30 xPix[0].vdiff.64 GndA 9.40836e-17
cixPix[0].vdiff.29 xPix[0].vdiff.67 GndA 4.29108e-17
cixPix[0].vdiff.28 xPix[0].vdiff.70 GndA 4.0173e-17
cixPix[0].vdiff.27 xPix[0].vdiff.71 GndA 1.42674e-17
cixPix[0].vdiff.26 xPix[0].vdiff.72 GndA 1.34084e-16
cixPix[0].vdiff.25 xPix[0].vdiff.73 GndA 1.78318e-16
cixPix[0].vdiff.24 xPix[0].vdiff.76 GndA 2.32684e-16
cixPix[0].vdiff.23 xPix[0].vdiff.79 GndA 1.03112e-16
cixPix[0].vdiff.22 xPix[0].vdiff.80 GndA 1.30292e-16
cixPix[0].vdiff.21 xPix[0].vdiff.81 GndA 2.54323e-17
cixPix[0].vdiff.20 xPix[0].vdiff.83 GndA 6.64212e-16
cixPix[0].vdiff.19 xPix[0].vdiff.88 GndA 1.71865e-16
cixPix[0].vdiff.18 xPix[0].vdiff.91 GndA 9.43914e-17
cixPix[0].vdiff.17 xPix[0].vdiff.92 GndA 1.09191e-16
cixPix[0].vdiff.16 xPix[0].vdiff.96 GndA 9.21588e-16
cixPix[0].vdiff.15 xPix[0].vdiff.97 GndA 6.22584e-17
cixPix[0].vdiff.14 xPix[0].vdiff.98 GndA 2.58702e-18
cixPix[0].vdiff.13 xPix[0].vdiff.102 GndA 6.51924e-17
cixPix[0].vdiff.12 xPix[0].vdiff.111 GndA 3.31224e-16
cixPix[0].vdiff.11 xPix[0].vdiff.115 GndA 1.07237e-16
cixPix[0].vdiff.10 xPix[0].vdiff.120 GndA 6.92614e-16
cixPix[0].vdiff.9 xPix[0].vdiff.136 GndA 1.23061e-16
cixPix[0].vdiff.8 xPix[0].vdiff.144 GndA 1.01025e-16
cixPix[0].vdiff.7 xPix[0].MMon.g GndA 1.07886e-15
cixPix[0].vdiff.6 xPix[0].MMP2.g GndA 1.03923e-15
cixPix[0].vdiff.5 xPix[0].MMchAmpBias.d GndA 1.76419e-16
cixPix[0].vdiff.4 xPix[0].MMchAmp.d GndA 1.68135e-16
cixPix[0].vdiff.3 xPix[0].vdiff GndA 4.22115e-17
cixPix[0].vdiff.2 xPix[0].vdiff.110 GndA 8.81266e-17
cixPix[0].vdiff.1 xPix[0].vdiff.107 GndA 2.24948e-16
cixPix[0].vdiff.0 xPix[0].vdiff.30 GndA 3.23568e-16
cixPix[0].vd.29 xPix[0].vd.2 GndA 1.10806e-16
cixPix[0].vd.28 xPix[0].vd.3 GndA 1.96521e-16
cixPix[0].vd.27 xPix[0].vd.4 GndA 3.14741e-17
cixPix[0].vd.26 xPix[0].vd.6 GndA 4.2756e-16
cixPix[0].vd.25 xPix[0].vd.7 GndA 9.13747e-17
cixPix[0].vd.24 xPix[0].vd.8 GndA 1.44517e-16
cixPix[0].vd.23 xPix[0].vd.14 GndA 7.66473e-17
cixPix[0].vd.22 xPix[0].vd.18 GndA 7.16866e-17
cixPix[0].vd.21 xPix[0].vd.19 GndA 9.55868e-17
cixPix[0].vd.20 xPix[0].vd.21 GndA 1.08141e-16
cixPix[0].vd.19 xPix[0].vd.27 GndA 1.20403e-16
cixPix[0].vd.18 xPix[0].vd.32 GndA 1.94841e-16
cixPix[0].vd.17 xPix[0].vd.35 GndA 1.62608e-16
cixPix[0].vd.16 xPix[0].vd.39 GndA 7.43004e-17
cixPix[0].vd.15 xPix[0].vd.41 GndA 1.35654e-16
cixPix[0].vd.14 xPix[0].vd.48 GndA 1.64821e-16
cixPix[0].vd.13 xPix[0].vd.51 GndA 2.93626e-16
cixPix[0].vd.12 xPix[0].vd.57 GndA 1.56078e-15
cixPix[0].vd.11 xPix[0].vd.59 GndA 1.69261e-15
cixPix[0].vd.10 xPix[0].vd.62 GndA 1.96518e-15
cixPix[0].vd.9 xPix[0].vd.63 GndA 3.45278e-16
cixPix[0].vd.8 xPix[0].vd.66 GndA 7.50035e-16
cixPix[0].vd.7 xPix[0].vd.70 GndA 4.92921e-16
cixPix[0].vd.6 xPix[0].vd.74 GndA 2.54484e-16
cixPix[0].vd.5 xPix[0].vd.76 GndA 7.49539e-16
cixPix[0].vd.4 xPix[0].vd.77 GndA 2.2074e-16
cixPix[0].vd.3 xPix[0].CC1.pos GndA 5.46292e-16
cixPix[0].vd.2 xPix[0].vd.87 GndA 1.33927e-16
cixPix[0].vd.1 xPix[0].MMchAmp.g GndA 1.28612e-15
cixPix[0].vd.0 xPix[0].vd GndA 3.76212e-17
cixPix[1].nOFF.18 xPix[1].nOFF.1 GndA 1.31951e-17
cixPix[1].nOFF.17 xPix[1].nOFF.3 GndA 2.09282e-16
cixPix[1].nOFF.16 xPix[1].nOFF.9 GndA 2.43997e-16
cixPix[1].nOFF.15 xPix[1].nOFF.10 GndA 1.66615e-16
cixPix[1].nOFF.14 xPix[1].nOFF.15 GndA 7.42698e-17
cixPix[1].nOFF.13 xPix[1].nOFF.17 GndA 1.92064e-16
cixPix[1].nOFF.12 xPix[1].nOFF.19 GndA 6.03249e-16
cixPix[1].nOFF.11 xPix[1].nOFF.23 GndA 2.21555e-16
cixPix[1].nOFF.10 xPix[1].nOFF.25 GndA 4.60768e-16
cixPix[1].nOFF.9 xPix[1].nOFF.26 GndA 1.43608e-16
cixPix[1].nOFF.8 xPix[1].nOFF.32 GndA 2.49181e-16
cixPix[1].nOFF.7 xPix[1].nOFF.34 GndA 3.47204e-16
cixPix[1].nOFF.6 xPix[1].nOFF.46 GndA 3.57734e-17
cixPix[1].nOFF.5 xPix[1].nOFF.57 GndA 2.05951e-16
cixPix[1].nOFF.4 xPix[1].nOFF.60 GndA 5.46462e-17
cixPix[1].nOFF.3 xPix[1].MMN8.g GndA 1.34765e-16
cixPix[1].nOFF.2 xPix[1].nOFF.70 GndA 8.17951e-17
cixPix[1].nOFF.1 xPix[1].MMoffBias.d GndA 2.01217e-16
cixPix[1].nOFF.0 xPix[1].nOFF GndA 1.63724e-16
cixPix[1].VPR.22 xPix[1].VPR.2 GndA 3.85799e-17
cixPix[1].VPR.21 xPix[1].VPR.4 GndA 1.65161e-16
cixPix[1].VPR.20 xPix[1].VPR.7 GndA 4.9382e-17
cixPix[1].VPR.19 xPix[1].VPR.8 GndA 1.1555e-16
cixPix[1].VPR.18 xPix[1].VPR.12 GndA 1.04163e-16
cixPix[1].VPR.17 xPix[1].VPR.17 GndA 9.34643e-17
cixPix[1].VPR.16 xPix[1].VPR.20 GndA 1.61399e-16
cixPix[1].VPR.15 xPix[1].VPR.26 GndA 1.22585e-16
cixPix[1].VPR.14 xPix[1].VPR.30 GndA 8.1024e-17
cixPix[1].VPR.13 xPix[1].VPR.31 GndA 1.68952e-16
cixPix[1].VPR.12 xPix[1].VPR.34 GndA 1.17392e-16
cixPix[1].VPR.11 xPix[1].VPR.40 GndA 8.42078e-16
cixPix[1].VPR.10 xPix[1].VPR.44 GndA 1.35939e-16
cixPix[1].VPR.9 xPix[1].VPR.49 GndA 2.29889e-16
cixPix[1].VPR.8 xPix[1].VPR.52 GndA 2.33158e-16
cixPix[1].VPR.7 xPix[1].VPR.53 GndA 2.05487e-16
cixPix[1].VPR.6 xPix[1].VPR.60 GndA 2.14934e-17
cixPix[1].VPR.5 xPix[1].VPR.65 GndA 1.99673e-17
cixPix[1].VPR.4 xPix[1].VPR.75 GndA 2.31021e-16
cixPix[1].VPR.3 xPix[1].VPR.80 GndA 5.66004e-17
cixPix[1].VPR.2 xPix[1].MMsf.g GndA 1.92508e-16
cixPix[1].VPR.1 xPix[1].MMpr.amp.d GndA 4.04016e-17
cixPix[1].VPR.0 xPix[1].VPR GndA 5.63305e-17
cixPix[1].nRst.27 xPix[1].nRst.3 GndA 1.63501e-16
cixPix[1].nRst.26 xPix[1].nRst.5 GndA 2.33853e-16
cixPix[1].nRst.25 xPix[1].nRst.7 GndA 1.62217e-16
cixPix[1].nRst.24 xPix[1].nRst.10 GndA 5.27144e-16
cixPix[1].nRst.23 xPix[1].nRst.12 GndA 6.68241e-16
cixPix[1].nRst.22 xPix[1].nRst.13 GndA 1.35378e-16
cixPix[1].nRst.21 xPix[1].nRst.14 GndA 9.80149e-17
cixPix[1].nRst.20 xPix[1].nRst.16 GndA 1.02996e-16
cixPix[1].nRst.19 xPix[1].nRst.18 GndA 3.54555e-17
cixPix[1].nRst.18 xPix[1].nRst.20 GndA 3.88319e-16
cixPix[1].nRst.17 xPix[1].nRst.21 GndA 2.00095e-16
cixPix[1].nRst.16 xPix[1].nRst.22 GndA 1.66034e-16
cixPix[1].nRst.15 xPix[1].nRst.28 GndA 1.19622e-16
cixPix[1].nRst.14 xPix[1].nRst.32 GndA 1.95304e-16
cixPix[1].nRst.13 xPix[1].nRst.36 GndA 1.27712e-16
cixPix[1].nRst.12 xPix[1].nRst.41 GndA 1.06163e-16
cixPix[1].nRst.11 xPix[1].nRst.44 GndA 1.61739e-17
cixPix[1].nRst.10 xPix[1].nRst.49 GndA 1.1944e-16
cixPix[1].nRst.9 xPix[1].nRst.55 GndA 7.22435e-17
cixPix[1].nRst.8 xPix[1].nRst.56 GndA 1.25912e-15
cixPix[1].nRst.7 xPix[1].nRst.74 GndA 1.05575e-16
cixPix[1].nRst.6 xPix[1].nRst.77 GndA 1.71405e-17
cixPix[1].nRst.5 xPix[1].MMcapRef.g GndA 1.29653e-15
cixPix[1].nRst.4 xPix[1].nRst.89 GndA 2.68763e-16
cixPix[1].nRst.3 xPix[1].MMPDrefrCol.d GndA 4.01105e-17
cixPix[1].nRst.2 xPix[1].nRst GndA 3.92214e-17
cixPix[1].nRst.1 xPix[1].nRst.23 GndA 8.52099e-17
cixPix[1].nRst.0 xPix[1].nRst.25 GndA 2.02187e-17
cixPix[1].ON.20 xPix[1].ON.2 GndA 6.66745e-17
cixPix[1].ON.19 xPix[1].ON.5 GndA 2.88302e-16
cixPix[1].ON.18 xPix[1].ON.9 GndA 2.46286e-16
cixPix[1].ON.17 xPix[1].ON.13 GndA 1.71497e-16
cixPix[1].ON.16 xPix[1].ON.16 GndA 5.62247e-17
cixPix[1].ON.15 xPix[1].ON.17 GndA 3.15053e-16
cixPix[1].ON.14 xPix[1].ON.18 GndA 7.03677e-17
cixPix[1].ON.13 xPix[1].ON.21 GndA 2.48153e-16
cixPix[1].ON.12 xPix[1].ON.24 GndA 1.21061e-16
cixPix[1].ON.11 xPix[1].ON.25 GndA 2.95923e-16
cixPix[1].ON.10 xPix[1].ON.30 GndA 7.63128e-17
cixPix[1].ON.9 xPix[1].ON.32 GndA 1.45856e-17
cixPix[1].ON.8 xPix[1].ON.34 GndA 3.99743e-17
cixPix[1].ON.7 xPix[1].ON.37 GndA 1.03084e-16
cixPix[1].ON.6 xPix[1].ON.42 GndA 7.77853e-16
cixPix[1].ON.5 xPix[1].ON.44 GndA 7.92295e-17
cixPix[1].ON.4 xPix[1].ON.51 GndA 3.41885e-17
cixPix[1].ON.3 xPix[1].MMN7.g GndA 1.37177e-16
cixPix[1].ON.2 xPix[1].ON.76 GndA 8.48399e-17
cixPix[1].ON.1 xPix[1].MMonBias.d GndA 2.01994e-16
cixPix[1].ON.0 xPix[1].ON GndA 1.72241e-16
cixPix[1].VSF.15 xPix[1].VSF.2 GndA 8.93886e-17
cixPix[1].VSF.14 xPix[1].VSF.3 GndA 1.95026e-16
cixPix[1].VSF.13 xPix[1].VSF.4 GndA 2.50846e-16
cixPix[1].VSF.12 xPix[1].VSF.7 GndA 8.72951e-17
cixPix[1].VSF.11 xPix[1].VSF.10 GndA 9.27067e-17
cixPix[1].VSF.10 xPix[1].VSF.16 GndA 2.90801e-16
cixPix[1].VSF.9 xPix[1].VSF.22 GndA 1.31778e-16
cixPix[1].VSF.8 xPix[1].VSF.25 GndA 9.66159e-16
cixPix[1].VSF.7 xPix[1].VSF.26 GndA 1.22612e-14
cixPix[1].VSF.6 xPix[1].VSF.29 GndA 1.95526e-15
cixPix[1].VSF.5 xPix[1].VSF.30 GndA 8.7355e-16
cixPix[1].VSF.4 xPix[1].VSF.33 GndA 3.28628e-16
cixPix[1].VSF.3 xPix[1].VSF.37 GndA 6.98658e-17
cixPix[1].VSF.2 xPix[1].VSF.39 GndA 3.99624e-16
cixPix[1].VSF.1 xPix[1].MMP0.d GndA 4.56818e-17
cixPix[1].VSF.0 xPix[1].VSF GndA 5.03462e-17
cixPix[1].vdiff.50 xPix[1].vdiff.1 GndA 2.46002e-17
cixPix[1].vdiff.49 xPix[1].vdiff.3 GndA 2.99905e-16
cixPix[1].vdiff.48 xPix[1].vdiff.9 GndA 1.36917e-16
cixPix[1].vdiff.47 xPix[1].vdiff.15 GndA 1.69811e-16
cixPix[1].vdiff.46 xPix[1].vdiff.19 GndA 1.10626e-16
cixPix[1].vdiff.45 xPix[1].vdiff.22 GndA 2.20483e-16
cixPix[1].vdiff.44 xPix[1].vdiff.25 GndA 1.28994e-16
cixPix[1].vdiff.43 xPix[1].vdiff.27 GndA 1.45258e-16
cixPix[1].vdiff.42 xPix[1].vdiff.36 GndA 1.14339e-16
cixPix[1].vdiff.41 xPix[1].vdiff.37 GndA 8.33774e-17
cixPix[1].vdiff.40 xPix[1].vdiff.38 GndA 3.51789e-16
cixPix[1].vdiff.39 xPix[1].vdiff.42 GndA 1.03808e-16
cixPix[1].vdiff.38 xPix[1].vdiff.47 GndA 9.76266e-17
cixPix[1].vdiff.37 xPix[1].vdiff.50 GndA 2.2463e-16
cixPix[1].vdiff.36 xPix[1].vdiff.51 GndA 8.26982e-17
cixPix[1].vdiff.35 xPix[1].vdiff.54 GndA 5.68948e-17
cixPix[1].vdiff.34 xPix[1].vdiff.58 GndA 1.87413e-16
cixPix[1].vdiff.33 xPix[1].vdiff.60 GndA 5.84656e-16
cixPix[1].vdiff.32 xPix[1].vdiff.62 GndA 5.33871e-16
cixPix[1].vdiff.31 xPix[1].vdiff.63 GndA 1.24498e-16
cixPix[1].vdiff.30 xPix[1].vdiff.64 GndA 9.40836e-17
cixPix[1].vdiff.29 xPix[1].vdiff.67 GndA 4.88795e-17
cixPix[1].vdiff.28 xPix[1].vdiff.70 GndA 3.42043e-17
cixPix[1].vdiff.27 xPix[1].vdiff.71 GndA 1.42674e-17
cixPix[1].vdiff.26 xPix[1].vdiff.72 GndA 1.34084e-16
cixPix[1].vdiff.25 xPix[1].vdiff.73 GndA 1.78318e-16
cixPix[1].vdiff.24 xPix[1].vdiff.76 GndA 1.69403e-16
cixPix[1].vdiff.23 xPix[1].vdiff.79 GndA 1.03112e-16
cixPix[1].vdiff.22 xPix[1].vdiff.80 GndA 4.60189e-17
cixPix[1].vdiff.21 xPix[1].vdiff.81 GndA 1.73233e-16
cixPix[1].vdiff.20 xPix[1].vdiff.83 GndA 4.50143e-16
cixPix[1].vdiff.19 xPix[1].vdiff.88 GndA 2.46676e-16
cixPix[1].vdiff.18 xPix[1].vdiff.91 GndA 9.43914e-17
cixPix[1].vdiff.17 xPix[1].vdiff.92 GndA 1.35066e-16
cixPix[1].vdiff.16 xPix[1].vdiff.96 GndA 9.21588e-16
cixPix[1].vdiff.15 xPix[1].vdiff.97 GndA 6.22584e-17
cixPix[1].vdiff.14 xPix[1].vdiff.98 GndA 2.58702e-18
cixPix[1].vdiff.13 xPix[1].vdiff.111 GndA 4.16901e-16
cixPix[1].vdiff.12 xPix[1].vdiff.115 GndA 1.64747e-16
cixPix[1].vdiff.11 xPix[1].vdiff.120 GndA 6.36319e-16
cixPix[1].vdiff.10 xPix[1].vdiff.136 GndA 1.19472e-16
cixPix[1].vdiff.9 xPix[1].vdiff.144 GndA 9.74359e-17
cixPix[1].vdiff.8 xPix[1].MMon.g GndA 1.08084e-15
cixPix[1].vdiff.7 xPix[1].MMP2.g GndA 1.04319e-15
cixPix[1].vdiff.6 xPix[1].MMchAmpBias.d GndA 1.7652e-16
cixPix[1].vdiff.5 xPix[1].MMchAmp.d GndA 1.68135e-16
cixPix[1].vdiff.4 xPix[1].vdiff GndA 4.53955e-17
cixPix[1].vdiff.3 xPix[1].vdiff.102 GndA 3.48298e-16
cixPix[1].vdiff.2 xPix[1].vdiff.110 GndA 8.8234e-17
cixPix[1].vdiff.1 xPix[1].vdiff.107 GndA 7.71479e-17
cixPix[1].vdiff.0 xPix[1].vdiff.30 GndA 3.23568e-16
cixPix[1].vd.29 xPix[1].vd.2 GndA 7.65048e-17
cixPix[1].vd.28 xPix[1].vd.3 GndA 1.96521e-16
cixPix[1].vd.27 xPix[1].vd.4 GndA 6.57818e-17
cixPix[1].vd.26 xPix[1].vd.6 GndA 4.26916e-16
cixPix[1].vd.25 xPix[1].vd.7 GndA 1.14739e-16
cixPix[1].vd.24 xPix[1].vd.8 GndA 1.58038e-16
cixPix[1].vd.23 xPix[1].vd.14 GndA 7.66467e-17
cixPix[1].vd.22 xPix[1].vd.18 GndA 7.16866e-17
cixPix[1].vd.21 xPix[1].vd.19 GndA 9.55868e-17
cixPix[1].vd.20 xPix[1].vd.21 GndA 1.22496e-16
cixPix[1].vd.19 xPix[1].vd.27 GndA 1.20408e-16
cixPix[1].vd.18 xPix[1].vd.32 GndA 2.60138e-16
cixPix[1].vd.17 xPix[1].vd.35 GndA 1.5031e-16
cixPix[1].vd.16 xPix[1].vd.39 GndA 7.43004e-17
cixPix[1].vd.15 xPix[1].vd.41 GndA 8.26555e-17
cixPix[1].vd.14 xPix[1].vd.48 GndA 1.64821e-16
cixPix[1].vd.13 xPix[1].vd.51 GndA 2.93626e-16
cixPix[1].vd.12 xPix[1].vd.57 GndA 1.55827e-15
cixPix[1].vd.11 xPix[1].vd.59 GndA 8.65912e-16
cixPix[1].vd.10 xPix[1].vd.62 GndA 2.00004e-15
cixPix[1].vd.9 xPix[1].vd.63 GndA 1.17022e-15
cixPix[1].vd.8 xPix[1].vd.66 GndA 7.50213e-16
cixPix[1].vd.7 xPix[1].vd.70 GndA 4.58364e-16
cixPix[1].vd.6 xPix[1].vd.74 GndA 3.87157e-16
cixPix[1].vd.5 xPix[1].vd.76 GndA 7.49539e-16
cixPix[1].vd.4 xPix[1].vd.77 GndA 2.2074e-16
cixPix[1].vd.3 xPix[1].CC1.pos GndA 4.13619e-16
cixPix[1].vd.2 xPix[1].vd.87 GndA 1.33927e-16
cixPix[1].vd.1 xPix[1].MMchAmp.g GndA 1.28612e-15
cixPix[1].vd.0 xPix[1].vd GndA 4.08255e-17
rvpd[2]_36 xPix[2].DD1.neg vpd[2]_32 9.3
rvpd[2]_35 vpd[2]_7 vpd[2]_8 0.216584
rvpd[2]_34 vpd[2]_7 vpd[2]_10 0.0698411
rvpd[2]_33 vpd[2]_8 vpd[2]_20 0.0373109
rvpd[2]_32 vpd[2]_9 vpd[2]_10 1.0396
rvpd[2]_31 vpd[2]_9 vpd[2]_26 0.0137558
rvpd[2]_30 vpd[2]_11 vpd[2]_12 1.32426
rvpd[2]_29 vpd[2]_11 vpd[2]_22 0.0073411
rvpd[2]_28 vpd[2]_12 vpd[2]_26 0.0529306
rvpd[2]_27 vpd[2]_13 vpd[2]_14 0.841584
rvpd[2]_26 vpd[2]_13 vpd[2]_26 0.0529306
rvpd[2]_25 vpd[2]_14 vpd[2]_27 0.0513368
rvpd[2]_24 vpd[2]_16 vpd[2]_58 3.76238
rvpd[2]_23 vpd[2]_16 vpd[2]_24 0.0073411
rvpd[2]_22 vpd[2]_18 vpd[2]_20 0.0752618
rvpd[2]_21 vpd[2]_18 vpd[2]_34 9.3
rvpd[2]_20 vpd[2]_22 vpd[2]_24 0.241337
rvpd[2]_19 vpd[2]_27 vpd[2]_30 0.0473108
rvpd[2]_18 vpd[2]_30 xPix[2].MMpd.s 9.3
rvpd[2]_17 vpd[2]_32 vpd[2] 0.00747012
rvpd[2]_16 vpd[2]_34 vpd[2]_49 152
rvpd[2]_15 vpd[2]_49 xPix[2].MMpr.amp.g 113.586
rvpd[2]_14 vpd[2]_58 vpd[2] 0.111232
rvpd[3]_37 xPix[3].DD1.neg vpd[3]_32 9.3
rvpd[3]_36 vpd[3]_7 vpd[3]_8 0.216584
rvpd[3]_35 vpd[3]_7 vpd[3]_10 0.0698411
rvpd[3]_34 vpd[3]_8 vpd[3]_20 0.0373109
rvpd[3]_33 vpd[3]_9 vpd[3]_10 1.0396
rvpd[3]_32 vpd[3]_9 vpd[3]_26 0.0137558
rvpd[3]_31 vpd[3]_11 vpd[3]_12 1.32426
rvpd[3]_30 vpd[3]_11 vpd[3]_22 0.0073411
rvpd[3]_29 vpd[3]_12 vpd[3]_26 0.0529306
rvpd[3]_28 vpd[3]_13 vpd[3]_14 0.841584
rvpd[3]_27 vpd[3]_13 vpd[3]_26 0.0529306
rvpd[3]_26 vpd[3]_14 vpd[3]_27 0.0513368
rvpd[3]_25 vpd[3]_16 vpd[3]_58 3.76238
rvpd[3]_24 vpd[3]_16 vpd[3]_24 0.0073411
rvpd[3]_23 vpd[3]_18 vpd[3]_20 0.0752618
rvpd[3]_22 vpd[3]_18 vpd[3]_34 9.3
rvpd[3]_21 vpd[3]_22 vpd[3]_24 0.241337
rvpd[3]_20 vpd[3]_27 vpd[3]_30 0.0473108
rvpd[3]_19 vpd[3]_30 xPix[3].MMpd.s 9.3
rvpd[3]_18 vpd[3]_32 vpd[3]_58 0.118702
rvpd[3]_17 vpd[3]_32 vpd[3] 0.00747012
rvpd[3]_16 vpd[3]_34 vpd[3]_49 152
rvpd[3]_15 vpd[3]_49 xPix[3].MMpr.amp.g 113.586
rvpd[0]_36 xPix[0].DD1.neg vpd[0]_32 9.3
rvpd[0]_35 vpd[0]_7 vpd[0]_8 0.216584
rvpd[0]_34 vpd[0]_7 vpd[0]_10 0.0698411
rvpd[0]_33 vpd[0]_8 vpd[0]_20 0.0373109
rvpd[0]_32 vpd[0]_9 vpd[0]_10 1.0396
rvpd[0]_31 vpd[0]_9 vpd[0]_26 0.0137558
rvpd[0]_30 vpd[0]_11 vpd[0]_12 1.32426
rvpd[0]_29 vpd[0]_11 vpd[0]_22 0.0073411
rvpd[0]_28 vpd[0]_12 vpd[0]_26 0.0529306
rvpd[0]_27 vpd[0]_13 vpd[0]_14 0.841584
rvpd[0]_26 vpd[0]_13 vpd[0]_26 0.0529306
rvpd[0]_25 vpd[0]_14 vpd[0]_27 0.0513368
rvpd[0]_24 vpd[0]_16 vpd[0]_58 3.76238
rvpd[0]_23 vpd[0]_16 vpd[0]_24 0.0073411
rvpd[0]_22 vpd[0]_18 vpd[0]_20 0.0752618
rvpd[0]_21 vpd[0]_18 vpd[0]_34 9.3
rvpd[0]_20 vpd[0]_22 vpd[0]_24 0.241337
rvpd[0]_19 vpd[0]_27 vpd[0]_30 0.0473108
rvpd[0]_18 vpd[0]_30 xPix[0].MMpd.s 9.3
rvpd[0]_17 vpd[0]_32 vpd[0] 0.00498008
rvpd[0]_16 vpd[0]_32 vpd[0]_58 0.118702
rvpd[0]_15 vpd[0]_34 vpd[0]_49 152
rvpd[0]_14 vpd[0]_49 xPix[0].MMpr.amp.g 113.586
rvpd[1]_37 xPix[1].DD1.neg vpd[1]_32 9.3
rvpd[1]_36 vpd[1]_7 vpd[1]_8 0.216584
rvpd[1]_35 vpd[1]_7 vpd[1]_10 0.0698411
rvpd[1]_34 vpd[1]_8 vpd[1]_20 0.0373109
rvpd[1]_33 vpd[1]_9 vpd[1]_10 1.0396
rvpd[1]_32 vpd[1]_9 vpd[1]_26 0.0137558
rvpd[1]_31 vpd[1]_11 vpd[1]_12 1.32426
rvpd[1]_30 vpd[1]_11 vpd[1]_22 0.0073411
rvpd[1]_29 vpd[1]_12 vpd[1]_26 0.0529306
rvpd[1]_28 vpd[1]_13 vpd[1]_14 0.841584
rvpd[1]_27 vpd[1]_13 vpd[1]_26 0.0529306
rvpd[1]_26 vpd[1]_14 vpd[1]_27 0.0513368
rvpd[1]_25 vpd[1]_16 vpd[1]_58 3.76238
rvpd[1]_24 vpd[1]_16 vpd[1]_24 0.0073411
rvpd[1]_23 vpd[1]_18 vpd[1]_20 0.0752618
rvpd[1]_22 vpd[1]_18 vpd[1]_34 9.3
rvpd[1]_21 vpd[1]_22 vpd[1]_24 0.241337
rvpd[1]_20 vpd[1]_27 vpd[1]_30 0.0473108
rvpd[1]_19 vpd[1]_30 xPix[1].MMpd.s 9.3
rvpd[1]_18 vpd[1]_32 vpd[1]_58 0.118702
rvpd[1]_17 vpd[1]_32 vpd[1] 0.00747012
rvpd[1]_16 vpd[1]_34 vpd[1]_49 152
rvpd[1]_15 vpd[1]_49 xPix[1].MMpr.amp.g 113.586
rrowReadOFF[0]_27 rowReadOFF[0]_1 rowReadOFF[0]_3 0.0687173
rrowReadOFF[0]_26 rowReadOFF[0]_1 rowReadOFF[0]_6 0.110863
rrowReadOFF[0]_25 rowReadOFF[0]_3 rowReadOFF[0]_9 9.3
rrowReadOFF[0]_24 rowReadOFF[0]_6 rowReadOFF[0]_7 4.5
rrowReadOFF[0]_23 rowReadOFF[0]_7 rowReadOFF[0] 1.69118
rrowReadOFF[0]_22 rowReadOFF[0]_7 rowReadOFF[0]_27 10.1923
rrowReadOFF[0]_21 rowReadOFF[0]_9 rowReadOFF[0]_18 152
rrowReadOFF[0]_20 xPix[0].MMN11.g rowReadOFF[0]_19 210.234
rrowReadOFF[0]_19 rowReadOFF[0]_18 rowReadOFF[0]_19 52.7279
rrowReadOFF[0]_18 rowReadOFF[0]_21 rowReadOFF[0]_23 0.0687173
rrowReadOFF[0]_17 rowReadOFF[0]_21 rowReadOFF[0]_26 0.110863
rrowReadOFF[0]_16 rowReadOFF[0]_23 rowReadOFF[0]_29 9.3
rrowReadOFF[0]_15 rowReadOFF[0]_26 rowReadOFF[0]_27 4.5
rrowReadOFF[0]_14 rowReadOFF[0]_27 rowReadOFF[0] 1.69118
rrowReadOFF[0]_13 rowReadOFF[0]_29 rowReadOFF[0]_38 152
rrowReadOFF[0]_12 xPix[2].MMN11.g rowReadOFF[0]_39 210.234
rrowReadOFF[0]_11 rowReadOFF[0]_38 rowReadOFF[0]_39 52.7279
rrowReadON[0]_79 rowReadON[0]_9 rowReadON[0]_16 0.0752618
rrowReadON[0]_78 rowReadON[0]_9 rowReadON[0]_33 9.3
rrowReadON[0]_77 rowReadON[0]_12 rowReadON[0]_14 0.0719419
rrowReadON[0]_76 rowReadON[0]_12 rowReadON[0]_17 4.5
rrowReadON[0]_75 rowReadON[0]_14 rowReadON[0]_15 0.292339
rrowReadON[0]_74 rowReadON[0]_15 rowReadON[0]_16 0.0458115
rrowReadON[0]_73 rowReadON[0]_17 rowReadON[0] 1.18778
rrowReadON[0]_72 rowReadON[0]_17 rowReadON[0]_66 11.1991
rrowReadON[0]_71 rowReadON[0]_18 rowReadON[0]_19 22.5882
rrowReadON[0]_70 rowReadON[0]_18 rowReadON[0]_21 7.15173
rrowReadON[0]_69 rowReadON[0]_19 rowReadON[0]_26 0.751729
rrowReadON[0]_68 rowReadON[0]_20 rowReadON[0]_21 43.8075
rrowReadON[0]_67 rowReadON[0]_20 rowReadON[0]_23 7.15173
rrowReadON[0]_66 rowReadON[0]_22 rowReadON[0]_23 27.0374
rrowReadON[0]_65 rowReadON[0]_22 rowReadON[0]_25 7.15173
rrowReadON[0]_64 rowReadON[0]_24 rowReadON[0]_25 13.6898
rrowReadON[0]_63 rowReadON[0]_24 rowReadON[0]_33 12.3509
rrowReadON[0]_62 rowReadON[0]_26 rowReadON[0]_29 5.47594
rrowReadON[0]_61 rowReadON[0]_29 rowReadON[0]_44 152
rrowReadON[0]_60 rowReadON[0]_33 rowReadON[0]_47 152
rrowReadON[0]_59 rowReadON[0]_35 xPix[0].MMPDRefrRow.g 210.234
rrowReadON[0]_58 rowReadON[0]_35 rowReadON[0]_44 52.7279
rrowReadON[0]_57 xPix[0].MMN10.g rowReadON[0]_48 210.234
rrowReadON[0]_56 rowReadON[0]_47 rowReadON[0]_48 52.7279
rrowReadON[0]_55 rowReadON[0]_58 rowReadON[0]_65 0.0752618
rrowReadON[0]_54 rowReadON[0]_58 rowReadON[0]_82 9.3
rrowReadON[0]_53 rowReadON[0]_61 rowReadON[0]_63 0.0719419
rrowReadON[0]_52 rowReadON[0]_61 rowReadON[0]_66 4.5
rrowReadON[0]_51 rowReadON[0]_63 rowReadON[0]_64 0.292339
rrowReadON[0]_50 rowReadON[0]_64 rowReadON[0]_65 0.0458115
rrowReadON[0]_49 rowReadON[0]_66 rowReadON[0] 1.18778
rrowReadON[0]_48 rowReadON[0]_67 rowReadON[0]_68 22.5882
rrowReadON[0]_47 rowReadON[0]_67 rowReadON[0]_70 7.15173
rrowReadON[0]_46 rowReadON[0]_68 rowReadON[0]_75 0.751729
rrowReadON[0]_45 rowReadON[0]_69 rowReadON[0]_70 43.8075
rrowReadON[0]_44 rowReadON[0]_69 rowReadON[0]_72 7.15173
rrowReadON[0]_43 rowReadON[0]_71 rowReadON[0]_72 27.0374
rrowReadON[0]_42 rowReadON[0]_71 rowReadON[0]_74 7.15173
rrowReadON[0]_41 rowReadON[0]_73 rowReadON[0]_74 13.6898
rrowReadON[0]_40 rowReadON[0]_73 rowReadON[0]_82 12.3509
rrowReadON[0]_39 rowReadON[0]_75 rowReadON[0]_78 5.47594
rrowReadON[0]_38 rowReadON[0]_78 rowReadON[0]_93 152
rrowReadON[0]_37 rowReadON[0]_82 rowReadON[0]_96 152
rrowReadON[0]_36 rowReadON[0]_84 xPix[2].MMPDRefrRow.g 210.234
rrowReadON[0]_35 rowReadON[0]_84 rowReadON[0]_93 52.7279
rrowReadON[0]_34 xPix[2].MMN10.g rowReadON[0]_97 210.234
rrowReadON[0]_33 rowReadON[0]_96 rowReadON[0]_97 52.7279
rrowReadOFF[1]_27 rowReadOFF[1]_1 rowReadOFF[1]_3 0.0687173
rrowReadOFF[1]_26 rowReadOFF[1]_1 rowReadOFF[1]_6 0.110863
rrowReadOFF[1]_25 rowReadOFF[1]_3 rowReadOFF[1]_9 9.3
rrowReadOFF[1]_24 rowReadOFF[1]_6 rowReadOFF[1]_7 4.5
rrowReadOFF[1]_23 rowReadOFF[1]_7 rowReadOFF[1] 1.69118
rrowReadOFF[1]_22 rowReadOFF[1]_7 rowReadOFF[1]_27 10.1923
rrowReadOFF[1]_21 rowReadOFF[1]_9 rowReadOFF[1]_18 152
rrowReadOFF[1]_20 xPix[1].MMN11.g rowReadOFF[1]_19 210.234
rrowReadOFF[1]_19 rowReadOFF[1]_18 rowReadOFF[1]_19 52.7279
rrowReadOFF[1]_18 rowReadOFF[1]_21 rowReadOFF[1]_23 0.0687173
rrowReadOFF[1]_17 rowReadOFF[1]_21 rowReadOFF[1]_26 0.110863
rrowReadOFF[1]_16 rowReadOFF[1]_23 rowReadOFF[1]_29 9.3
rrowReadOFF[1]_15 rowReadOFF[1]_26 rowReadOFF[1]_27 4.5
rrowReadOFF[1]_14 rowReadOFF[1]_27 rowReadOFF[1] 1.69118
rrowReadOFF[1]_13 rowReadOFF[1]_29 rowReadOFF[1]_38 152
rrowReadOFF[1]_12 xPix[3].MMN11.g rowReadOFF[1]_39 210.234
rrowReadOFF[1]_11 rowReadOFF[1]_38 rowReadOFF[1]_39 52.7279
rrowReadON[1]_79 rowReadON[1]_9 rowReadON[1]_16 0.0752618
rrowReadON[1]_78 rowReadON[1]_9 rowReadON[1]_33 9.3
rrowReadON[1]_77 rowReadON[1]_12 rowReadON[1]_14 0.0719419
rrowReadON[1]_76 rowReadON[1]_12 rowReadON[1]_17 4.5
rrowReadON[1]_75 rowReadON[1]_14 rowReadON[1]_15 0.292339
rrowReadON[1]_74 rowReadON[1]_15 rowReadON[1]_16 0.0458115
rrowReadON[1]_73 rowReadON[1]_17 rowReadON[1] 1.18778
rrowReadON[1]_72 rowReadON[1]_17 rowReadON[1]_66 11.1991
rrowReadON[1]_71 rowReadON[1]_18 rowReadON[1]_19 22.5882
rrowReadON[1]_70 rowReadON[1]_18 rowReadON[1]_21 7.15173
rrowReadON[1]_69 rowReadON[1]_19 rowReadON[1]_26 0.751729
rrowReadON[1]_68 rowReadON[1]_20 rowReadON[1]_21 43.8075
rrowReadON[1]_67 rowReadON[1]_20 rowReadON[1]_23 7.15173
rrowReadON[1]_66 rowReadON[1]_22 rowReadON[1]_23 27.0374
rrowReadON[1]_65 rowReadON[1]_22 rowReadON[1]_25 7.15173
rrowReadON[1]_64 rowReadON[1]_24 rowReadON[1]_25 13.6898
rrowReadON[1]_63 rowReadON[1]_24 rowReadON[1]_33 12.3509
rrowReadON[1]_62 rowReadON[1]_26 rowReadON[1]_29 5.47594
rrowReadON[1]_61 rowReadON[1]_29 rowReadON[1]_44 152
rrowReadON[1]_60 rowReadON[1]_33 rowReadON[1]_47 152
rrowReadON[1]_59 rowReadON[1]_35 xPix[1].MMPDRefrRow.g 210.234
rrowReadON[1]_58 rowReadON[1]_35 rowReadON[1]_44 52.7279
rrowReadON[1]_57 xPix[1].MMN10.g rowReadON[1]_48 210.234
rrowReadON[1]_56 rowReadON[1]_47 rowReadON[1]_48 52.7279
rrowReadON[1]_55 rowReadON[1]_58 rowReadON[1]_65 0.0752618
rrowReadON[1]_54 rowReadON[1]_58 rowReadON[1]_82 9.3
rrowReadON[1]_53 rowReadON[1]_61 rowReadON[1]_63 0.0719419
rrowReadON[1]_52 rowReadON[1]_61 rowReadON[1]_66 4.5
rrowReadON[1]_51 rowReadON[1]_63 rowReadON[1]_64 0.292339
rrowReadON[1]_50 rowReadON[1]_64 rowReadON[1]_65 0.0458115
rrowReadON[1]_49 rowReadON[1]_66 rowReadON[1] 1.18778
rrowReadON[1]_48 rowReadON[1]_67 rowReadON[1]_68 22.5882
rrowReadON[1]_47 rowReadON[1]_67 rowReadON[1]_70 7.15173
rrowReadON[1]_46 rowReadON[1]_68 rowReadON[1]_75 0.751729
rrowReadON[1]_45 rowReadON[1]_69 rowReadON[1]_70 43.8075
rrowReadON[1]_44 rowReadON[1]_69 rowReadON[1]_72 7.15173
rrowReadON[1]_43 rowReadON[1]_71 rowReadON[1]_72 27.0374
rrowReadON[1]_42 rowReadON[1]_71 rowReadON[1]_74 7.15173
rrowReadON[1]_41 rowReadON[1]_73 rowReadON[1]_74 13.6898
rrowReadON[1]_40 rowReadON[1]_73 rowReadON[1]_82 12.3509
rrowReadON[1]_39 rowReadON[1]_75 rowReadON[1]_78 5.47594
rrowReadON[1]_38 rowReadON[1]_78 rowReadON[1]_93 152
rrowReadON[1]_37 rowReadON[1]_82 rowReadON[1]_96 152
rrowReadON[1]_36 rowReadON[1]_84 xPix[3].MMPDRefrRow.g 210.234
rrowReadON[1]_35 rowReadON[1]_84 rowReadON[1]_93 52.7279
rrowReadON[1]_34 xPix[3].MMN10.g rowReadON[1]_97 210.234
rrowReadON[1]_33 rowReadON[1]_96 rowReadON[1]_97 52.7279
rGndD_87 GndD_1 GndD_3 0.221614
rGndD_86 GndD_1 GndD_5 0.0700611
rGndD_85 GndD_3 xPix[1].MMN7.s 9.3
rGndD_84 GndD_5 GndD_7 0.0845196
rGndD_83 GndD_7 GndD_18 1.5
rGndD_82 GndD_9 GndD_11 0.0845196
rGndD_81 GndD_9 GndD_13 0.0700611
rGndD_80 GndD_11 GndD_17 1.5
rGndD_79 GndD_13 GndD_15 0.221614
rGndD_78 GndD_15 xPix[1].MMN8.s 9.3
rGndD_77 GndD_17 GndD_43 1.5
rGndD_76 GndD_17 GndD_18 0.196412
rGndD_75 GndD_17 GndD_81 1.9505
rGndD_74 GndD_18 GndD_39 1.5
rGndD_73 GndD_18 GndD_150 0.126022
rGndD_72 GndD_33 GndD_35 0.221614
rGndD_71 GndD_33 GndD_37 0.0700611
rGndD_70 GndD_35 xPix[0].MMN7.s 9.3
rGndD_69 GndD_37 GndD_39 0.0845196
rGndD_68 GndD_41 GndD_43 0.0845196
rGndD_67 GndD_41 GndD_45 0.0700611
rGndD_66 GndD_45 GndD_47 0.221614
rGndD_65 GndD_47 xPix[0].MMN8.s 9.3
rGndD_64 GndD_65 GndD_67 0.221614
rGndD_63 GndD_65 GndD_69 0.0700611
rGndD_62 GndD_67 xPix[3].MMN7.s 9.3
rGndD_61 GndD_69 GndD_71 0.0845196
rGndD_60 GndD_71 GndD_82 1.5
rGndD_59 GndD_73 GndD_75 0.0845196
rGndD_58 GndD_73 GndD_77 0.0700611
rGndD_57 GndD_75 GndD_81 1.5
rGndD_56 GndD_77 GndD_79 0.221614
rGndD_55 GndD_79 xPix[3].MMN8.s 9.3
rGndD_54 GndD_81 GndD_107 1.5
rGndD_53 GndD_81 GndD_82 0.196412
rGndD_52 GndD_82 GndD_103 1.5
rGndD_51 GndD_82 GndD_149 0.126022
rGndD_50 GndD_97 GndD_99 0.221614
rGndD_49 GndD_97 GndD_101 0.0700611
rGndD_48 GndD_99 xPix[2].MMN7.s 9.3
rGndD_47 GndD_101 GndD_103 0.0845196
rGndD_46 GndD_105 GndD_107 0.0845196
rGndD_45 GndD_105 GndD_109 0.0700611
rGndD_44 GndD_109 GndD_111 0.221614
rGndD_43 GndD_111 xPix[2].MMN8.s 9.3
rGndD_42 GndD_138 GndD_141 0.132904
rGndD_41 GndD_138 GndD_156 1.125
rGndD_40 GndD_141 GndD_156 2.25
rGndD_39 GndD_144 GndD_147 0.132904
rGndD_38 GndD_144 GndD_161 1.125
rGndD_37 GndD_147 GndD_161 2.25
rGndD_36 GndD_149 GndD_161 0.0455087
rGndD_35 GndD_150 GndD 0.0630526
rGndD_34 GndD_156 GndD 0.0184884
rGndD_33 GndD_161 GndD 0.0186047
rpixRst[1]_33 pixRst[1]_3 pixRst[1]_8 0.29123
rpixRst[1]_32 pixRst[1]_3 pixRst[1]_17 9.3
rpixRst[1]_31 pixRst[1]_6 pixRst[1]_8 0.093249
rpixRst[1]_30 pixRst[1]_6 pixRst[1]_13 4.5
rpixRst[1]_29 pixRst[1]_10 pixRst[1]_13 0.0585347
rpixRst[1]_28 pixRst[1]_10 pixRst[1]_15 3.41
rpixRst[1]_27 pixRst[1]_15 pixRst[1] 1.58798
rpixRst[1]_26 pixRst[1]_15 pixRst[1]_42 0.522393
rpixRst[1]_25 pixRst[1]_17 pixRst[1]_26 152
rpixRst[1]_24 pixRst[1]_21 xPix[3].MMPDrefrCol.g 210.234
rpixRst[1]_23 pixRst[1]_21 pixRst[1]_26 52.7279
rpixRst[1]_22 pixRst[1]_30 pixRst[1]_35 0.29123
rpixRst[1]_21 pixRst[1]_30 pixRst[1]_44 9.3
rpixRst[1]_20 pixRst[1]_33 pixRst[1]_35 0.093249
rpixRst[1]_19 pixRst[1]_33 pixRst[1]_40 4.5
rpixRst[1]_18 pixRst[1]_37 pixRst[1]_40 0.0585347
rpixRst[1]_17 pixRst[1]_37 pixRst[1]_42 3.41
rpixRst[1]_16 pixRst[1]_42 pixRst[1] 1.58798
rpixRst[1]_15 pixRst[1]_44 pixRst[1]_53 152
rpixRst[1]_14 pixRst[1]_48 xPix[2].MMPDrefrCol.g 210.234
rpixRst[1]_13 pixRst[1]_48 pixRst[1]_53 52.7279
rreadLine[1]_63 xPix[2].MMN11.d xPix[2].MMN10.d 0.01
rreadLine[1]_62 xPix[3].MMN11.d xPix[3].MMN10.d 0.01
rreadLine[1]_61 readLine[1]_5 readLine[1]_6 0.389851
rreadLine[1]_60 readLine[1]_5 readLine[1]_8 0.118702
rreadLine[1]_59 readLine[1]_6 readLine[1]_11 0.13093
rreadLine[1]_58 readLine[1]_8 xPix[3].MMN10.d 9.3
rreadLine[1]_57 readLine[1]_11 readLine[1]_27 4.5
rreadLine[1]_56 readLine[1]_13 readLine[1]_14 0.173267
rreadLine[1]_55 readLine[1]_13 readLine[1]_25 0.0642422
rreadLine[1]_54 readLine[1]_14 readLine[1]_16 0.0698411
rreadLine[1]_53 readLine[1]_15 readLine[1]_16 0.971535
rreadLine[1]_52 readLine[1]_15 readLine[1]_18 0.0698411
rreadLine[1]_51 readLine[1]_17 readLine[1]_18 0.309406
rreadLine[1]_50 readLine[1]_17 readLine[1]_20 0.0698411
rreadLine[1]_49 readLine[1]_20 readLine[1]_28 1.06436
rreadLine[1]_48 readLine[1]_22 readLine[1]_24 0.0665266
rreadLine[1]_47 readLine[1]_22 readLine[1]_30 3.41
rreadLine[1]_46 readLine[1]_24 readLine[1]_25 0.0070028
rreadLine[1]_45 readLine[1]_27 readLine[1]_28 0.13093
rreadLine[1]_44 readLine[1]_30 readLine[1] 1.58798
rreadLine[1]_43 readLine[1]_30 readLine[1]_67 0.522393
rreadLine[1]_42 readLine[1]_42 readLine[1]_43 0.389851
rreadLine[1]_41 readLine[1]_42 readLine[1]_45 0.118702
rreadLine[1]_40 readLine[1]_43 readLine[1]_48 0.13093
rreadLine[1]_39 readLine[1]_45 xPix[2].MMN10.d 9.3
rreadLine[1]_38 readLine[1]_48 readLine[1]_64 4.5
rreadLine[1]_37 readLine[1]_50 readLine[1]_51 0.173267
rreadLine[1]_36 readLine[1]_50 readLine[1]_62 0.0642422
rreadLine[1]_35 readLine[1]_51 readLine[1]_53 0.0698411
rreadLine[1]_34 readLine[1]_52 readLine[1]_53 0.971535
rreadLine[1]_33 readLine[1]_52 readLine[1]_55 0.0698411
rreadLine[1]_32 readLine[1]_54 readLine[1]_55 0.309406
rreadLine[1]_31 readLine[1]_54 readLine[1]_57 0.0698411
rreadLine[1]_30 readLine[1]_57 readLine[1]_65 1.06436
rreadLine[1]_29 readLine[1]_59 readLine[1]_61 0.0665266
rreadLine[1]_28 readLine[1]_59 readLine[1]_67 3.41
rreadLine[1]_27 readLine[1]_61 readLine[1]_62 0.0070028
rreadLine[1]_26 readLine[1]_64 readLine[1]_65 0.13093
rreadLine[1]_25 readLine[1]_67 readLine[1] 1.58798
rOnBn_203 OnBn_1 OnBn_27 9.3
rOnBn_202 OnBn_1 OnBn_178 0.061645
rOnBn_201 OnBn_1 OnBn_180 0.00934164
rOnBn_200 OnBn_2 OnBn_23 3.1
rOnBn_199 OnBn_2 OnBn_178 0.331522
rOnBn_198 OnBn_4 OnBn_5 0.371287
rOnBn_197 OnBn_4 OnBn_197 0.0698411
rOnBn_196 OnBn_5 OnBn_7 0.0698411
rOnBn_195 OnBn_6 OnBn_7 6.52228
rOnBn_194 OnBn_6 OnBn_20 0.0073411
rOnBn_193 OnBn_9 OnBn_209 0.618812
rOnBn_192 OnBn_9 OnBn_18 0.0073411
rOnBn_191 OnBn_11 OnBn_12 1.99257
rOnBn_190 OnBn_11 OnBn_199 0.0698411
rOnBn_189 OnBn_12 OnBn_15 0.0698411
rOnBn_188 OnBn_14 OnBn_15 0.19802
rOnBn_187 OnBn_14 OnBn_16 0.0698411
rOnBn_186 OnBn_16 OnBn_17 1.2005
rOnBn_185 OnBn_17 OnBn_201 0.0698411
rOnBn_184 OnBn_18 OnBn_20 0.284653
rOnBn_183 OnBn_23 OnBn_27 49.2834
rOnBn_182 OnBn_23 OnBn_34 50.6667
rOnBn_181 OnBn_27 OnBn_34 152
rOnBn_180 xPix[1].MMonBias.g OnBn_34 37.2181
rOnBn_179 OnBn_37 OnBn_63 9.3
rOnBn_178 OnBn_37 OnBn_183 0.061645
rOnBn_177 OnBn_37 OnBn_185 0.00934164
rOnBn_176 OnBn_38 OnBn_59 3.1
rOnBn_175 OnBn_38 OnBn_183 0.331522
rOnBn_174 OnBn_40 OnBn_41 0.371287
rOnBn_173 OnBn_40 OnBn_198 0.0698411
rOnBn_172 OnBn_41 OnBn_43 0.0698411
rOnBn_171 OnBn_42 OnBn_43 6.52228
rOnBn_170 OnBn_42 OnBn_56 0.0073411
rOnBn_169 OnBn_45 OnBn_210 0.618812
rOnBn_168 OnBn_45 OnBn_54 0.0073411
rOnBn_167 OnBn_47 OnBn_48 1.99257
rOnBn_166 OnBn_47 OnBn_200 0.0698411
rOnBn_165 OnBn_48 OnBn_51 0.0698411
rOnBn_164 OnBn_50 OnBn_51 0.19802
rOnBn_163 OnBn_50 OnBn_52 0.0698411
rOnBn_162 OnBn_52 OnBn_53 1.2005
rOnBn_161 OnBn_53 OnBn_202 0.0698411
rOnBn_160 OnBn_54 OnBn_56 0.284653
rOnBn_159 OnBn_59 OnBn_63 49.2834
rOnBn_158 OnBn_59 OnBn_70 50.6667
rOnBn_157 OnBn_63 OnBn_70 152
rOnBn_156 xPix[0].MMonBias.g OnBn_70 37.2181
rOnBn_155 OnBn_73 OnBn_99 9.3
rOnBn_154 OnBn_73 OnBn_188 0.0088968
rOnBn_153 OnBn_73 OnBn_191 0.061645
rOnBn_152 OnBn_74 OnBn_95 3.1
rOnBn_151 OnBn_74 OnBn_191 0.331522
rOnBn_150 OnBn_76 OnBn_77 0.371287
rOnBn_149 OnBn_76 OnBn_207 0.0698411
rOnBn_148 OnBn_77 OnBn_79 0.0698411
rOnBn_147 OnBn_78 OnBn_79 6.52228
rOnBn_146 OnBn_78 OnBn_92 0.0073411
rOnBn_145 OnBn_81 OnBn_211 0.618812
rOnBn_144 OnBn_81 OnBn_90 0.0073411
rOnBn_143 OnBn_83 OnBn_84 1.99257
rOnBn_142 OnBn_83 OnBn_205 0.0698411
rOnBn_141 OnBn_84 OnBn_87 0.0698411
rOnBn_140 OnBn_86 OnBn_87 0.19802
rOnBn_139 OnBn_86 OnBn_88 0.0698411
rOnBn_138 OnBn_88 OnBn_89 1.2005
rOnBn_137 OnBn_89 OnBn_203 0.0698411
rOnBn_136 OnBn_90 OnBn_92 0.284653
rOnBn_135 OnBn_95 OnBn_99 49.2834
rOnBn_134 OnBn_95 OnBn_106 50.6667
rOnBn_133 OnBn_99 OnBn_106 152
rOnBn_132 xPix[3].MMonBias.g OnBn_106 37.2181
rOnBn_131 OnBn_109 OnBn_135 9.3
rOnBn_130 OnBn_109 OnBn_193 0.0088968
rOnBn_129 OnBn_109 OnBn_196 0.061645
rOnBn_128 OnBn_110 OnBn_131 3.1
rOnBn_127 OnBn_110 OnBn_196 0.331522
rOnBn_126 OnBn_112 OnBn_113 0.371287
rOnBn_125 OnBn_112 OnBn_208 0.0698411
rOnBn_124 OnBn_113 OnBn_115 0.0698411
rOnBn_123 OnBn_114 OnBn_115 6.52228
rOnBn_122 OnBn_114 OnBn_128 0.0073411
rOnBn_121 OnBn_117 OnBn_212 0.618812
rOnBn_120 OnBn_117 OnBn_126 0.0073411
rOnBn_119 OnBn_119 OnBn_120 1.99257
rOnBn_118 OnBn_119 OnBn_206 0.0698411
rOnBn_117 OnBn_120 OnBn_123 0.0698411
rOnBn_116 OnBn_122 OnBn_123 0.19802
rOnBn_115 OnBn_122 OnBn_124 0.0698411
rOnBn_114 OnBn_124 OnBn_125 1.2005
rOnBn_113 OnBn_125 OnBn_204 0.0698411
rOnBn_112 OnBn_126 OnBn_128 0.284653
rOnBn_111 OnBn_131 OnBn_135 49.2834
rOnBn_110 OnBn_131 OnBn_142 50.6667
rOnBn_109 OnBn_135 OnBn_142 152
rOnBn_108 xPix[2].MMonBias.g OnBn_142 37.2181
rOnBn_107 OnBn_180 OnBn_215 4.5
rOnBn_106 OnBn_185 OnBn_219 4.5
rOnBn_105 OnBn_188 OnBn_231 4.5
rOnBn_104 OnBn_193 OnBn_235 4.5
rOnBn_103 OnBn_197 OnBn_221 3.21782
rOnBn_102 OnBn_198 OnBn_222 3.21782
rOnBn_101 OnBn_199 OnBn_205 2.27723
rOnBn_100 OnBn_200 OnBn_206 2.27723
rOnBn_99 OnBn_201 OnBn_238 0.779703
rOnBn_98 OnBn_202 OnBn_240 0.779703
rOnBn_97 OnBn_203 OnBn_243 0.779703
rOnBn_96 OnBn_204 OnBn_247 0.779703
rOnBn_95 OnBn_207 OnBn_227 3.21782
rOnBn_94 OnBn_208 OnBn_228 3.21782
rOnBn_93 OnBn_209 OnBn_238 0.192188
rOnBn_92 OnBn_210 OnBn_240 0.192188
rOnBn_91 OnBn_211 OnBn_242 0.139052
rOnBn_90 OnBn_212 OnBn_246 0.139052
rOnBn_89 OnBn_213 OnBn_215 0.0910634
rOnBn_88 OnBn_213 OnBn_221 0.0783445
rOnBn_87 OnBn_217 OnBn_219 0.0904977
rOnBn_86 OnBn_217 OnBn_222 0.0783445
rOnBn_85 OnBn_227 OnBn_229 0.0783445
rOnBn_84 OnBn_228 OnBn_233 0.0783445
rOnBn_83 OnBn_229 OnBn_231 0.0910634
rOnBn_82 OnBn_233 OnBn_235 0.0904977
rOnBn_81 OnBn_242 OnBn_243 0.14009
rOnBn_80 OnBn_242 OnBn_253 3.41
rOnBn_79 OnBn_246 OnBn_247 0.14009
rOnBn_78 OnBn_246 OnBn_255 3.41
rOnBn_77 OnBn OnBn_253 0.341482
rOnBn_76 OnBn_253 OnBn_255 3.01555
rOnBn_75 OnBn_255 OnBn 0.341328
rRefrBp_61 RefrBp_1 RefrBp_8 9.3
rRefrBp_60 RefrBp_1 RefrBp_2 0.471204
rRefrBp_59 RefrBp_1 RefrBp_37 0.471204
rRefrBp_58 RefrBp_2 RefrBp_4 3.1
rRefrBp_57 RefrBp_4 RefrBp_8 49.2834
rRefrBp_56 RefrBp_4 RefrBp_12 50.6667
rRefrBp_55 RefrBp_8 RefrBp_17 152
rRefrBp_54 RefrBp_12 xPix[1].MMrefrBias.g 7.93053
rRefrBp_53 xPix[1].MMrefrBias.g RefrBp_17 23.7916
rRefrBp_52 RefrBp_19 RefrBp_26 9.3
rRefrBp_51 RefrBp_19 RefrBp_20 0.471204
rRefrBp_50 RefrBp_19 RefrBp_55 0.471204
rRefrBp_49 RefrBp_20 RefrBp_22 3.1
rRefrBp_48 RefrBp_22 RefrBp_26 49.2834
rRefrBp_47 RefrBp_22 RefrBp_30 50.6667
rRefrBp_46 RefrBp_26 RefrBp_35 152
rRefrBp_45 RefrBp_30 xPix[0].MMrefrBias.g 7.93053
rRefrBp_44 xPix[0].MMrefrBias.g RefrBp_35 23.7916
rRefrBp_43 RefrBp_37 RefrBp_44 9.3
rRefrBp_42 RefrBp_37 RefrBp_97 0.274869
rRefrBp_41 RefrBp_38 RefrBp_40 3.1
rRefrBp_40 RefrBp_38 RefrBp_96 0.0524924
rRefrBp_39 RefrBp_40 RefrBp_44 49.2834
rRefrBp_38 RefrBp_40 RefrBp_48 50.6667
rRefrBp_37 RefrBp_44 RefrBp_53 152
rRefrBp_36 RefrBp_48 xPix[3].MMrefrBias.g 7.93053
rRefrBp_35 xPix[3].MMrefrBias.g RefrBp_53 23.7916
rRefrBp_34 RefrBp_55 RefrBp_62 9.3
rRefrBp_33 RefrBp_55 RefrBp_102 0.274869
rRefrBp_32 RefrBp_56 RefrBp_58 3.1
rRefrBp_31 RefrBp_56 RefrBp_101 0.0524924
rRefrBp_30 RefrBp_58 RefrBp_62 49.2834
rRefrBp_29 RefrBp_58 RefrBp_66 50.6667
rRefrBp_28 RefrBp_62 RefrBp_71 152
rRefrBp_27 RefrBp_66 xPix[2].MMrefrBias.g 7.93053
rRefrBp_26 xPix[2].MMrefrBias.g RefrBp_71 23.7916
rRefrBp_25 RefrBp_96 RefrBp_97 0.0827918
rRefrBp_24 RefrBp_96 RefrBp_109 4.5
rRefrBp_23 RefrBp_101 RefrBp_102 0.0827918
rRefrBp_22 RefrBp_101 RefrBp_115 4.5
rRefrBp_21 RefrBp_106 RefrBp_109 0.00259336
rRefrBp_20 RefrBp_106 RefrBp_121 3.41
rRefrBp_19 RefrBp_112 RefrBp_115 0.00259336
rRefrBp_18 RefrBp_112 RefrBp_123 3.41
rRefrBp_17 RefrBp RefrBp_121 1.04648
rRefrBp_16 RefrBp_121 RefrBp_123 1.60555
rRefrBp_15 RefrBp_123 RefrBp 1.04633
rPrBp_40 xPix[1].MMprBias.g PrBp_51 230.745
rPrBp_39 xPix[0].MMprBias.g PrBp_54 230.745
rPrBp_38 xPix[3].MMprBias.g PrBp_57 230.745
rPrBp_37 xPix[2].MMprBias.g PrBp_60 230.745
rPrBp_36 PrBp_10 PrBp_20 4.5
rPrBp_35 PrBp_10 PrBp_42 9.3
rPrBp_34 PrBp_13 PrBp_23 4.5
rPrBp_33 PrBp_13 PrBp_47 9.3
rPrBp_32 PrBp_15 PrBp_16 1.67079
rPrBp_31 PrBp_15 PrBp_20 0.127536
rPrBp_30 PrBp_16 PrBp_27 0.150763
rPrBp_29 PrBp_17 PrBp_18 1.67079
rPrBp_28 PrBp_17 PrBp_30 0.150763
rPrBp_27 PrBp_18 PrBp_23 0.128102
rPrBp_26 PrBp_27 PrBp_35 3.41
rPrBp_25 PrBp_30 PrBp_37 3.41
rPrBp_24 PrBp PrBp_35 0.628105
rPrBp_23 PrBp_35 PrBp_37 2.4423
rPrBp_22 PrBp_37 PrBp 0.627951
rPrBp_21 PrBp_42 PrBp_64 152
rPrBp_20 PrBp_47 PrBp_66 152
rPrBp_19 PrBp_51 PrBp_64 52.9531
rPrBp_18 PrBp_54 PrBp_66 52.9531
rPrBp_17 PrBp_57 PrBp_64 52.5026
rPrBp_16 PrBp_60 PrBp_66 52.5026
rPrSFBp_65 PrSFBp_1 PrSFBp_8 9.3
rPrSFBp_64 PrSFBp_1 PrSFBp_96 0.0647257
rPrSFBp_63 PrSFBp_1 PrSFBp_98 0.0288462
rPrSFBp_62 PrSFBp_2 PrSFBp_4 3.1
rPrSFBp_61 PrSFBp_2 PrSFBp_96 0.399215
rPrSFBp_60 PrSFBp_4 PrSFBp_8 49.2834
rPrSFBp_59 PrSFBp_4 PrSFBp_12 50.6667
rPrSFBp_58 PrSFBp_8 PrSFBp_17 152
rPrSFBp_57 PrSFBp_12 xPix[1].MMP0.g 7.93053
rPrSFBp_56 xPix[1].MMP0.g PrSFBp_17 23.7916
rPrSFBp_55 PrSFBp_19 PrSFBp_26 9.3
rPrSFBp_54 PrSFBp_19 PrSFBp_101 0.0647257
rPrSFBp_53 PrSFBp_19 PrSFBp_103 0.0288462
rPrSFBp_52 PrSFBp_20 PrSFBp_22 3.1
rPrSFBp_51 PrSFBp_20 PrSFBp_101 0.399215
rPrSFBp_50 PrSFBp_22 PrSFBp_26 49.2834
rPrSFBp_49 PrSFBp_22 PrSFBp_30 50.6667
rPrSFBp_48 PrSFBp_26 PrSFBp_35 152
rPrSFBp_47 PrSFBp_30 xPix[0].MMP0.g 7.93053
rPrSFBp_46 xPix[0].MMP0.g PrSFBp_35 23.7916
rPrSFBp_45 PrSFBp_37 PrSFBp_44 9.3
rPrSFBp_44 PrSFBp_37 PrSFBp_99 0.33377
rPrSFBp_43 PrSFBp_37 PrSFBp_38 0.471204
rPrSFBp_42 PrSFBp_38 PrSFBp_40 3.1
rPrSFBp_41 PrSFBp_40 PrSFBp_44 49.2834
rPrSFBp_40 PrSFBp_40 PrSFBp_48 50.6667
rPrSFBp_39 PrSFBp_44 PrSFBp_53 152
rPrSFBp_38 PrSFBp_48 xPix[3].MMP0.g 7.93053
rPrSFBp_37 xPix[3].MMP0.g PrSFBp_53 23.7916
rPrSFBp_36 PrSFBp_55 PrSFBp_62 9.3
rPrSFBp_35 PrSFBp_55 PrSFBp_104 0.33377
rPrSFBp_34 PrSFBp_55 PrSFBp_56 0.471204
rPrSFBp_33 PrSFBp_56 PrSFBp_58 3.1
rPrSFBp_32 PrSFBp_58 PrSFBp_62 49.2834
rPrSFBp_31 PrSFBp_58 PrSFBp_66 50.6667
rPrSFBp_30 PrSFBp_62 PrSFBp_71 152
rPrSFBp_29 PrSFBp_66 xPix[2].MMP0.g 7.93053
rPrSFBp_28 xPix[2].MMP0.g PrSFBp_71 23.7916
rPrSFBp_27 PrSFBp_98 PrSFBp_99 0.0924406
rPrSFBp_26 PrSFBp_98 PrSFBp_109 4.5
rPrSFBp_25 PrSFBp_103 PrSFBp_104 0.0924406
rPrSFBp_24 PrSFBp_103 PrSFBp_112 4.5
rPrSFBp_23 PrSFBp_106 PrSFBp_109 0.00377644
rPrSFBp_22 PrSFBp_106 PrSFBp_121 3.41
rPrSFBp_21 PrSFBp_112 PrSFBp_115 0.00377644
rPrSFBp_20 PrSFBp_115 PrSFBp_123 3.41
rPrSFBp_19 PrSFBp PrSFBp_121 0.677416
rPrSFBp_18 PrSFBp_121 PrSFBp_123 2.34368
rPrSFBp_17 PrSFBp_123 PrSFBp 0.677262
rOffBn_207 OffBn_1 OffBn_28 9.3
rOffBn_206 OffBn_1 OffBn_177 0.314136
rOffBn_205 OffBn_2 OffBn_24 3.1
rOffBn_204 OffBn_2 OffBn_195 0.0458145
rOffBn_203 OffBn_4 OffBn_5 1.64604
rOffBn_202 OffBn_4 OffBn_17 0.0073411
rOffBn_201 OffBn_5 OffBn_7 0.0698411
rOffBn_200 OffBn_6 OffBn_7 3.36634
rOffBn_199 OffBn_6 OffBn_8 0.0698411
rOffBn_198 OffBn_8 OffBn_9 0.371287
rOffBn_197 OffBn_9 OffBn_11 0.0698411
rOffBn_196 OffBn_10 OffBn_11 7.22153
rOffBn_195 OffBn_10 OffBn_21 0.0242995
rOffBn_194 OffBn_15 OffBn_205 0.0073411
rOffBn_193 OffBn_15 OffBn_17 0.284653
rOffBn_192 OffBn_19 OffBn_207 0.0242995
rOffBn_191 OffBn_19 OffBn_21 0.0984589
rOffBn_190 OffBn_24 OffBn_28 49.2834
rOffBn_189 OffBn_24 OffBn_35 50.6667
rOffBn_188 OffBn_28 OffBn_35 152
rOffBn_187 xPix[1].MMoffBias.g OffBn_35 37.2181
rOffBn_186 OffBn_38 OffBn_65 9.3
rOffBn_185 OffBn_38 OffBn_180 0.314136
rOffBn_184 OffBn_39 OffBn_61 3.1
rOffBn_183 OffBn_39 OffBn_198 0.0458145
rOffBn_182 OffBn_41 OffBn_42 1.64604
rOffBn_181 OffBn_41 OffBn_54 0.0073411
rOffBn_180 OffBn_42 OffBn_44 0.0698411
rOffBn_179 OffBn_43 OffBn_44 3.36634
rOffBn_178 OffBn_43 OffBn_45 0.0698411
rOffBn_177 OffBn_45 OffBn_46 0.371287
rOffBn_176 OffBn_46 OffBn_48 0.0698411
rOffBn_175 OffBn_47 OffBn_48 7.22153
rOffBn_174 OffBn_47 OffBn_58 0.0242995
rOffBn_173 OffBn_52 OffBn_206 0.0073411
rOffBn_172 OffBn_52 OffBn_54 0.284653
rOffBn_171 OffBn_56 OffBn_208 0.0242995
rOffBn_170 OffBn_56 OffBn_58 0.0984589
rOffBn_169 OffBn_61 OffBn_65 49.2834
rOffBn_168 OffBn_61 OffBn_72 50.6667
rOffBn_167 OffBn_65 OffBn_72 152
rOffBn_166 xPix[0].MMoffBias.g OffBn_72 37.2181
rOffBn_165 OffBn_75 OffBn_102 9.3
rOffBn_164 OffBn_75 OffBn_183 0.314136
rOffBn_163 OffBn_76 OffBn_98 3.1
rOffBn_162 OffBn_76 OffBn_200 0.0452489
rOffBn_161 OffBn_78 OffBn_79 1.64604
rOffBn_160 OffBn_78 OffBn_91 0.0073411
rOffBn_159 OffBn_79 OffBn_81 0.0698411
rOffBn_158 OffBn_80 OffBn_81 3.36634
rOffBn_157 OffBn_80 OffBn_82 0.0698411
rOffBn_156 OffBn_82 OffBn_83 0.371287
rOffBn_155 OffBn_83 OffBn_85 0.0698411
rOffBn_154 OffBn_84 OffBn_85 7.22153
rOffBn_153 OffBn_84 OffBn_95 0.0242995
rOffBn_152 OffBn_89 OffBn_219 0.0073411
rOffBn_151 OffBn_89 OffBn_91 0.284653
rOffBn_150 OffBn_93 OffBn_217 0.0242995
rOffBn_149 OffBn_93 OffBn_95 0.0984589
rOffBn_148 OffBn_98 OffBn_102 49.2834
rOffBn_147 OffBn_98 OffBn_109 50.6667
rOffBn_146 OffBn_102 OffBn_109 152
rOffBn_145 xPix[3].MMoffBias.g OffBn_109 37.2181
rOffBn_144 OffBn_112 OffBn_139 9.3
rOffBn_143 OffBn_112 OffBn_186 0.314136
rOffBn_142 OffBn_113 OffBn_135 3.1
rOffBn_141 OffBn_113 OffBn_203 0.0452489
rOffBn_140 OffBn_115 OffBn_116 1.64604
rOffBn_139 OffBn_115 OffBn_128 0.0073411
rOffBn_138 OffBn_116 OffBn_118 0.0698411
rOffBn_137 OffBn_117 OffBn_118 3.36634
rOffBn_136 OffBn_117 OffBn_119 0.0698411
rOffBn_135 OffBn_119 OffBn_120 0.371287
rOffBn_134 OffBn_120 OffBn_122 0.0698411
rOffBn_133 OffBn_121 OffBn_122 7.22153
rOffBn_132 OffBn_121 OffBn_132 0.0242995
rOffBn_131 OffBn_126 OffBn_220 0.0073411
rOffBn_130 OffBn_126 OffBn_128 0.284653
rOffBn_129 OffBn_130 OffBn_218 0.0242995
rOffBn_128 OffBn_130 OffBn_132 0.0984589
rOffBn_127 OffBn_135 OffBn_139 49.2834
rOffBn_126 OffBn_135 OffBn_146 50.6667
rOffBn_125 OffBn_139 OffBn_146 152
rOffBn_124 xPix[2].MMoffBias.g OffBn_146 37.2181
rOffBn_123 OffBn_177 OffBn_195 0.0924406
rOffBn_122 OffBn_180 OffBn_198 0.0924406
rOffBn_121 OffBn_183 OffBn_200 0.0930063
rOffBn_120 OffBn_186 OffBn_203 0.0930063
rOffBn_119 OffBn_195 OffBn_234 4.5
rOffBn_118 OffBn_198 OffBn_239 4.5
rOffBn_117 OffBn_200 OffBn_254 4.5
rOffBn_116 OffBn_203 OffBn_259 4.5
rOffBn_115 OffBn_205 OffBn_221 1.59653
rOffBn_114 OffBn_206 OffBn_222 1.59653
rOffBn_113 OffBn_207 OffBn_223 0.990099
rOffBn_112 OffBn_208 OffBn_224 0.990099
rOffBn_111 OffBn_209 OffBn_211 0.0698411
rOffBn_110 OffBn_209 OffBn_225 0.761139
rOffBn_109 OffBn_210 OffBn_212 0.0698411
rOffBn_108 OffBn_210 OffBn_226 0.761139
rOffBn_107 OffBn_211 OffBn_213 1.53465
rOffBn_106 OffBn_212 OffBn_216 1.53465
rOffBn_105 OffBn_213 OffBn_214 0.0698411
rOffBn_104 OffBn_214 OffBn_227 0.761139
rOffBn_103 OffBn_215 OffBn_216 0.0698411
rOffBn_102 OffBn_215 OffBn_228 0.761139
rOffBn_101 OffBn_217 OffBn_229 0.990099
rOffBn_100 OffBn_218 OffBn_230 0.990099
rOffBn_99 OffBn_219 OffBn_231 1.59653
rOffBn_98 OffBn_220 OffBn_232 1.59653
rOffBn_97 OffBn_221 OffBn_236 0.0446906
rOffBn_96 OffBn_222 OffBn_241 0.0446906
rOffBn_95 OffBn_223 OffBn_244 0.114203
rOffBn_94 OffBn_224 OffBn_247 0.116762
rOffBn_93 OffBn_225 OffBn_245 0.0494096
rOffBn_92 OffBn_226 OffBn_248 0.0428024
rOffBn_91 OffBn_227 OffBn_249 0.0428024
rOffBn_90 OffBn_228 OffBn_250 0.0428024
rOffBn_89 OffBn_229 OffBn_249 0.242754
rOffBn_88 OffBn_230 OffBn_250 0.242754
rOffBn_87 OffBn_231 OffBn_251 0.0446906
rOffBn_86 OffBn_232 OffBn_256 0.0446906
rOffBn_85 OffBn_234 OffBn_236 0.0503394
rOffBn_84 OffBn_239 OffBn_241 0.0503394
rOffBn_83 OffBn_244 OffBn_245 0.112989
rOffBn_82 OffBn_244 OffBn_265 3.41
rOffBn_81 OffBn_247 OffBn_248 0.125992
rOffBn_80 OffBn_247 OffBn_267 3.41
rOffBn_79 OffBn_251 OffBn_254 0.050905
rOffBn_78 OffBn_256 OffBn_259 0.050905
rOffBn_77 OffBn OffBn_265 0.298334
rOffBn_76 OffBn_265 OffBn_267 3.10801
rOffBn_75 OffBn_267 OffBn 0.292016
rDiffBn_129 DiffBn_1 DiffBn_18 9.3
rDiffBn_128 DiffBn_1 DiffBn_145 0.399215
rDiffBn_127 DiffBn_2 DiffBn_14 3.1
rDiffBn_126 DiffBn_2 DiffBn_145 0.0585435
rDiffBn_125 DiffBn_2 DiffBn_137 0.00927272
rDiffBn_124 DiffBn_4 DiffBn_5 0.321782
rDiffBn_123 DiffBn_4 DiffBn_7 0.0698411
rDiffBn_122 DiffBn_5 DiffBn_173 0.0698411
rDiffBn_121 DiffBn_6 DiffBn_7 1.96163
rDiffBn_120 DiffBn_6 DiffBn_9 0.0073411
rDiffBn_119 DiffBn_9 DiffBn_11 0.148515
rDiffBn_118 DiffBn_11 DiffBn_175 0.0073411
rDiffBn_117 DiffBn_14 DiffBn_18 49.2834
rDiffBn_116 DiffBn_14 DiffBn_26 50.6667
rDiffBn_115 DiffBn_18 DiffBn_26 152
rDiffBn_114 xPix[1].MMchAmpBias.g DiffBn_27 31.7105
rDiffBn_113 DiffBn_26 DiffBn_27 5.51601
rDiffBn_112 DiffBn_30 DiffBn_47 9.3
rDiffBn_111 DiffBn_30 DiffBn_148 0.399215
rDiffBn_110 DiffBn_31 DiffBn_43 3.1
rDiffBn_109 DiffBn_31 DiffBn_148 0.0585435
rDiffBn_108 DiffBn_31 DiffBn_141 0.00927272
rDiffBn_107 DiffBn_33 DiffBn_34 0.321782
rDiffBn_106 DiffBn_33 DiffBn_36 0.0698411
rDiffBn_105 DiffBn_34 DiffBn_174 0.0698411
rDiffBn_104 DiffBn_35 DiffBn_36 1.96163
rDiffBn_103 DiffBn_35 DiffBn_38 0.0073411
rDiffBn_102 DiffBn_38 DiffBn_40 0.148515
rDiffBn_101 DiffBn_40 DiffBn_176 0.0073411
rDiffBn_100 DiffBn_43 DiffBn_47 49.2834
rDiffBn_99 DiffBn_43 DiffBn_55 50.6667
rDiffBn_98 DiffBn_47 DiffBn_55 152
rDiffBn_97 xPix[0].MMchAmpBias.g DiffBn_56 31.7105
rDiffBn_96 DiffBn_55 DiffBn_56 5.51601
rDiffBn_95 DiffBn_59 DiffBn_76 9.3
rDiffBn_94 DiffBn_59 DiffBn_151 0.405759
rDiffBn_93 DiffBn_60 DiffBn_72 3.1
rDiffBn_92 DiffBn_60 DiffBn_151 0.0585435
rDiffBn_91 DiffBn_60 DiffBn_157 0.00927272
rDiffBn_90 DiffBn_72 DiffBn_76 49.2834
rDiffBn_89 DiffBn_72 DiffBn_84 50.6667
rDiffBn_88 DiffBn_76 DiffBn_84 152
rDiffBn_87 xPix[3].MMchAmpBias.g DiffBn_85 31.7105
rDiffBn_86 DiffBn_84 DiffBn_85 5.51601
rDiffBn_85 DiffBn_88 DiffBn_105 9.3
rDiffBn_84 DiffBn_88 DiffBn_154 0.405759
rDiffBn_83 DiffBn_89 DiffBn_101 3.1
rDiffBn_82 DiffBn_89 DiffBn_154 0.0585435
rDiffBn_81 DiffBn_89 DiffBn_161 0.00927272
rDiffBn_80 DiffBn_101 DiffBn_105 49.2834
rDiffBn_79 DiffBn_101 DiffBn_113 50.6667
rDiffBn_78 DiffBn_105 DiffBn_113 152
rDiffBn_77 xPix[2].MMchAmpBias.g DiffBn_114 31.7105
rDiffBn_76 DiffBn_113 DiffBn_114 5.51601
rDiffBn_75 DiffBn_137 DiffBn_139 0.421946
rDiffBn_74 DiffBn_139 DiffBn_202 4.5
rDiffBn_73 DiffBn_141 DiffBn_143 0.42138
rDiffBn_72 DiffBn_143 DiffBn_206 4.5
rDiffBn_71 DiffBn_157 DiffBn_159 0.421946
rDiffBn_70 DiffBn_159 DiffBn_222 4.5
rDiffBn_69 DiffBn_161 DiffBn_163 0.42138
rDiffBn_68 DiffBn_163 DiffBn_226 4.5
rDiffBn_67 DiffBn_173 DiffBn_204 4.81436
rDiffBn_66 DiffBn_174 DiffBn_208 4.81436
rDiffBn_65 DiffBn_175 DiffBn_187 4.53589
rDiffBn_64 DiffBn_176 DiffBn_188 4.53589
rDiffBn_63 DiffBn_187 DiffBn_214 0.0532121
rDiffBn_62 DiffBn_188 DiffBn_212 0.0502728
rDiffBn_61 DiffBn DiffBn_224 0.655941
rDiffBn_60 DiffBn DiffBn_228 0.655941
rDiffBn_59 DiffBn_202 DiffBn_204 0.127536
rDiffBn_58 DiffBn_206 DiffBn_208 0.127536
rDiffBn_57 DiffBn_210 DiffBn_212 0.0609756
rDiffBn_56 DiffBn_210 DiffBn_235 3.41
rDiffBn_55 DiffBn_214 DiffBn_216 0.0505853
rDiffBn_54 DiffBn_216 DiffBn_233 3.41
rDiffBn_53 DiffBn_222 DiffBn_224 0.128102
rDiffBn_52 DiffBn_226 DiffBn_228 0.128102
rDiffBn_51 DiffBn DiffBn_233 0.226679
rDiffBn_50 DiffBn_233 DiffBn_235 3.24516
rDiffBn_49 DiffBn_235 DiffBn 0.226525
rpixRst[0]_33 pixRst[0]_3 pixRst[0]_8 0.29123
rpixRst[0]_32 pixRst[0]_3 pixRst[0]_17 9.3
rpixRst[0]_31 pixRst[0]_6 pixRst[0]_8 0.093249
rpixRst[0]_30 pixRst[0]_6 pixRst[0]_13 4.5
rpixRst[0]_29 pixRst[0]_10 pixRst[0]_13 0.0585347
rpixRst[0]_28 pixRst[0]_10 pixRst[0]_15 3.41
rpixRst[0]_27 pixRst[0]_15 pixRst[0] 1.58798
rpixRst[0]_26 pixRst[0]_15 pixRst[0]_42 0.522393
rpixRst[0]_25 pixRst[0]_17 pixRst[0]_26 152
rpixRst[0]_24 pixRst[0]_21 xPix[1].MMPDrefrCol.g 210.234
rpixRst[0]_23 pixRst[0]_21 pixRst[0]_26 52.7279
rpixRst[0]_22 pixRst[0]_30 pixRst[0]_35 0.29123
rpixRst[0]_21 pixRst[0]_30 pixRst[0]_44 9.3
rpixRst[0]_20 pixRst[0]_33 pixRst[0]_35 0.093249
rpixRst[0]_19 pixRst[0]_33 pixRst[0]_40 4.5
rpixRst[0]_18 pixRst[0]_37 pixRst[0]_40 0.0585347
rpixRst[0]_17 pixRst[0]_37 pixRst[0]_42 3.41
rpixRst[0]_16 pixRst[0]_42 pixRst[0] 1.58798
rpixRst[0]_15 pixRst[0]_44 pixRst[0]_53 152
rpixRst[0]_14 pixRst[0]_48 xPix[0].MMPDrefrCol.g 210.234
rpixRst[0]_13 pixRst[0]_48 pixRst[0]_53 52.7279
rreadLine[0]_63 xPix[0].MMN11.d xPix[0].MMN10.d 0.01
rreadLine[0]_62 xPix[1].MMN11.d xPix[1].MMN10.d 0.01
rreadLine[0]_61 readLine[0]_5 readLine[0]_6 0.389851
rreadLine[0]_60 readLine[0]_5 readLine[0]_8 0.118702
rreadLine[0]_59 readLine[0]_6 readLine[0]_11 0.13093
rreadLine[0]_58 readLine[0]_8 xPix[1].MMN10.d 9.3
rreadLine[0]_57 readLine[0]_11 readLine[0]_27 4.5
rreadLine[0]_56 readLine[0]_13 readLine[0]_14 0.173267
rreadLine[0]_55 readLine[0]_13 readLine[0]_25 0.0642422
rreadLine[0]_54 readLine[0]_14 readLine[0]_16 0.0698411
rreadLine[0]_53 readLine[0]_15 readLine[0]_16 0.971535
rreadLine[0]_52 readLine[0]_15 readLine[0]_18 0.0698411
rreadLine[0]_51 readLine[0]_17 readLine[0]_18 0.309406
rreadLine[0]_50 readLine[0]_17 readLine[0]_20 0.0698411
rreadLine[0]_49 readLine[0]_20 readLine[0]_28 1.06436
rreadLine[0]_48 readLine[0]_22 readLine[0]_24 0.0665266
rreadLine[0]_47 readLine[0]_22 readLine[0]_30 3.41
rreadLine[0]_46 readLine[0]_24 readLine[0]_25 0.0070028
rreadLine[0]_45 readLine[0]_27 readLine[0]_28 0.13093
rreadLine[0]_44 readLine[0]_30 readLine[0] 1.58798
rreadLine[0]_43 readLine[0]_30 readLine[0]_67 0.522393
rreadLine[0]_42 readLine[0]_42 readLine[0]_43 0.389851
rreadLine[0]_41 readLine[0]_42 readLine[0]_45 0.118702
rreadLine[0]_40 readLine[0]_43 readLine[0]_48 0.13093
rreadLine[0]_39 readLine[0]_45 xPix[0].MMN10.d 9.3
rreadLine[0]_38 readLine[0]_48 readLine[0]_64 4.5
rreadLine[0]_37 readLine[0]_50 readLine[0]_51 0.173267
rreadLine[0]_36 readLine[0]_50 readLine[0]_62 0.0642422
rreadLine[0]_35 readLine[0]_51 readLine[0]_53 0.0698411
rreadLine[0]_34 readLine[0]_52 readLine[0]_53 0.971535
rreadLine[0]_33 readLine[0]_52 readLine[0]_55 0.0698411
rreadLine[0]_32 readLine[0]_54 readLine[0]_55 0.309406
rreadLine[0]_31 readLine[0]_54 readLine[0]_57 0.0698411
rreadLine[0]_30 readLine[0]_57 readLine[0]_65 1.06436
rreadLine[0]_29 readLine[0]_59 readLine[0]_61 0.0665266
rreadLine[0]_28 readLine[0]_59 readLine[0]_67 3.41
rreadLine[0]_27 readLine[0]_61 readLine[0]_62 0.0070028
rreadLine[0]_26 readLine[0]_64 readLine[0]_65 0.13093
rreadLine[0]_25 readLine[0]_67 readLine[0] 1.58798
rVddA18_606 xPix[2].MMP2.s xPix[2].MMon.s 0.01
rVddA18_605 xPix[2].MMP2.b xPix[2].MMon.b 0.01
rVddA18_604 xPix[2].MMchAmp.b xPix[2].MMon.b 0.01
rVddA18_603 xPix[2].MMcapRef.b xPix[2].MMon.b 0.01
rVddA18_602 xPix[2].MMrefrBias.b xPix[2].MMon.b 0.01
rVddA18_601 xPix[2].MMprBias.b xPix[2].MMon.b 0.01
rVddA18_600 xPix[2].MMsf.b xPix[2].MMon.b 0.01
rVddA18_599 xPix[2].MMP0.b xPix[2].MMon.b 0.01
rVddA18_598 xPix[2].MMrst.b xPix[2].MMon.b 0.01
rVddA18_597 xPix[3].MMP2.s xPix[3].MMon.s 0.01
rVddA18_596 xPix[3].MMP2.b xPix[3].MMon.b 0.01
rVddA18_595 xPix[3].MMchAmp.b xPix[3].MMon.b 0.01
rVddA18_594 xPix[3].MMcapRef.b xPix[3].MMon.b 0.01
rVddA18_593 xPix[3].MMrefrBias.b xPix[3].MMon.b 0.01
rVddA18_592 xPix[3].MMprBias.b xPix[3].MMon.b 0.01
rVddA18_591 xPix[3].MMsf.b xPix[3].MMon.b 0.01
rVddA18_590 xPix[3].MMP0.b xPix[3].MMon.b 0.01
rVddA18_589 xPix[3].MMrst.b xPix[3].MMon.b 0.01
rVddA18_588 xPix[2].MMP0.s xPix[0].MMP0.s 0.01
rVddA18_587 xPix[2].MMrefrBias.s xPix[0].MMrefrBias.s 0.01
rVddA18_586 xPix[2].MMchAmp.s xPix[0].MMchAmp.s 0.01
rVddA18_585 xPix[0].MMcapRef.d xPix[0].MMcapRef.s 0.01
rVddA18_584 xPix[2].MMcapRef.s xPix[0].MMcapRef.s 0.01
rVddA18_583 xPix[2].MMcapRef.d xPix[0].MMcapRef.s 0.01
rVddA18_582 xPix[0].MMP2.s xPix[0].MMon.s 0.01
rVddA18_581 xPix[0].MMP2.b xPix[0].MMon.b 0.01
rVddA18_580 xPix[0].MMchAmp.b xPix[0].MMon.b 0.01
rVddA18_579 xPix[0].MMcapRef.b xPix[0].MMon.b 0.01
rVddA18_578 xPix[0].MMrefrBias.b xPix[0].MMon.b 0.01
rVddA18_577 xPix[0].MMprBias.b xPix[0].MMon.b 0.01
rVddA18_576 xPix[0].MMsf.b xPix[0].MMon.b 0.01
rVddA18_575 xPix[0].MMP0.b xPix[0].MMon.b 0.01
rVddA18_574 xPix[0].MMrst.b xPix[0].MMon.b 0.01
rVddA18_573 xPix[3].MMP0.s xPix[1].MMP0.s 0.01
rVddA18_572 xPix[3].MMrefrBias.s xPix[1].MMrefrBias.s 0.01
rVddA18_571 xPix[3].MMchAmp.s xPix[1].MMchAmp.s 0.01
rVddA18_570 xPix[1].MMcapRef.d xPix[1].MMcapRef.s 0.01
rVddA18_569 xPix[3].MMcapRef.s xPix[1].MMcapRef.s 0.01
rVddA18_568 xPix[3].MMcapRef.d xPix[1].MMcapRef.s 0.01
rVddA18_567 xPix[1].MMP2.s xPix[1].MMon.s 0.01
rVddA18_566 xPix[1].MMP2.b xPix[1].MMon.b 0.01
rVddA18_565 xPix[1].MMchAmp.b xPix[1].MMon.b 0.01
rVddA18_564 xPix[1].MMcapRef.b xPix[1].MMon.b 0.01
rVddA18_563 xPix[1].MMrefrBias.b xPix[1].MMon.b 0.01
rVddA18_562 xPix[1].MMprBias.b xPix[1].MMon.b 0.01
rVddA18_561 xPix[1].MMsf.b xPix[1].MMon.b 0.01
rVddA18_560 xPix[1].MMP0.b xPix[1].MMon.b 0.01
rVddA18_559 xPix[1].MMrst.b xPix[1].MMon.b 0.01
rVddA18_558 xPix[1].MMon.b VddA18_19 1.03333
rVddA18_557 VddA18_9 VddA18_12 0.412371
rVddA18_556 VddA18_9 VddA18_33 1.5
rVddA18_555 VddA18_12 VddA18_14 0.412371
rVddA18_554 VddA18_12 VddA18_38 1.5
rVddA18_553 VddA18_14 VddA18_41 1.5
rVddA18_552 VddA18_18 VddA18_83 3.1
rVddA18_551 VddA18_18 VddA18_201 3.1
rVddA18_550 VddA18_18 VddA18_592 0.192384
rVddA18_549 VddA18_18 VddA18_595 0.19217
rVddA18_548 VddA18_19 VddA18_680 0.000809199
rVddA18_547 VddA18_20 xPix[1].MMpd.d 9.3
rVddA18_546 VddA18_20 VddA18_670 0.00579216
rVddA18_545 VddA18_22 VddA18_24 0.0722112
rVddA18_544 VddA18_22 xPix[1].MMprBias.s 9.3
rVddA18_543 VddA18_24 VddA18_584 0.0513368
rVddA18_542 VddA18_26 VddA18_96 3.1
rVddA18_541 VddA18_26 VddA18_702 0.137116
rVddA18_540 VddA18_27 VddA18_57 3.41
rVddA18_539 VddA18_27 VddA18_805 0.0325235
rVddA18_538 VddA18_27 VddA18_890 0.0543968
rVddA18_537 VddA18_28 VddA18_53 1.13667
rVddA18_536 VddA18_28 VddA18_820 0.0128772
rVddA18_535 VddA18_28 VddA18_805 0.0721904
rVddA18_534 VddA18_29 VddA18_49 1.13667
rVddA18_533 VddA18_29 VddA18_813 0.023283
rVddA18_532 VddA18_29 VddA18_816 0.0183403
rVddA18_531 VddA18_30 VddA18_44 1.13667
rVddA18_530 VddA18_30 VddA18_806 0.0110562
rVddA18_529 VddA18_30 VddA18_809 0.00793444
rVddA18_528 VddA18_31 VddA18_38 0.0720373
rVddA18_527 VddA18_31 VddA18_41 0.0358882
rVddA18_526 VddA18_33 VddA18_36 0.036526
rVddA18_525 VddA18_36 VddA18_38 0.158279
rVddA18_524 VddA18_36 VddA18_60 1.13667
rVddA18_523 VddA18_41 VddA18_774 0.0341005
rVddA18_522 VddA18_41 VddA18_64 1.13667
rVddA18_521 VddA18_44 VddA18_47 0.0685738
rVddA18_520 VddA18_47 VddA18_49 0.116344
rVddA18_519 VddA18_47 VddA18_69 1.13667
rVddA18_518 VddA18_49 VddA18_51 0.137918
rVddA18_517 VddA18_51 VddA18_53 0.047
rVddA18_516 VddA18_51 VddA18_68 1.13667
rVddA18_515 VddA18_53 VddA18_55 0.122508
rVddA18_514 VddA18_55 VddA18_57 0.000770492
rVddA18_513 VddA18_55 VddA18_67 3.41
rVddA18_512 VddA18_60 VddA18_64 0.0895238
rVddA18_511 VddA18_60 VddA18_70 1.13667
rVddA18_510 VddA18_64 VddA18_70 1.13667
rVddA18_509 VddA18_67 VddA18_68 0.0316208
rVddA18_508 VddA18_67 VddA18_911 0.0317645
rVddA18_507 VddA18_68 VddA18_69 0.0474312
rVddA18_506 VddA18_70 VddA18_948 0.0396908
rVddA18_505 VddA18_83 xPix[1].MMon.s 4.4492
rVddA18_504 VddA18_83 xPix[1].MMon.s 44.8342
rVddA18_503 VddA18_96 xPix[1].MMcapRef.s 19.508
rVddA18_502 VddA18_96 xPix[1].MMcapRef.s 29.7754
rVddA18_501 xPix[1].MMcapRef.s VddA18_332 19.508
rVddA18_500 xPix[1].MMcapRef.s VddA18_332 29.7754
rVddA18_499 xPix[1].MMcapRef.s VddA18_990 5.13369
rVddA18_498 xPix[1].MMcapRef.s VddA18_990 44.1497
rVddA18_497 xPix[1].MMchAmp.s VddA18_995 11.2941
rVddA18_496 xPix[1].MMrefrBias.s VddA18_624 9.3
rVddA18_495 xPix[1].MMP0.s VddA18_634 9.3
rVddA18_494 xPix[0].MMon.b VddA18_137 1.03333
rVddA18_493 VddA18_124 VddA18_135 4.65
rVddA18_492 VddA18_124 VddA18_135 4.65
rVddA18_491 VddA18_127 VddA18_130 0.412371
rVddA18_490 VddA18_127 VddA18_151 1.5
rVddA18_489 VddA18_130 VddA18_132 0.412371
rVddA18_488 VddA18_130 VddA18_156 1.5
rVddA18_487 VddA18_132 VddA18_159 1.5
rVddA18_486 VddA18_135 VddA18_593 0.00723041
rVddA18_485 VddA18_137 VddA18_694 0.000689805
rVddA18_484 VddA18_137 VddA18_697 0.010928
rVddA18_483 VddA18_138 xPix[0].MMpd.d 9.3
rVddA18_482 VddA18_138 VddA18_684 0.00493755
rVddA18_481 VddA18_140 VddA18_142 0.0722112
rVddA18_480 VddA18_140 xPix[0].MMprBias.s 9.3
rVddA18_479 VddA18_142 VddA18_585 0.0513368
rVddA18_478 VddA18_144 VddA18_214 3.1
rVddA18_477 VddA18_144 VddA18_711 0.137116
rVddA18_476 VddA18_145 VddA18_175 3.41
rVddA18_475 VddA18_145 VddA18_786 0.0325235
rVddA18_474 VddA18_145 VddA18_893 0.0543968
rVddA18_473 VddA18_146 VddA18_171 1.13667
rVddA18_472 VddA18_146 VddA18_801 0.0128772
rVddA18_471 VddA18_146 VddA18_804 0.0287461
rVddA18_470 VddA18_147 VddA18_167 1.13667
rVddA18_469 VddA18_147 VddA18_794 0.023283
rVddA18_468 VddA18_147 VddA18_797 0.0183403
rVddA18_467 VddA18_148 VddA18_162 1.13667
rVddA18_466 VddA18_148 VddA18_787 0.0123569
rVddA18_465 VddA18_148 VddA18_790 0.00793444
rVddA18_464 VddA18_149 VddA18_156 0.0720373
rVddA18_463 VddA18_149 VddA18_159 0.0358882
rVddA18_462 VddA18_151 VddA18_154 0.036526
rVddA18_461 VddA18_154 VddA18_156 0.158279
rVddA18_460 VddA18_154 VddA18_178 1.13667
rVddA18_459 VddA18_159 VddA18_775 0.0341005
rVddA18_458 VddA18_159 VddA18_182 1.13667
rVddA18_457 VddA18_162 VddA18_165 0.0685738
rVddA18_456 VddA18_165 VddA18_167 0.116344
rVddA18_455 VddA18_165 VddA18_187 1.13667
rVddA18_454 VddA18_167 VddA18_169 0.137918
rVddA18_453 VddA18_169 VddA18_171 0.047
rVddA18_452 VddA18_169 VddA18_186 1.13667
rVddA18_451 VddA18_171 VddA18_173 0.122508
rVddA18_450 VddA18_173 VddA18_175 0.000770492
rVddA18_449 VddA18_173 VddA18_185 3.41
rVddA18_448 VddA18_178 VddA18_182 0.0895238
rVddA18_447 VddA18_178 VddA18_189 1.13667
rVddA18_446 VddA18_182 VddA18_189 1.13667
rVddA18_445 VddA18_185 VddA18_186 0.0316208
rVddA18_444 VddA18_185 VddA18_916 0.0317645
rVddA18_443 VddA18_186 VddA18_187 0.0474312
rVddA18_442 VddA18_189 VddA18_953 0.0396908
rVddA18_441 VddA18_201 xPix[0].MMon.s 4.4492
rVddA18_440 VddA18_201 xPix[0].MMon.s 44.8342
rVddA18_439 VddA18_214 xPix[0].MMcapRef.s 19.508
rVddA18_438 VddA18_214 xPix[0].MMcapRef.s 29.7754
rVddA18_437 xPix[0].MMcapRef.s VddA18_450 19.508
rVddA18_436 xPix[0].MMcapRef.s VddA18_450 29.7754
rVddA18_435 xPix[0].MMcapRef.s VddA18_1014 19.508
rVddA18_434 xPix[0].MMcapRef.s VddA18_1014 29.7754
rVddA18_433 xPix[0].MMchAmp.s VddA18_1006 11.2941
rVddA18_432 xPix[0].MMchAmp.s VddA18_1006 37.9893
rVddA18_431 xPix[0].MMrefrBias.s VddA18_631 9.3
rVddA18_430 xPix[0].MMP0.s VddA18_638 9.3
rVddA18_429 xPix[3].MMon.b VddA18_255 1.03333
rVddA18_428 VddA18_245 VddA18_248 0.412371
rVddA18_427 VddA18_245 VddA18_269 1.5
rVddA18_426 VddA18_248 VddA18_250 0.412371
rVddA18_425 VddA18_248 VddA18_274 1.5
rVddA18_424 VddA18_250 VddA18_277 1.5
rVddA18_423 VddA18_254 VddA18_319 3.1
rVddA18_422 VddA18_254 VddA18_437 3.1
rVddA18_421 VddA18_254 VddA18_658 0.19217
rVddA18_420 VddA18_254 VddA18_661 0.192384
rVddA18_419 VddA18_255 VddA18_742 0.0127342
rVddA18_418 VddA18_255 VddA18_745 0.000894378
rVddA18_417 VddA18_256 xPix[3].MMpd.d 9.3
rVddA18_416 VddA18_256 VddA18_755 0.00570698
rVddA18_415 VddA18_258 VddA18_260 0.0722112
rVddA18_414 VddA18_258 xPix[3].MMprBias.s 9.3
rVddA18_413 VddA18_260 VddA18_586 0.0513368
rVddA18_412 VddA18_262 VddA18_332 3.1
rVddA18_411 VddA18_262 VddA18_705 0.150318
rVddA18_410 VddA18_263 VddA18_293 3.41
rVddA18_409 VddA18_263 VddA18_898 0.0992108
rVddA18_408 VddA18_263 VddA18_841 0.0325235
rVddA18_407 VddA18_264 VddA18_289 1.13667
rVddA18_406 VddA18_264 VddA18_843 0.028486
rVddA18_405 VddA18_264 VddA18_846 0.0131374
rVddA18_404 VddA18_265 VddA18_285 1.13667
rVddA18_403 VddA18_265 VddA18_850 0.0180801
rVddA18_402 VddA18_265 VddA18_853 0.0651665
rVddA18_401 VddA18_266 VddA18_280 1.13667
rVddA18_400 VddA18_266 VddA18_857 0.0076743
rVddA18_399 VddA18_266 VddA18_840 0.0110562
rVddA18_398 VddA18_267 VddA18_274 0.0720373
rVddA18_397 VddA18_267 VddA18_277 0.0358882
rVddA18_396 VddA18_269 VddA18_272 0.036526
rVddA18_395 VddA18_272 VddA18_274 0.158279
rVddA18_394 VddA18_272 VddA18_296 1.13667
rVddA18_393 VddA18_277 VddA18_776 0.0341005
rVddA18_392 VddA18_277 VddA18_300 1.13667
rVddA18_391 VddA18_280 VddA18_283 0.0685738
rVddA18_390 VddA18_283 VddA18_285 0.116344
rVddA18_389 VddA18_283 VddA18_305 1.13667
rVddA18_388 VddA18_285 VddA18_287 0.137918
rVddA18_387 VddA18_287 VddA18_289 0.047
rVddA18_386 VddA18_287 VddA18_304 1.13667
rVddA18_385 VddA18_289 VddA18_291 0.122508
rVddA18_384 VddA18_291 VddA18_293 0.000770492
rVddA18_383 VddA18_291 VddA18_303 3.41
rVddA18_382 VddA18_296 VddA18_300 0.0895238
rVddA18_381 VddA18_296 VddA18_306 1.13667
rVddA18_380 VddA18_300 VddA18_306 1.13667
rVddA18_379 VddA18_303 VddA18_929 0.0317645
rVddA18_378 VddA18_303 VddA18_304 0.0316208
rVddA18_377 VddA18_304 VddA18_305 0.0474312
rVddA18_376 VddA18_306 VddA18_948 0.0396908
rVddA18_375 VddA18_319 xPix[3].MMon.s 4.4492
rVddA18_374 VddA18_319 xPix[3].MMon.s 44.8342
rVddA18_373 xPix[2].MMon.b VddA18_373 1.03333
rVddA18_372 VddA18_360 VddA18_371 4.65
rVddA18_371 VddA18_360 VddA18_371 4.65
rVddA18_370 VddA18_363 VddA18_366 0.412371
rVddA18_369 VddA18_363 VddA18_387 1.5
rVddA18_368 VddA18_366 VddA18_368 0.412371
rVddA18_367 VddA18_366 VddA18_392 1.5
rVddA18_366 VddA18_368 VddA18_395 1.5
rVddA18_365 VddA18_371 VddA18_660 0.00723041
rVddA18_364 VddA18_373 VddA18_758 0.0108554
rVddA18_363 VddA18_373 VddA18_761 0.000762417
rVddA18_362 VddA18_374 xPix[2].MMpd.d 9.3
rVddA18_361 VddA18_374 VddA18_771 0.00486494
rVddA18_360 VddA18_376 VddA18_378 0.0722112
rVddA18_359 VddA18_376 xPix[2].MMprBias.s 9.3
rVddA18_358 VddA18_378 VddA18_587 0.0513368
rVddA18_357 VddA18_380 VddA18_450 3.1
rVddA18_356 VddA18_380 VddA18_714 0.150318
rVddA18_355 VddA18_381 VddA18_411 3.41
rVddA18_354 VddA18_381 VddA18_901 0.0992108
rVddA18_353 VddA18_381 VddA18_860 0.0325235
rVddA18_352 VddA18_382 VddA18_407 1.13667
rVddA18_351 VddA18_382 VddA18_862 0.028486
rVddA18_350 VddA18_382 VddA18_865 0.0131374
rVddA18_349 VddA18_383 VddA18_403 1.13667
rVddA18_348 VddA18_383 VddA18_869 0.0180801
rVddA18_347 VddA18_383 VddA18_872 0.0651665
rVddA18_346 VddA18_384 VddA18_398 1.13667
rVddA18_345 VddA18_384 VddA18_876 0.0076743
rVddA18_344 VddA18_384 VddA18_859 0.0130073
rVddA18_343 VddA18_385 VddA18_392 0.0720373
rVddA18_342 VddA18_385 VddA18_395 0.0358882
rVddA18_341 VddA18_387 VddA18_390 0.036526
rVddA18_340 VddA18_390 VddA18_392 0.158279
rVddA18_339 VddA18_390 VddA18_414 1.13667
rVddA18_338 VddA18_395 VddA18_777 0.0341005
rVddA18_337 VddA18_395 VddA18_418 1.13667
rVddA18_336 VddA18_398 VddA18_401 0.0685738
rVddA18_335 VddA18_401 VddA18_403 0.116344
rVddA18_334 VddA18_401 VddA18_423 1.13667
rVddA18_333 VddA18_403 VddA18_405 0.137918
rVddA18_332 VddA18_405 VddA18_407 0.047
rVddA18_331 VddA18_405 VddA18_422 1.13667
rVddA18_330 VddA18_407 VddA18_409 0.122508
rVddA18_329 VddA18_409 VddA18_411 0.000770492
rVddA18_328 VddA18_409 VddA18_421 3.41
rVddA18_327 VddA18_414 VddA18_418 0.0895238
rVddA18_326 VddA18_414 VddA18_425 1.13667
rVddA18_325 VddA18_418 VddA18_425 1.13667
rVddA18_324 VddA18_421 VddA18_936 0.0317645
rVddA18_323 VddA18_421 VddA18_422 0.0316208
rVddA18_322 VddA18_422 VddA18_423 0.0474312
rVddA18_321 VddA18_425 VddA18_953 0.0396908
rVddA18_320 VddA18_437 xPix[2].MMon.s 4.4492
rVddA18_319 VddA18_437 xPix[2].MMon.s 44.8342
rVddA18_318 VddA18_584 VddA18_618 0.49505
rVddA18_317 VddA18_585 VddA18_619 0.49505
rVddA18_316 VddA18_586 VddA18_646 0.49505
rVddA18_315 VddA18_587 VddA18_647 0.49505
rVddA18_314 VddA18_592 VddA18_593 0.308399
rVddA18_313 VddA18_594 VddA18_595 0.213255
rVddA18_312 VddA18_594 VddA18_698 0.0625
rVddA18_311 VddA18_600 VddA18_601 0.214895
rVddA18_310 VddA18_600 VddA18_721 0.129007
rVddA18_309 VddA18_601 VddA18_698 0.0625
rVddA18_308 VddA18_602 VddA18_604 0.145833
rVddA18_307 VddA18_602 VddA18_718 0.124421
rVddA18_306 VddA18_604 VddA18_890 2.25
rVddA18_305 VddA18_606 VddA18_608 0.141904
rVddA18_304 VddA18_606 VddA18_717 0.125797
rVddA18_303 VddA18_608 VddA18_893 2.25
rVddA18_302 VddA18_610 VddA18_718 1.59653
rVddA18_301 VddA18_610 VddA18_728 0.0529306
rVddA18_300 VddA18_612 VddA18_717 1.59653
rVddA18_299 VddA18_612 VddA18_731 0.0529306
rVddA18_298 VddA18_614 VddA18_615 0.086546
rVddA18_297 VddA18_614 VddA18_703 0.017072
rVddA18_296 VddA18_615 VddA18_720 0.0537948
rVddA18_295 VddA18_616 VddA18_617 0.086546
rVddA18_294 VddA18_616 VddA18_723 0.070048
rVddA18_293 VddA18_617 VddA18_712 0.017072
rVddA18_292 VddA18_618 VddA18_729 0.0529306
rVddA18_291 VddA18_619 VddA18_730 0.0529306
rVddA18_290 VddA18_620 VddA18_622 0.062604
rVddA18_289 VddA18_620 VddA18_725 0.0232303
rVddA18_288 VddA18_622 VddA18_624 0.0332779
rVddA18_287 VddA18_622 VddA18_895 1.125
rVddA18_286 VddA18_626 VddA18_631 0.0956739
rVddA18_285 VddA18_626 VddA18_727 0.0234086
rVddA18_284 VddA18_628 VddA18_631 0.0332779
rVddA18_283 VddA18_628 VddA18_837 1.125
rVddA18_282 VddA18_632 VddA18_634 0.243526
rVddA18_281 VddA18_632 VddA18_725 0.0753071
rVddA18_280 VddA18_636 VddA18_638 0.244024
rVddA18_279 VddA18_636 VddA18_727 0.0751288
rVddA18_278 VddA18_640 VddA18_641 2.14109
rVddA18_277 VddA18_640 VddA18_728 0.0137558
rVddA18_276 VddA18_641 VddA18_729 0.0137558
rVddA18_275 VddA18_642 VddA18_643 2.48762
rVddA18_274 VddA18_642 VddA18_730 0.0137558
rVddA18_273 VddA18_643 VddA18_731 0.0137558
rVddA18_272 VddA18_645 VddA18_734 1.59653
rVddA18_271 VddA18_645 VddA18_728 0.0529306
rVddA18_270 VddA18_646 VddA18_729 0.0529306
rVddA18_269 VddA18_647 VddA18_730 0.0529306
rVddA18_268 VddA18_649 VddA18_737 1.59653
rVddA18_267 VddA18_649 VddA18_731 0.0529306
rVddA18_266 VddA18_650 VddA18_651 0.214895
rVddA18_265 VddA18_650 VddA18_739 0.0625
rVddA18_264 VddA18_651 VddA18_721 0.129007
rVddA18_263 VddA18_658 VddA18_659 0.213255
rVddA18_262 VddA18_659 VddA18_739 0.0625
rVddA18_261 VddA18_660 VddA18_661 0.308399
rVddA18_260 VddA18_670 VddA18_672 0.0136286
rVddA18_259 VddA18_670 VddA18_809 1.5
rVddA18_258 VddA18_672 VddA18_674 0.0272572
rVddA18_257 VddA18_672 VddA18_811 1.5
rVddA18_256 VddA18_674 VddA18_676 0.0136286
rVddA18_255 VddA18_674 VddA18_813 1.5
rVddA18_254 VddA18_676 VddA18_678 0.0272572
rVddA18_253 VddA18_676 VddA18_816 1.5
rVddA18_252 VddA18_678 VddA18_680 0.0136286
rVddA18_251 VddA18_678 VddA18_818 1.5
rVddA18_250 VddA18_680 VddA18_820 1.5
rVddA18_249 VddA18_684 VddA18_686 0.0116178
rVddA18_248 VddA18_684 VddA18_790 1.5
rVddA18_247 VddA18_686 VddA18_688 0.0232356
rVddA18_246 VddA18_686 VddA18_792 1.5
rVddA18_245 VddA18_688 VddA18_690 0.0116178
rVddA18_244 VddA18_688 VddA18_794 1.5
rVddA18_243 VddA18_690 VddA18_692 0.0232356
rVddA18_242 VddA18_690 VddA18_797 1.5
rVddA18_241 VddA18_692 VddA18_694 0.0116178
rVddA18_240 VddA18_692 VddA18_799 1.5
rVddA18_239 VddA18_694 VddA18_801 4.5
rVddA18_238 VddA18_697 VddA18_804 2.25
rVddA18_237 VddA18_702 VddA18_703 0.0132854
rVddA18_236 VddA18_702 VddA18_830 1.125
rVddA18_235 VddA18_703 VddA18_705 8.35562e-05
rVddA18_234 VddA18_705 VddA18_990 3.1
rVddA18_233 VddA18_711 VddA18_712 0.0132854
rVddA18_232 VddA18_711 VddA18_834 1.125
rVddA18_231 VddA18_712 VddA18_714 8.35562e-05
rVddA18_230 VddA18_714 VddA18_1014 3.1
rVddA18_229 VddA18_720 VddA18_721 0.0637903
rVddA18_228 VddA18_720 VddA18_995 4.65
rVddA18_227 VddA18_721 VddA18_723 0.0475371
rVddA18_226 VddA18_723 VddA18_1006 4.65
rVddA18_225 VddA18_733 VddA18_734 0.126233
rVddA18_224 VddA18_733 VddA18_898 2.25
rVddA18_223 VddA18_736 VddA18_737 0.126242
rVddA18_222 VddA18_736 VddA18_901 2.25
rVddA18_221 VddA18_742 VddA18_843 1.5
rVddA18_220 VddA18_745 VddA18_747 0.0272572
rVddA18_219 VddA18_745 VddA18_846 1.5
rVddA18_218 VddA18_747 VddA18_749 0.0136286
rVddA18_217 VddA18_747 VddA18_848 1.5
rVddA18_216 VddA18_749 VddA18_751 0.0272572
rVddA18_215 VddA18_749 VddA18_850 1.5
rVddA18_214 VddA18_751 VddA18_753 0.0136286
rVddA18_213 VddA18_751 VddA18_853 1.5
rVddA18_212 VddA18_753 VddA18_755 0.0136286
rVddA18_211 VddA18_753 VddA18_855 4.5
rVddA18_210 VddA18_755 VddA18_857 2.25
rVddA18_209 VddA18_758 VddA18_862 1.5
rVddA18_208 VddA18_761 VddA18_763 0.0232356
rVddA18_207 VddA18_761 VddA18_865 1.5
rVddA18_206 VddA18_763 VddA18_765 0.0116178
rVddA18_205 VddA18_763 VddA18_867 1.5
rVddA18_204 VddA18_765 VddA18_767 0.0232356
rVddA18_203 VddA18_765 VddA18_869 1.5
rVddA18_202 VddA18_767 VddA18_769 0.0116178
rVddA18_201 VddA18_767 VddA18_872 1.5
rVddA18_200 VddA18_769 VddA18_771 0.0116178
rVddA18_199 VddA18_769 VddA18_874 4.5
rVddA18_198 VddA18_771 VddA18_876 2.25
rVddA18_197 VddA18_774 VddA18_822 0.320417
rVddA18_196 VddA18_775 VddA18_823 0.320417
rVddA18_195 VddA18_776 VddA18_838 0.320417
rVddA18_194 VddA18_777 VddA18_839 0.320417
rVddA18_193 VddA18 VddA18_887 1.38401
rVddA18_192 VddA18 VddA18_886 1.3817
rVddA18_191 VddA18_786 VddA18_804 0.0434443
rVddA18_190 VddA18_787 VddA18_886 0.0887684
rVddA18_189 VddA18_790 VddA18_792 0.0416233
rVddA18_188 VddA18_792 VddA18_794 0.0832466
rVddA18_187 VddA18_797 VddA18_799 0.0832466
rVddA18_186 VddA18_799 VddA18_801 0.0416233
rVddA18_185 VddA18_806 VddA18_887 0.0887684
rVddA18_184 VddA18_809 VddA18_811 0.0416233
rVddA18_183 VddA18_811 VddA18_813 0.0832466
rVddA18_182 VddA18_816 VddA18_818 0.0832466
rVddA18_181 VddA18_818 VddA18_820 0.0416233
rVddA18_180 VddA18_822 VddA18_895 0.0485091
rVddA18_179 VddA18_823 VddA18_896 0.0485091
rVddA18_178 VddA18_824 VddA18_825 0.642329
rVddA18_177 VddA18_824 VddA18_898 0.0334261
rVddA18_176 VddA18_825 VddA18_890 0.0782401
rVddA18_175 VddA18_826 VddA18_827 0.642329
rVddA18_174 VddA18_826 VddA18_901 0.0334261
rVddA18_173 VddA18_827 VddA18_893 0.0782401
rVddA18_172 VddA18_828 VddA18_830 0.465058
rVddA18_171 VddA18_828 VddA18_895 0.0176113
rVddA18_170 VddA18_832 VddA18_837 0.0499168
rVddA18_169 VddA18_832 VddA18_896 0.0176113
rVddA18_168 VddA18_834 VddA18_837 0.481489
rVddA18_167 VddA18_838 VddA18_895 0.0485091
rVddA18_166 VddA18_839 VddA18_896 0.0485091
rVddA18_165 VddA18_840 VddA18_903 0.0887684
rVddA18_164 VddA18_841 VddA18_843 0.0437045
rVddA18_163 VddA18_846 VddA18_848 0.0832466
rVddA18_162 VddA18_848 VddA18_850 0.0416233
rVddA18_161 VddA18_853 VddA18_855 0.0416233
rVddA18_160 VddA18_855 VddA18_857 0.0416233
rVddA18_159 VddA18_859 VddA18_904 0.0887684
rVddA18_158 VddA18_860 VddA18_862 0.0437045
rVddA18_157 VddA18_865 VddA18_867 0.0832466
rVddA18_156 VddA18_867 VddA18_869 0.0416233
rVddA18_155 VddA18_872 VddA18_874 0.0416233
rVddA18_154 VddA18_874 VddA18_876 0.0416233
rVddA18_153 VddA18 VddA18_903 1.38401
rVddA18_152 VddA18 VddA18_904 1.38055
rVddA18_151 VddA18_911 VddA18 0.0254291
rVddA18_150 VddA18_916 VddA18 0.0254291
rVddA18_149 VddA18_921 VddA18_922 0.0911483
rVddA18_148 VddA18_921 VddA18 0.00105578
rVddA18_147 VddA18_922 VddA18_948 0.00770265
rVddA18_146 VddA18_923 VddA18_924 0.0742494
rVddA18_145 VddA18_923 VddA18_948 0.00770265
rVddA18_144 VddA18_924 VddA18_958 0.0114889
rVddA18_143 VddA18_925 VddA18_926 0.0742494
rVddA18_142 VddA18_925 VddA18_958 0.0114889
rVddA18_141 VddA18_926 VddA18_953 0.00770265
rVddA18_140 VddA18_927 VddA18_928 0.0911483
rVddA18_139 VddA18_927 VddA18_953 0.00770265
rVddA18_138 VddA18_928 VddA18 0.00105578
rVddA18_137 VddA18_929 VddA18 0.0254291
rVddA18_136 VddA18_936 VddA18 0.0254291
rGndA_1106 xPix[2].MMonBias.b xPix[2].MMoffBias.b 0.01
rGndA_1105 xPix[2].MMchAmpBias.b xPix[2].MMoffBias.b 0.01
rGndA_1104 xPix[2].MMPDrefrCol.b xPix[2].MMoffBias.b 0.01
rGndA_1103 xPix[2].MMPDRefrRow.b xPix[2].MMoffBias.b 0.01
rGndA_1102 xPix[2].MMN7.b xPix[2].MMoffBias.b 0.01
rGndA_1101 xPix[2].MMN10.b xPix[2].MMoffBias.b 0.01
rGndA_1100 xPix[2].MMN11.b xPix[2].MMoffBias.b 0.01
rGndA_1099 xPix[2].MMN8.b xPix[2].MMoffBias.b 0.01
rGndA_1098 xPix[2].MMpr.amp.b xPix[2].MMoffBias.b 0.01
rGndA_1097 xPix[2].MMpd.b xPix[2].MMoffBias.b 0.01
rGndA_1096 xPix[2].DD1.pos xPix[2].MMoffBias.b 0.01
rGndA_1095 xPix[3].MMonBias.b xPix[3].MMoffBias.b 0.01
rGndA_1094 xPix[3].MMchAmpBias.b xPix[3].MMoffBias.b 0.01
rGndA_1093 xPix[3].MMPDrefrCol.b xPix[3].MMoffBias.b 0.01
rGndA_1092 xPix[3].MMPDRefrRow.b xPix[3].MMoffBias.b 0.01
rGndA_1091 xPix[3].MMN7.b xPix[3].MMoffBias.b 0.01
rGndA_1090 xPix[3].MMN10.b xPix[3].MMoffBias.b 0.01
rGndA_1089 xPix[3].MMN11.b xPix[3].MMoffBias.b 0.01
rGndA_1088 xPix[3].MMN8.b xPix[3].MMoffBias.b 0.01
rGndA_1087 xPix[3].MMpr.amp.b xPix[3].MMoffBias.b 0.01
rGndA_1086 xPix[3].MMpd.b xPix[3].MMoffBias.b 0.01
rGndA_1085 xPix[3].DD1.pos xPix[3].MMoffBias.b 0.01
rGndA_1084 xPix[0].MMonBias.b xPix[0].MMoffBias.b 0.01
rGndA_1083 xPix[0].MMchAmpBias.b xPix[0].MMoffBias.b 0.01
rGndA_1082 xPix[0].MMPDrefrCol.b xPix[0].MMoffBias.b 0.01
rGndA_1081 xPix[0].MMPDRefrRow.b xPix[0].MMoffBias.b 0.01
rGndA_1080 xPix[0].MMN7.b xPix[0].MMoffBias.b 0.01
rGndA_1079 xPix[0].MMN10.b xPix[0].MMoffBias.b 0.01
rGndA_1078 xPix[0].MMN11.b xPix[0].MMoffBias.b 0.01
rGndA_1077 xPix[0].MMN8.b xPix[0].MMoffBias.b 0.01
rGndA_1076 xPix[0].MMpr.amp.b xPix[0].MMoffBias.b 0.01
rGndA_1075 xPix[0].MMpd.b xPix[0].MMoffBias.b 0.01
rGndA_1074 xPix[0].DD1.pos xPix[0].MMoffBias.b 0.01
rGndA_1073 xPix[1].MMonBias.b xPix[1].MMoffBias.b 0.01
rGndA_1072 xPix[1].MMchAmpBias.b xPix[1].MMoffBias.b 0.01
rGndA_1071 xPix[1].MMPDrefrCol.b xPix[1].MMoffBias.b 0.01
rGndA_1070 xPix[1].MMPDRefrRow.b xPix[1].MMoffBias.b 0.01
rGndA_1069 xPix[1].MMN7.b xPix[1].MMoffBias.b 0.01
rGndA_1068 xPix[1].MMN10.b xPix[1].MMoffBias.b 0.01
rGndA_1067 xPix[1].MMN11.b xPix[1].MMoffBias.b 0.01
rGndA_1066 xPix[1].MMN8.b xPix[1].MMoffBias.b 0.01
rGndA_1065 xPix[1].MMpr.amp.b xPix[1].MMoffBias.b 0.01
rGndA_1064 xPix[1].MMpd.b xPix[1].MMoffBias.b 0.01
rGndA_1063 xPix[1].DD1.pos xPix[1].MMoffBias.b 0.01
rGndA_1062 GndA_1 GndA_1925 0.0118264
rGndA_1061 GndA_1 GndA_1925 0.00334077
rGndA_1060 GndA_1 GndA_1931 0.01575
rGndA_1059 GndA_1 GndA_1931 0.01575
rGndA_1058 GndA_1 GndA_1931 0.0128929
rGndA_1057 GndA_1 GndA_1937 0.0118264
rGndA_1056 GndA_1 GndA_1937 0.00334077
rGndA_1055 GndA_1 GndA_1945 0.00201843
rGndA_1054 GndA_1 GndA_1947 0.00201843
rGndA_1053 GndA_1 GndA_381 0.00613008
rGndA_1052 xPix[1].MMoffBias.b GndA_351 4.37607
rGndA_1051 xPix[1].MMoffBias.b GndA_355 4.37607
rGndA_1050 xPix[1].MMoffBias.b GndA_355 4.37607
rGndA_1049 GndA_17 GndA_256 49.2834
rGndA_1048 GndA_17 GndA_360 4.10695
rGndA_1047 GndA_17 GndA_280 49.6257
rGndA_1046 GndA_17 GndA_286 19.1658
rGndA_1045 GndA_17 GndA_286 55.4439
rGndA_1044 GndA_17 GndA_290 18.8235
rGndA_1043 GndA_17 GndA_292 5.81818
rGndA_1042 GndA_17 GndA_279 49.6257
rGndA_1041 GndA_17 GndA_365 5.63824
rGndA_1040 GndA_17 GndA_308 41.4118
rGndA_1039 GndA_17 GndA_313 49.6257
rGndA_1038 GndA_17 GndA_313 24.6417
rGndA_1037 GndA_17 GndA_307 5.47594
rGndA_1036 GndA_17 GndA_331 58.1818
rGndA_1035 GndA_17 GndA_332 42.4385
rGndA_1034 GndA_17 GndA_360 13.6215
rGndA_1033 GndA_17 GndA_308 14.1627
rGndA_1032 GndA_17 GndA_364 5.33741
rGndA_1031 GndA_17 GndA_79 3.1
rGndA_1030 GndA_17 GndA_81 3.1
rGndA_1029 GndA_17 GndA_83 3.1
rGndA_1028 GndA_17 GndA_85 3.1
rGndA_1027 GndA_17 GndA_87 3.1
rGndA_1026 GndA_17 GndA_89 3.1
rGndA_1025 GndA_17 GndA_91 9.3
rGndA_1024 GndA_17 GndA_150 1.03333
rGndA_1023 GndA_17 GndA_149 1.55
rGndA_1022 GndA_17 GndA_98 3.1
rGndA_1021 GndA_17 GndA_100 3.1
rGndA_1020 GndA_47 GndA_48 0.475067
rGndA_1019 GndA_47 GndA_114 0.024102
rGndA_1018 GndA_48 GndA_140 0.0539746
rGndA_1017 GndA_49 GndA_52 0.0503096
rGndA_1016 GndA_49 GndA_142 0.0254633
rGndA_1015 GndA_50 GndA_52 0.0861068
rGndA_1014 GndA_50 GndA_119 0.0506589
rGndA_1013 GndA_52 GndA_162 1.125
rGndA_1012 GndA_53 GndA_56 0.0357972
rGndA_1011 GndA_53 GndA_119 0.0506589
rGndA_1010 GndA_54 GndA_60 0.0741099
rGndA_1009 GndA_54 GndA_130 0.0366249
rGndA_1008 GndA_56 GndA_58 0.123839
rGndA_1007 GndA_56 GndA_166 1.125
rGndA_1006 GndA_58 GndA_60 0.0145124
rGndA_1005 GndA_58 GndA_168 1.125
rGndA_1004 GndA_60 xPix[1].MMoffBias.s 3.1
rGndA_1003 GndA_61 GndA_64 0.0280782
rGndA_1002 GndA_61 GndA_134 0.0324465
rGndA_1001 GndA_62 GndA_66 0.0998336
rGndA_1000 GndA_62 GndA_136 0.0320891
rGndA_999 GndA_64 GndA_66 0.00519967
rGndA_998 GndA_64 xPix[1].MMonBias.s 3.1
rGndA_997 GndA_66 GndA_174 1.125
rGndA_996 GndA_69 GndA_128 0.382853
rGndA_995 GndA_69 xPix[1].MMchAmpBias.s 9.3
rGndA_994 GndA_72 GndA_74 0.0490998
rGndA_993 GndA_72 GndA_119 0.0156976
rGndA_992 GndA_74 GndA_355 2.325
rGndA_991 GndA_76 GndA_79 0.451571
rGndA_990 GndA_76 GndA_95 0.0753543
rGndA_989 GndA_77 GndA_91 0.0196335
rGndA_988 GndA_77 GndA_143 0.0529306
rGndA_987 GndA_79 GndA_81 0.706806
rGndA_986 GndA_81 GndA_83 0.706806
rGndA_985 GndA_83 GndA_85 0.706806
rGndA_984 GndA_85 GndA_87 0.706806
rGndA_983 GndA_87 GndA_89 0.706806
rGndA_982 GndA_89 GndA_91 0.471204
rGndA_981 GndA_92 GndA_93 0.163613
rGndA_980 GndA_92 GndA_143 0.0529306
rGndA_979 GndA_93 GndA_147 0.15234
rGndA_978 GndA_95 GndA_152 1.79455
rGndA_977 GndA_96 GndA_98 0.399215
rGndA_976 GndA_96 GndA_143 0.0137558
rGndA_975 GndA_98 GndA_100 0.710079
rGndA_974 GndA_100 GndA_102 0.474476
rGndA_973 GndA_102 GndA_313 4.65
rGndA_972 GndA_104 GndA_106 0.320681
rGndA_971 GndA_104 GndA_152 0.103504
rGndA_970 GndA_106 GndA_108 0.710079
rGndA_969 GndA_106 GndA_286 3.1
rGndA_968 GndA_108 GndA_110 0.474476
rGndA_967 GndA_108 GndA_290 3.1
rGndA_966 GndA_110 GndA_292 9.3
rGndA_965 GndA_112 GndA_411 4.65
rGndA_964 GndA_112 GndA_1685 0.0380435
rGndA_963 GndA_114 GndA_116 0.143962
rGndA_962 GndA_116 GndA_1673 0.0578484
rGndA_961 GndA_119 GndA_164 1.125
rGndA_960 GndA_119 GndA_351 2.325
rGndA_959 GndA_122 GndA_125 0.133111
rGndA_958 GndA_122 GndA_178 1.125
rGndA_957 GndA_125 GndA_127 0.00519967
rGndA_956 GndA_125 GndA_198 2.25
rGndA_955 GndA_127 GndA_128 0.0911428
rGndA_954 GndA_127 xPix[1].MMchAmpBias.s 3.1
rGndA_953 GndA_130 GndA_132 0.0335208
rGndA_952 GndA_130 GndA_170 2.25
rGndA_951 GndA_132 xPix[1].MMoffBias.s 9.3
rGndA_950 GndA_134 GndA_172 2.25
rGndA_949 GndA_136 GndA_138 0.0115741
rGndA_948 GndA_136 GndA_176 2.25
rGndA_947 GndA_138 xPix[1].MMonBias.s 9.3
rGndA_946 GndA_140 GndA_142 0.0373253
rGndA_945 GndA_140 GndA_159 1.125
rGndA_944 GndA_142 xPix[1].MMPDRefrRow.s 9.3
rGndA_943 GndA_146 GndA_203 1.5
rGndA_942 GndA_146 GndA_189 4.5
rGndA_941 GndA_146 GndA_150 0.0260159
rGndA_940 GndA_146 GndA_151 0.0185828
rGndA_939 GndA_147 GndA_200 1.5
rGndA_938 GndA_147 GndA_187 1.5
rGndA_937 GndA_147 GndA_151 0.00123885
rGndA_936 GndA_148 xPix[1].MMpr.amp.s 9.3
rGndA_935 GndA_148 GndA_149 0.0145565
rGndA_934 GndA_148 GndA_150 0.0300421
rGndA_933 GndA_149 GndA_1720 0.0476338
rGndA_932 GndA_151 GndA_364 3.1
rGndA_931 GndA_154 GndA_1675 0.0186508
rGndA_930 GndA_154 GndA_205 4.5
rGndA_929 GndA_155 GndA_195 4.5
rGndA_928 GndA_155 GndA_156 0.158208
rGndA_927 GndA_156 xPix[1].MMsf.d 9.3
rGndA_926 GndA_156 GndA_1698 0.0926896
rGndA_925 GndA_157 GndA_178 0.0519967
rGndA_924 GndA_157 GndA_198 0.0333077
rGndA_923 GndA_159 GndA_162 0.133111
rGndA_922 GndA_162 GndA_164 0.133111
rGndA_921 GndA_164 GndA_166 0.133111
rGndA_920 GndA_166 GndA_168 0.133111
rGndA_919 GndA_168 GndA_170 0.133111
rGndA_918 GndA_170 GndA_172 0.328619
rGndA_917 GndA_172 GndA_174 0.0665557
rGndA_916 GndA_174 GndA_176 0.133111
rGndA_915 GndA_176 GndA_178 0.230865
rGndA_914 GndA_180 GndA_201 0.390481
rGndA_913 GndA_180 GndA_198 0.0367533
rGndA_912 GndA_181 GndA_222 3.41
rGndA_911 GndA_181 GndA_1791 0.0292664
rGndA_910 GndA_181 GndA_1874 0.059502
rGndA_909 GndA_182 GndA_218 1.13667
rGndA_908 GndA_182 GndA_1799 0.0590531
rGndA_907 GndA_182 GndA_1791 0.0747919
rGndA_906 GndA_183 GndA_214 1.13667
rGndA_905 GndA_183 GndA_1794 0.0278356
rGndA_904 GndA_183 GndA_1797 0.0137877
rGndA_903 GndA_184 GndA_209 1.13667
rGndA_902 GndA_184 GndA_1862 0.102426
rGndA_901 GndA_184 GndA_1864 0.00338189
rGndA_900 GndA_185 GndA_187 0.0998336
rGndA_899 GndA_185 GndA_203 0.0332779
rGndA_898 GndA_187 GndA_189 0.0665557
rGndA_897 GndA_191 GndA_207 0.478516
rGndA_896 GndA_191 GndA_193 0.070203
rGndA_895 GndA_193 GndA_195 0.132919
rGndA_894 GndA_200 GndA_201 0.0348003
rGndA_893 GndA_200 GndA_203 0.0665557
rGndA_892 GndA_205 GndA_207 0.0590701
rGndA_891 GndA_209 GndA_212 0.0362131
rGndA_890 GndA_212 GndA_214 0.148705
rGndA_889 GndA_212 GndA_226 1.13667
rGndA_888 GndA_214 GndA_216 0.105557
rGndA_887 GndA_216 GndA_218 0.0793607
rGndA_886 GndA_216 GndA_225 1.13667
rGndA_885 GndA_218 GndA_220 0.0901475
rGndA_884 GndA_220 GndA_222 0.0331311
rGndA_883 GndA_220 GndA_224 3.41
rGndA_882 GndA_224 GndA_225 0.0312387
rGndA_881 GndA_225 GndA_1886 0.0163009
rGndA_880 GndA_226 GndA_1886 0.0305571
rGndA_879 GndA_256 GndA_280 7.15173
rGndA_878 GndA_279 GndA_331 7.15173
rGndA_877 GndA_290 GndA_292 49.6257
rGndA_876 GndA_307 GndA_332 7.15173
rGndA_875 GndA_364 GndA_365 2.91838
rGndA_874 GndA_381 GndA_1928 0.0118264
rGndA_873 GndA_381 GndA_1928 0.0118264
rGndA_872 GndA_381 GndA_1928 0.00334077
rGndA_871 GndA_381 GndA_1934 0.01575
rGndA_870 GndA_381 GndA_1934 0.01575
rGndA_869 GndA_381 GndA_1934 0.0128929
rGndA_868 GndA_381 GndA_1934 0.0128929
rGndA_867 GndA_381 GndA_1940 0.0118264
rGndA_866 GndA_381 GndA_1940 0.0118264
rGndA_865 GndA_381 GndA_1940 0.00334077
rGndA_864 GndA_381 GndA_1955 0.00310883
rGndA_863 xPix[0].MMoffBias.b GndA_731 4.37607
rGndA_862 xPix[0].MMoffBias.b GndA_735 4.37607
rGndA_861 xPix[0].MMoffBias.b GndA_735 4.37607
rGndA_860 GndA_397 GndA_636 49.2834
rGndA_859 GndA_397 GndA_740 4.10695
rGndA_858 GndA_397 GndA_660 49.6257
rGndA_857 GndA_397 GndA_666 19.1658
rGndA_856 GndA_397 GndA_666 55.4439
rGndA_855 GndA_397 GndA_670 18.8235
rGndA_854 GndA_397 GndA_672 5.81818
rGndA_853 GndA_397 GndA_659 49.6257
rGndA_852 GndA_397 GndA_745 5.63824
rGndA_851 GndA_397 GndA_688 41.4118
rGndA_850 GndA_397 GndA_693 49.6257
rGndA_849 GndA_397 GndA_693 24.6417
rGndA_848 GndA_397 GndA_687 5.47594
rGndA_847 GndA_397 GndA_711 58.1818
rGndA_846 GndA_397 GndA_712 42.4385
rGndA_845 GndA_397 GndA_740 13.6215
rGndA_844 GndA_397 GndA_688 14.1627
rGndA_843 GndA_397 GndA_744 5.33741
rGndA_842 GndA_397 GndA_459 3.1
rGndA_841 GndA_397 GndA_461 3.1
rGndA_840 GndA_397 GndA_463 3.1
rGndA_839 GndA_397 GndA_465 3.1
rGndA_838 GndA_397 GndA_467 3.1
rGndA_837 GndA_397 GndA_469 3.1
rGndA_836 GndA_397 GndA_471 9.3
rGndA_835 GndA_397 GndA_531 1.03333
rGndA_834 GndA_397 GndA_531 1.55
rGndA_833 GndA_397 GndA_478 3.1
rGndA_832 GndA_397 GndA_480 3.1
rGndA_831 GndA_411 GndA_492 4.65
rGndA_830 GndA_427 GndA_428 0.475067
rGndA_829 GndA_427 GndA_494 0.024102
rGndA_828 GndA_428 GndA_520 0.0539746
rGndA_827 GndA_429 GndA_432 0.0503096
rGndA_826 GndA_429 GndA_522 0.0254633
rGndA_825 GndA_430 GndA_432 0.0861068
rGndA_824 GndA_430 GndA_499 0.0506589
rGndA_823 GndA_432 GndA_542 1.125
rGndA_822 GndA_433 GndA_436 0.0357972
rGndA_821 GndA_433 GndA_499 0.0506589
rGndA_820 GndA_434 GndA_440 0.0741099
rGndA_819 GndA_434 GndA_510 0.0366249
rGndA_818 GndA_436 GndA_438 0.123839
rGndA_817 GndA_436 GndA_546 1.125
rGndA_816 GndA_438 GndA_440 0.0145124
rGndA_815 GndA_438 GndA_548 1.125
rGndA_814 GndA_440 xPix[0].MMoffBias.s 3.1
rGndA_813 GndA_441 GndA_444 0.0280782
rGndA_812 GndA_441 GndA_514 0.0324465
rGndA_811 GndA_442 GndA_446 0.0998336
rGndA_810 GndA_442 GndA_516 0.0320891
rGndA_809 GndA_444 GndA_446 0.00519967
rGndA_808 GndA_444 xPix[0].MMonBias.s 3.1
rGndA_807 GndA_446 GndA_554 1.125
rGndA_806 GndA_449 GndA_508 0.382853
rGndA_805 GndA_449 xPix[0].MMchAmpBias.s 9.3
rGndA_804 GndA_452 GndA_454 0.0490998
rGndA_803 GndA_452 GndA_499 0.0156976
rGndA_802 GndA_454 GndA_735 2.325
rGndA_801 GndA_456 GndA_459 0.451571
rGndA_800 GndA_456 GndA_475 0.0753543
rGndA_799 GndA_457 GndA_471 0.0196335
rGndA_798 GndA_457 GndA_523 0.0529306
rGndA_797 GndA_459 GndA_461 0.706806
rGndA_796 GndA_461 GndA_463 0.706806
rGndA_795 GndA_463 GndA_465 0.706806
rGndA_794 GndA_465 GndA_467 0.706806
rGndA_793 GndA_467 GndA_469 0.706806
rGndA_792 GndA_469 GndA_471 0.471204
rGndA_791 GndA_472 GndA_473 0.163613
rGndA_790 GndA_472 GndA_523 0.0529306
rGndA_789 GndA_473 GndA_1728 0.146808
rGndA_788 GndA_475 GndA_532 1.79455
rGndA_787 GndA_476 GndA_478 0.399215
rGndA_786 GndA_476 GndA_523 0.0137558
rGndA_785 GndA_478 GndA_480 0.710079
rGndA_784 GndA_480 GndA_482 0.474476
rGndA_783 GndA_482 GndA_693 4.65
rGndA_782 GndA_484 GndA_486 0.320681
rGndA_781 GndA_484 GndA_532 0.103504
rGndA_780 GndA_486 GndA_488 0.710079
rGndA_779 GndA_486 GndA_666 3.1
rGndA_778 GndA_488 GndA_490 0.474476
rGndA_777 GndA_488 GndA_670 3.1
rGndA_776 GndA_490 GndA_672 9.3
rGndA_775 GndA_492 GndA_1687 0.0380435
rGndA_774 GndA_494 GndA_496 0.143962
rGndA_773 GndA_496 GndA_1674 0.0578484
rGndA_772 GndA_499 GndA_544 1.125
rGndA_771 GndA_499 GndA_731 2.325
rGndA_770 GndA_502 GndA_505 0.133111
rGndA_769 GndA_502 GndA_558 1.125
rGndA_768 GndA_505 GndA_507 0.00519967
rGndA_767 GndA_505 GndA_578 2.25
rGndA_766 GndA_507 GndA_508 0.0911428
rGndA_765 GndA_507 xPix[0].MMchAmpBias.s 3.1
rGndA_764 GndA_510 GndA_512 0.0335208
rGndA_763 GndA_510 GndA_550 2.25
rGndA_762 GndA_512 xPix[0].MMoffBias.s 9.3
rGndA_761 GndA_514 GndA_552 2.25
rGndA_760 GndA_516 GndA_518 0.0115741
rGndA_759 GndA_516 GndA_556 2.25
rGndA_758 GndA_518 xPix[0].MMonBias.s 9.3
rGndA_757 GndA_520 GndA_522 0.0373253
rGndA_756 GndA_520 GndA_539 1.125
rGndA_755 GndA_522 xPix[0].MMPDRefrRow.s 9.3
rGndA_754 GndA_524 GndA_569 4.5
rGndA_753 GndA_524 GndA_1738 0.0203236
rGndA_752 GndA_524 GndA_1741 6.37105e-05
rGndA_751 GndA_525 GndA_567 1.5
rGndA_750 GndA_525 GndA_531 0.0194317
rGndA_749 GndA_525 GndA_1738 6.37105e-05
rGndA_748 GndA_526 GndA_583 1.5
rGndA_747 GndA_526 GndA_1731 0.0203236
rGndA_746 GndA_526 GndA_1734 6.37105e-05
rGndA_745 GndA_527 GndA_580 1.5
rGndA_744 GndA_527 GndA_1728 0.00159276
rGndA_743 GndA_527 GndA_1731 6.37105e-05
rGndA_742 GndA_528 xPix[0].MMpr.amp.s 9.3
rGndA_741 GndA_528 GndA_1743 0.01013
rGndA_740 GndA_531 GndA_744 3.1
rGndA_739 GndA_531 GndA_1734 0.0212793
rGndA_738 GndA_534 GndA_1676 0.0186508
rGndA_737 GndA_534 GndA_585 4.5
rGndA_736 GndA_535 GndA_575 4.5
rGndA_735 GndA_535 GndA_536 0.171535
rGndA_734 GndA_536 xPix[0].MMsf.d 9.3
rGndA_733 GndA_536 GndA_1696 0.0335418
rGndA_732 GndA_537 GndA_558 0.0519967
rGndA_731 GndA_537 GndA_578 0.0333077
rGndA_730 GndA_539 GndA_542 0.133111
rGndA_729 GndA_542 GndA_544 0.133111
rGndA_728 GndA_544 GndA_546 0.133111
rGndA_727 GndA_546 GndA_548 0.133111
rGndA_726 GndA_548 GndA_550 0.133111
rGndA_725 GndA_550 GndA_552 0.328619
rGndA_724 GndA_552 GndA_554 0.0665557
rGndA_723 GndA_554 GndA_556 0.133111
rGndA_722 GndA_556 GndA_558 0.230865
rGndA_721 GndA_560 GndA_581 0.390481
rGndA_720 GndA_560 GndA_578 0.0367533
rGndA_719 GndA_561 GndA_602 3.41
rGndA_718 GndA_561 GndA_1801 0.0292664
rGndA_717 GndA_561 GndA_1876 0.059502
rGndA_716 GndA_562 GndA_598 1.13667
rGndA_715 GndA_562 GndA_1809 0.0590531
rGndA_714 GndA_562 GndA_1801 0.0747919
rGndA_713 GndA_563 GndA_594 1.13667
rGndA_712 GndA_563 GndA_1804 0.0278356
rGndA_711 GndA_563 GndA_1807 0.0137877
rGndA_710 GndA_564 GndA_589 1.13667
rGndA_709 GndA_564 GndA_1868 0.102426
rGndA_708 GndA_564 GndA_1870 0.00338189
rGndA_707 GndA_565 GndA_567 0.0998336
rGndA_706 GndA_565 GndA_583 0.0332779
rGndA_705 GndA_567 GndA_569 0.0665557
rGndA_704 GndA_571 GndA_587 0.478516
rGndA_703 GndA_571 GndA_573 0.070203
rGndA_702 GndA_573 GndA_575 0.132919
rGndA_701 GndA_580 GndA_581 0.0348003
rGndA_700 GndA_580 GndA_583 0.0665557
rGndA_699 GndA_585 GndA_587 0.0590701
rGndA_698 GndA_589 GndA_592 0.0362131
rGndA_697 GndA_592 GndA_594 0.148705
rGndA_696 GndA_592 GndA_606 1.13667
rGndA_695 GndA_594 GndA_596 0.105557
rGndA_694 GndA_596 GndA_598 0.0793607
rGndA_693 GndA_596 GndA_605 1.13667
rGndA_692 GndA_598 GndA_600 0.0901475
rGndA_691 GndA_600 GndA_602 0.0331311
rGndA_690 GndA_600 GndA_604 3.41
rGndA_689 GndA_604 GndA_605 0.0312387
rGndA_688 GndA_605 GndA_1893 0.0163009
rGndA_687 GndA_606 GndA_1893 0.0305571
rGndA_686 GndA_636 GndA_660 7.15173
rGndA_685 GndA_659 GndA_711 7.15173
rGndA_684 GndA_670 GndA_672 49.6257
rGndA_683 GndA_687 GndA_712 7.15173
rGndA_682 GndA_744 GndA_745 2.91838
rGndA_681 xPix[3].MMoffBias.b GndA_1111 4.37607
rGndA_680 xPix[3].MMoffBias.b GndA_1115 4.37607
rGndA_679 xPix[3].MMoffBias.b GndA_1115 4.37607
rGndA_678 GndA_777 GndA_1016 49.2834
rGndA_677 GndA_777 GndA_1120 4.10695
rGndA_676 GndA_777 GndA_1040 49.6257
rGndA_675 GndA_777 GndA_1046 19.1658
rGndA_674 GndA_777 GndA_1046 55.4439
rGndA_673 GndA_777 GndA_1050 18.8235
rGndA_672 GndA_777 GndA_1052 5.81818
rGndA_671 GndA_777 GndA_1039 49.6257
rGndA_670 GndA_777 GndA_1125 5.63824
rGndA_669 GndA_777 GndA_1068 41.4118
rGndA_668 GndA_777 GndA_1073 49.6257
rGndA_667 GndA_777 GndA_1073 24.6417
rGndA_666 GndA_777 GndA_1067 5.47594
rGndA_665 GndA_777 GndA_1091 58.1818
rGndA_664 GndA_777 GndA_1092 42.4385
rGndA_663 GndA_777 GndA_1120 13.6215
rGndA_662 GndA_777 GndA_1068 14.1627
rGndA_661 GndA_777 GndA_1124 5.33741
rGndA_660 GndA_777 GndA_839 3.1
rGndA_659 GndA_777 GndA_841 3.1
rGndA_658 GndA_777 GndA_843 3.1
rGndA_657 GndA_777 GndA_845 3.1
rGndA_656 GndA_777 GndA_847 3.1
rGndA_655 GndA_777 GndA_849 3.1
rGndA_654 GndA_777 GndA_851 9.3
rGndA_653 GndA_777 GndA_910 1.03333
rGndA_652 GndA_777 GndA_909 1.55
rGndA_651 GndA_777 GndA_858 3.1
rGndA_650 GndA_777 GndA_860 3.1
rGndA_649 GndA_807 GndA_808 0.475067
rGndA_648 GndA_807 GndA_874 0.024102
rGndA_647 GndA_808 GndA_900 0.0539746
rGndA_646 GndA_809 GndA_812 0.0503096
rGndA_645 GndA_809 GndA_902 0.0254633
rGndA_644 GndA_810 GndA_812 0.0861068
rGndA_643 GndA_810 GndA_879 0.0506589
rGndA_642 GndA_812 GndA_922 1.125
rGndA_641 GndA_813 GndA_816 0.0357972
rGndA_640 GndA_813 GndA_879 0.0506589
rGndA_639 GndA_814 GndA_820 0.0741099
rGndA_638 GndA_814 GndA_890 0.0366249
rGndA_637 GndA_816 GndA_818 0.123839
rGndA_636 GndA_816 GndA_926 1.125
rGndA_635 GndA_818 GndA_820 0.0145124
rGndA_634 GndA_818 GndA_928 1.125
rGndA_633 GndA_820 xPix[3].MMoffBias.s 3.1
rGndA_632 GndA_821 GndA_824 0.0280782
rGndA_631 GndA_821 GndA_894 0.0324465
rGndA_630 GndA_822 GndA_826 0.0998336
rGndA_629 GndA_822 GndA_896 0.0320891
rGndA_628 GndA_824 GndA_826 0.00519967
rGndA_627 GndA_824 xPix[3].MMonBias.s 3.1
rGndA_626 GndA_826 GndA_934 1.125
rGndA_625 GndA_829 GndA_888 0.382853
rGndA_624 GndA_829 xPix[3].MMchAmpBias.s 9.3
rGndA_623 GndA_832 GndA_834 0.0490998
rGndA_622 GndA_832 GndA_879 0.0156976
rGndA_621 GndA_834 GndA_1115 2.325
rGndA_620 GndA_836 GndA_839 0.451571
rGndA_619 GndA_836 GndA_855 0.0753543
rGndA_618 GndA_837 GndA_851 0.0196335
rGndA_617 GndA_837 GndA_903 0.0529306
rGndA_616 GndA_839 GndA_841 0.706806
rGndA_615 GndA_841 GndA_843 0.706806
rGndA_614 GndA_843 GndA_845 0.706806
rGndA_613 GndA_845 GndA_847 0.706806
rGndA_612 GndA_847 GndA_849 0.706806
rGndA_611 GndA_849 GndA_851 0.471204
rGndA_610 GndA_852 GndA_853 0.163613
rGndA_609 GndA_852 GndA_903 0.0529306
rGndA_608 GndA_853 GndA_905 0.15234
rGndA_607 GndA_855 GndA_912 1.79455
rGndA_606 GndA_856 GndA_858 0.399215
rGndA_605 GndA_856 GndA_903 0.0137558
rGndA_604 GndA_858 GndA_860 0.710079
rGndA_603 GndA_860 GndA_862 0.474476
rGndA_602 GndA_862 GndA_1073 4.65
rGndA_601 GndA_864 GndA_866 0.320681
rGndA_600 GndA_864 GndA_912 0.103504
rGndA_599 GndA_866 GndA_868 0.710079
rGndA_598 GndA_866 GndA_1046 3.1
rGndA_597 GndA_868 GndA_870 0.474476
rGndA_596 GndA_868 GndA_1050 3.1
rGndA_595 GndA_870 GndA_1052 9.3
rGndA_594 GndA_872 GndA_1171 4.65
rGndA_593 GndA_872 GndA_1705 0.0380435
rGndA_592 GndA_874 GndA_876 0.143962
rGndA_591 GndA_876 GndA_1679 0.0578484
rGndA_590 GndA_879 GndA_924 1.125
rGndA_589 GndA_879 GndA_1111 2.325
rGndA_588 GndA_882 GndA_885 0.133111
rGndA_587 GndA_882 GndA_938 1.125
rGndA_586 GndA_885 GndA_887 0.00519967
rGndA_585 GndA_885 GndA_958 2.25
rGndA_584 GndA_887 GndA_888 0.0911428
rGndA_583 GndA_887 xPix[3].MMchAmpBias.s 3.1
rGndA_582 GndA_890 GndA_892 0.0335208
rGndA_581 GndA_890 GndA_930 2.25
rGndA_580 GndA_892 xPix[3].MMoffBias.s 9.3
rGndA_579 GndA_894 GndA_932 2.25
rGndA_578 GndA_896 GndA_898 0.0115741
rGndA_577 GndA_896 GndA_936 2.25
rGndA_576 GndA_898 xPix[3].MMonBias.s 9.3
rGndA_575 GndA_900 GndA_902 0.0373253
rGndA_574 GndA_900 GndA_919 1.125
rGndA_573 GndA_902 xPix[3].MMPDRefrRow.s 9.3
rGndA_572 GndA_904 GndA_963 1.5
rGndA_571 GndA_904 GndA_949 4.5
rGndA_570 GndA_904 GndA_910 0.0260159
rGndA_569 GndA_904 GndA_911 0.0185828
rGndA_568 GndA_905 GndA_960 1.5
rGndA_567 GndA_905 GndA_947 1.5
rGndA_566 GndA_905 GndA_911 0.00123885
rGndA_565 GndA_908 xPix[3].MMpr.amp.s 9.3
rGndA_564 GndA_908 GndA_909 0.0145565
rGndA_563 GndA_908 GndA_910 0.0300421
rGndA_562 GndA_909 GndA_1759 0.0476338
rGndA_561 GndA_911 GndA_1124 3.1
rGndA_560 GndA_914 GndA_1677 0.0186508
rGndA_559 GndA_914 GndA_965 4.5
rGndA_558 GndA_915 GndA_955 4.5
rGndA_557 GndA_915 GndA_916 0.171535
rGndA_556 GndA_916 xPix[3].MMsf.d 9.3
rGndA_555 GndA_916 GndA_1697 0.0335418
rGndA_554 GndA_917 GndA_938 0.0519967
rGndA_553 GndA_917 GndA_958 0.0333077
rGndA_552 GndA_919 GndA_922 0.133111
rGndA_551 GndA_922 GndA_924 0.133111
rGndA_550 GndA_924 GndA_926 0.133111
rGndA_549 GndA_926 GndA_928 0.133111
rGndA_548 GndA_928 GndA_930 0.133111
rGndA_547 GndA_930 GndA_932 0.328619
rGndA_546 GndA_932 GndA_934 0.0665557
rGndA_545 GndA_934 GndA_936 0.133111
rGndA_544 GndA_936 GndA_938 0.230865
rGndA_543 GndA_940 GndA_961 0.390481
rGndA_542 GndA_940 GndA_958 0.0367533
rGndA_541 GndA_941 GndA_982 3.41
rGndA_540 GndA_941 GndA_1878 0.059502
rGndA_539 GndA_941 GndA_1824 0.0943028
rGndA_538 GndA_942 GndA_978 1.13667
rGndA_537 GndA_942 GndA_1824 0.00975546
rGndA_536 GndA_942 GndA_1827 0.0591831
rGndA_535 GndA_943 GndA_974 1.13667
rGndA_534 GndA_943 GndA_1831 0.0136576
rGndA_533 GndA_943 GndA_1834 0.069589
rGndA_532 GndA_944 GndA_969 1.13667
rGndA_531 GndA_944 GndA_1836 0.0448751
rGndA_530 GndA_944 GndA_1823 0.0136576
rGndA_529 GndA_945 GndA_947 0.0998336
rGndA_528 GndA_945 GndA_963 0.0332779
rGndA_527 GndA_947 GndA_949 0.0665557
rGndA_526 GndA_951 GndA_967 0.478516
rGndA_525 GndA_951 GndA_953 0.070203
rGndA_524 GndA_953 GndA_955 0.132919
rGndA_523 GndA_960 GndA_961 0.0348003
rGndA_522 GndA_960 GndA_963 0.0665557
rGndA_521 GndA_965 GndA_967 0.0590701
rGndA_520 GndA_969 GndA_972 0.0362131
rGndA_519 GndA_972 GndA_974 0.148705
rGndA_518 GndA_972 GndA_986 1.13667
rGndA_517 GndA_974 GndA_976 0.105557
rGndA_516 GndA_976 GndA_978 0.0793607
rGndA_515 GndA_976 GndA_985 1.13667
rGndA_514 GndA_978 GndA_980 0.0901475
rGndA_513 GndA_980 GndA_982 0.0331311
rGndA_512 GndA_980 GndA_984 3.41
rGndA_511 GndA_984 GndA_985 0.0312387
rGndA_510 GndA_985 GndA_1901 0.0163293
rGndA_509 GndA_986 GndA_1901 0.0305287
rGndA_508 GndA_1016 GndA_1040 7.15173
rGndA_507 GndA_1039 GndA_1091 7.15173
rGndA_506 GndA_1050 GndA_1052 49.6257
rGndA_505 GndA_1067 GndA_1092 7.15173
rGndA_504 GndA_1124 GndA_1125 2.91838
rGndA_503 xPix[2].MMoffBias.b GndA_1491 4.37607
rGndA_502 xPix[2].MMoffBias.b GndA_1495 4.37607
rGndA_501 xPix[2].MMoffBias.b GndA_1495 4.37607
rGndA_500 GndA_1157 GndA_1396 49.2834
rGndA_499 GndA_1157 GndA_1500 4.10695
rGndA_498 GndA_1157 GndA_1420 49.6257
rGndA_497 GndA_1157 GndA_1426 19.1658
rGndA_496 GndA_1157 GndA_1426 55.4439
rGndA_495 GndA_1157 GndA_1430 18.8235
rGndA_494 GndA_1157 GndA_1432 5.81818
rGndA_493 GndA_1157 GndA_1419 49.6257
rGndA_492 GndA_1157 GndA_1505 5.63824
rGndA_491 GndA_1157 GndA_1448 41.4118
rGndA_490 GndA_1157 GndA_1453 49.6257
rGndA_489 GndA_1157 GndA_1453 24.6417
rGndA_488 GndA_1157 GndA_1447 5.47594
rGndA_487 GndA_1157 GndA_1471 58.1818
rGndA_486 GndA_1157 GndA_1472 42.4385
rGndA_485 GndA_1157 GndA_1500 13.6215
rGndA_484 GndA_1157 GndA_1448 14.1627
rGndA_483 GndA_1157 GndA_1504 5.33741
rGndA_482 GndA_1157 GndA_1219 3.1
rGndA_481 GndA_1157 GndA_1221 3.1
rGndA_480 GndA_1157 GndA_1223 3.1
rGndA_479 GndA_1157 GndA_1225 3.1
rGndA_478 GndA_1157 GndA_1227 3.1
rGndA_477 GndA_1157 GndA_1229 3.1
rGndA_476 GndA_1157 GndA_1231 9.3
rGndA_475 GndA_1157 GndA_1291 1.03333
rGndA_474 GndA_1157 GndA_1291 1.55
rGndA_473 GndA_1157 GndA_1238 3.1
rGndA_472 GndA_1157 GndA_1240 3.1
rGndA_471 GndA_1171 GndA_1252 4.65
rGndA_470 GndA_1187 GndA_1188 0.475067
rGndA_469 GndA_1187 GndA_1254 0.024102
rGndA_468 GndA_1188 GndA_1280 0.0539746
rGndA_467 GndA_1189 GndA_1192 0.0503096
rGndA_466 GndA_1189 GndA_1282 0.0254633
rGndA_465 GndA_1190 GndA_1192 0.0861068
rGndA_464 GndA_1190 GndA_1259 0.0506589
rGndA_463 GndA_1192 GndA_1302 1.125
rGndA_462 GndA_1193 GndA_1196 0.0357972
rGndA_461 GndA_1193 GndA_1259 0.0506589
rGndA_460 GndA_1194 GndA_1200 0.0741099
rGndA_459 GndA_1194 GndA_1270 0.0366249
rGndA_458 GndA_1196 GndA_1198 0.123839
rGndA_457 GndA_1196 GndA_1306 1.125
rGndA_456 GndA_1198 GndA_1200 0.0145124
rGndA_455 GndA_1198 GndA_1308 1.125
rGndA_454 GndA_1200 xPix[2].MMoffBias.s 3.1
rGndA_453 GndA_1201 GndA_1204 0.0280782
rGndA_452 GndA_1201 GndA_1274 0.0324465
rGndA_451 GndA_1202 GndA_1206 0.0998336
rGndA_450 GndA_1202 GndA_1276 0.0320891
rGndA_449 GndA_1204 GndA_1206 0.00519967
rGndA_448 GndA_1204 xPix[2].MMonBias.s 3.1
rGndA_447 GndA_1206 GndA_1314 1.125
rGndA_446 GndA_1209 GndA_1268 0.382853
rGndA_445 GndA_1209 xPix[2].MMchAmpBias.s 9.3
rGndA_444 GndA_1212 GndA_1214 0.0490998
rGndA_443 GndA_1212 GndA_1259 0.0156976
rGndA_442 GndA_1214 GndA_1495 2.325
rGndA_441 GndA_1216 GndA_1219 0.451571
rGndA_440 GndA_1216 GndA_1235 0.0753543
rGndA_439 GndA_1217 GndA_1231 0.0196335
rGndA_438 GndA_1217 GndA_1283 0.0529306
rGndA_437 GndA_1219 GndA_1221 0.706806
rGndA_436 GndA_1221 GndA_1223 0.706806
rGndA_435 GndA_1223 GndA_1225 0.706806
rGndA_434 GndA_1225 GndA_1227 0.706806
rGndA_433 GndA_1227 GndA_1229 0.706806
rGndA_432 GndA_1229 GndA_1231 0.471204
rGndA_431 GndA_1232 GndA_1233 0.163613
rGndA_430 GndA_1232 GndA_1283 0.0529306
rGndA_429 GndA_1233 GndA_1781 0.146808
rGndA_428 GndA_1235 GndA_1292 1.79455
rGndA_427 GndA_1236 GndA_1238 0.399215
rGndA_426 GndA_1236 GndA_1283 0.0137558
rGndA_425 GndA_1238 GndA_1240 0.710079
rGndA_424 GndA_1240 GndA_1242 0.474476
rGndA_423 GndA_1242 GndA_1453 4.65
rGndA_422 GndA_1244 GndA_1246 0.320681
rGndA_421 GndA_1244 GndA_1292 0.103504
rGndA_420 GndA_1246 GndA_1248 0.710079
rGndA_419 GndA_1246 GndA_1426 3.1
rGndA_418 GndA_1248 GndA_1250 0.474476
rGndA_417 GndA_1248 GndA_1430 3.1
rGndA_416 GndA_1250 GndA_1432 9.3
rGndA_415 GndA_1252 GndA_1707 0.0380435
rGndA_414 GndA_1254 GndA_1256 0.143962
rGndA_413 GndA_1256 GndA_1680 0.0578484
rGndA_412 GndA_1259 GndA_1304 1.125
rGndA_411 GndA_1259 GndA_1491 2.325
rGndA_410 GndA_1262 GndA_1265 0.133111
rGndA_409 GndA_1262 GndA_1318 1.125
rGndA_408 GndA_1265 GndA_1267 0.00519967
rGndA_407 GndA_1265 GndA_1338 2.25
rGndA_406 GndA_1267 GndA_1268 0.0911428
rGndA_405 GndA_1267 xPix[2].MMchAmpBias.s 3.1
rGndA_404 GndA_1270 GndA_1272 0.0335208
rGndA_403 GndA_1270 GndA_1310 2.25
rGndA_402 GndA_1272 xPix[2].MMoffBias.s 9.3
rGndA_401 GndA_1274 GndA_1312 2.25
rGndA_400 GndA_1276 GndA_1278 0.0115741
rGndA_399 GndA_1276 GndA_1316 2.25
rGndA_398 GndA_1278 xPix[2].MMonBias.s 9.3
rGndA_397 GndA_1280 GndA_1282 0.0373253
rGndA_396 GndA_1280 GndA_1299 1.125
rGndA_395 GndA_1282 xPix[2].MMPDRefrRow.s 9.3
rGndA_394 GndA_1284 GndA_1329 4.5
rGndA_393 GndA_1284 GndA_1771 0.0203874
rGndA_392 GndA_1284 GndA_1285 0.0203874
rGndA_391 GndA_1284 GndA_1846 1.5
rGndA_390 GndA_1285 GndA_1327 1.5
rGndA_389 GndA_1285 GndA_1291 0.0194317
rGndA_388 GndA_1286 GndA_1343 1.5
rGndA_387 GndA_1286 GndA_1777 0.0203874
rGndA_386 GndA_1286 GndA_1287 0.0203874
rGndA_385 GndA_1286 GndA_1851 1.5
rGndA_384 GndA_1287 GndA_1340 1.5
rGndA_383 GndA_1287 GndA_1781 0.00159276
rGndA_382 GndA_1288 xPix[2].MMpr.amp.s 9.3
rGndA_381 GndA_1288 GndA_1769 0.0101937
rGndA_380 GndA_1291 GndA_1504 3.1
rGndA_379 GndA_1291 GndA_1777 0.000955658
rGndA_378 GndA_1294 GndA_1678 0.0186508
rGndA_377 GndA_1294 GndA_1345 4.5
rGndA_376 GndA_1295 GndA_1335 4.5
rGndA_375 GndA_1295 GndA_1296 0.171535
rGndA_374 GndA_1296 xPix[2].MMsf.d 9.3
rGndA_373 GndA_1296 GndA_1695 0.0335418
rGndA_372 GndA_1297 GndA_1318 0.0519967
rGndA_371 GndA_1297 GndA_1338 0.0333077
rGndA_370 GndA_1299 GndA_1302 0.133111
rGndA_369 GndA_1302 GndA_1304 0.133111
rGndA_368 GndA_1304 GndA_1306 0.133111
rGndA_367 GndA_1306 GndA_1308 0.133111
rGndA_366 GndA_1308 GndA_1310 0.133111
rGndA_365 GndA_1310 GndA_1312 0.328619
rGndA_364 GndA_1312 GndA_1314 0.0665557
rGndA_363 GndA_1314 GndA_1316 0.133111
rGndA_362 GndA_1316 GndA_1318 0.230865
rGndA_361 GndA_1320 GndA_1341 0.390481
rGndA_360 GndA_1320 GndA_1338 0.0367533
rGndA_359 GndA_1321 GndA_1362 3.41
rGndA_358 GndA_1321 GndA_1880 0.059502
rGndA_357 GndA_1321 GndA_1839 0.0943028
rGndA_356 GndA_1322 GndA_1358 1.13667
rGndA_355 GndA_1322 GndA_1839 0.00975546
rGndA_354 GndA_1322 GndA_1842 0.0591831
rGndA_353 GndA_1323 GndA_1354 1.13667
rGndA_352 GndA_1323 GndA_1846 0.0136576
rGndA_351 GndA_1323 GndA_1849 0.069589
rGndA_350 GndA_1324 GndA_1349 1.13667
rGndA_349 GndA_1324 GndA_1851 0.0448751
rGndA_348 GndA_1324 GndA_1838 0.0136576
rGndA_347 GndA_1325 GndA_1327 0.0998336
rGndA_346 GndA_1325 GndA_1343 0.0332779
rGndA_345 GndA_1327 GndA_1329 0.0665557
rGndA_344 GndA_1331 GndA_1347 0.478516
rGndA_343 GndA_1331 GndA_1333 0.070203
rGndA_342 GndA_1333 GndA_1335 0.132919
rGndA_341 GndA_1340 GndA_1341 0.0348003
rGndA_340 GndA_1340 GndA_1343 0.0665557
rGndA_339 GndA_1345 GndA_1347 0.0590701
rGndA_338 GndA_1349 GndA_1352 0.0362131
rGndA_337 GndA_1352 GndA_1354 0.148705
rGndA_336 GndA_1352 GndA_1366 1.13667
rGndA_335 GndA_1354 GndA_1356 0.105557
rGndA_334 GndA_1356 GndA_1358 0.0793607
rGndA_333 GndA_1356 GndA_1365 1.13667
rGndA_332 GndA_1358 GndA_1360 0.0901475
rGndA_331 GndA_1360 GndA_1362 0.0331311
rGndA_330 GndA_1360 GndA_1364 3.41
rGndA_329 GndA_1364 GndA_1365 0.0312387
rGndA_328 GndA_1365 GndA_1908 0.0163293
rGndA_327 GndA_1366 GndA_1908 0.0305287
rGndA_326 GndA_1396 GndA_1420 7.15173
rGndA_325 GndA_1419 GndA_1471 7.15173
rGndA_324 GndA_1430 GndA_1432 49.6257
rGndA_323 GndA_1447 GndA_1472 7.15173
rGndA_322 GndA_1504 GndA_1505 2.91838
rGndA_321 GndA_1673 GndA_1681 0.446429
rGndA_320 GndA_1674 GndA_1682 0.446429
rGndA_319 GndA_1675 GndA_1690 1.5
rGndA_318 GndA_1676 GndA_1693 0.839221
rGndA_317 GndA_1677 GndA_1700 1.5
rGndA_316 GndA_1678 GndA_1703 0.839221
rGndA_315 GndA_1679 GndA_1711 0.446429
rGndA_314 GndA_1680 GndA_1712 0.446429
rGndA_313 GndA_1681 GndA_1713 0.0500861
rGndA_312 GndA_1682 GndA_1713 0.0500861
rGndA_311 GndA_1683 GndA_1684 2.37569
rGndA_310 GndA_1683 GndA_1714 0.0154007
rGndA_309 GndA_1684 GndA_1713 0.0162
rGndA_308 GndA_1685 GndA_1714 0.0510002
rGndA_307 GndA_1687 GndA_1714 0.0510002
rGndA_306 GndA_1690 GndA_1814 2.25
rGndA_305 GndA_1693 GndA_1820 2.25
rGndA_304 GndA_1695 GndA_1696 0.235588
rGndA_303 GndA_1697 GndA_1698 0.167683
rGndA_302 GndA_1700 GndA_1816 2.25
rGndA_301 GndA_1703 GndA_1822 2.25
rGndA_300 GndA_1705 GndA_1753 0.0510002
rGndA_299 GndA_1707 GndA_1753 0.0510002
rGndA_298 GndA_1709 GndA_1710 2.37569
rGndA_297 GndA_1709 GndA_1782 0.0162
rGndA_296 GndA_1710 GndA_1753 0.0154007
rGndA_295 GndA_1711 GndA_1782 0.0500861
rGndA_294 GndA_1712 GndA_1782 0.0500861
rGndA_293 GndA_1716 GndA_1720 0.0198216
rGndA_292 GndA_1716 GndA_1864 1.5
rGndA_291 GndA_1716 GndA_1794 1.5
rGndA_290 GndA_1716 GndA_1799 2.25
rGndA_289 GndA_1720 GndA_1866 1.5
rGndA_288 GndA_1720 GndA_1797 1.5
rGndA_287 GndA_1731 GndA_1870 1.5
rGndA_286 GndA_1734 GndA_1872 1.5
rGndA_285 GndA_1738 GndA_1804 1.5
rGndA_284 GndA_1741 GndA_1743 0.0407747
rGndA_283 GndA_1741 GndA_1807 1.5
rGndA_282 GndA_1743 GndA_1809 2.25
rGndA_281 GndA_1755 GndA_1759 0.0198216
rGndA_280 GndA_1755 GndA_1827 2.25
rGndA_279 GndA_1755 GndA_1829 1.5
rGndA_278 GndA_1755 GndA_1834 1.5
rGndA_277 GndA_1759 GndA_1831 1.5
rGndA_276 GndA_1759 GndA_1836 1.5
rGndA_275 GndA_1769 GndA_1771 0.0203874
rGndA_274 GndA_1769 GndA_1842 2.25
rGndA_273 GndA_1771 GndA_1844 1.5
rGndA_272 GndA_1777 GndA_1849 1.5
rGndA_271 GndA GndA_1862 0.392791
rGndA_270 GndA GndA_1868 0.392791
rGndA_269 GndA_1792 GndA_1794 0.076873
rGndA_268 GndA_1792 GndA_1866 0.00637357
rGndA_267 GndA_1797 GndA_1799 0.0832466
rGndA_266 GndA_1802 GndA_1804 0.076873
rGndA_265 GndA_1802 GndA_1872 0.00637357
rGndA_264 GndA_1807 GndA_1809 0.0832466
rGndA_263 GndA_1814 GndA_1874 0.907116
rGndA_262 GndA_1814 GndA_1816 1.06169
rGndA_261 GndA_1816 GndA_1878 0.905499
rGndA_260 GndA_1820 GndA_1876 0.907116
rGndA_259 GndA_1820 GndA_1822 1.06169
rGndA_258 GndA_1822 GndA_1880 0.905499
rGndA_257 GndA_1823 GndA_1881 0.0887684
rGndA_256 GndA_1827 GndA_1829 0.0416233
rGndA_255 GndA_1829 GndA_1831 0.0416233
rGndA_254 GndA_1834 GndA_1836 0.0416233
rGndA_253 GndA_1838 GndA_1882 0.0887684
rGndA_252 GndA_1842 GndA_1844 0.0416233
rGndA_251 GndA_1844 GndA_1846 0.0416233
rGndA_250 GndA_1849 GndA_1851 0.0416233
rGndA_249 GndA GndA_1881 0.392791
rGndA_248 GndA GndA_1882 0.392791
rGndA_247 GndA_1864 GndA_1866 0.0416233
rGndA_246 GndA_1870 GndA_1872 0.0416233
rGndA_245 GndA_1886 GndA_1944 0.126667
rGndA_244 GndA_1893 GndA_1955 0.126667
rGndA_243 GndA_1901 GndA_1949 0.126667
rGndA_242 GndA_1908 GndA_1955 0.126667
rGndA_241 GndA_1923 GndA_1925 0.0118264
rGndA_240 GndA_1923 GndA_1941 0.00167377
rGndA_239 GndA_1929 GndA_1931 0.0128929
rGndA_238 GndA_1929 GndA_1946 0.000581095
rGndA_237 GndA_1935 GndA_1937 0.0118264
rGndA_236 GndA_1935 GndA_1950 0.00167377
rGndA_235 GndA_1941 GndA_1944 0.0167828
rGndA_234 GndA_1944 GndA_1945 0.0118163
rGndA_233 GndA_1945 GndA_1946 0.0297391
rGndA_232 GndA_1946 GndA_1947 0.0297391
rGndA_231 GndA_1947 GndA_1949 0.0118213
rGndA_230 GndA_1949 GndA_1950 0.0167778
rGndA_229 GndA_1955 GndA 0.00257366
rxPix[2].nOFF.53 xPix[2].MMP2.d xPix[2].nOFF 0.01
rxPix[2].nOFF.52 xPix[2].nOFF.1 xPix[2].nOFF.3 0.255236
rxPix[2].nOFF.51 xPix[2].nOFF.1 xPix[2].nOFF.25 0.10068
rxPix[2].nOFF.50 xPix[2].nOFF.3 xPix[2].nOFF.5 0.471204
rxPix[2].nOFF.49 xPix[2].nOFF.3 xPix[2].MMoffBias.d 3.1
rxPix[2].nOFF.48 xPix[2].nOFF.5 xPix[2].MMoffBias.d 9.3
rxPix[2].nOFF.47 xPix[2].nOFF.7 xPix[2].nOFF.25 3.32921
rxPix[2].nOFF.46 xPix[2].nOFF.7 xPix[2].nOFF.10 0.0698411
rxPix[2].nOFF.45 xPix[2].nOFF.9 xPix[2].nOFF.10 1.9245
rxPix[2].nOFF.44 xPix[2].nOFF.9 xPix[2].nOFF.28 0.0073411
rxPix[2].nOFF.43 xPix[2].nOFF.15 xPix[2].nOFF.16 0.643564
rxPix[2].nOFF.42 xPix[2].nOFF.15 xPix[2].nOFF.32 0.150768
rxPix[2].nOFF.41 xPix[2].nOFF.16 xPix[2].nOFF.26 0.0073411
rxPix[2].nOFF.40 xPix[2].nOFF.17 xPix[2].nOFF.18 1.88738
rxPix[2].nOFF.39 xPix[2].nOFF.17 xPix[2].nOFF.36 0.0073411
rxPix[2].nOFF.38 xPix[2].nOFF.18 xPix[2].nOFF.30 0.0367876
rxPix[2].nOFF.37 xPix[2].nOFF.19 xPix[2].nOFF.20 3.80569
rxPix[2].nOFF.36 xPix[2].nOFF.19 xPix[2].nOFF.21 0.0753543
rxPix[2].nOFF.35 xPix[2].nOFF.20 xPix[2].nOFF.34 0.0073411
rxPix[2].nOFF.34 xPix[2].nOFF.21 xPix[2].nOFF.23 0.376309
rxPix[2].nOFF.33 xPix[2].nOFF.23 xPix[2].nOFF.52 3.1
rxPix[2].nOFF.32 xPix[2].nOFF.26 xPix[2].nOFF.28 0.117574
rxPix[2].nOFF.31 xPix[2].nOFF.30 xPix[2].nOFF.32 0.0411184
rxPix[2].nOFF.30 xPix[2].nOFF.32 xPix[2].nOFF.63 9.3
rxPix[2].nOFF.29 xPix[2].nOFF.34 xPix[2].nOFF.36 0.185644
rxPix[2].nOFF.28 xPix[2].nOFF.46 xPix[2].nOFF.47 28.7487
rxPix[2].nOFF.27 xPix[2].nOFF.46 xPix[2].nOFF.60 4.85115
rxPix[2].nOFF.26 xPix[2].nOFF.47 xPix[2].nOFF.59 2.73809
rxPix[2].nOFF.25 xPix[2].nOFF.52 xPix[2].nOFF 11.2941
rxPix[2].nOFF.24 xPix[2].nOFF.52 xPix[2].nOFF 37.9893
rxPix[2].nOFF.23 xPix[2].nOFF.57 xPix[2].nOFF.59 13.6752
rxPix[2].nOFF.22 xPix[2].nOFF.57 xPix[2].nOFF.70 152
rxPix[2].nOFF.21 xPix[2].nOFF.60 xPix[2].nOFF.63 2.95101
rxPix[2].nOFF.20 xPix[2].nOFF.65 xPix[2].MMN8.g 210.234
rxPix[2].nOFF.19 xPix[2].nOFF.65 xPix[2].nOFF.70 52.7279
rxPix[2].VPR.60 xPix[2].MMprBias.d xPix[2].VPR 0.01
rxPix[2].VPR.59 xPix[2].VPR.1 xPix[2].VPR.2 0.321782
rxPix[2].VPR.58 xPix[2].VPR.1 xPix[2].VPR.14 0.0446906
rxPix[2].VPR.57 xPix[2].VPR.2 xPix[2].VPR.12 0.0513368
rxPix[2].VPR.56 xPix[2].VPR.3 xPix[2].VPR.4 0.897277
rxPix[2].VPR.55 xPix[2].VPR.3 xPix[2].VPR.26 0.0644185
rxPix[2].VPR.54 xPix[2].VPR.4 xPix[2].VPR.23 0.0073411
rxPix[2].VPR.53 xPix[2].VPR.5 xPix[2].VPR.31 1.04579
rxPix[2].VPR.52 xPix[2].VPR.5 xPix[2].VPR.25 0.0073411
rxPix[2].VPR.51 xPix[2].VPR.7 xPix[2].VPR.8 0.377475
rxPix[2].VPR.50 xPix[2].VPR.7 xPix[2].VPR.36 0.0513368
rxPix[2].VPR.49 xPix[2].VPR.8 xPix[2].VPR.25 0.0866337
rxPix[2].VPR.48 xPix[2].VPR.10 xPix[2].VPR.12 0.0473108
rxPix[2].VPR.47 xPix[2].VPR.10 xPix[2].MMpr.amp.d 9.3
rxPix[2].VPR.46 xPix[2].VPR.14 xPix[2].VPR.17 0.050905
rxPix[2].VPR.45 xPix[2].VPR.17 xPix[2].VPR.47 4.5
rxPix[2].VPR.44 xPix[2].VPR.20 xPix[2].VPR.22 0.042735
rxPix[2].VPR.43 xPix[2].VPR.20 xPix[2].VPR.60 9.3
rxPix[2].VPR.42 xPix[2].VPR.22 xPix[2].VPR.51 4.5
rxPix[2].VPR.41 xPix[2].VPR.23 xPix[2].VPR.25 0.290842
rxPix[2].VPR.40 xPix[2].VPR.26 xPix[2].VPR.28 0.0942737
rxPix[2].VPR.39 xPix[2].VPR.28 xPix[2].VPR.65 9.3
rxPix[2].VPR.38 xPix[2].VPR.30 xPix[2].VPR.31 0.112452
rxPix[2].VPR.37 xPix[2].VPR.30 xPix[2].VPR.44 4.5
rxPix[2].VPR.36 xPix[2].VPR.34 xPix[2].VPR.36 0.0373506
rxPix[2].VPR.35 xPix[2].VPR.34 xPix[2].VPR 9.3
rxPix[2].VPR.34 xPix[2].VPR.40 xPix[2].VPR.53 5.44554
rxPix[2].VPR.33 xPix[2].VPR.40 xPix[2].VPR.42 0.0847472
rxPix[2].VPR.32 xPix[2].VPR.42 xPix[2].VPR.44 0.15347
rxPix[2].VPR.31 xPix[2].VPR.47 xPix[2].VPR.49 0.128102
rxPix[2].VPR.30 xPix[2].VPR.49 xPix[2].VPR.52 0.816832
rxPix[2].VPR.29 xPix[2].VPR.51 xPix[2].VPR.52 0.128102
rxPix[2].VPR.28 xPix[2].VPR.51 xPix[2].VPR.53 0.128102
rxPix[2].VPR.27 xPix[2].VPR.60 xPix[2].VPR.75 152
rxPix[2].VPR.26 xPix[2].VPR.65 xPix[2].VPR.85 152
rxPix[2].VPR.25 xPix[2].VPR.75 xPix[2].MMpd.g 121.488
rxPix[2].VPR.24 xPix[2].VPR.80 xPix[2].MMsf.g 101.866
rxPix[2].VPR.23 xPix[2].VPR.80 xPix[2].VPR.85 37.6412
rxPix[2].nRst.72 xPix[2].MMrefrBias.d xPix[2].nRst 0.01
rxPix[2].nRst.71 xPix[2].nRst.3 xPix[2].nRst.28 0.149402
rxPix[2].nRst.70 xPix[2].nRst.3 xPix[2].nRst.52 4.5
rxPix[2].nRst.69 xPix[2].nRst.5 xPix[2].nRst.6 1.57178
rxPix[2].nRst.68 xPix[2].nRst.5 xPix[2].nRst.38 0.0136246
rxPix[2].nRst.67 xPix[2].nRst.6 xPix[2].nRst.34 0.0583662
rxPix[2].nRst.66 xPix[2].nRst.7 xPix[2].nRst.8 1.41708
rxPix[2].nRst.65 xPix[2].nRst.7 xPix[2].nRst.9 0.0698411
rxPix[2].nRst.64 xPix[2].nRst.8 xPix[2].nRst.36 0.0136246
rxPix[2].nRst.63 xPix[2].nRst.9 xPix[2].nRst.10 4.18936
rxPix[2].nRst.62 xPix[2].nRst.10 xPix[2].nRst.11 0.0335533
rxPix[2].nRst.61 xPix[2].nRst.10 xPix[2].nRst.41 0.162037
rxPix[2].nRst.60 xPix[2].nRst.11 xPix[2].nRst.12 2.94554
rxPix[2].nRst.59 xPix[2].nRst.12 xPix[2].nRst.14 0.0698411
rxPix[2].nRst.58 xPix[2].nRst.13 xPix[2].nRst.14 0.451733
rxPix[2].nRst.57 xPix[2].nRst.13 xPix[2].nRst.19 0.0698411
rxPix[2].nRst.56 xPix[2].nRst.15 xPix[2].nRst.16 1.20668
rxPix[2].nRst.55 xPix[2].nRst.15 xPix[2].nRst.18 0.0698411
rxPix[2].nRst.54 xPix[2].nRst.16 xPix[2].nRst.41 0.0335533
rxPix[2].nRst.53 xPix[2].nRst.18 xPix[2].nRst.44 0.272277
rxPix[2].nRst.52 xPix[2].nRst.19 xPix[2].nRst.20 2.95173
rxPix[2].nRst.51 xPix[2].nRst.20 xPix[2].nRst.22 0.0698411
rxPix[2].nRst.50 xPix[2].nRst.21 xPix[2].nRst.22 0.829208
rxPix[2].nRst.49 xPix[2].nRst.21 xPix[2].nRst.46 0.115813
rxPix[2].nRst.48 xPix[2].nRst.23 xPix[2].nRst.25 0.0196335
rxPix[2].nRst.47 xPix[2].nRst.23 xPix[2].nRst.44 0.103504
rxPix[2].nRst.46 xPix[2].nRst.25 xPix[2].nRst.69 4.65
rxPix[2].nRst.45 xPix[2].nRst.28 xPix[2].MMPDrefrCol.d 9.3
rxPix[2].nRst.44 xPix[2].nRst.32 xPix[2].nRst.34 0.083042
rxPix[2].nRst.43 xPix[2].nRst.32 xPix[2].nRst.55 4.5
rxPix[2].nRst.42 xPix[2].nRst.36 xPix[2].nRst.38 0.107759
rxPix[2].nRst.41 xPix[2].nRst.41 xPix[2].nRst.43 0.0434028
rxPix[2].nRst.40 xPix[2].nRst.43 xPix[2].nRst 9.3
rxPix[2].nRst.39 xPix[2].nRst.46 xPix[2].nRst.77 9.3
rxPix[2].nRst.38 xPix[2].nRst.48 xPix[2].nRst.56 7.7104
rxPix[2].nRst.37 xPix[2].nRst.48 xPix[2].nRst.49 0.0469786
rxPix[2].nRst.36 xPix[2].nRst.49 xPix[2].nRst.52 0.0487013
rxPix[2].nRst.35 xPix[2].nRst.55 xPix[2].nRst.56 0.13093
rxPix[2].nRst.34 xPix[2].nRst.69 xPix[2].nRst.72 24.6417
rxPix[2].nRst.33 xPix[2].nRst.72 xPix[2].nRst.74 49.2834
rxPix[2].nRst.32 xPix[2].nRst.72 xPix[2].nRst.85 50.6667
rxPix[2].nRst.31 xPix[2].nRst.74 xPix[2].nRst.85 152
rxPix[2].nRst.30 xPix[2].nRst.77 xPix[2].nRst.89 152
rxPix[2].nRst.29 xPix[2].MMcapRef.g xPix[2].nRst.85 37.2181
rxPix[2].nRst.28 xPix[2].nRst.89 xPix[2].MMrst.g 76.8022
rxPix[2].ON.57 xPix[2].MMon.d xPix[2].ON 0.01
rxPix[2].ON.56 xPix[2].ON.1 xPix[2].ON.2 0.290842
rxPix[2].ON.55 xPix[2].ON.1 xPix[2].ON.27 0.0373109
rxPix[2].ON.54 xPix[2].ON.2 xPix[2].ON.32 0.0529306
rxPix[2].ON.53 xPix[2].ON.3 xPix[2].ON.25 1.7203
rxPix[2].ON.52 xPix[2].ON.3 xPix[2].ON.32 0.0529306
rxPix[2].ON.51 xPix[2].ON.5 xPix[2].ON.6 2.06064
rxPix[2].ON.50 xPix[2].ON.5 xPix[2].ON.39 0.0073411
rxPix[2].ON.49 xPix[2].ON.6 xPix[2].ON.32 0.0137558
rxPix[2].ON.48 xPix[2].ON.9 xPix[2].ON.36 0.121073
rxPix[2].ON.47 xPix[2].ON.9 xPix[2].ON.11 0.471204
rxPix[2].ON.46 xPix[2].ON.9 xPix[2].MMonBias.d 3.1
rxPix[2].ON.45 xPix[2].ON.11 xPix[2].MMonBias.d 9.3
rxPix[2].ON.44 xPix[2].ON.13 xPix[2].ON.14 0.643564
rxPix[2].ON.43 xPix[2].ON.13 xPix[2].ON.16 0.0698411
rxPix[2].ON.42 xPix[2].ON.14 xPix[2].ON.37 0.0073411
rxPix[2].ON.41 xPix[2].ON.15 xPix[2].ON.16 0.259901
rxPix[2].ON.40 xPix[2].ON.15 xPix[2].ON.18 0.0698411
rxPix[2].ON.39 xPix[2].ON.17 xPix[2].ON.18 1.94307
rxPix[2].ON.38 xPix[2].ON.17 xPix[2].ON.19 0.0753543
rxPix[2].ON.37 xPix[2].ON.19 xPix[2].ON.21 0.356675
rxPix[2].ON.36 xPix[2].ON.21 xPix[2].ON.67 3.1
rxPix[2].ON.35 xPix[2].ON.24 xPix[2].ON.25 0.125797
rxPix[2].ON.34 xPix[2].ON.24 xPix[2].ON.44 4.5
rxPix[2].ON.33 xPix[2].ON.27 xPix[2].ON.30 0.078534
rxPix[2].ON.32 xPix[2].ON.30 xPix[2].ON.51 9.3
rxPix[2].ON.31 xPix[2].ON.34 xPix[2].ON.36 0.083887
rxPix[2].ON.30 xPix[2].ON.34 xPix[2].ON.49 4.5
rxPix[2].ON.29 xPix[2].ON.37 xPix[2].ON.39 0.117574
rxPix[2].ON.28 xPix[2].ON.42 xPix[2].ON.46 4.57921
rxPix[2].ON.27 xPix[2].ON.42 xPix[2].ON.49 0.154352
rxPix[2].ON.26 xPix[2].ON.44 xPix[2].ON.46 0.125797
rxPix[2].ON.25 xPix[2].ON.51 xPix[2].ON.76 152
rxPix[2].ON.24 xPix[2].ON.67 xPix[2].ON 4.4492
rxPix[2].ON.23 xPix[2].ON.67 xPix[2].ON 44.8342
rxPix[2].ON.22 xPix[2].ON.71 xPix[2].MMN7.g 210.234
rxPix[2].ON.21 xPix[2].ON.71 xPix[2].ON.76 52.7279
rxPix[2].VSF.41 xPix[2].MMsf.s xPix[2].VSF 0.01
rxPix[2].VSF.40 xPix[2].VSF.2 xPix[2].VSF.12 0.847772
rxPix[2].VSF.39 xPix[2].VSF.2 xPix[2].VSF.13 0.063711
rxPix[2].VSF.38 xPix[2].VSF.3 xPix[2].VSF.4 1.04579
rxPix[2].VSF.37 xPix[2].VSF.3 xPix[2].VSF.5 0.0815092
rxPix[2].VSF.36 xPix[2].VSF.4 xPix[2].VSF.15 0.103794
rxPix[2].VSF.35 xPix[2].VSF.5 xPix[2].VSF.7 0.104582
rxPix[2].VSF.34 xPix[2].VSF.7 xPix[2].VSF 9.3
rxPix[2].VSF.33 xPix[2].VSF.10 xPix[2].VSF.12 0.118702
rxPix[2].VSF.32 xPix[2].VSF.10 xPix[2].MMP0.d 9.3
rxPix[2].VSF.31 xPix[2].VSF.13 xPix[2].VSF.15 0.0423729
rxPix[2].VSF.30 xPix[2].VSF.15 xPix[2].VSF.22 4.5
rxPix[2].VSF.29 xPix[2].VSF.16 xPix[2].VSF.18 0.119819
rxPix[2].VSF.28 xPix[2].VSF.16 xPix[2].VSF.20 0.0716608
rxPix[2].VSF.27 xPix[2].VSF.18 xPix[2].VSF.37 3.41
rxPix[2].VSF.26 xPix[2].VSF.20 xPix[2].VSF.22 0.237989
rxPix[2].VSF.25 xPix[2].VSF.24 xPix[2].VSF.25 0.328712
rxPix[2].VSF.24 xPix[2].VSF.24 xPix[2].VSF.26 0.0360789
rxPix[2].VSF.23 xPix[2].VSF.25 xPix[2].VSF.30 0.0309504
rxPix[2].VSF.22 xPix[2].VSF.26 xPix[2].CC1b.neg 0.0238133
rxPix[2].VSF.21 xPix[2].VSF.29 xPix[2].CC3.neg 0.0663074
rxPix[2].VSF.20 xPix[2].VSF.29 xPix[2].VSF.39 0.0491116
rxPix[2].VSF.19 xPix[2].VSF.30 xPix[2].CC3.neg 0.067696
rxPix[2].VSF.18 xPix[2].VSF.33 xPix[2].VSF.39 0.0878361
rxPix[2].VSF.17 xPix[2].VSF.33 xPix[2].VSF.35 0.0262603
rxPix[2].VSF.16 xPix[2].VSF.35 xPix[2].VSF.37 0.0739672
rxPix[2].vdiff.137 xPix[2].MMrst.d xPix[2].vdiff 0.01
rxPix[2].vdiff.136 xPix[2].vdiff.1 xPix[2].vdiff.3 0.255236
rxPix[2].vdiff.135 xPix[2].vdiff.1 xPix[2].vdiff.25 0.0964438
rxPix[2].vdiff.134 xPix[2].vdiff.3 xPix[2].vdiff.5 0.471204
rxPix[2].vdiff.133 xPix[2].vdiff.3 xPix[2].MMchAmpBias.d 3.1
rxPix[2].vdiff.132 xPix[2].vdiff.5 xPix[2].MMchAmpBias.d 9.3
rxPix[2].vdiff.131 xPix[2].vdiff.9 xPix[2].vdiff.11 0.238874
rxPix[2].vdiff.130 xPix[2].vdiff.9 xPix[2].vdiff.30 0.253713
rxPix[2].vdiff.129 xPix[2].vdiff.11 xPix[2].vdiff.131 4.65
rxPix[2].vdiff.128 xPix[2].vdiff.14 xPix[2].vdiff.36 1.42327
rxPix[2].vdiff.127 xPix[2].vdiff.14 xPix[2].vdiff.30 0.0073411
rxPix[2].vdiff.126 xPix[2].vdiff.15 xPix[2].vdiff.37 1.94307
rxPix[2].vdiff.125 xPix[2].vdiff.15 xPix[2].vdiff.38 0.044923
rxPix[2].vdiff.124 xPix[2].vdiff.17 xPix[2].vdiff.19 0.368622
rxPix[2].vdiff.123 xPix[2].vdiff.17 xPix[2].vdiff.38 0.1677
rxPix[2].vdiff.122 xPix[2].vdiff.19 xPix[2].vdiff.150 3.1
rxPix[2].vdiff.121 xPix[2].vdiff.21 xPix[2].vdiff.22 1.57178
rxPix[2].vdiff.120 xPix[2].vdiff.21 xPix[2].vdiff.42 0.112452
rxPix[2].vdiff.119 xPix[2].vdiff.22 xPix[2].vdiff.44 0.0446906
rxPix[2].vdiff.118 xPix[2].vdiff.25 xPix[2].vdiff.29 0.754951
rxPix[2].vdiff.117 xPix[2].vdiff.27 xPix[2].vdiff.29 0.125797
rxPix[2].vdiff.116 xPix[2].vdiff.27 xPix[2].vdiff.91 4.5
rxPix[2].vdiff.115 xPix[2].vdiff.35 xPix[2].vdiff.36 0.122773
rxPix[2].vdiff.114 xPix[2].vdiff.35 xPix[2].vdiff.37 0.250978
rxPix[2].vdiff.113 xPix[2].vdiff.35 xPix[2].vdiff.139 4.65
rxPix[2].vdiff.112 xPix[2].vdiff.38 xPix[2].vdiff.40 0.0287356
rxPix[2].vdiff.111 xPix[2].vdiff.40 xPix[2].vdiff.75 4.5
rxPix[2].vdiff.110 xPix[2].vdiff.42 xPix[2].vdiff.100 4.5
rxPix[2].vdiff.109 xPix[2].vdiff.44 xPix[2].vdiff.47 0.050905
rxPix[2].vdiff.108 xPix[2].vdiff.47 xPix[2].vdiff.107 4.5
rxPix[2].vdiff.107 xPix[2].vdiff.50 xPix[2].vdiff.51 0.118702
rxPix[2].vdiff.106 xPix[2].vdiff.50 xPix[2].vdiff 9.3
rxPix[2].vdiff.105 xPix[2].vdiff.51 xPix[2].vdiff.56 0.847772
rxPix[2].vdiff.104 xPix[2].vdiff.54 xPix[2].vdiff.56 0.128102
rxPix[2].vdiff.103 xPix[2].vdiff.54 xPix[2].vdiff.110 4.5
rxPix[2].vdiff.102 xPix[2].vdiff.57 xPix[2].vdiff.58 1.57797
rxPix[2].vdiff.101 xPix[2].vdiff.57 xPix[2].vdiff.60 0.0698411
rxPix[2].vdiff.100 xPix[2].vdiff.58 xPix[2].vdiff.86 0.0073411
rxPix[2].vdiff.99 xPix[2].vdiff.60 xPix[2].vdiff.96 9.44307
rxPix[2].vdiff.98 xPix[2].vdiff.61 xPix[2].vdiff.62 4.73391
rxPix[2].vdiff.97 xPix[2].vdiff.61 xPix[2].vdiff.88 0.0073411
rxPix[2].vdiff.96 xPix[2].vdiff.62 xPix[2].vdiff.64 0.0698411
rxPix[2].vdiff.95 xPix[2].vdiff.63 xPix[2].vdiff.64 0.643564
rxPix[2].vdiff.94 xPix[2].vdiff.63 xPix[2].vdiff.65 0.0698411
rxPix[2].vdiff.93 xPix[2].vdiff.65 xPix[2].vdiff.92 1.10767
rxPix[2].vdiff.92 xPix[2].vdiff.67 xPix[2].vdiff.97 0.303218
rxPix[2].vdiff.91 xPix[2].vdiff.67 xPix[2].vdiff.70 0.0698411
rxPix[2].vdiff.90 xPix[2].vdiff.69 xPix[2].vdiff.70 0.878713
rxPix[2].vdiff.89 xPix[2].vdiff.69 xPix[2].vdiff.72 0.0698411
rxPix[2].vdiff.88 xPix[2].vdiff.71 xPix[2].vdiff.72 0.439356
rxPix[2].vdiff.87 xPix[2].vdiff.71 xPix[2].vdiff.98 0.117917
rxPix[2].vdiff.86 xPix[2].vdiff.73 xPix[2].vdiff.75 0.0470588
rxPix[2].vdiff.85 xPix[2].vdiff.73 xPix[2].vdiff.98 0.0220814
rxPix[2].vdiff.84 xPix[2].vdiff.76 xPix[2].vdiff.77 1.41708
rxPix[2].vdiff.83 xPix[2].vdiff.76 xPix[2].vdiff.82 0.0698411
rxPix[2].vdiff.82 xPix[2].vdiff.77 xPix[2].vdiff.98 0.117917
rxPix[2].vdiff.81 xPix[2].vdiff.78 xPix[2].vdiff.79 1.15099
rxPix[2].vdiff.80 xPix[2].vdiff.78 xPix[2].vdiff.104 0.0446906
rxPix[2].vdiff.79 xPix[2].vdiff.79 xPix[2].vdiff.81 0.0698411
rxPix[2].vdiff.78 xPix[2].vdiff.80 xPix[2].vdiff.81 0.210396
rxPix[2].vdiff.77 xPix[2].vdiff.80 xPix[2].vdiff.84 0.0698411
rxPix[2].vdiff.76 xPix[2].vdiff.82 xPix[2].vdiff.83 4.5297
rxPix[2].vdiff.75 xPix[2].vdiff.83 xPix[2].vdiff.102 0.0446906
rxPix[2].vdiff.74 xPix[2].vdiff.84 xPix[2].vdiff.111 2.38861
rxPix[2].vdiff.73 xPix[2].vdiff.86 xPix[2].vdiff.88 0.222772
rxPix[2].vdiff.72 xPix[2].vdiff.91 xPix[2].vdiff.92 0.125797
rxPix[2].vdiff.71 xPix[2].vdiff.95 xPix[2].vdiff.96 0.136592
rxPix[2].vdiff.70 xPix[2].vdiff.95 xPix[2].vdiff.97 0.136592
rxPix[2].vdiff.69 xPix[2].vdiff.95 xPix[2].vdiff.115 3.41
rxPix[2].vdiff.68 xPix[2].vdiff.100 xPix[2].vdiff.102 0.050905
rxPix[2].vdiff.67 xPix[2].vdiff.104 xPix[2].vdiff.107 0.0848416
rxPix[2].vdiff.66 xPix[2].vdiff.110 xPix[2].vdiff.111 0.128102
rxPix[2].vdiff.65 xPix[2].vdiff.113 xPix[2].vdiff.115 0.089913
rxPix[2].vdiff.64 xPix[2].vdiff.113 xPix[2].vdiff.120 0.0315435
rxPix[2].vdiff.63 xPix[2].CC1.neg xPix[2].vdiff.120 0.0170398
rxPix[2].vdiff.62 xPix[2].vdiff.131 xPix[2].vdiff.134 24.6417
rxPix[2].vdiff.61 xPix[2].vdiff.134 xPix[2].vdiff.136 49.2834
rxPix[2].vdiff.60 xPix[2].vdiff.134 xPix[2].vdiff.163 50.6667
rxPix[2].vdiff.59 xPix[2].vdiff.136 xPix[2].vdiff.163 152
rxPix[2].vdiff.58 xPix[2].vdiff.139 xPix[2].vdiff.142 24.6417
rxPix[2].vdiff.57 xPix[2].vdiff.142 xPix[2].vdiff.144 49.2834
rxPix[2].vdiff.56 xPix[2].vdiff.142 xPix[2].vdiff.170 50.6667
rxPix[2].vdiff.55 xPix[2].vdiff.144 xPix[2].vdiff.170 152
rxPix[2].vdiff.54 xPix[2].vdiff.150 xPix[2].MMchAmp.d 11.2941
rxPix[2].vdiff.53 xPix[2].vdiff.150 xPix[2].MMchAmp.d 37.9893
rxPix[2].vdiff.52 xPix[2].MMon.g xPix[2].vdiff.163 37.2181
rxPix[2].vdiff.51 xPix[2].MMP2.g xPix[2].vdiff.170 37.2181
rxPix[2].vd.78 xPix[2].MMrst.s xPix[2].vd 0.01
rxPix[2].vd.77 xPix[2].vd.2 xPix[2].vd.16 0.699257
rxPix[2].vd.76 xPix[2].vd.2 xPix[2].vd.4 0.0698411
rxPix[2].vd.75 xPix[2].vd.3 xPix[2].vd.4 0.451733
rxPix[2].vd.74 xPix[2].vd.3 xPix[2].vd.5 0.0698411
rxPix[2].vd.73 xPix[2].vd.5 xPix[2].vd.6 3.13119
rxPix[2].vd.72 xPix[2].vd.6 xPix[2].vd.8 0.0698411
rxPix[2].vd.71 xPix[2].vd.7 xPix[2].vd.8 0.792079
rxPix[2].vd.70 xPix[2].vd.7 xPix[2].vd.21 0.0513368
rxPix[2].vd.69 xPix[2].vd.11 xPix[2].vd.19 0.121073
rxPix[2].vd.68 xPix[2].vd.11 xPix[2].vd.82 4.65
rxPix[2].vd.67 xPix[2].vd.14 xPix[2].vd.16 0.128102
rxPix[2].vd.66 xPix[2].vd.14 xPix[2].vd.30 4.5
rxPix[2].vd.65 xPix[2].vd.18 xPix[2].vd.19 0.083887
rxPix[2].vd.64 xPix[2].vd.18 xPix[2].vd.41 4.5
rxPix[2].vd.63 xPix[2].vd.21 xPix[2].vd.24 0.0373506
rxPix[2].vd.62 xPix[2].vd.24 xPix[2].vd 9.3
rxPix[2].vd.61 xPix[2].vd.27 xPix[2].vd.30 0.243776
rxPix[2].vd.60 xPix[2].vd.27 xPix[2].vd.54 3.41
rxPix[2].vd.59 xPix[2].vd.32 xPix[2].vd.39 1.26238
rxPix[2].vd.58 xPix[2].vd.32 xPix[2].vd.35 0.0698411
rxPix[2].vd.57 xPix[2].vd.35 xPix[2].vd.43 1.24381
rxPix[2].vd.56 xPix[2].vd.37 xPix[2].vd.39 0.139571
rxPix[2].vd.55 xPix[2].vd.37 xPix[2].vd.45 3.41
rxPix[2].vd.54 xPix[2].vd.41 xPix[2].vd.43 0.125797
rxPix[2].vd.53 xPix[2].vd.45 xPix[2].vd.48 0.00656989
rxPix[2].vd.52 xPix[2].vd.48 xPix[2].vd.74 3.41
rxPix[2].vd.51 xPix[2].vd.51 xPix[2].vd.54 0.000315966
rxPix[2].vd.50 xPix[2].vd.51 xPix[2].vd.70 3.41
rxPix[2].vd.49 xPix[2].vd.56 xPix[2].vd.57 0.464434
rxPix[2].vd.48 xPix[2].vd.56 xPix[2].vd.59 0.0280223
rxPix[2].vd.47 xPix[2].vd.57 xPix[2].vd.63 0.0262616
rxPix[2].vd.46 xPix[2].vd.59 xPix[2].CC1b.pos 0.0758963
rxPix[2].vd.45 xPix[2].CC1b.pos xPix[2].vd.76 0.0208115
rxPix[2].vd.44 xPix[2].vd.62 xPix[2].CC3.pos 0.223097
rxPix[2].vd.43 xPix[2].vd.62 xPix[2].vd.68 0.032569
rxPix[2].vd.42 xPix[2].vd.63 xPix[2].CC3.pos 0.19563
rxPix[2].vd.41 xPix[2].vd.66 xPix[2].vd.77 0.103477
rxPix[2].vd.40 xPix[2].vd.66 xPix[2].CC1.pos 0.0039471
rxPix[2].vd.39 xPix[2].vd.68 xPix[2].vd.70 0.333623
rxPix[2].vd.38 xPix[2].vd.72 xPix[2].vd.74 0.180056
rxPix[2].vd.37 xPix[2].vd.72 xPix[2].vd.80 0.023786
rxPix[2].vd.36 xPix[2].vd.76 xPix[2].vd.77 0.0276694
rxPix[2].vd.35 xPix[2].CC1.pos xPix[2].vd.80 0.0583805
rxPix[2].vd.34 xPix[2].vd.82 xPix[2].vd.85 24.6417
rxPix[2].vd.33 xPix[2].vd.85 xPix[2].vd.87 49.2834
rxPix[2].vd.32 xPix[2].vd.85 xPix[2].vd.98 50.6667
rxPix[2].vd.31 xPix[2].vd.87 xPix[2].vd.98 152
rxPix[2].vd.30 xPix[2].MMchAmp.g xPix[2].vd.98 37.2181
rxPix[3].nOFF.53 xPix[3].MMP2.d xPix[3].nOFF 0.01
rxPix[3].nOFF.52 xPix[3].nOFF.1 xPix[3].nOFF.3 0.255236
rxPix[3].nOFF.51 xPix[3].nOFF.1 xPix[3].nOFF.25 0.10068
rxPix[3].nOFF.50 xPix[3].nOFF.3 xPix[3].nOFF.5 0.471204
rxPix[3].nOFF.49 xPix[3].nOFF.3 xPix[3].MMoffBias.d 3.1
rxPix[3].nOFF.48 xPix[3].nOFF.5 xPix[3].MMoffBias.d 9.3
rxPix[3].nOFF.47 xPix[3].nOFF.7 xPix[3].nOFF.25 3.32921
rxPix[3].nOFF.46 xPix[3].nOFF.7 xPix[3].nOFF.10 0.0698411
rxPix[3].nOFF.45 xPix[3].nOFF.9 xPix[3].nOFF.10 1.9245
rxPix[3].nOFF.44 xPix[3].nOFF.9 xPix[3].nOFF.28 0.0073411
rxPix[3].nOFF.43 xPix[3].nOFF.15 xPix[3].nOFF.16 0.643564
rxPix[3].nOFF.42 xPix[3].nOFF.15 xPix[3].nOFF.32 0.150768
rxPix[3].nOFF.41 xPix[3].nOFF.16 xPix[3].nOFF.26 0.0073411
rxPix[3].nOFF.40 xPix[3].nOFF.17 xPix[3].nOFF.18 1.88738
rxPix[3].nOFF.39 xPix[3].nOFF.17 xPix[3].nOFF.36 0.0073411
rxPix[3].nOFF.38 xPix[3].nOFF.18 xPix[3].nOFF.30 0.0367876
rxPix[3].nOFF.37 xPix[3].nOFF.19 xPix[3].nOFF.20 3.80569
rxPix[3].nOFF.36 xPix[3].nOFF.19 xPix[3].nOFF.21 0.0753543
rxPix[3].nOFF.35 xPix[3].nOFF.20 xPix[3].nOFF.34 0.0073411
rxPix[3].nOFF.34 xPix[3].nOFF.21 xPix[3].nOFF.23 0.376309
rxPix[3].nOFF.33 xPix[3].nOFF.23 xPix[3].nOFF.52 3.1
rxPix[3].nOFF.32 xPix[3].nOFF.26 xPix[3].nOFF.28 0.117574
rxPix[3].nOFF.31 xPix[3].nOFF.30 xPix[3].nOFF.32 0.0411184
rxPix[3].nOFF.30 xPix[3].nOFF.32 xPix[3].nOFF.63 9.3
rxPix[3].nOFF.29 xPix[3].nOFF.34 xPix[3].nOFF.36 0.185644
rxPix[3].nOFF.28 xPix[3].nOFF.46 xPix[3].nOFF.47 28.7487
rxPix[3].nOFF.27 xPix[3].nOFF.46 xPix[3].nOFF.60 4.85115
rxPix[3].nOFF.26 xPix[3].nOFF.47 xPix[3].nOFF.59 2.73809
rxPix[3].nOFF.25 xPix[3].nOFF.52 xPix[3].nOFF 11.2941
rxPix[3].nOFF.24 xPix[3].nOFF.52 xPix[3].nOFF 37.9893
rxPix[3].nOFF.23 xPix[3].nOFF.57 xPix[3].nOFF.59 13.6752
rxPix[3].nOFF.22 xPix[3].nOFF.57 xPix[3].nOFF.70 152
rxPix[3].nOFF.21 xPix[3].nOFF.60 xPix[3].nOFF.63 2.95101
rxPix[3].nOFF.20 xPix[3].nOFF.65 xPix[3].MMN8.g 210.234
rxPix[3].nOFF.19 xPix[3].nOFF.65 xPix[3].nOFF.70 52.7279
rxPix[3].VPR.60 xPix[3].MMprBias.d xPix[3].VPR 0.01
rxPix[3].VPR.59 xPix[3].VPR.1 xPix[3].VPR.2 0.321782
rxPix[3].VPR.58 xPix[3].VPR.1 xPix[3].VPR.14 0.0446906
rxPix[3].VPR.57 xPix[3].VPR.2 xPix[3].VPR.12 0.0513368
rxPix[3].VPR.56 xPix[3].VPR.3 xPix[3].VPR.4 0.897277
rxPix[3].VPR.55 xPix[3].VPR.3 xPix[3].VPR.26 0.0644185
rxPix[3].VPR.54 xPix[3].VPR.4 xPix[3].VPR.23 0.0073411
rxPix[3].VPR.53 xPix[3].VPR.5 xPix[3].VPR.31 1.04579
rxPix[3].VPR.52 xPix[3].VPR.5 xPix[3].VPR.25 0.0073411
rxPix[3].VPR.51 xPix[3].VPR.7 xPix[3].VPR.8 0.377475
rxPix[3].VPR.50 xPix[3].VPR.7 xPix[3].VPR.36 0.0513368
rxPix[3].VPR.49 xPix[3].VPR.8 xPix[3].VPR.25 0.0866337
rxPix[3].VPR.48 xPix[3].VPR.10 xPix[3].VPR.12 0.0473108
rxPix[3].VPR.47 xPix[3].VPR.10 xPix[3].MMpr.amp.d 9.3
rxPix[3].VPR.46 xPix[3].VPR.14 xPix[3].VPR.17 0.050905
rxPix[3].VPR.45 xPix[3].VPR.17 xPix[3].VPR.47 4.5
rxPix[3].VPR.44 xPix[3].VPR.20 xPix[3].VPR.22 0.042735
rxPix[3].VPR.43 xPix[3].VPR.20 xPix[3].VPR.60 9.3
rxPix[3].VPR.42 xPix[3].VPR.22 xPix[3].VPR.51 4.5
rxPix[3].VPR.41 xPix[3].VPR.23 xPix[3].VPR.25 0.290842
rxPix[3].VPR.40 xPix[3].VPR.26 xPix[3].VPR.28 0.0942737
rxPix[3].VPR.39 xPix[3].VPR.28 xPix[3].VPR.65 9.3
rxPix[3].VPR.38 xPix[3].VPR.30 xPix[3].VPR.31 0.112452
rxPix[3].VPR.37 xPix[3].VPR.30 xPix[3].VPR.44 4.5
rxPix[3].VPR.36 xPix[3].VPR.34 xPix[3].VPR.36 0.0373506
rxPix[3].VPR.35 xPix[3].VPR.34 xPix[3].VPR 9.3
rxPix[3].VPR.34 xPix[3].VPR.40 xPix[3].VPR.53 5.44554
rxPix[3].VPR.33 xPix[3].VPR.40 xPix[3].VPR.42 0.0847472
rxPix[3].VPR.32 xPix[3].VPR.42 xPix[3].VPR.44 0.15347
rxPix[3].VPR.31 xPix[3].VPR.47 xPix[3].VPR.49 0.128102
rxPix[3].VPR.30 xPix[3].VPR.49 xPix[3].VPR.52 0.816832
rxPix[3].VPR.29 xPix[3].VPR.51 xPix[3].VPR.52 0.128102
rxPix[3].VPR.28 xPix[3].VPR.51 xPix[3].VPR.53 0.128102
rxPix[3].VPR.27 xPix[3].VPR.60 xPix[3].VPR.75 152
rxPix[3].VPR.26 xPix[3].VPR.65 xPix[3].VPR.85 152
rxPix[3].VPR.25 xPix[3].VPR.75 xPix[3].MMpd.g 121.488
rxPix[3].VPR.24 xPix[3].VPR.80 xPix[3].MMsf.g 101.866
rxPix[3].VPR.23 xPix[3].VPR.80 xPix[3].VPR.85 37.6412
rxPix[3].nRst.72 xPix[3].MMrefrBias.d xPix[3].nRst 0.01
rxPix[3].nRst.71 xPix[3].nRst.3 xPix[3].nRst.28 0.149402
rxPix[3].nRst.70 xPix[3].nRst.3 xPix[3].nRst.52 4.5
rxPix[3].nRst.69 xPix[3].nRst.5 xPix[3].nRst.6 1.57178
rxPix[3].nRst.68 xPix[3].nRst.5 xPix[3].nRst.38 0.0136246
rxPix[3].nRst.67 xPix[3].nRst.6 xPix[3].nRst.34 0.0583662
rxPix[3].nRst.66 xPix[3].nRst.7 xPix[3].nRst.8 1.41708
rxPix[3].nRst.65 xPix[3].nRst.7 xPix[3].nRst.9 0.0698411
rxPix[3].nRst.64 xPix[3].nRst.8 xPix[3].nRst.36 0.0136246
rxPix[3].nRst.63 xPix[3].nRst.9 xPix[3].nRst.10 4.18936
rxPix[3].nRst.62 xPix[3].nRst.10 xPix[3].nRst.11 0.0335533
rxPix[3].nRst.61 xPix[3].nRst.10 xPix[3].nRst.41 0.162037
rxPix[3].nRst.60 xPix[3].nRst.11 xPix[3].nRst.12 2.94554
rxPix[3].nRst.59 xPix[3].nRst.12 xPix[3].nRst.14 0.0698411
rxPix[3].nRst.58 xPix[3].nRst.13 xPix[3].nRst.14 0.451733
rxPix[3].nRst.57 xPix[3].nRst.13 xPix[3].nRst.19 0.0698411
rxPix[3].nRst.56 xPix[3].nRst.15 xPix[3].nRst.16 1.20668
rxPix[3].nRst.55 xPix[3].nRst.15 xPix[3].nRst.18 0.0698411
rxPix[3].nRst.54 xPix[3].nRst.16 xPix[3].nRst.41 0.0335533
rxPix[3].nRst.53 xPix[3].nRst.18 xPix[3].nRst.44 0.272277
rxPix[3].nRst.52 xPix[3].nRst.19 xPix[3].nRst.20 2.95173
rxPix[3].nRst.51 xPix[3].nRst.20 xPix[3].nRst.22 0.0698411
rxPix[3].nRst.50 xPix[3].nRst.21 xPix[3].nRst.22 0.829208
rxPix[3].nRst.49 xPix[3].nRst.21 xPix[3].nRst.46 0.115813
rxPix[3].nRst.48 xPix[3].nRst.23 xPix[3].nRst.25 0.0196335
rxPix[3].nRst.47 xPix[3].nRst.23 xPix[3].nRst.44 0.103504
rxPix[3].nRst.46 xPix[3].nRst.25 xPix[3].nRst.69 4.65
rxPix[3].nRst.45 xPix[3].nRst.28 xPix[3].MMPDrefrCol.d 9.3
rxPix[3].nRst.44 xPix[3].nRst.32 xPix[3].nRst.34 0.083042
rxPix[3].nRst.43 xPix[3].nRst.32 xPix[3].nRst.55 4.5
rxPix[3].nRst.42 xPix[3].nRst.36 xPix[3].nRst.38 0.107759
rxPix[3].nRst.41 xPix[3].nRst.41 xPix[3].nRst.43 0.0434028
rxPix[3].nRst.40 xPix[3].nRst.43 xPix[3].nRst 9.3
rxPix[3].nRst.39 xPix[3].nRst.46 xPix[3].nRst.77 9.3
rxPix[3].nRst.38 xPix[3].nRst.48 xPix[3].nRst.56 7.7104
rxPix[3].nRst.37 xPix[3].nRst.48 xPix[3].nRst.49 0.0469786
rxPix[3].nRst.36 xPix[3].nRst.49 xPix[3].nRst.52 0.0487013
rxPix[3].nRst.35 xPix[3].nRst.55 xPix[3].nRst.56 0.13093
rxPix[3].nRst.34 xPix[3].nRst.69 xPix[3].nRst.72 24.6417
rxPix[3].nRst.33 xPix[3].nRst.72 xPix[3].nRst.74 49.2834
rxPix[3].nRst.32 xPix[3].nRst.72 xPix[3].nRst.85 50.6667
rxPix[3].nRst.31 xPix[3].nRst.74 xPix[3].nRst.85 152
rxPix[3].nRst.30 xPix[3].nRst.77 xPix[3].nRst.89 152
rxPix[3].nRst.29 xPix[3].MMcapRef.g xPix[3].nRst.85 37.2181
rxPix[3].nRst.28 xPix[3].nRst.89 xPix[3].MMrst.g 76.8022
rxPix[3].ON.57 xPix[3].MMon.d xPix[3].ON 0.01
rxPix[3].ON.56 xPix[3].ON.1 xPix[3].ON.2 0.290842
rxPix[3].ON.55 xPix[3].ON.1 xPix[3].ON.27 0.0373109
rxPix[3].ON.54 xPix[3].ON.2 xPix[3].ON.32 0.0529306
rxPix[3].ON.53 xPix[3].ON.3 xPix[3].ON.25 1.7203
rxPix[3].ON.52 xPix[3].ON.3 xPix[3].ON.32 0.0529306
rxPix[3].ON.51 xPix[3].ON.5 xPix[3].ON.6 2.06064
rxPix[3].ON.50 xPix[3].ON.5 xPix[3].ON.39 0.0073411
rxPix[3].ON.49 xPix[3].ON.6 xPix[3].ON.32 0.0137558
rxPix[3].ON.48 xPix[3].ON.9 xPix[3].ON.36 0.121073
rxPix[3].ON.47 xPix[3].ON.9 xPix[3].ON.11 0.471204
rxPix[3].ON.46 xPix[3].ON.9 xPix[3].MMonBias.d 3.1
rxPix[3].ON.45 xPix[3].ON.11 xPix[3].MMonBias.d 9.3
rxPix[3].ON.44 xPix[3].ON.13 xPix[3].ON.14 0.643564
rxPix[3].ON.43 xPix[3].ON.13 xPix[3].ON.16 0.0698411
rxPix[3].ON.42 xPix[3].ON.14 xPix[3].ON.37 0.0073411
rxPix[3].ON.41 xPix[3].ON.15 xPix[3].ON.16 0.259901
rxPix[3].ON.40 xPix[3].ON.15 xPix[3].ON.18 0.0698411
rxPix[3].ON.39 xPix[3].ON.17 xPix[3].ON.18 1.94307
rxPix[3].ON.38 xPix[3].ON.17 xPix[3].ON.19 0.0753543
rxPix[3].ON.37 xPix[3].ON.19 xPix[3].ON.21 0.356675
rxPix[3].ON.36 xPix[3].ON.21 xPix[3].ON.67 3.1
rxPix[3].ON.35 xPix[3].ON.24 xPix[3].ON.25 0.125797
rxPix[3].ON.34 xPix[3].ON.24 xPix[3].ON.44 4.5
rxPix[3].ON.33 xPix[3].ON.27 xPix[3].ON.30 0.078534
rxPix[3].ON.32 xPix[3].ON.30 xPix[3].ON.51 9.3
rxPix[3].ON.31 xPix[3].ON.34 xPix[3].ON.36 0.083887
rxPix[3].ON.30 xPix[3].ON.34 xPix[3].ON.49 4.5
rxPix[3].ON.29 xPix[3].ON.37 xPix[3].ON.39 0.117574
rxPix[3].ON.28 xPix[3].ON.42 xPix[3].ON.46 4.57921
rxPix[3].ON.27 xPix[3].ON.42 xPix[3].ON.49 0.154352
rxPix[3].ON.26 xPix[3].ON.44 xPix[3].ON.46 0.125797
rxPix[3].ON.25 xPix[3].ON.51 xPix[3].ON.76 152
rxPix[3].ON.24 xPix[3].ON.67 xPix[3].ON 4.4492
rxPix[3].ON.23 xPix[3].ON.67 xPix[3].ON 44.8342
rxPix[3].ON.22 xPix[3].ON.71 xPix[3].MMN7.g 210.234
rxPix[3].ON.21 xPix[3].ON.71 xPix[3].ON.76 52.7279
rxPix[3].VSF.41 xPix[3].MMsf.s xPix[3].VSF 0.01
rxPix[3].VSF.40 xPix[3].VSF.2 xPix[3].VSF.12 0.847772
rxPix[3].VSF.39 xPix[3].VSF.2 xPix[3].VSF.13 0.063711
rxPix[3].VSF.38 xPix[3].VSF.3 xPix[3].VSF.4 1.04579
rxPix[3].VSF.37 xPix[3].VSF.3 xPix[3].VSF.5 0.0815092
rxPix[3].VSF.36 xPix[3].VSF.4 xPix[3].VSF.15 0.103794
rxPix[3].VSF.35 xPix[3].VSF.5 xPix[3].VSF.7 0.104582
rxPix[3].VSF.34 xPix[3].VSF.7 xPix[3].VSF 9.3
rxPix[3].VSF.33 xPix[3].VSF.10 xPix[3].VSF.12 0.118702
rxPix[3].VSF.32 xPix[3].VSF.10 xPix[3].MMP0.d 9.3
rxPix[3].VSF.31 xPix[3].VSF.13 xPix[3].VSF.15 0.0423729
rxPix[3].VSF.30 xPix[3].VSF.15 xPix[3].VSF.22 4.5
rxPix[3].VSF.29 xPix[3].VSF.16 xPix[3].VSF.18 0.119819
rxPix[3].VSF.28 xPix[3].VSF.16 xPix[3].VSF.20 0.0716608
rxPix[3].VSF.27 xPix[3].VSF.18 xPix[3].VSF.37 3.41
rxPix[3].VSF.26 xPix[3].VSF.20 xPix[3].VSF.22 0.237989
rxPix[3].VSF.25 xPix[3].VSF.24 xPix[3].VSF.25 0.328712
rxPix[3].VSF.24 xPix[3].VSF.24 xPix[3].VSF.26 0.0360789
rxPix[3].VSF.23 xPix[3].VSF.25 xPix[3].VSF.30 0.0309504
rxPix[3].VSF.22 xPix[3].VSF.26 xPix[3].CC1b.neg 0.0238133
rxPix[3].VSF.21 xPix[3].VSF.29 xPix[3].CC3.neg 0.0663074
rxPix[3].VSF.20 xPix[3].VSF.29 xPix[3].VSF.39 0.0491116
rxPix[3].VSF.19 xPix[3].VSF.30 xPix[3].CC3.neg 0.067696
rxPix[3].VSF.18 xPix[3].VSF.33 xPix[3].VSF.39 0.0878361
rxPix[3].VSF.17 xPix[3].VSF.33 xPix[3].VSF.35 0.0262603
rxPix[3].VSF.16 xPix[3].VSF.35 xPix[3].VSF.37 0.0739672
rxPix[3].vdiff.137 xPix[3].MMrst.d xPix[3].vdiff 0.01
rxPix[3].vdiff.136 xPix[3].vdiff.1 xPix[3].vdiff.3 0.255236
rxPix[3].vdiff.135 xPix[3].vdiff.1 xPix[3].vdiff.25 0.0964438
rxPix[3].vdiff.134 xPix[3].vdiff.3 xPix[3].vdiff.5 0.471204
rxPix[3].vdiff.133 xPix[3].vdiff.3 xPix[3].MMchAmpBias.d 3.1
rxPix[3].vdiff.132 xPix[3].vdiff.5 xPix[3].MMchAmpBias.d 9.3
rxPix[3].vdiff.131 xPix[3].vdiff.9 xPix[3].vdiff.11 0.238874
rxPix[3].vdiff.130 xPix[3].vdiff.9 xPix[3].vdiff.30 0.253713
rxPix[3].vdiff.129 xPix[3].vdiff.11 xPix[3].vdiff.131 4.65
rxPix[3].vdiff.128 xPix[3].vdiff.14 xPix[3].vdiff.36 1.42327
rxPix[3].vdiff.127 xPix[3].vdiff.14 xPix[3].vdiff.30 0.0073411
rxPix[3].vdiff.126 xPix[3].vdiff.15 xPix[3].vdiff.37 1.94307
rxPix[3].vdiff.125 xPix[3].vdiff.15 xPix[3].vdiff.38 0.044923
rxPix[3].vdiff.124 xPix[3].vdiff.17 xPix[3].vdiff.19 0.368622
rxPix[3].vdiff.123 xPix[3].vdiff.17 xPix[3].vdiff.38 0.1677
rxPix[3].vdiff.122 xPix[3].vdiff.19 xPix[3].vdiff.150 3.1
rxPix[3].vdiff.121 xPix[3].vdiff.21 xPix[3].vdiff.22 1.57178
rxPix[3].vdiff.120 xPix[3].vdiff.21 xPix[3].vdiff.42 0.112452
rxPix[3].vdiff.119 xPix[3].vdiff.22 xPix[3].vdiff.44 0.0446906
rxPix[3].vdiff.118 xPix[3].vdiff.25 xPix[3].vdiff.29 0.754951
rxPix[3].vdiff.117 xPix[3].vdiff.27 xPix[3].vdiff.29 0.125797
rxPix[3].vdiff.116 xPix[3].vdiff.27 xPix[3].vdiff.91 4.5
rxPix[3].vdiff.115 xPix[3].vdiff.35 xPix[3].vdiff.36 0.122773
rxPix[3].vdiff.114 xPix[3].vdiff.35 xPix[3].vdiff.37 0.250978
rxPix[3].vdiff.113 xPix[3].vdiff.35 xPix[3].vdiff.139 4.65
rxPix[3].vdiff.112 xPix[3].vdiff.38 xPix[3].vdiff.40 0.0287356
rxPix[3].vdiff.111 xPix[3].vdiff.40 xPix[3].vdiff.75 4.5
rxPix[3].vdiff.110 xPix[3].vdiff.42 xPix[3].vdiff.100 4.5
rxPix[3].vdiff.109 xPix[3].vdiff.44 xPix[3].vdiff.47 0.050905
rxPix[3].vdiff.108 xPix[3].vdiff.47 xPix[3].vdiff.107 4.5
rxPix[3].vdiff.107 xPix[3].vdiff.50 xPix[3].vdiff.51 0.118702
rxPix[3].vdiff.106 xPix[3].vdiff.50 xPix[3].vdiff 9.3
rxPix[3].vdiff.105 xPix[3].vdiff.51 xPix[3].vdiff.56 0.847772
rxPix[3].vdiff.104 xPix[3].vdiff.54 xPix[3].vdiff.56 0.128102
rxPix[3].vdiff.103 xPix[3].vdiff.54 xPix[3].vdiff.110 4.5
rxPix[3].vdiff.102 xPix[3].vdiff.57 xPix[3].vdiff.58 1.57797
rxPix[3].vdiff.101 xPix[3].vdiff.57 xPix[3].vdiff.60 0.0698411
rxPix[3].vdiff.100 xPix[3].vdiff.58 xPix[3].vdiff.86 0.0073411
rxPix[3].vdiff.99 xPix[3].vdiff.60 xPix[3].vdiff.96 9.44307
rxPix[3].vdiff.98 xPix[3].vdiff.61 xPix[3].vdiff.62 4.73391
rxPix[3].vdiff.97 xPix[3].vdiff.61 xPix[3].vdiff.88 0.0073411
rxPix[3].vdiff.96 xPix[3].vdiff.62 xPix[3].vdiff.64 0.0698411
rxPix[3].vdiff.95 xPix[3].vdiff.63 xPix[3].vdiff.64 0.643564
rxPix[3].vdiff.94 xPix[3].vdiff.63 xPix[3].vdiff.65 0.0698411
rxPix[3].vdiff.93 xPix[3].vdiff.65 xPix[3].vdiff.92 1.10767
rxPix[3].vdiff.92 xPix[3].vdiff.67 xPix[3].vdiff.97 0.303218
rxPix[3].vdiff.91 xPix[3].vdiff.67 xPix[3].vdiff.70 0.0698411
rxPix[3].vdiff.90 xPix[3].vdiff.69 xPix[3].vdiff.70 0.878713
rxPix[3].vdiff.89 xPix[3].vdiff.69 xPix[3].vdiff.72 0.0698411
rxPix[3].vdiff.88 xPix[3].vdiff.71 xPix[3].vdiff.72 0.439356
rxPix[3].vdiff.87 xPix[3].vdiff.71 xPix[3].vdiff.98 0.117917
rxPix[3].vdiff.86 xPix[3].vdiff.73 xPix[3].vdiff.75 0.0470588
rxPix[3].vdiff.85 xPix[3].vdiff.73 xPix[3].vdiff.98 0.0220814
rxPix[3].vdiff.84 xPix[3].vdiff.76 xPix[3].vdiff.77 1.41708
rxPix[3].vdiff.83 xPix[3].vdiff.76 xPix[3].vdiff.82 0.0698411
rxPix[3].vdiff.82 xPix[3].vdiff.77 xPix[3].vdiff.98 0.117917
rxPix[3].vdiff.81 xPix[3].vdiff.78 xPix[3].vdiff.79 1.15099
rxPix[3].vdiff.80 xPix[3].vdiff.78 xPix[3].vdiff.104 0.0446906
rxPix[3].vdiff.79 xPix[3].vdiff.79 xPix[3].vdiff.81 0.0698411
rxPix[3].vdiff.78 xPix[3].vdiff.80 xPix[3].vdiff.81 0.210396
rxPix[3].vdiff.77 xPix[3].vdiff.80 xPix[3].vdiff.84 0.0698411
rxPix[3].vdiff.76 xPix[3].vdiff.82 xPix[3].vdiff.83 4.5297
rxPix[3].vdiff.75 xPix[3].vdiff.83 xPix[3].vdiff.102 0.0446906
rxPix[3].vdiff.74 xPix[3].vdiff.84 xPix[3].vdiff.111 2.38861
rxPix[3].vdiff.73 xPix[3].vdiff.86 xPix[3].vdiff.88 0.222772
rxPix[3].vdiff.72 xPix[3].vdiff.91 xPix[3].vdiff.92 0.125797
rxPix[3].vdiff.71 xPix[3].vdiff.95 xPix[3].vdiff.96 0.136592
rxPix[3].vdiff.70 xPix[3].vdiff.95 xPix[3].vdiff.97 0.136592
rxPix[3].vdiff.69 xPix[3].vdiff.95 xPix[3].vdiff.115 3.41
rxPix[3].vdiff.68 xPix[3].vdiff.100 xPix[3].vdiff.102 0.050905
rxPix[3].vdiff.67 xPix[3].vdiff.104 xPix[3].vdiff.107 0.0848416
rxPix[3].vdiff.66 xPix[3].vdiff.110 xPix[3].vdiff.111 0.128102
rxPix[3].vdiff.65 xPix[3].vdiff.113 xPix[3].vdiff.115 0.089913
rxPix[3].vdiff.64 xPix[3].vdiff.113 xPix[3].vdiff.120 0.0315435
rxPix[3].vdiff.63 xPix[3].CC1.neg xPix[3].vdiff.120 0.0170398
rxPix[3].vdiff.62 xPix[3].vdiff.131 xPix[3].vdiff.134 24.6417
rxPix[3].vdiff.61 xPix[3].vdiff.134 xPix[3].vdiff.136 49.2834
rxPix[3].vdiff.60 xPix[3].vdiff.134 xPix[3].vdiff.163 50.6667
rxPix[3].vdiff.59 xPix[3].vdiff.136 xPix[3].vdiff.163 152
rxPix[3].vdiff.58 xPix[3].vdiff.139 xPix[3].vdiff.142 24.6417
rxPix[3].vdiff.57 xPix[3].vdiff.142 xPix[3].vdiff.144 49.2834
rxPix[3].vdiff.56 xPix[3].vdiff.142 xPix[3].vdiff.170 50.6667
rxPix[3].vdiff.55 xPix[3].vdiff.144 xPix[3].vdiff.170 152
rxPix[3].vdiff.54 xPix[3].vdiff.150 xPix[3].MMchAmp.d 11.2941
rxPix[3].vdiff.53 xPix[3].vdiff.150 xPix[3].MMchAmp.d 37.9893
rxPix[3].vdiff.52 xPix[3].MMon.g xPix[3].vdiff.163 37.2181
rxPix[3].vdiff.51 xPix[3].MMP2.g xPix[3].vdiff.170 37.2181
rxPix[3].vd.78 xPix[3].MMrst.s xPix[3].vd 0.01
rxPix[3].vd.77 xPix[3].vd.2 xPix[3].vd.16 0.699257
rxPix[3].vd.76 xPix[3].vd.2 xPix[3].vd.4 0.0698411
rxPix[3].vd.75 xPix[3].vd.3 xPix[3].vd.4 0.451733
rxPix[3].vd.74 xPix[3].vd.3 xPix[3].vd.5 0.0698411
rxPix[3].vd.73 xPix[3].vd.5 xPix[3].vd.6 3.13119
rxPix[3].vd.72 xPix[3].vd.6 xPix[3].vd.8 0.0698411
rxPix[3].vd.71 xPix[3].vd.7 xPix[3].vd.8 0.792079
rxPix[3].vd.70 xPix[3].vd.7 xPix[3].vd.21 0.0513368
rxPix[3].vd.69 xPix[3].vd.11 xPix[3].vd.19 0.121073
rxPix[3].vd.68 xPix[3].vd.11 xPix[3].vd.82 4.65
rxPix[3].vd.67 xPix[3].vd.14 xPix[3].vd.16 0.128102
rxPix[3].vd.66 xPix[3].vd.14 xPix[3].vd.30 4.5
rxPix[3].vd.65 xPix[3].vd.18 xPix[3].vd.19 0.083887
rxPix[3].vd.64 xPix[3].vd.18 xPix[3].vd.41 4.5
rxPix[3].vd.63 xPix[3].vd.21 xPix[3].vd.24 0.0373506
rxPix[3].vd.62 xPix[3].vd.24 xPix[3].vd 9.3
rxPix[3].vd.61 xPix[3].vd.27 xPix[3].vd.30 0.243776
rxPix[3].vd.60 xPix[3].vd.27 xPix[3].vd.54 3.41
rxPix[3].vd.59 xPix[3].vd.32 xPix[3].vd.39 1.26238
rxPix[3].vd.58 xPix[3].vd.32 xPix[3].vd.35 0.0698411
rxPix[3].vd.57 xPix[3].vd.35 xPix[3].vd.43 1.24381
rxPix[3].vd.56 xPix[3].vd.37 xPix[3].vd.39 0.139571
rxPix[3].vd.55 xPix[3].vd.37 xPix[3].vd.45 3.41
rxPix[3].vd.54 xPix[3].vd.41 xPix[3].vd.43 0.125797
rxPix[3].vd.53 xPix[3].vd.45 xPix[3].vd.48 0.00656989
rxPix[3].vd.52 xPix[3].vd.48 xPix[3].vd.74 3.41
rxPix[3].vd.51 xPix[3].vd.51 xPix[3].vd.54 0.000315966
rxPix[3].vd.50 xPix[3].vd.51 xPix[3].vd.70 3.41
rxPix[3].vd.49 xPix[3].vd.56 xPix[3].vd.57 0.464434
rxPix[3].vd.48 xPix[3].vd.56 xPix[3].vd.59 0.0280223
rxPix[3].vd.47 xPix[3].vd.57 xPix[3].vd.63 0.0262616
rxPix[3].vd.46 xPix[3].vd.59 xPix[3].CC1b.pos 0.0758963
rxPix[3].vd.45 xPix[3].CC1b.pos xPix[3].vd.76 0.0208115
rxPix[3].vd.44 xPix[3].vd.62 xPix[3].CC3.pos 0.223097
rxPix[3].vd.43 xPix[3].vd.62 xPix[3].vd.68 0.032569
rxPix[3].vd.42 xPix[3].vd.63 xPix[3].CC3.pos 0.19563
rxPix[3].vd.41 xPix[3].vd.66 xPix[3].vd.77 0.103477
rxPix[3].vd.40 xPix[3].vd.66 xPix[3].CC1.pos 0.0039471
rxPix[3].vd.39 xPix[3].vd.68 xPix[3].vd.70 0.333623
rxPix[3].vd.38 xPix[3].vd.72 xPix[3].vd.74 0.180056
rxPix[3].vd.37 xPix[3].vd.72 xPix[3].vd.80 0.023786
rxPix[3].vd.36 xPix[3].vd.76 xPix[3].vd.77 0.0276694
rxPix[3].vd.35 xPix[3].CC1.pos xPix[3].vd.80 0.0583805
rxPix[3].vd.34 xPix[3].vd.82 xPix[3].vd.85 24.6417
rxPix[3].vd.33 xPix[3].vd.85 xPix[3].vd.87 49.2834
rxPix[3].vd.32 xPix[3].vd.85 xPix[3].vd.98 50.6667
rxPix[3].vd.31 xPix[3].vd.87 xPix[3].vd.98 152
rxPix[3].vd.30 xPix[3].MMchAmp.g xPix[3].vd.98 37.2181
rxPix[0].nOFF.53 xPix[0].MMP2.d xPix[0].nOFF 0.01
rxPix[0].nOFF.52 xPix[0].nOFF.1 xPix[0].nOFF.3 0.255236
rxPix[0].nOFF.51 xPix[0].nOFF.1 xPix[0].nOFF.25 0.10068
rxPix[0].nOFF.50 xPix[0].nOFF.3 xPix[0].nOFF.5 0.471204
rxPix[0].nOFF.49 xPix[0].nOFF.3 xPix[0].MMoffBias.d 3.1
rxPix[0].nOFF.48 xPix[0].nOFF.5 xPix[0].MMoffBias.d 9.3
rxPix[0].nOFF.47 xPix[0].nOFF.7 xPix[0].nOFF.25 3.32921
rxPix[0].nOFF.46 xPix[0].nOFF.7 xPix[0].nOFF.10 0.0698411
rxPix[0].nOFF.45 xPix[0].nOFF.9 xPix[0].nOFF.10 1.9245
rxPix[0].nOFF.44 xPix[0].nOFF.9 xPix[0].nOFF.28 0.0073411
rxPix[0].nOFF.43 xPix[0].nOFF.15 xPix[0].nOFF.16 0.643564
rxPix[0].nOFF.42 xPix[0].nOFF.15 xPix[0].nOFF.32 0.150768
rxPix[0].nOFF.41 xPix[0].nOFF.16 xPix[0].nOFF.26 0.0073411
rxPix[0].nOFF.40 xPix[0].nOFF.17 xPix[0].nOFF.18 1.88738
rxPix[0].nOFF.39 xPix[0].nOFF.17 xPix[0].nOFF.36 0.0073411
rxPix[0].nOFF.38 xPix[0].nOFF.18 xPix[0].nOFF.30 0.0367876
rxPix[0].nOFF.37 xPix[0].nOFF.19 xPix[0].nOFF.20 3.80569
rxPix[0].nOFF.36 xPix[0].nOFF.19 xPix[0].nOFF.21 0.0753543
rxPix[0].nOFF.35 xPix[0].nOFF.20 xPix[0].nOFF.34 0.0073411
rxPix[0].nOFF.34 xPix[0].nOFF.21 xPix[0].nOFF.23 0.376309
rxPix[0].nOFF.33 xPix[0].nOFF.23 xPix[0].nOFF.52 3.1
rxPix[0].nOFF.32 xPix[0].nOFF.26 xPix[0].nOFF.28 0.117574
rxPix[0].nOFF.31 xPix[0].nOFF.30 xPix[0].nOFF.32 0.0411184
rxPix[0].nOFF.30 xPix[0].nOFF.32 xPix[0].nOFF.63 9.3
rxPix[0].nOFF.29 xPix[0].nOFF.34 xPix[0].nOFF.36 0.185644
rxPix[0].nOFF.28 xPix[0].nOFF.46 xPix[0].nOFF.47 28.7487
rxPix[0].nOFF.27 xPix[0].nOFF.46 xPix[0].nOFF.60 4.85115
rxPix[0].nOFF.26 xPix[0].nOFF.47 xPix[0].nOFF.59 2.73809
rxPix[0].nOFF.25 xPix[0].nOFF.52 xPix[0].nOFF 11.2941
rxPix[0].nOFF.24 xPix[0].nOFF.52 xPix[0].nOFF 37.9893
rxPix[0].nOFF.23 xPix[0].nOFF.57 xPix[0].nOFF.59 13.6752
rxPix[0].nOFF.22 xPix[0].nOFF.57 xPix[0].nOFF.70 152
rxPix[0].nOFF.21 xPix[0].nOFF.60 xPix[0].nOFF.63 2.95101
rxPix[0].nOFF.20 xPix[0].nOFF.65 xPix[0].MMN8.g 210.234
rxPix[0].nOFF.19 xPix[0].nOFF.65 xPix[0].nOFF.70 52.7279
rxPix[0].VPR.60 xPix[0].MMprBias.d xPix[0].VPR 0.01
rxPix[0].VPR.59 xPix[0].VPR.1 xPix[0].VPR.2 0.321782
rxPix[0].VPR.58 xPix[0].VPR.1 xPix[0].VPR.14 0.0446906
rxPix[0].VPR.57 xPix[0].VPR.2 xPix[0].VPR.12 0.0513368
rxPix[0].VPR.56 xPix[0].VPR.3 xPix[0].VPR.4 0.897277
rxPix[0].VPR.55 xPix[0].VPR.3 xPix[0].VPR.26 0.0644185
rxPix[0].VPR.54 xPix[0].VPR.4 xPix[0].VPR.23 0.0073411
rxPix[0].VPR.53 xPix[0].VPR.5 xPix[0].VPR.31 1.04579
rxPix[0].VPR.52 xPix[0].VPR.5 xPix[0].VPR.25 0.0073411
rxPix[0].VPR.51 xPix[0].VPR.7 xPix[0].VPR.8 0.377475
rxPix[0].VPR.50 xPix[0].VPR.7 xPix[0].VPR.36 0.0513368
rxPix[0].VPR.49 xPix[0].VPR.8 xPix[0].VPR.25 0.0866337
rxPix[0].VPR.48 xPix[0].VPR.10 xPix[0].VPR.12 0.0473108
rxPix[0].VPR.47 xPix[0].VPR.10 xPix[0].MMpr.amp.d 9.3
rxPix[0].VPR.46 xPix[0].VPR.14 xPix[0].VPR.17 0.050905
rxPix[0].VPR.45 xPix[0].VPR.17 xPix[0].VPR.47 4.5
rxPix[0].VPR.44 xPix[0].VPR.20 xPix[0].VPR.22 0.042735
rxPix[0].VPR.43 xPix[0].VPR.20 xPix[0].VPR.60 9.3
rxPix[0].VPR.42 xPix[0].VPR.22 xPix[0].VPR.51 4.5
rxPix[0].VPR.41 xPix[0].VPR.23 xPix[0].VPR.25 0.290842
rxPix[0].VPR.40 xPix[0].VPR.26 xPix[0].VPR.28 0.0942737
rxPix[0].VPR.39 xPix[0].VPR.28 xPix[0].VPR.65 9.3
rxPix[0].VPR.38 xPix[0].VPR.30 xPix[0].VPR.31 0.112452
rxPix[0].VPR.37 xPix[0].VPR.30 xPix[0].VPR.44 4.5
rxPix[0].VPR.36 xPix[0].VPR.34 xPix[0].VPR.36 0.0373506
rxPix[0].VPR.35 xPix[0].VPR.34 xPix[0].VPR 9.3
rxPix[0].VPR.34 xPix[0].VPR.40 xPix[0].VPR.53 5.44554
rxPix[0].VPR.33 xPix[0].VPR.40 xPix[0].VPR.42 0.0847472
rxPix[0].VPR.32 xPix[0].VPR.42 xPix[0].VPR.44 0.15347
rxPix[0].VPR.31 xPix[0].VPR.47 xPix[0].VPR.49 0.128102
rxPix[0].VPR.30 xPix[0].VPR.49 xPix[0].VPR.52 0.816832
rxPix[0].VPR.29 xPix[0].VPR.51 xPix[0].VPR.52 0.128102
rxPix[0].VPR.28 xPix[0].VPR.51 xPix[0].VPR.53 0.128102
rxPix[0].VPR.27 xPix[0].VPR.60 xPix[0].VPR.75 152
rxPix[0].VPR.26 xPix[0].VPR.65 xPix[0].VPR.85 152
rxPix[0].VPR.25 xPix[0].VPR.75 xPix[0].MMpd.g 121.488
rxPix[0].VPR.24 xPix[0].VPR.80 xPix[0].MMsf.g 101.866
rxPix[0].VPR.23 xPix[0].VPR.80 xPix[0].VPR.85 37.6412
rxPix[0].nRst.72 xPix[0].MMrefrBias.d xPix[0].nRst 0.01
rxPix[0].nRst.71 xPix[0].nRst.3 xPix[0].nRst.28 0.149402
rxPix[0].nRst.70 xPix[0].nRst.3 xPix[0].nRst.52 4.5
rxPix[0].nRst.69 xPix[0].nRst.5 xPix[0].nRst.6 1.57178
rxPix[0].nRst.68 xPix[0].nRst.5 xPix[0].nRst.38 0.0136246
rxPix[0].nRst.67 xPix[0].nRst.6 xPix[0].nRst.34 0.0583662
rxPix[0].nRst.66 xPix[0].nRst.7 xPix[0].nRst.8 1.41708
rxPix[0].nRst.65 xPix[0].nRst.7 xPix[0].nRst.9 0.0698411
rxPix[0].nRst.64 xPix[0].nRst.8 xPix[0].nRst.36 0.0136246
rxPix[0].nRst.63 xPix[0].nRst.9 xPix[0].nRst.10 4.18936
rxPix[0].nRst.62 xPix[0].nRst.10 xPix[0].nRst.11 0.0335533
rxPix[0].nRst.61 xPix[0].nRst.10 xPix[0].nRst.41 0.162037
rxPix[0].nRst.60 xPix[0].nRst.11 xPix[0].nRst.12 2.94554
rxPix[0].nRst.59 xPix[0].nRst.12 xPix[0].nRst.14 0.0698411
rxPix[0].nRst.58 xPix[0].nRst.13 xPix[0].nRst.14 0.451733
rxPix[0].nRst.57 xPix[0].nRst.13 xPix[0].nRst.19 0.0698411
rxPix[0].nRst.56 xPix[0].nRst.15 xPix[0].nRst.16 1.20668
rxPix[0].nRst.55 xPix[0].nRst.15 xPix[0].nRst.18 0.0698411
rxPix[0].nRst.54 xPix[0].nRst.16 xPix[0].nRst.41 0.0335533
rxPix[0].nRst.53 xPix[0].nRst.18 xPix[0].nRst.44 0.272277
rxPix[0].nRst.52 xPix[0].nRst.19 xPix[0].nRst.20 2.95173
rxPix[0].nRst.51 xPix[0].nRst.20 xPix[0].nRst.22 0.0698411
rxPix[0].nRst.50 xPix[0].nRst.21 xPix[0].nRst.22 0.829208
rxPix[0].nRst.49 xPix[0].nRst.21 xPix[0].nRst.46 0.115813
rxPix[0].nRst.48 xPix[0].nRst.23 xPix[0].nRst.25 0.0196335
rxPix[0].nRst.47 xPix[0].nRst.23 xPix[0].nRst.44 0.103504
rxPix[0].nRst.46 xPix[0].nRst.25 xPix[0].nRst.69 4.65
rxPix[0].nRst.45 xPix[0].nRst.28 xPix[0].MMPDrefrCol.d 9.3
rxPix[0].nRst.44 xPix[0].nRst.32 xPix[0].nRst.34 0.083042
rxPix[0].nRst.43 xPix[0].nRst.32 xPix[0].nRst.55 4.5
rxPix[0].nRst.42 xPix[0].nRst.36 xPix[0].nRst.38 0.107759
rxPix[0].nRst.41 xPix[0].nRst.41 xPix[0].nRst.43 0.0434028
rxPix[0].nRst.40 xPix[0].nRst.43 xPix[0].nRst 9.3
rxPix[0].nRst.39 xPix[0].nRst.46 xPix[0].nRst.77 9.3
rxPix[0].nRst.38 xPix[0].nRst.48 xPix[0].nRst.56 7.7104
rxPix[0].nRst.37 xPix[0].nRst.48 xPix[0].nRst.49 0.0469786
rxPix[0].nRst.36 xPix[0].nRst.49 xPix[0].nRst.52 0.0487013
rxPix[0].nRst.35 xPix[0].nRst.55 xPix[0].nRst.56 0.13093
rxPix[0].nRst.34 xPix[0].nRst.69 xPix[0].nRst.72 24.6417
rxPix[0].nRst.33 xPix[0].nRst.72 xPix[0].nRst.74 49.2834
rxPix[0].nRst.32 xPix[0].nRst.72 xPix[0].nRst.85 50.6667
rxPix[0].nRst.31 xPix[0].nRst.74 xPix[0].nRst.85 152
rxPix[0].nRst.30 xPix[0].nRst.77 xPix[0].nRst.89 152
rxPix[0].nRst.29 xPix[0].MMcapRef.g xPix[0].nRst.85 37.2181
rxPix[0].nRst.28 xPix[0].nRst.89 xPix[0].MMrst.g 76.8022
rxPix[0].ON.57 xPix[0].MMon.d xPix[0].ON 0.01
rxPix[0].ON.56 xPix[0].ON.1 xPix[0].ON.2 0.290842
rxPix[0].ON.55 xPix[0].ON.1 xPix[0].ON.27 0.0373109
rxPix[0].ON.54 xPix[0].ON.2 xPix[0].ON.32 0.0529306
rxPix[0].ON.53 xPix[0].ON.3 xPix[0].ON.25 1.7203
rxPix[0].ON.52 xPix[0].ON.3 xPix[0].ON.32 0.0529306
rxPix[0].ON.51 xPix[0].ON.5 xPix[0].ON.6 2.06064
rxPix[0].ON.50 xPix[0].ON.5 xPix[0].ON.39 0.0073411
rxPix[0].ON.49 xPix[0].ON.6 xPix[0].ON.32 0.0137558
rxPix[0].ON.48 xPix[0].ON.9 xPix[0].ON.36 0.121073
rxPix[0].ON.47 xPix[0].ON.9 xPix[0].ON.11 0.471204
rxPix[0].ON.46 xPix[0].ON.9 xPix[0].MMonBias.d 3.1
rxPix[0].ON.45 xPix[0].ON.11 xPix[0].MMonBias.d 9.3
rxPix[0].ON.44 xPix[0].ON.13 xPix[0].ON.14 0.643564
rxPix[0].ON.43 xPix[0].ON.13 xPix[0].ON.16 0.0698411
rxPix[0].ON.42 xPix[0].ON.14 xPix[0].ON.37 0.0073411
rxPix[0].ON.41 xPix[0].ON.15 xPix[0].ON.16 0.259901
rxPix[0].ON.40 xPix[0].ON.15 xPix[0].ON.18 0.0698411
rxPix[0].ON.39 xPix[0].ON.17 xPix[0].ON.18 1.94307
rxPix[0].ON.38 xPix[0].ON.17 xPix[0].ON.19 0.0753543
rxPix[0].ON.37 xPix[0].ON.19 xPix[0].ON.21 0.356675
rxPix[0].ON.36 xPix[0].ON.21 xPix[0].ON.67 3.1
rxPix[0].ON.35 xPix[0].ON.24 xPix[0].ON.25 0.125797
rxPix[0].ON.34 xPix[0].ON.24 xPix[0].ON.44 4.5
rxPix[0].ON.33 xPix[0].ON.27 xPix[0].ON.30 0.078534
rxPix[0].ON.32 xPix[0].ON.30 xPix[0].ON.51 9.3
rxPix[0].ON.31 xPix[0].ON.34 xPix[0].ON.36 0.083887
rxPix[0].ON.30 xPix[0].ON.34 xPix[0].ON.49 4.5
rxPix[0].ON.29 xPix[0].ON.37 xPix[0].ON.39 0.117574
rxPix[0].ON.28 xPix[0].ON.42 xPix[0].ON.46 4.57921
rxPix[0].ON.27 xPix[0].ON.42 xPix[0].ON.49 0.154352
rxPix[0].ON.26 xPix[0].ON.44 xPix[0].ON.46 0.125797
rxPix[0].ON.25 xPix[0].ON.51 xPix[0].ON.76 152
rxPix[0].ON.24 xPix[0].ON.67 xPix[0].ON 4.4492
rxPix[0].ON.23 xPix[0].ON.67 xPix[0].ON 44.8342
rxPix[0].ON.22 xPix[0].ON.71 xPix[0].MMN7.g 210.234
rxPix[0].ON.21 xPix[0].ON.71 xPix[0].ON.76 52.7279
rxPix[0].VSF.41 xPix[0].MMsf.s xPix[0].VSF 0.01
rxPix[0].VSF.40 xPix[0].VSF.2 xPix[0].VSF.12 0.847772
rxPix[0].VSF.39 xPix[0].VSF.2 xPix[0].VSF.13 0.063711
rxPix[0].VSF.38 xPix[0].VSF.3 xPix[0].VSF.4 1.04579
rxPix[0].VSF.37 xPix[0].VSF.3 xPix[0].VSF.5 0.0815092
rxPix[0].VSF.36 xPix[0].VSF.4 xPix[0].VSF.15 0.103794
rxPix[0].VSF.35 xPix[0].VSF.5 xPix[0].VSF.7 0.104582
rxPix[0].VSF.34 xPix[0].VSF.7 xPix[0].VSF 9.3
rxPix[0].VSF.33 xPix[0].VSF.10 xPix[0].VSF.12 0.118702
rxPix[0].VSF.32 xPix[0].VSF.10 xPix[0].MMP0.d 9.3
rxPix[0].VSF.31 xPix[0].VSF.13 xPix[0].VSF.15 0.0423729
rxPix[0].VSF.30 xPix[0].VSF.15 xPix[0].VSF.22 4.5
rxPix[0].VSF.29 xPix[0].VSF.16 xPix[0].VSF.18 0.119819
rxPix[0].VSF.28 xPix[0].VSF.16 xPix[0].VSF.20 0.0716608
rxPix[0].VSF.27 xPix[0].VSF.18 xPix[0].VSF.37 3.41
rxPix[0].VSF.26 xPix[0].VSF.20 xPix[0].VSF.22 0.237989
rxPix[0].VSF.25 xPix[0].VSF.24 xPix[0].VSF.25 0.328712
rxPix[0].VSF.24 xPix[0].VSF.24 xPix[0].VSF.26 0.0360789
rxPix[0].VSF.23 xPix[0].VSF.25 xPix[0].VSF.30 0.0309504
rxPix[0].VSF.22 xPix[0].VSF.26 xPix[0].CC1b.neg 0.0238133
rxPix[0].VSF.21 xPix[0].VSF.29 xPix[0].CC3.neg 0.0663074
rxPix[0].VSF.20 xPix[0].VSF.29 xPix[0].VSF.39 0.0491116
rxPix[0].VSF.19 xPix[0].VSF.30 xPix[0].CC3.neg 0.067696
rxPix[0].VSF.18 xPix[0].VSF.33 xPix[0].VSF.39 0.0878361
rxPix[0].VSF.17 xPix[0].VSF.33 xPix[0].VSF.35 0.0262603
rxPix[0].VSF.16 xPix[0].VSF.35 xPix[0].VSF.37 0.0739672
rxPix[0].vdiff.137 xPix[0].MMrst.d xPix[0].vdiff 0.01
rxPix[0].vdiff.136 xPix[0].vdiff.1 xPix[0].vdiff.3 0.255236
rxPix[0].vdiff.135 xPix[0].vdiff.1 xPix[0].vdiff.25 0.0964438
rxPix[0].vdiff.134 xPix[0].vdiff.3 xPix[0].vdiff.5 0.471204
rxPix[0].vdiff.133 xPix[0].vdiff.3 xPix[0].MMchAmpBias.d 3.1
rxPix[0].vdiff.132 xPix[0].vdiff.5 xPix[0].MMchAmpBias.d 9.3
rxPix[0].vdiff.131 xPix[0].vdiff.9 xPix[0].vdiff.11 0.238874
rxPix[0].vdiff.130 xPix[0].vdiff.9 xPix[0].vdiff.30 0.253713
rxPix[0].vdiff.129 xPix[0].vdiff.11 xPix[0].vdiff.131 4.65
rxPix[0].vdiff.128 xPix[0].vdiff.14 xPix[0].vdiff.36 1.42327
rxPix[0].vdiff.127 xPix[0].vdiff.14 xPix[0].vdiff.30 0.0073411
rxPix[0].vdiff.126 xPix[0].vdiff.15 xPix[0].vdiff.37 1.94307
rxPix[0].vdiff.125 xPix[0].vdiff.15 xPix[0].vdiff.38 0.044923
rxPix[0].vdiff.124 xPix[0].vdiff.17 xPix[0].vdiff.19 0.368622
rxPix[0].vdiff.123 xPix[0].vdiff.17 xPix[0].vdiff.38 0.1677
rxPix[0].vdiff.122 xPix[0].vdiff.19 xPix[0].vdiff.150 3.1
rxPix[0].vdiff.121 xPix[0].vdiff.21 xPix[0].vdiff.22 1.57178
rxPix[0].vdiff.120 xPix[0].vdiff.21 xPix[0].vdiff.42 0.112452
rxPix[0].vdiff.119 xPix[0].vdiff.22 xPix[0].vdiff.44 0.0446906
rxPix[0].vdiff.118 xPix[0].vdiff.25 xPix[0].vdiff.29 0.754951
rxPix[0].vdiff.117 xPix[0].vdiff.27 xPix[0].vdiff.29 0.125797
rxPix[0].vdiff.116 xPix[0].vdiff.27 xPix[0].vdiff.91 4.5
rxPix[0].vdiff.115 xPix[0].vdiff.35 xPix[0].vdiff.36 0.122773
rxPix[0].vdiff.114 xPix[0].vdiff.35 xPix[0].vdiff.37 0.250978
rxPix[0].vdiff.113 xPix[0].vdiff.35 xPix[0].vdiff.139 4.65
rxPix[0].vdiff.112 xPix[0].vdiff.38 xPix[0].vdiff.40 0.0287356
rxPix[0].vdiff.111 xPix[0].vdiff.40 xPix[0].vdiff.75 4.5
rxPix[0].vdiff.110 xPix[0].vdiff.42 xPix[0].vdiff.100 4.5
rxPix[0].vdiff.109 xPix[0].vdiff.44 xPix[0].vdiff.47 0.050905
rxPix[0].vdiff.108 xPix[0].vdiff.47 xPix[0].vdiff.107 4.5
rxPix[0].vdiff.107 xPix[0].vdiff.50 xPix[0].vdiff.51 0.118702
rxPix[0].vdiff.106 xPix[0].vdiff.50 xPix[0].vdiff 9.3
rxPix[0].vdiff.105 xPix[0].vdiff.51 xPix[0].vdiff.56 0.847772
rxPix[0].vdiff.104 xPix[0].vdiff.54 xPix[0].vdiff.56 0.128102
rxPix[0].vdiff.103 xPix[0].vdiff.54 xPix[0].vdiff.110 4.5
rxPix[0].vdiff.102 xPix[0].vdiff.57 xPix[0].vdiff.58 1.57797
rxPix[0].vdiff.101 xPix[0].vdiff.57 xPix[0].vdiff.60 0.0698411
rxPix[0].vdiff.100 xPix[0].vdiff.58 xPix[0].vdiff.86 0.0073411
rxPix[0].vdiff.99 xPix[0].vdiff.60 xPix[0].vdiff.96 9.44307
rxPix[0].vdiff.98 xPix[0].vdiff.61 xPix[0].vdiff.62 4.73391
rxPix[0].vdiff.97 xPix[0].vdiff.61 xPix[0].vdiff.88 0.0073411
rxPix[0].vdiff.96 xPix[0].vdiff.62 xPix[0].vdiff.64 0.0698411
rxPix[0].vdiff.95 xPix[0].vdiff.63 xPix[0].vdiff.64 0.643564
rxPix[0].vdiff.94 xPix[0].vdiff.63 xPix[0].vdiff.65 0.0698411
rxPix[0].vdiff.93 xPix[0].vdiff.65 xPix[0].vdiff.92 1.10767
rxPix[0].vdiff.92 xPix[0].vdiff.67 xPix[0].vdiff.97 0.303218
rxPix[0].vdiff.91 xPix[0].vdiff.67 xPix[0].vdiff.70 0.0698411
rxPix[0].vdiff.90 xPix[0].vdiff.69 xPix[0].vdiff.70 0.878713
rxPix[0].vdiff.89 xPix[0].vdiff.69 xPix[0].vdiff.72 0.0698411
rxPix[0].vdiff.88 xPix[0].vdiff.71 xPix[0].vdiff.72 0.439356
rxPix[0].vdiff.87 xPix[0].vdiff.71 xPix[0].vdiff.98 0.117917
rxPix[0].vdiff.86 xPix[0].vdiff.73 xPix[0].vdiff.75 0.0470588
rxPix[0].vdiff.85 xPix[0].vdiff.73 xPix[0].vdiff.98 0.0220814
rxPix[0].vdiff.84 xPix[0].vdiff.76 xPix[0].vdiff.77 1.41708
rxPix[0].vdiff.83 xPix[0].vdiff.76 xPix[0].vdiff.82 0.0698411
rxPix[0].vdiff.82 xPix[0].vdiff.77 xPix[0].vdiff.98 0.117917
rxPix[0].vdiff.81 xPix[0].vdiff.78 xPix[0].vdiff.79 1.15099
rxPix[0].vdiff.80 xPix[0].vdiff.78 xPix[0].vdiff.104 0.0446906
rxPix[0].vdiff.79 xPix[0].vdiff.79 xPix[0].vdiff.81 0.0698411
rxPix[0].vdiff.78 xPix[0].vdiff.80 xPix[0].vdiff.81 0.210396
rxPix[0].vdiff.77 xPix[0].vdiff.80 xPix[0].vdiff.84 0.0698411
rxPix[0].vdiff.76 xPix[0].vdiff.82 xPix[0].vdiff.83 4.5297
rxPix[0].vdiff.75 xPix[0].vdiff.83 xPix[0].vdiff.102 0.0446906
rxPix[0].vdiff.74 xPix[0].vdiff.84 xPix[0].vdiff.111 2.38861
rxPix[0].vdiff.73 xPix[0].vdiff.86 xPix[0].vdiff.88 0.222772
rxPix[0].vdiff.72 xPix[0].vdiff.91 xPix[0].vdiff.92 0.125797
rxPix[0].vdiff.71 xPix[0].vdiff.95 xPix[0].vdiff.96 0.136592
rxPix[0].vdiff.70 xPix[0].vdiff.95 xPix[0].vdiff.97 0.136592
rxPix[0].vdiff.69 xPix[0].vdiff.95 xPix[0].vdiff.115 3.41
rxPix[0].vdiff.68 xPix[0].vdiff.100 xPix[0].vdiff.102 0.050905
rxPix[0].vdiff.67 xPix[0].vdiff.104 xPix[0].vdiff.107 0.0848416
rxPix[0].vdiff.66 xPix[0].vdiff.110 xPix[0].vdiff.111 0.128102
rxPix[0].vdiff.65 xPix[0].vdiff.113 xPix[0].vdiff.115 0.089913
rxPix[0].vdiff.64 xPix[0].vdiff.113 xPix[0].vdiff.120 0.0315435
rxPix[0].vdiff.63 xPix[0].CC1.neg xPix[0].vdiff.120 0.0170398
rxPix[0].vdiff.62 xPix[0].vdiff.131 xPix[0].vdiff.134 24.6417
rxPix[0].vdiff.61 xPix[0].vdiff.134 xPix[0].vdiff.136 49.2834
rxPix[0].vdiff.60 xPix[0].vdiff.134 xPix[0].vdiff.163 50.6667
rxPix[0].vdiff.59 xPix[0].vdiff.136 xPix[0].vdiff.163 152
rxPix[0].vdiff.58 xPix[0].vdiff.139 xPix[0].vdiff.142 24.6417
rxPix[0].vdiff.57 xPix[0].vdiff.142 xPix[0].vdiff.144 49.2834
rxPix[0].vdiff.56 xPix[0].vdiff.142 xPix[0].vdiff.170 50.6667
rxPix[0].vdiff.55 xPix[0].vdiff.144 xPix[0].vdiff.170 152
rxPix[0].vdiff.54 xPix[0].vdiff.150 xPix[0].MMchAmp.d 11.2941
rxPix[0].vdiff.53 xPix[0].vdiff.150 xPix[0].MMchAmp.d 37.9893
rxPix[0].vdiff.52 xPix[0].MMon.g xPix[0].vdiff.163 37.2181
rxPix[0].vdiff.51 xPix[0].MMP2.g xPix[0].vdiff.170 37.2181
rxPix[0].vd.78 xPix[0].MMrst.s xPix[0].vd 0.01
rxPix[0].vd.77 xPix[0].vd.2 xPix[0].vd.16 0.699257
rxPix[0].vd.76 xPix[0].vd.2 xPix[0].vd.4 0.0698411
rxPix[0].vd.75 xPix[0].vd.3 xPix[0].vd.4 0.451733
rxPix[0].vd.74 xPix[0].vd.3 xPix[0].vd.5 0.0698411
rxPix[0].vd.73 xPix[0].vd.5 xPix[0].vd.6 3.13119
rxPix[0].vd.72 xPix[0].vd.6 xPix[0].vd.8 0.0698411
rxPix[0].vd.71 xPix[0].vd.7 xPix[0].vd.8 0.792079
rxPix[0].vd.70 xPix[0].vd.7 xPix[0].vd.21 0.0513368
rxPix[0].vd.69 xPix[0].vd.11 xPix[0].vd.19 0.121073
rxPix[0].vd.68 xPix[0].vd.11 xPix[0].vd.82 4.65
rxPix[0].vd.67 xPix[0].vd.14 xPix[0].vd.16 0.128102
rxPix[0].vd.66 xPix[0].vd.14 xPix[0].vd.30 4.5
rxPix[0].vd.65 xPix[0].vd.18 xPix[0].vd.19 0.083887
rxPix[0].vd.64 xPix[0].vd.18 xPix[0].vd.41 4.5
rxPix[0].vd.63 xPix[0].vd.21 xPix[0].vd.24 0.0373506
rxPix[0].vd.62 xPix[0].vd.24 xPix[0].vd 9.3
rxPix[0].vd.61 xPix[0].vd.27 xPix[0].vd.30 0.243776
rxPix[0].vd.60 xPix[0].vd.27 xPix[0].vd.54 3.41
rxPix[0].vd.59 xPix[0].vd.32 xPix[0].vd.39 1.26238
rxPix[0].vd.58 xPix[0].vd.32 xPix[0].vd.35 0.0698411
rxPix[0].vd.57 xPix[0].vd.35 xPix[0].vd.43 1.24381
rxPix[0].vd.56 xPix[0].vd.37 xPix[0].vd.39 0.139571
rxPix[0].vd.55 xPix[0].vd.37 xPix[0].vd.45 3.41
rxPix[0].vd.54 xPix[0].vd.41 xPix[0].vd.43 0.125797
rxPix[0].vd.53 xPix[0].vd.45 xPix[0].vd.48 0.00656989
rxPix[0].vd.52 xPix[0].vd.48 xPix[0].vd.74 3.41
rxPix[0].vd.51 xPix[0].vd.51 xPix[0].vd.54 0.000315966
rxPix[0].vd.50 xPix[0].vd.51 xPix[0].vd.70 3.41
rxPix[0].vd.49 xPix[0].vd.56 xPix[0].vd.57 0.464434
rxPix[0].vd.48 xPix[0].vd.56 xPix[0].vd.59 0.0280223
rxPix[0].vd.47 xPix[0].vd.57 xPix[0].vd.63 0.0262616
rxPix[0].vd.46 xPix[0].vd.59 xPix[0].CC1b.pos 0.0758963
rxPix[0].vd.45 xPix[0].CC1b.pos xPix[0].vd.76 0.0208115
rxPix[0].vd.44 xPix[0].vd.62 xPix[0].CC3.pos 0.223097
rxPix[0].vd.43 xPix[0].vd.62 xPix[0].vd.68 0.032569
rxPix[0].vd.42 xPix[0].vd.63 xPix[0].CC3.pos 0.19563
rxPix[0].vd.41 xPix[0].vd.66 xPix[0].vd.77 0.103477
rxPix[0].vd.40 xPix[0].vd.66 xPix[0].CC1.pos 0.0039471
rxPix[0].vd.39 xPix[0].vd.68 xPix[0].vd.70 0.333623
rxPix[0].vd.38 xPix[0].vd.72 xPix[0].vd.74 0.180056
rxPix[0].vd.37 xPix[0].vd.72 xPix[0].vd.80 0.023786
rxPix[0].vd.36 xPix[0].vd.76 xPix[0].vd.77 0.0276694
rxPix[0].vd.35 xPix[0].CC1.pos xPix[0].vd.80 0.0583805
rxPix[0].vd.34 xPix[0].vd.82 xPix[0].vd.85 24.6417
rxPix[0].vd.33 xPix[0].vd.85 xPix[0].vd.87 49.2834
rxPix[0].vd.32 xPix[0].vd.85 xPix[0].vd.98 50.6667
rxPix[0].vd.31 xPix[0].vd.87 xPix[0].vd.98 152
rxPix[0].vd.30 xPix[0].MMchAmp.g xPix[0].vd.98 37.2181
rxPix[1].nOFF.53 xPix[1].MMP2.d xPix[1].nOFF 0.01
rxPix[1].nOFF.52 xPix[1].nOFF.1 xPix[1].nOFF.3 0.255236
rxPix[1].nOFF.51 xPix[1].nOFF.1 xPix[1].nOFF.25 0.10068
rxPix[1].nOFF.50 xPix[1].nOFF.3 xPix[1].nOFF.5 0.471204
rxPix[1].nOFF.49 xPix[1].nOFF.3 xPix[1].MMoffBias.d 3.1
rxPix[1].nOFF.48 xPix[1].nOFF.5 xPix[1].MMoffBias.d 9.3
rxPix[1].nOFF.47 xPix[1].nOFF.7 xPix[1].nOFF.25 3.32921
rxPix[1].nOFF.46 xPix[1].nOFF.7 xPix[1].nOFF.10 0.0698411
rxPix[1].nOFF.45 xPix[1].nOFF.9 xPix[1].nOFF.10 1.9245
rxPix[1].nOFF.44 xPix[1].nOFF.9 xPix[1].nOFF.28 0.0073411
rxPix[1].nOFF.43 xPix[1].nOFF.15 xPix[1].nOFF.16 0.643564
rxPix[1].nOFF.42 xPix[1].nOFF.15 xPix[1].nOFF.32 0.150768
rxPix[1].nOFF.41 xPix[1].nOFF.16 xPix[1].nOFF.26 0.0073411
rxPix[1].nOFF.40 xPix[1].nOFF.17 xPix[1].nOFF.18 1.88738
rxPix[1].nOFF.39 xPix[1].nOFF.17 xPix[1].nOFF.36 0.0073411
rxPix[1].nOFF.38 xPix[1].nOFF.18 xPix[1].nOFF.30 0.0367876
rxPix[1].nOFF.37 xPix[1].nOFF.19 xPix[1].nOFF.20 3.80569
rxPix[1].nOFF.36 xPix[1].nOFF.19 xPix[1].nOFF.21 0.0753543
rxPix[1].nOFF.35 xPix[1].nOFF.20 xPix[1].nOFF.34 0.0073411
rxPix[1].nOFF.34 xPix[1].nOFF.21 xPix[1].nOFF.23 0.376309
rxPix[1].nOFF.33 xPix[1].nOFF.23 xPix[1].nOFF.52 3.1
rxPix[1].nOFF.32 xPix[1].nOFF.26 xPix[1].nOFF.28 0.117574
rxPix[1].nOFF.31 xPix[1].nOFF.30 xPix[1].nOFF.32 0.0411184
rxPix[1].nOFF.30 xPix[1].nOFF.32 xPix[1].nOFF.63 9.3
rxPix[1].nOFF.29 xPix[1].nOFF.34 xPix[1].nOFF.36 0.185644
rxPix[1].nOFF.28 xPix[1].nOFF.46 xPix[1].nOFF.47 28.7487
rxPix[1].nOFF.27 xPix[1].nOFF.46 xPix[1].nOFF.60 4.85115
rxPix[1].nOFF.26 xPix[1].nOFF.47 xPix[1].nOFF.59 2.73809
rxPix[1].nOFF.25 xPix[1].nOFF.52 xPix[1].nOFF 11.2941
rxPix[1].nOFF.24 xPix[1].nOFF.52 xPix[1].nOFF 37.9893
rxPix[1].nOFF.23 xPix[1].nOFF.57 xPix[1].nOFF.59 13.6752
rxPix[1].nOFF.22 xPix[1].nOFF.57 xPix[1].nOFF.70 152
rxPix[1].nOFF.21 xPix[1].nOFF.60 xPix[1].nOFF.63 2.95101
rxPix[1].nOFF.20 xPix[1].nOFF.65 xPix[1].MMN8.g 210.234
rxPix[1].nOFF.19 xPix[1].nOFF.65 xPix[1].nOFF.70 52.7279
rxPix[1].VPR.60 xPix[1].MMprBias.d xPix[1].VPR 0.01
rxPix[1].VPR.59 xPix[1].VPR.1 xPix[1].VPR.2 0.321782
rxPix[1].VPR.58 xPix[1].VPR.1 xPix[1].VPR.14 0.0446906
rxPix[1].VPR.57 xPix[1].VPR.2 xPix[1].VPR.12 0.0513368
rxPix[1].VPR.56 xPix[1].VPR.3 xPix[1].VPR.4 0.897277
rxPix[1].VPR.55 xPix[1].VPR.3 xPix[1].VPR.26 0.0644185
rxPix[1].VPR.54 xPix[1].VPR.4 xPix[1].VPR.23 0.0073411
rxPix[1].VPR.53 xPix[1].VPR.5 xPix[1].VPR.31 1.04579
rxPix[1].VPR.52 xPix[1].VPR.5 xPix[1].VPR.25 0.0073411
rxPix[1].VPR.51 xPix[1].VPR.7 xPix[1].VPR.8 0.377475
rxPix[1].VPR.50 xPix[1].VPR.7 xPix[1].VPR.36 0.0513368
rxPix[1].VPR.49 xPix[1].VPR.8 xPix[1].VPR.25 0.0866337
rxPix[1].VPR.48 xPix[1].VPR.10 xPix[1].VPR.12 0.0473108
rxPix[1].VPR.47 xPix[1].VPR.10 xPix[1].MMpr.amp.d 9.3
rxPix[1].VPR.46 xPix[1].VPR.14 xPix[1].VPR.17 0.050905
rxPix[1].VPR.45 xPix[1].VPR.17 xPix[1].VPR.47 4.5
rxPix[1].VPR.44 xPix[1].VPR.20 xPix[1].VPR.22 0.042735
rxPix[1].VPR.43 xPix[1].VPR.20 xPix[1].VPR.60 9.3
rxPix[1].VPR.42 xPix[1].VPR.22 xPix[1].VPR.51 4.5
rxPix[1].VPR.41 xPix[1].VPR.23 xPix[1].VPR.25 0.290842
rxPix[1].VPR.40 xPix[1].VPR.26 xPix[1].VPR.28 0.0942737
rxPix[1].VPR.39 xPix[1].VPR.28 xPix[1].VPR.65 9.3
rxPix[1].VPR.38 xPix[1].VPR.30 xPix[1].VPR.31 0.112452
rxPix[1].VPR.37 xPix[1].VPR.30 xPix[1].VPR.44 4.5
rxPix[1].VPR.36 xPix[1].VPR.34 xPix[1].VPR.36 0.0373506
rxPix[1].VPR.35 xPix[1].VPR.34 xPix[1].VPR 9.3
rxPix[1].VPR.34 xPix[1].VPR.40 xPix[1].VPR.53 5.44554
rxPix[1].VPR.33 xPix[1].VPR.40 xPix[1].VPR.42 0.0847472
rxPix[1].VPR.32 xPix[1].VPR.42 xPix[1].VPR.44 0.15347
rxPix[1].VPR.31 xPix[1].VPR.47 xPix[1].VPR.49 0.128102
rxPix[1].VPR.30 xPix[1].VPR.49 xPix[1].VPR.52 0.816832
rxPix[1].VPR.29 xPix[1].VPR.51 xPix[1].VPR.52 0.128102
rxPix[1].VPR.28 xPix[1].VPR.51 xPix[1].VPR.53 0.128102
rxPix[1].VPR.27 xPix[1].VPR.60 xPix[1].VPR.75 152
rxPix[1].VPR.26 xPix[1].VPR.65 xPix[1].VPR.85 152
rxPix[1].VPR.25 xPix[1].VPR.75 xPix[1].MMpd.g 121.488
rxPix[1].VPR.24 xPix[1].VPR.80 xPix[1].MMsf.g 101.866
rxPix[1].VPR.23 xPix[1].VPR.80 xPix[1].VPR.85 37.6412
rxPix[1].nRst.72 xPix[1].MMrefrBias.d xPix[1].nRst 0.01
rxPix[1].nRst.71 xPix[1].nRst.3 xPix[1].nRst.28 0.149402
rxPix[1].nRst.70 xPix[1].nRst.3 xPix[1].nRst.52 4.5
rxPix[1].nRst.69 xPix[1].nRst.5 xPix[1].nRst.6 1.57178
rxPix[1].nRst.68 xPix[1].nRst.5 xPix[1].nRst.38 0.0136246
rxPix[1].nRst.67 xPix[1].nRst.6 xPix[1].nRst.34 0.0583662
rxPix[1].nRst.66 xPix[1].nRst.7 xPix[1].nRst.8 1.41708
rxPix[1].nRst.65 xPix[1].nRst.7 xPix[1].nRst.9 0.0698411
rxPix[1].nRst.64 xPix[1].nRst.8 xPix[1].nRst.36 0.0136246
rxPix[1].nRst.63 xPix[1].nRst.9 xPix[1].nRst.10 4.18936
rxPix[1].nRst.62 xPix[1].nRst.10 xPix[1].nRst.11 0.0335533
rxPix[1].nRst.61 xPix[1].nRst.10 xPix[1].nRst.41 0.162037
rxPix[1].nRst.60 xPix[1].nRst.11 xPix[1].nRst.12 2.94554
rxPix[1].nRst.59 xPix[1].nRst.12 xPix[1].nRst.14 0.0698411
rxPix[1].nRst.58 xPix[1].nRst.13 xPix[1].nRst.14 0.451733
rxPix[1].nRst.57 xPix[1].nRst.13 xPix[1].nRst.19 0.0698411
rxPix[1].nRst.56 xPix[1].nRst.15 xPix[1].nRst.16 1.20668
rxPix[1].nRst.55 xPix[1].nRst.15 xPix[1].nRst.18 0.0698411
rxPix[1].nRst.54 xPix[1].nRst.16 xPix[1].nRst.41 0.0335533
rxPix[1].nRst.53 xPix[1].nRst.18 xPix[1].nRst.44 0.272277
rxPix[1].nRst.52 xPix[1].nRst.19 xPix[1].nRst.20 2.95173
rxPix[1].nRst.51 xPix[1].nRst.20 xPix[1].nRst.22 0.0698411
rxPix[1].nRst.50 xPix[1].nRst.21 xPix[1].nRst.22 0.829208
rxPix[1].nRst.49 xPix[1].nRst.21 xPix[1].nRst.46 0.115813
rxPix[1].nRst.48 xPix[1].nRst.23 xPix[1].nRst.25 0.0196335
rxPix[1].nRst.47 xPix[1].nRst.23 xPix[1].nRst.44 0.103504
rxPix[1].nRst.46 xPix[1].nRst.25 xPix[1].nRst.69 4.65
rxPix[1].nRst.45 xPix[1].nRst.28 xPix[1].MMPDrefrCol.d 9.3
rxPix[1].nRst.44 xPix[1].nRst.32 xPix[1].nRst.34 0.083042
rxPix[1].nRst.43 xPix[1].nRst.32 xPix[1].nRst.55 4.5
rxPix[1].nRst.42 xPix[1].nRst.36 xPix[1].nRst.38 0.107759
rxPix[1].nRst.41 xPix[1].nRst.41 xPix[1].nRst.43 0.0434028
rxPix[1].nRst.40 xPix[1].nRst.43 xPix[1].nRst 9.3
rxPix[1].nRst.39 xPix[1].nRst.46 xPix[1].nRst.77 9.3
rxPix[1].nRst.38 xPix[1].nRst.48 xPix[1].nRst.56 7.7104
rxPix[1].nRst.37 xPix[1].nRst.48 xPix[1].nRst.49 0.0469786
rxPix[1].nRst.36 xPix[1].nRst.49 xPix[1].nRst.52 0.0487013
rxPix[1].nRst.35 xPix[1].nRst.55 xPix[1].nRst.56 0.13093
rxPix[1].nRst.34 xPix[1].nRst.69 xPix[1].nRst.72 24.6417
rxPix[1].nRst.33 xPix[1].nRst.72 xPix[1].nRst.74 49.2834
rxPix[1].nRst.32 xPix[1].nRst.72 xPix[1].nRst.85 50.6667
rxPix[1].nRst.31 xPix[1].nRst.74 xPix[1].nRst.85 152
rxPix[1].nRst.30 xPix[1].nRst.77 xPix[1].nRst.89 152
rxPix[1].nRst.29 xPix[1].MMcapRef.g xPix[1].nRst.85 37.2181
rxPix[1].nRst.28 xPix[1].nRst.89 xPix[1].MMrst.g 76.8022
rxPix[1].ON.57 xPix[1].MMon.d xPix[1].ON 0.01
rxPix[1].ON.56 xPix[1].ON.1 xPix[1].ON.2 0.290842
rxPix[1].ON.55 xPix[1].ON.1 xPix[1].ON.27 0.0373109
rxPix[1].ON.54 xPix[1].ON.2 xPix[1].ON.32 0.0529306
rxPix[1].ON.53 xPix[1].ON.3 xPix[1].ON.25 1.7203
rxPix[1].ON.52 xPix[1].ON.3 xPix[1].ON.32 0.0529306
rxPix[1].ON.51 xPix[1].ON.5 xPix[1].ON.6 2.06064
rxPix[1].ON.50 xPix[1].ON.5 xPix[1].ON.39 0.0073411
rxPix[1].ON.49 xPix[1].ON.6 xPix[1].ON.32 0.0137558
rxPix[1].ON.48 xPix[1].ON.9 xPix[1].ON.36 0.121073
rxPix[1].ON.47 xPix[1].ON.9 xPix[1].ON.11 0.471204
rxPix[1].ON.46 xPix[1].ON.9 xPix[1].MMonBias.d 3.1
rxPix[1].ON.45 xPix[1].ON.11 xPix[1].MMonBias.d 9.3
rxPix[1].ON.44 xPix[1].ON.13 xPix[1].ON.14 0.643564
rxPix[1].ON.43 xPix[1].ON.13 xPix[1].ON.16 0.0698411
rxPix[1].ON.42 xPix[1].ON.14 xPix[1].ON.37 0.0073411
rxPix[1].ON.41 xPix[1].ON.15 xPix[1].ON.16 0.259901
rxPix[1].ON.40 xPix[1].ON.15 xPix[1].ON.18 0.0698411
rxPix[1].ON.39 xPix[1].ON.17 xPix[1].ON.18 1.94307
rxPix[1].ON.38 xPix[1].ON.17 xPix[1].ON.19 0.0753543
rxPix[1].ON.37 xPix[1].ON.19 xPix[1].ON.21 0.356675
rxPix[1].ON.36 xPix[1].ON.21 xPix[1].ON.67 3.1
rxPix[1].ON.35 xPix[1].ON.24 xPix[1].ON.25 0.125797
rxPix[1].ON.34 xPix[1].ON.24 xPix[1].ON.44 4.5
rxPix[1].ON.33 xPix[1].ON.27 xPix[1].ON.30 0.078534
rxPix[1].ON.32 xPix[1].ON.30 xPix[1].ON.51 9.3
rxPix[1].ON.31 xPix[1].ON.34 xPix[1].ON.36 0.083887
rxPix[1].ON.30 xPix[1].ON.34 xPix[1].ON.49 4.5
rxPix[1].ON.29 xPix[1].ON.37 xPix[1].ON.39 0.117574
rxPix[1].ON.28 xPix[1].ON.42 xPix[1].ON.46 4.57921
rxPix[1].ON.27 xPix[1].ON.42 xPix[1].ON.49 0.154352
rxPix[1].ON.26 xPix[1].ON.44 xPix[1].ON.46 0.125797
rxPix[1].ON.25 xPix[1].ON.51 xPix[1].ON.76 152
rxPix[1].ON.24 xPix[1].ON.67 xPix[1].ON 4.4492
rxPix[1].ON.23 xPix[1].ON.67 xPix[1].ON 44.8342
rxPix[1].ON.22 xPix[1].ON.71 xPix[1].MMN7.g 210.234
rxPix[1].ON.21 xPix[1].ON.71 xPix[1].ON.76 52.7279
rxPix[1].VSF.41 xPix[1].MMsf.s xPix[1].VSF 0.01
rxPix[1].VSF.40 xPix[1].VSF.2 xPix[1].VSF.12 0.847772
rxPix[1].VSF.39 xPix[1].VSF.2 xPix[1].VSF.13 0.063711
rxPix[1].VSF.38 xPix[1].VSF.3 xPix[1].VSF.4 1.04579
rxPix[1].VSF.37 xPix[1].VSF.3 xPix[1].VSF.5 0.0815092
rxPix[1].VSF.36 xPix[1].VSF.4 xPix[1].VSF.15 0.103794
rxPix[1].VSF.35 xPix[1].VSF.5 xPix[1].VSF.7 0.104582
rxPix[1].VSF.34 xPix[1].VSF.7 xPix[1].VSF 9.3
rxPix[1].VSF.33 xPix[1].VSF.10 xPix[1].VSF.12 0.118702
rxPix[1].VSF.32 xPix[1].VSF.10 xPix[1].MMP0.d 9.3
rxPix[1].VSF.31 xPix[1].VSF.13 xPix[1].VSF.15 0.0423729
rxPix[1].VSF.30 xPix[1].VSF.15 xPix[1].VSF.22 4.5
rxPix[1].VSF.29 xPix[1].VSF.16 xPix[1].VSF.18 0.119819
rxPix[1].VSF.28 xPix[1].VSF.16 xPix[1].VSF.20 0.0716608
rxPix[1].VSF.27 xPix[1].VSF.18 xPix[1].VSF.37 3.41
rxPix[1].VSF.26 xPix[1].VSF.20 xPix[1].VSF.22 0.237989
rxPix[1].VSF.25 xPix[1].VSF.24 xPix[1].VSF.25 0.328712
rxPix[1].VSF.24 xPix[1].VSF.24 xPix[1].VSF.26 0.0360789
rxPix[1].VSF.23 xPix[1].VSF.25 xPix[1].VSF.30 0.0309504
rxPix[1].VSF.22 xPix[1].VSF.26 xPix[1].CC1b.neg 0.0238133
rxPix[1].VSF.21 xPix[1].VSF.29 xPix[1].CC3.neg 0.0663074
rxPix[1].VSF.20 xPix[1].VSF.29 xPix[1].VSF.39 0.0491116
rxPix[1].VSF.19 xPix[1].VSF.30 xPix[1].CC3.neg 0.067696
rxPix[1].VSF.18 xPix[1].VSF.33 xPix[1].VSF.39 0.0878361
rxPix[1].VSF.17 xPix[1].VSF.33 xPix[1].VSF.35 0.0262603
rxPix[1].VSF.16 xPix[1].VSF.35 xPix[1].VSF.37 0.0739672
rxPix[1].vdiff.137 xPix[1].MMrst.d xPix[1].vdiff 0.01
rxPix[1].vdiff.136 xPix[1].vdiff.1 xPix[1].vdiff.3 0.255236
rxPix[1].vdiff.135 xPix[1].vdiff.1 xPix[1].vdiff.25 0.0964438
rxPix[1].vdiff.134 xPix[1].vdiff.3 xPix[1].vdiff.5 0.471204
rxPix[1].vdiff.133 xPix[1].vdiff.3 xPix[1].MMchAmpBias.d 3.1
rxPix[1].vdiff.132 xPix[1].vdiff.5 xPix[1].MMchAmpBias.d 9.3
rxPix[1].vdiff.131 xPix[1].vdiff.9 xPix[1].vdiff.11 0.238874
rxPix[1].vdiff.130 xPix[1].vdiff.9 xPix[1].vdiff.30 0.253713
rxPix[1].vdiff.129 xPix[1].vdiff.11 xPix[1].vdiff.131 4.65
rxPix[1].vdiff.128 xPix[1].vdiff.14 xPix[1].vdiff.36 1.42327
rxPix[1].vdiff.127 xPix[1].vdiff.14 xPix[1].vdiff.30 0.0073411
rxPix[1].vdiff.126 xPix[1].vdiff.15 xPix[1].vdiff.37 1.94307
rxPix[1].vdiff.125 xPix[1].vdiff.15 xPix[1].vdiff.38 0.044923
rxPix[1].vdiff.124 xPix[1].vdiff.17 xPix[1].vdiff.19 0.368622
rxPix[1].vdiff.123 xPix[1].vdiff.17 xPix[1].vdiff.38 0.1677
rxPix[1].vdiff.122 xPix[1].vdiff.19 xPix[1].vdiff.150 3.1
rxPix[1].vdiff.121 xPix[1].vdiff.21 xPix[1].vdiff.22 1.57178
rxPix[1].vdiff.120 xPix[1].vdiff.21 xPix[1].vdiff.42 0.112452
rxPix[1].vdiff.119 xPix[1].vdiff.22 xPix[1].vdiff.44 0.0446906
rxPix[1].vdiff.118 xPix[1].vdiff.25 xPix[1].vdiff.29 0.754951
rxPix[1].vdiff.117 xPix[1].vdiff.27 xPix[1].vdiff.29 0.125797
rxPix[1].vdiff.116 xPix[1].vdiff.27 xPix[1].vdiff.91 4.5
rxPix[1].vdiff.115 xPix[1].vdiff.35 xPix[1].vdiff.36 0.122773
rxPix[1].vdiff.114 xPix[1].vdiff.35 xPix[1].vdiff.37 0.250978
rxPix[1].vdiff.113 xPix[1].vdiff.35 xPix[1].vdiff.139 4.65
rxPix[1].vdiff.112 xPix[1].vdiff.38 xPix[1].vdiff.40 0.0287356
rxPix[1].vdiff.111 xPix[1].vdiff.40 xPix[1].vdiff.75 4.5
rxPix[1].vdiff.110 xPix[1].vdiff.42 xPix[1].vdiff.100 4.5
rxPix[1].vdiff.109 xPix[1].vdiff.44 xPix[1].vdiff.47 0.050905
rxPix[1].vdiff.108 xPix[1].vdiff.47 xPix[1].vdiff.107 4.5
rxPix[1].vdiff.107 xPix[1].vdiff.50 xPix[1].vdiff.51 0.118702
rxPix[1].vdiff.106 xPix[1].vdiff.50 xPix[1].vdiff 9.3
rxPix[1].vdiff.105 xPix[1].vdiff.51 xPix[1].vdiff.56 0.847772
rxPix[1].vdiff.104 xPix[1].vdiff.54 xPix[1].vdiff.56 0.128102
rxPix[1].vdiff.103 xPix[1].vdiff.54 xPix[1].vdiff.110 4.5
rxPix[1].vdiff.102 xPix[1].vdiff.57 xPix[1].vdiff.58 1.57797
rxPix[1].vdiff.101 xPix[1].vdiff.57 xPix[1].vdiff.60 0.0698411
rxPix[1].vdiff.100 xPix[1].vdiff.58 xPix[1].vdiff.86 0.0073411
rxPix[1].vdiff.99 xPix[1].vdiff.60 xPix[1].vdiff.96 9.44307
rxPix[1].vdiff.98 xPix[1].vdiff.61 xPix[1].vdiff.62 4.73391
rxPix[1].vdiff.97 xPix[1].vdiff.61 xPix[1].vdiff.88 0.0073411
rxPix[1].vdiff.96 xPix[1].vdiff.62 xPix[1].vdiff.64 0.0698411
rxPix[1].vdiff.95 xPix[1].vdiff.63 xPix[1].vdiff.64 0.643564
rxPix[1].vdiff.94 xPix[1].vdiff.63 xPix[1].vdiff.65 0.0698411
rxPix[1].vdiff.93 xPix[1].vdiff.65 xPix[1].vdiff.92 1.10767
rxPix[1].vdiff.92 xPix[1].vdiff.67 xPix[1].vdiff.97 0.303218
rxPix[1].vdiff.91 xPix[1].vdiff.67 xPix[1].vdiff.70 0.0698411
rxPix[1].vdiff.90 xPix[1].vdiff.69 xPix[1].vdiff.70 0.878713
rxPix[1].vdiff.89 xPix[1].vdiff.69 xPix[1].vdiff.72 0.0698411
rxPix[1].vdiff.88 xPix[1].vdiff.71 xPix[1].vdiff.72 0.439356
rxPix[1].vdiff.87 xPix[1].vdiff.71 xPix[1].vdiff.98 0.117917
rxPix[1].vdiff.86 xPix[1].vdiff.73 xPix[1].vdiff.75 0.0470588
rxPix[1].vdiff.85 xPix[1].vdiff.73 xPix[1].vdiff.98 0.0220814
rxPix[1].vdiff.84 xPix[1].vdiff.76 xPix[1].vdiff.77 1.41708
rxPix[1].vdiff.83 xPix[1].vdiff.76 xPix[1].vdiff.82 0.0698411
rxPix[1].vdiff.82 xPix[1].vdiff.77 xPix[1].vdiff.98 0.117917
rxPix[1].vdiff.81 xPix[1].vdiff.78 xPix[1].vdiff.79 1.15099
rxPix[1].vdiff.80 xPix[1].vdiff.78 xPix[1].vdiff.104 0.0446906
rxPix[1].vdiff.79 xPix[1].vdiff.79 xPix[1].vdiff.81 0.0698411
rxPix[1].vdiff.78 xPix[1].vdiff.80 xPix[1].vdiff.81 0.210396
rxPix[1].vdiff.77 xPix[1].vdiff.80 xPix[1].vdiff.84 0.0698411
rxPix[1].vdiff.76 xPix[1].vdiff.82 xPix[1].vdiff.83 4.5297
rxPix[1].vdiff.75 xPix[1].vdiff.83 xPix[1].vdiff.102 0.0446906
rxPix[1].vdiff.74 xPix[1].vdiff.84 xPix[1].vdiff.111 2.38861
rxPix[1].vdiff.73 xPix[1].vdiff.86 xPix[1].vdiff.88 0.222772
rxPix[1].vdiff.72 xPix[1].vdiff.91 xPix[1].vdiff.92 0.125797
rxPix[1].vdiff.71 xPix[1].vdiff.95 xPix[1].vdiff.96 0.136592
rxPix[1].vdiff.70 xPix[1].vdiff.95 xPix[1].vdiff.97 0.136592
rxPix[1].vdiff.69 xPix[1].vdiff.95 xPix[1].vdiff.115 3.41
rxPix[1].vdiff.68 xPix[1].vdiff.100 xPix[1].vdiff.102 0.050905
rxPix[1].vdiff.67 xPix[1].vdiff.104 xPix[1].vdiff.107 0.0848416
rxPix[1].vdiff.66 xPix[1].vdiff.110 xPix[1].vdiff.111 0.128102
rxPix[1].vdiff.65 xPix[1].vdiff.113 xPix[1].vdiff.115 0.089913
rxPix[1].vdiff.64 xPix[1].vdiff.113 xPix[1].vdiff.120 0.0315435
rxPix[1].vdiff.63 xPix[1].CC1.neg xPix[1].vdiff.120 0.0170398
rxPix[1].vdiff.62 xPix[1].vdiff.131 xPix[1].vdiff.134 24.6417
rxPix[1].vdiff.61 xPix[1].vdiff.134 xPix[1].vdiff.136 49.2834
rxPix[1].vdiff.60 xPix[1].vdiff.134 xPix[1].vdiff.163 50.6667
rxPix[1].vdiff.59 xPix[1].vdiff.136 xPix[1].vdiff.163 152
rxPix[1].vdiff.58 xPix[1].vdiff.139 xPix[1].vdiff.142 24.6417
rxPix[1].vdiff.57 xPix[1].vdiff.142 xPix[1].vdiff.144 49.2834
rxPix[1].vdiff.56 xPix[1].vdiff.142 xPix[1].vdiff.170 50.6667
rxPix[1].vdiff.55 xPix[1].vdiff.144 xPix[1].vdiff.170 152
rxPix[1].vdiff.54 xPix[1].vdiff.150 xPix[1].MMchAmp.d 11.2941
rxPix[1].vdiff.53 xPix[1].vdiff.150 xPix[1].MMchAmp.d 37.9893
rxPix[1].vdiff.52 xPix[1].MMon.g xPix[1].vdiff.163 37.2181
rxPix[1].vdiff.51 xPix[1].MMP2.g xPix[1].vdiff.170 37.2181
rxPix[1].vd.78 xPix[1].MMrst.s xPix[1].vd 0.01
rxPix[1].vd.77 xPix[1].vd.2 xPix[1].vd.16 0.699257
rxPix[1].vd.76 xPix[1].vd.2 xPix[1].vd.4 0.0698411
rxPix[1].vd.75 xPix[1].vd.3 xPix[1].vd.4 0.451733
rxPix[1].vd.74 xPix[1].vd.3 xPix[1].vd.5 0.0698411
rxPix[1].vd.73 xPix[1].vd.5 xPix[1].vd.6 3.13119
rxPix[1].vd.72 xPix[1].vd.6 xPix[1].vd.8 0.0698411
rxPix[1].vd.71 xPix[1].vd.7 xPix[1].vd.8 0.792079
rxPix[1].vd.70 xPix[1].vd.7 xPix[1].vd.21 0.0513368
rxPix[1].vd.69 xPix[1].vd.11 xPix[1].vd.19 0.121073
rxPix[1].vd.68 xPix[1].vd.11 xPix[1].vd.82 4.65
rxPix[1].vd.67 xPix[1].vd.14 xPix[1].vd.16 0.128102
rxPix[1].vd.66 xPix[1].vd.14 xPix[1].vd.30 4.5
rxPix[1].vd.65 xPix[1].vd.18 xPix[1].vd.19 0.083887
rxPix[1].vd.64 xPix[1].vd.18 xPix[1].vd.41 4.5
rxPix[1].vd.63 xPix[1].vd.21 xPix[1].vd.24 0.0373506
rxPix[1].vd.62 xPix[1].vd.24 xPix[1].vd 9.3
rxPix[1].vd.61 xPix[1].vd.27 xPix[1].vd.30 0.243776
rxPix[1].vd.60 xPix[1].vd.27 xPix[1].vd.54 3.41
rxPix[1].vd.59 xPix[1].vd.32 xPix[1].vd.39 1.26238
rxPix[1].vd.58 xPix[1].vd.32 xPix[1].vd.35 0.0698411
rxPix[1].vd.57 xPix[1].vd.35 xPix[1].vd.43 1.24381
rxPix[1].vd.56 xPix[1].vd.37 xPix[1].vd.39 0.139571
rxPix[1].vd.55 xPix[1].vd.37 xPix[1].vd.45 3.41
rxPix[1].vd.54 xPix[1].vd.41 xPix[1].vd.43 0.125797
rxPix[1].vd.53 xPix[1].vd.45 xPix[1].vd.48 0.00656989
rxPix[1].vd.52 xPix[1].vd.48 xPix[1].vd.74 3.41
rxPix[1].vd.51 xPix[1].vd.51 xPix[1].vd.54 0.000315966
rxPix[1].vd.50 xPix[1].vd.51 xPix[1].vd.70 3.41
rxPix[1].vd.49 xPix[1].vd.56 xPix[1].vd.57 0.464434
rxPix[1].vd.48 xPix[1].vd.56 xPix[1].vd.59 0.0280223
rxPix[1].vd.47 xPix[1].vd.57 xPix[1].vd.63 0.0262616
rxPix[1].vd.46 xPix[1].vd.59 xPix[1].CC1b.pos 0.0758963
rxPix[1].vd.45 xPix[1].CC1b.pos xPix[1].vd.76 0.0208115
rxPix[1].vd.44 xPix[1].vd.62 xPix[1].CC3.pos 0.223097
rxPix[1].vd.43 xPix[1].vd.62 xPix[1].vd.68 0.032569
rxPix[1].vd.42 xPix[1].vd.63 xPix[1].CC3.pos 0.19563
rxPix[1].vd.41 xPix[1].vd.66 xPix[1].vd.77 0.103477
rxPix[1].vd.40 xPix[1].vd.66 xPix[1].CC1.pos 0.0039471
rxPix[1].vd.39 xPix[1].vd.68 xPix[1].vd.70 0.333623
rxPix[1].vd.38 xPix[1].vd.72 xPix[1].vd.74 0.180056
rxPix[1].vd.37 xPix[1].vd.72 xPix[1].vd.80 0.023786
rxPix[1].vd.36 xPix[1].vd.76 xPix[1].vd.77 0.0276694
rxPix[1].vd.35 xPix[1].CC1.pos xPix[1].vd.80 0.0583805
rxPix[1].vd.34 xPix[1].vd.82 xPix[1].vd.85 24.6417
rxPix[1].vd.33 xPix[1].vd.85 xPix[1].vd.87 49.2834
rxPix[1].vd.32 xPix[1].vd.85 xPix[1].vd.98 50.6667
rxPix[1].vd.31 xPix[1].vd.87 xPix[1].vd.98 152
rxPix[1].vd.30 xPix[1].MMchAmp.g xPix[1].vd.98 37.2181
* [skipped spectre directive] simulatorOptions options psfversion="1.4.0" reltol=1e-3 vabstol=1e-6     iabstol=1e-12 temp=27 tnom=27 gmin=1e-12 rforce=1 maxnotes=5     maxwarns=5 digits=5 cols=80 pivrel=1e-3 sensfile="../psf/sens.output"     checklimitdest=psf
* [skipped spectre directive] modelParameter info what=models where=rawfile
* [skipped spectre directive] element info what=inst where=rawfile
* [skipped spectre directive] outputParameter info what=output where=rawfile
* [skipped spectre directive] designParamVals info what=parameters where=rawfile
* [skipped spectre directive] primitives info what=primitives where=rawfile
* [skipped spectre directive] subckts info what=subckts where=rawfile
* [skipped spectre directive] saveOptions options save=allpub

.ends openDVS_pixel2x2
.end
