* Extracted by KLayout with SKY130 LVS runset on : 22/09/2026 22:00

.SUBCKT openDVS_pixel2x2 GndA VddA18 DiffBn OffBn PrSFBp PrBp RefrBp OnBn
+ readLine[0] pixRst[0] pixRst[1] readLine[1] vpd[1] vpd[3] rowReadOFF[1] GndD
+ rowReadON[1] rowReadON[0] rowReadOFF[0] vpd[0] vpd[2]
X$1 GndD pixRst[1] \$I136 rowReadON[0] rowReadOFF[0] VddA18 \$I16 \$I142
+ readLine[1] \$I126 \$I12 GndA OffBn vpd[2] GndA OnBn PrBp DiffBn openDVS_pixel
X$2 GndD pixRst[0] \$I136 rowReadON[0] rowReadOFF[0] VddA18 \$I128 \$I146
+ readLine[0] \$I144 \$I131 GndA OffBn vpd[0] GndA OnBn PrBp DiffBn
+ openDVS_pixel
X$4 GndD pixRst[0] \$I136 rowReadON[1] rowReadOFF[1] VddA18 \$I130 \$I140
+ readLine[0] \$I124 \$I133 GndA OffBn vpd[1] GndA OnBn PrBp DiffBn
+ openDVS_pixel
X$5 GndD pixRst[1] \$I136 rowReadON[1] rowReadOFF[1] VddA18 \$I129 \$I141
+ readLine[1] \$I125 \$I132 GndA OffBn vpd[3] GndA OnBn PrBp DiffBn
+ openDVS_pixel
XM$1 \$I124 RefrBp VddA18 \$I136 sky130_fd_pr__pfet_01v8 L=1.5 W=0.42 AS=0.126
+ AD=0.063 PS=1.44 PD=0.72
XM$2 VddA18 RefrBp \$I125 \$I136 sky130_fd_pr__pfet_01v8 L=1.5 W=0.42 AS=0.063
+ AD=0.126 PS=0.72 PD=1.44
XM$3 \$I144 RefrBp VddA18 \$I136 sky130_fd_pr__pfet_01v8 L=1.5 W=0.42 AS=0.126
+ AD=0.063 PS=1.44 PD=0.72
XM$4 VddA18 RefrBp \$I126 \$I136 sky130_fd_pr__pfet_01v8 L=1.5 W=0.42 AS=0.063
+ AD=0.126 PS=0.72 PD=1.44
XM$5 \$I133 \$I130 VddA18 \$I136 sky130_fd_pr__pfet_01v8 L=1.5 W=1.5 AS=0.45
+ AD=0.225 PS=3.6 PD=1.8
XM$6 VddA18 \$I129 \$I132 \$I136 sky130_fd_pr__pfet_01v8 L=1.5 W=1.5 AS=0.225
+ AD=0.45 PS=1.8 PD=3.6
XM$7 \$I131 \$I128 VddA18 \$I136 sky130_fd_pr__pfet_01v8 L=1.5 W=1.5 AS=0.45
+ AD=0.225 PS=3.6 PD=1.8
XM$8 VddA18 \$I16 \$I12 \$I136 sky130_fd_pr__pfet_01v8 L=1.5 W=1.5 AS=0.225
+ AD=0.45 PS=1.8 PD=3.6
XM$9 \$I140 PrSFBp VddA18 \$I136 sky130_fd_pr__pfet_01v8_hvt L=1.5 W=0.42
+ AS=0.126 AD=0.063 PS=1.44 PD=0.72
XM$10 VddA18 PrSFBp \$I141 \$I136 sky130_fd_pr__pfet_01v8_hvt L=1.5 W=0.42
+ AS=0.063 AD=0.126 PS=0.72 PD=1.44
XM$11 \$I146 PrSFBp VddA18 \$I136 sky130_fd_pr__pfet_01v8_hvt L=1.5 W=0.42
+ AS=0.126 AD=0.063 PS=1.44 PD=0.72
XM$12 VddA18 PrSFBp \$I142 \$I136 sky130_fd_pr__pfet_01v8_hvt L=1.5 W=0.42
+ AS=0.063 AD=0.126 PS=0.72 PD=1.44
.ENDS openDVS_pixel2x2

.SUBCKT openDVS_pixel GndD pixRst \$3 rowReadON rowReadOFF VddA18 vd vsf
+ readLine nRst vdiff GndA OffBn vpd \$32 OnBn PrBp DiffBn
XM$1 vpr PrBp VddA18 \$3 sky130_fd_pr__pfet_01v8 L=0.15 W=0.5 AS=0.15 AD=0.15
+ PS=1.6 PD=1.6
XM$2 vsf vpr \$32 \$3 sky130_fd_pr__pfet_01v8 L=0.25 W=0.42 AS=0.126 AD=0.126
+ PS=1.44 PD=1.44
XM$3 VddA18 nRst VddA18 \$3 sky130_fd_pr__pfet_01v8 L=1.5 W=1.5 AS=0.45 AD=0.42
+ PS=3.6 PD=3.56
XM$4 ON vdiff VddA18 \$3 sky130_fd_pr__pfet_01v8 L=1.5 W=1.5 AS=0.45 AD=0.225
+ PS=3.6 PD=1.8
XM$5 VddA18 vdiff nOFF \$3 sky130_fd_pr__pfet_01v8 L=1.5 W=1.5 AS=0.225 AD=0.45
+ PS=1.8 PD=3.6
XM$6 vd nRst vdiff \$3 sky130_fd_pr__pfet_01v8_hvt L=0.42 W=0.42 AS=0.126
+ AD=0.126 PS=1.44 PD=1.44
XM$7 GndA OnBn ON GndA sky130_fd_pr__nfet_01v8 L=1.5 W=1.5 AS=0.45 AD=0.45
+ PS=3.6 PD=3.6
XM$8 GndA DiffBn vdiff GndA sky130_fd_pr__nfet_01v8 L=1.5 W=1.5 AS=0.45 AD=0.45
+ PS=3.6 PD=3.6
XM$9 GndA vpd vpr GndA sky130_fd_pr__nfet_01v8 L=0.3 W=0.42 AS=0.126 AD=0.126
+ PS=1.44 PD=1.44
XM$10 GndD ON \$18 GndA sky130_fd_pr__nfet_01v8 L=0.15 W=0.42 AS=0.126 AD=0.105
+ PS=1.44 PD=0.92
XM$11 \$18 rowReadON readLine GndA sky130_fd_pr__nfet_01v8 L=0.15 W=0.42
+ AS=0.105 AD=0.105 PS=0.92 PD=0.92
XM$12 readLine rowReadOFF \$19 GndA sky130_fd_pr__nfet_01v8 L=0.15 W=0.42
+ AS=0.105 AD=0.105 PS=0.92 PD=0.92
XM$13 \$19 nOFF GndD GndA sky130_fd_pr__nfet_01v8 L=0.15 W=0.42 AS=0.105
+ AD=0.126 PS=0.92 PD=1.44
XM$14 GndA OffBn nOFF GndA sky130_fd_pr__nfet_01v8 L=1.5 W=1.5 AS=0.45 AD=0.45
+ PS=3.6 PD=3.6
XM$15 vpd vpr VddA18 GndA sky130_fd_pr__nfet_01v8 L=0.3 W=0.5 AS=0.15 AD=0.15
+ PS=1.6 PD=1.6
XM$16 nRst pixRst \$24 GndA sky130_fd_pr__nfet_01v8 L=0.15 W=0.42 AS=0.126
+ AD=0.105 PS=1.44 PD=0.92
XM$17 \$24 rowReadON GndA GndA sky130_fd_pr__nfet_01v8 L=0.15 W=0.42 AS=0.105
+ AD=0.126 PS=0.92 PD=1.44
XC$18 vdiff vd sky130_fd_pr__model__cap_mim C=2e-15 A=1 P=4
XC$19 vsf vd sky130_fd_pr__model__cap_mim C=3.75666e-14 A=18.7833 P=28.46
.ENDS openDVS_pixel
