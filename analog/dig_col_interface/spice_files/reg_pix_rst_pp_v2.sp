* SPICE netlist generated by Yosys 0.63+89 (git sha1 de99d67bb, g++ 13.3.0-6ubuntu2~24.04.1 -fPIC -O3)

.SUBCKT _extern:simplemap:_adff:CLK_POLARITY_1'1:ARST_VALUE_1'0:ARST_POLARITY_0:WIDTH_1 CLK ARST Q D
X0 CLK D ARST GND GND VDD VDD Q sky130_fd_sc_hd__dfrtp_1
.ENDS _extern:simplemap:_adff:CLK_POLARITY_1'1:ARST_VALUE_1'0:ARST_POLARITY_0:WIDTH_1

.SUBCKT _extern:simplemap:_mux:WIDTH_1 Y S B A
X0 A B S GND GND VDD VDD Y sky130_fd_sc_hd__mux2_1
.ENDS _extern:simplemap:_mux:WIDTH_1

.SUBCKT _extern:simplemap:_or:Y_WIDTH_1:B_WIDTH_1:A_WIDTH_1:B_SIGNED_0:A_SIGNED_0 Y B A
X0 A B GND GND VDD VDD Y sky130_fd_sc_hd__lpflow_inputiso1p_1
.ENDS _extern:simplemap:_or:Y_WIDTH_1:B_WIDTH_1:A_WIDTH_1:B_SIGNED_0:A_SIGNED_0

.SUBCKT _extern:simplemap:_not:Y_WIDTH_1:A_WIDTH_1:A_SIGNED_0 Y A
X0 A GND GND VDD VDD Y sky130_fd_sc_hd__clkinv_1
.ENDS _extern:simplemap:_not:Y_WIDTH_1:A_WIDTH_1:A_SIGNED_0

.SUBCKT reg_pix_rst clk rst en_on en_off evt global_pix_rst dout_on dout_off pix_rst
X0 _0_dout_on_0:0_ en_on evt dout_on _extern:simplemap:_mux:WIDTH_1
X1 _0_dout_off_0:0_ en_off evt_off dout_off _extern:simplemap:_mux:WIDTH_1
X2 pix_rst global_pix_rst _or_../v_files/reg_pix_rst.v:37_6_Y _extern:simplemap:_or:Y_WIDTH_1:B_WIDTH_1:A_WIDTH_1:B_SIGNED_0:A_SIGNED_0
X3 _or_../v_files/reg_pix_rst.v:37_6_Y dout_on dout_off _extern:simplemap:_or:Y_WIDTH_1:B_WIDTH_1:A_WIDTH_1:B_SIGNED_0:A_SIGNED_0
X4 clk rst dout_off _0_dout_off_0:0_ _extern:simplemap:_adff:CLK_POLARITY_1'1:ARST_VALUE_1'0:ARST_POLARITY_0:WIDTH_1
X5 evt_off evt _extern:simplemap:_not:Y_WIDTH_1:A_WIDTH_1:A_SIGNED_0
X6 clk rst dout_on _0_dout_on_0:0_ _extern:simplemap:_adff:CLK_POLARITY_1'1:ARST_VALUE_1'0:ARST_POLARITY_0:WIDTH_1
.ENDS reg_pix_rst

************************
* end of SPICE netlist *
************************
