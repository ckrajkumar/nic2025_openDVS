* NGSPICE file created from pixel_4tile.ext - technology: sky130A

* 2-pin LVS stub for Magic photodiode (avoids dummy_25/26)
* ps2dn 2-pin X-instance sky130_fd_pr__model__parasitic__diode_ps2dn [1 rewritten]
.subckt sky130_fd_pr__model__parasitic__diode_ps2dn PLUS MINUS
.ends

.subckt openDVS_pixel m2_32_2198# rowReadOFF m2_298_1861# m3_2210_26# m2_196_1392#
+ PrSFBp m5_n506_n512# m2_32_2482# rowReadON m2_32_2254# RefrBp m3_2462_26# m2_372_2398#
+ readLine VddA18 m3_2084_26# vpd pixRst PrBp m3_2714_26# GndD m3_2336_26# GndA OnBn
+ DiffBn OffBn m3_2588_26#
X0 a_361_187# ON GndD GndA sky130_fd_pr__nfet_01v8 ad=0.105 pd=0.92 as=0.126 ps=1.44 w=0.42 l=0.15
X1 GndD nOFF a_621_187# GndA sky130_fd_pr__nfet_01v8 ad=0.126 pd=1.44 as=0.105 ps=0.92 w=0.42 l=0.15
X2 VddA18 vpr vpd GndA sky130_fd_pr__nfet_01v8 ad=0.15 pd=1.6 as=0.15 ps=1.6 w=0.5 l=0.3
X3 GndA vpr vsf VddA18 sky130_fd_pr__pfet_01v8 ad=0.126 pd=1.44 as=0.126 ps=1.44 w=0.42 l=0.25
X4 a_95_497# pixRst nRst GndA sky130_fd_pr__nfet_01v8 ad=0.105 pd=0.92 as=0.126 ps=1.44 w=0.42 l=0.15
X5 VddA18 nRst VddA18 VddA18 sky130_fd_pr__pfet_01v8 ad=0.45 pd=3.6 as=2.202 ps=18.88 w=1.5 l=1.5
X6 vd vdiff sky130_fd_pr__cap_mim_m3_1 l=1 w=1
X7 vdiff nRst vd VddA18 sky130_fd_pr__pfet_01v8_hvt ad=0.126 pd=1.44 as=0.126 ps=1.44 w=0.42 l=0.42
XD0 GndA vpd sky130_fd_pr__model__parasitic__diode_ps2dn area=32.49
X8 nOFF OffBn GndA GndA sky130_fd_pr__nfet_01v8 ad=0.45 pd=3.6 as=0.45 ps=3.6 w=1.5 l=1.5
X9 vd vsf sky130_fd_pr__cap_mim_m3_1 l=1.505 w=6.47
X10 vpr vpd GndA GndA sky130_fd_pr__nfet_01v8 ad=0.126 pd=1.44 as=0.126 ps=1.44 w=0.42 l=0.3
X11 ON OnBn GndA GndA sky130_fd_pr__nfet_01v8 ad=0.45 pd=3.6 as=0.45 ps=3.6 w=1.5 l=1.5
X12 vdiff DiffBn GndA GndA sky130_fd_pr__nfet_01v8 ad=0.45 pd=3.6 as=0.45 ps=3.6 w=1.5 l=1.5
X13 VddA18 vdiff ON VddA18 sky130_fd_pr__pfet_01v8 ad=0.225 pd=1.8 as=0.45 ps=3.6 w=1.5 l=1.5
X14 VddA18 PrBp vpr VddA18 sky130_fd_pr__pfet_01v8 ad=0.15 pd=1.6 as=0.15 ps=1.6 w=0.5 l=0.15
X15 VddA18 vd vdiff VddA18 sky130_fd_pr__pfet_01v8 ad=0.45 pd=3.6 as=0.45 ps=3.6 w=1.5 l=1.5
X16 nOFF vdiff VddA18 VddA18 sky130_fd_pr__pfet_01v8 ad=0.45 pd=3.6 as=0.225 ps=1.8 w=1.5 l=1.5
X17 vd vsf sky130_fd_pr__cap_mim_m3_1 l=2.27 w=3.985
X18 VddA18 PrSFBp vsf VddA18 sky130_fd_pr__pfet_01v8_hvt ad=0.126 pd=1.44 as=0.126 ps=1.44 w=0.42 l=1.5
X19 a_621_187# rowReadOFF readLine GndA sky130_fd_pr__nfet_01v8 ad=0.105 pd=0.92 as=0.105 ps=0.92 w=0.42 l=0.15
X20 GndA rowReadON a_95_497# GndA sky130_fd_pr__nfet_01v8 ad=0.126 pd=1.44 as=0.105 ps=0.92 w=0.42 l=0.15
X21 readLine rowReadON a_361_187# GndA sky130_fd_pr__nfet_01v8 ad=0.105 pd=0.92 as=0.105 ps=0.92 w=0.42 l=0.15
X22 VddA18 RefrBp nRst VddA18 sky130_fd_pr__pfet_01v8 ad=0.126 pd=1.44 as=0.126 ps=1.44 w=0.42 l=1.5
.ends

.subckt openDVS_pixel2x2_bot rowReadOFF[1] rowReadOFF[0] rowReadON[0] RefrBp PrBp
+ PrSFBp readLine[0] pixRst[0] pixRst[1] readLine[1] OffBn vpd[2] vpd[3] vpd[1] vpd[0]
+ rowReadON[1] GndD DiffBn GndA VddA18 OnBn
XopenDVS_pixel_1 DiffBn rowReadOFF[1] OnBn RefrBp OffBn PrSFBp GndA GndA rowReadON[1]
+ VddA18 RefrBp PrSFBp GndA readLine[1] VddA18 OnBn vpd[3] pixRst[1] PrBp DiffBn GndD
+ PrBp GndA OnBn DiffBn OffBn OffBn openDVS_pixel
XopenDVS_pixel_2 DiffBn rowReadOFF[1] OnBn OffBn OffBn PrSFBp GndA GndA rowReadON[1]
+ VddA18 RefrBp PrBp GndA readLine[0] VddA18 DiffBn vpd[1] pixRst[0] PrBp OnBn GndD
+ PrSFBp GndA OnBn DiffBn OffBn RefrBp openDVS_pixel
XopenDVS_pixel_3 DiffBn rowReadOFF[0] OnBn RefrBp OffBn PrSFBp GndA VddA18 rowReadON[0]
+ GndA RefrBp PrSFBp GndA readLine[1] VddA18 OnBn vpd[2] pixRst[1] PrBp DiffBn GndD
+ PrBp GndA OnBn DiffBn OffBn OffBn openDVS_pixel
XopenDVS_pixel_0 DiffBn rowReadOFF[0] OnBn OffBn OffBn PrSFBp GndA VddA18 rowReadON[0]
+ GndA RefrBp PrBp GndA readLine[0] VddA18 DiffBn vpd[0] pixRst[0] PrBp OnBn GndD
+ PrSFBp GndA OnBn DiffBn OffBn RefrBp openDVS_pixel
.ends

.subckt nmos_MAG_784910779141 d s g b a_n53_0# a_200_0#
X0 a_200_0# g a_n53_0# b sky130_fd_pr__nfet_01v8 ad=0.265 pd=2.53 as=0.265 ps=2.53 w=1 l=1
.ends

.subckt pmos_MAG_784910779140 d s g b
X0 d g s b sky130_fd_pr__pfet_01v8 ad=0.265 pd=2.53 as=0.265 ps=2.53 w=1 l=1
.ends

.subckt sky130_fd_pr__nfet_01v8_9ZWGZ9 G D m1_n29_101# S VSUBS
X0 S G D VSUBS sky130_fd_pr__nfet_01v8 ad=0.29 pd=2.58 as=0.29 ps=2.58 w=1 l=0.15
.ends

.subckt sky130_fd_pr__pfet_01v8_D48SMA G D S w_n194_n264#
X0 S G D w_n194_n264# sky130_fd_pr__pfet_01v8 ad=0.58 pd=4.58 as=0.58 ps=4.58 w=2 l=1
.ends

.subckt sky130_fd_pr__nfet_01v8_ML4XRG G D m1_n67_n69# S m1_21_n69# VSUBS
X0 S G D VSUBS sky130_fd_pr__nfet_01v8 ad=0.29 pd=2.58 as=0.29 ps=2.58 w=1 l=0.15
.ends

.subckt sky130_fd_pr__nfet_01v8_V52S8A G D S VSUBS
X0 S G D VSUBS sky130_fd_pr__nfet_01v8 ad=0.29 pd=2.58 as=0.29 ps=2.58 w=1 l=1
.ends

.subckt sky130_fd_pr__pfet_01v8_U2XPXD G D w_n144_n200# S
X0 S G D w_n144_n200# sky130_fd_pr__pfet_01v8 ad=0.29 pd=2.58 as=0.29 ps=2.58 w=1 l=0.5
.ends

.subckt sky130_fd_pr__pfet_01v8_KDZMJM G D S w_n144_n198#
X0 S G D w_n144_n198# sky130_fd_pr__pfet_01v8 ad=0.29 pd=2.58 as=0.29 ps=2.58 w=1 l=0.5
.ends

.subckt sky130_fd_pr__nfet_01v8_9ZAZEB G D S VSUBS
X0 S G D VSUBS sky130_fd_pr__nfet_01v8 ad=0.29 pd=2.58 as=0.29 ps=2.58 w=1 l=0.15
.ends

.subckt dyn_comp_v1 nDETECT VDD DETECT vm vp voutn GND
Xsky130_fd_pr__nfet_01v8_9ZWGZ9_7 sky130_fd_pr__pfet_01v8_KDZMJM_3/S sky130_fd_pr__pfet_01v8_KDZMJM_2/S
+ sky130_fd_pr__pfet_01v8_KDZMJM_3/S GND GND sky130_fd_pr__nfet_01v8_9ZWGZ9
Xsky130_fd_pr__nfet_01v8_9ZWGZ9_6 sky130_fd_pr__pfet_01v8_KDZMJM_1/D sky130_fd_pr__pfet_01v8_KDZMJM_2/G
+ sky130_fd_pr__pfet_01v8_KDZMJM_1/D GND GND sky130_fd_pr__nfet_01v8_9ZWGZ9
Xsky130_fd_pr__nfet_01v8_9ZWGZ9_8 sky130_fd_pr__pfet_01v8_KDZMJM_1/D sky130_fd_pr__pfet_01v8_KDZMJM_2/G
+ sky130_fd_pr__pfet_01v8_KDZMJM_1/D GND GND sky130_fd_pr__nfet_01v8_9ZWGZ9
Xsky130_fd_pr__pfet_01v8_D48SMA_0 sky130_fd_pr__pfet_01v8_KDZMJM_2/G voutn VDD VDD
+ sky130_fd_pr__pfet_01v8_D48SMA
Xsky130_fd_pr__nfet_01v8_9ZWGZ9_9 sky130_fd_pr__pfet_01v8_KDZMJM_3/S sky130_fd_pr__pfet_01v8_KDZMJM_2/S
+ sky130_fd_pr__pfet_01v8_KDZMJM_3/S GND GND sky130_fd_pr__nfet_01v8_9ZWGZ9
Xsky130_fd_pr__pfet_01v8_D48SMA_1 sky130_fd_pr__pfet_01v8_KDZMJM_2/S voutp VDD VDD
+ sky130_fd_pr__pfet_01v8_D48SMA
Xsky130_fd_pr__nfet_01v8_ML4XRG_0 sky130_fd_pr__pfet_01v8_KDZMJM_2/S sky130_fd_pr__pfet_01v8_KDZMJM_2/G
+ sky130_fd_pr__pfet_01v8_KDZMJM_2/G GND GND GND sky130_fd_pr__nfet_01v8_ML4XRG
Xsky130_fd_pr__nfet_01v8_V52S8A_0 sky130_fd_pr__pfet_01v8_KDZMJM_2/S GND voutp GND
+ sky130_fd_pr__nfet_01v8_V52S8A
Xsky130_fd_pr__nfet_01v8_ML4XRG_1 sky130_fd_pr__pfet_01v8_KDZMJM_2/G GND GND sky130_fd_pr__pfet_01v8_KDZMJM_2/S
+ sky130_fd_pr__pfet_01v8_KDZMJM_2/S GND sky130_fd_pr__nfet_01v8_ML4XRG
Xsky130_fd_pr__nfet_01v8_V52S8A_1 sky130_fd_pr__pfet_01v8_KDZMJM_2/G voutn GND GND
+ sky130_fd_pr__nfet_01v8_V52S8A
Xsky130_fd_pr__pfet_01v8_U2XPXD_0 nDETECT VDD VDD sky130_fd_pr__pfet_01v8_U2XPXD_0/S
+ sky130_fd_pr__pfet_01v8_U2XPXD
Xsky130_fd_pr__pfet_01v8_KDZMJM_0 sky130_fd_pr__pfet_01v8_KDZMJM_2/S sky130_fd_pr__pfet_01v8_KDZMJM_2/G
+ sky130_fd_pr__pfet_01v8_U2XPXD_0/S VDD sky130_fd_pr__pfet_01v8_KDZMJM
Xsky130_fd_pr__pfet_01v8_KDZMJM_1 DETECT sky130_fd_pr__pfet_01v8_KDZMJM_1/D VDD VDD
+ sky130_fd_pr__pfet_01v8_KDZMJM
Xsky130_fd_pr__pfet_01v8_KDZMJM_2 sky130_fd_pr__pfet_01v8_KDZMJM_2/G sky130_fd_pr__pfet_01v8_U2XPXD_0/S
+ sky130_fd_pr__pfet_01v8_KDZMJM_2/S VDD sky130_fd_pr__pfet_01v8_KDZMJM
Xsky130_fd_pr__pfet_01v8_KDZMJM_3 DETECT VDD sky130_fd_pr__pfet_01v8_KDZMJM_3/S VDD
+ sky130_fd_pr__pfet_01v8_KDZMJM
Xsky130_fd_pr__nfet_01v8_9ZAZEB_0 DETECT GND sky130_fd_pr__nfet_01v8_9ZWGZ9_2/D GND
+ sky130_fd_pr__nfet_01v8_9ZAZEB
Xsky130_fd_pr__nfet_01v8_9ZWGZ9_0 sky130_fd_pr__pfet_01v8_KDZMJM_1/D GND sky130_fd_pr__pfet_01v8_KDZMJM_1/D
+ sky130_fd_pr__pfet_01v8_KDZMJM_2/G GND sky130_fd_pr__nfet_01v8_9ZWGZ9
Xsky130_fd_pr__nfet_01v8_9ZWGZ9_1 vm sky130_fd_pr__pfet_01v8_KDZMJM_3/S vm sky130_fd_pr__nfet_01v8_9ZWGZ9_2/D
+ GND sky130_fd_pr__nfet_01v8_9ZWGZ9
Xsky130_fd_pr__nfet_01v8_9ZWGZ9_2 vp sky130_fd_pr__nfet_01v8_9ZWGZ9_2/D vp sky130_fd_pr__pfet_01v8_KDZMJM_1/D
+ GND sky130_fd_pr__nfet_01v8_9ZWGZ9
Xsky130_fd_pr__nfet_01v8_9ZWGZ9_3 sky130_fd_pr__pfet_01v8_KDZMJM_3/S sky130_fd_pr__pfet_01v8_KDZMJM_2/S
+ sky130_fd_pr__pfet_01v8_KDZMJM_3/S GND GND sky130_fd_pr__nfet_01v8_9ZWGZ9
Xsky130_fd_pr__nfet_01v8_9ZWGZ9_4 sky130_fd_pr__pfet_01v8_KDZMJM_1/D GND sky130_fd_pr__pfet_01v8_KDZMJM_1/D
+ sky130_fd_pr__pfet_01v8_KDZMJM_2/G GND sky130_fd_pr__nfet_01v8_9ZWGZ9
Xsky130_fd_pr__nfet_01v8_9ZWGZ9_5 sky130_fd_pr__pfet_01v8_KDZMJM_3/S sky130_fd_pr__pfet_01v8_KDZMJM_2/S
+ sky130_fd_pr__pfet_01v8_KDZMJM_3/S GND GND sky130_fd_pr__nfet_01v8_9ZWGZ9
.ends

.subckt col_periphery VDD COL_LINE VTHRESH voutn pixRst nDETECT NCHARGE DETECT dyn_comp_v1_0/vp
+ GND
Xnmos_MAG_784910779141_0 nmos_MAG_784910779141_0/d nmos_MAG_784910779141_0/s dyn_comp_v1_0/vp
+ GND COL_LINE dyn_comp_v1_0/vp nmos_MAG_784910779141
Xnmos_MAG_784910779141_1 nmos_MAG_784910779141_1/d nmos_MAG_784910779141_1/s dyn_comp_v1_0/vp
+ GND COL_LINE dyn_comp_v1_0/vp nmos_MAG_784910779141
Xnmos_MAG_784910779141_2 nmos_MAG_784910779141_2/d nmos_MAG_784910779141_2/s dyn_comp_v1_0/vp
+ GND COL_LINE dyn_comp_v1_0/vp nmos_MAG_784910779141
Xnmos_MAG_784910779141_3 nmos_MAG_784910779141_3/d nmos_MAG_784910779141_3/s dyn_comp_v1_0/vp
+ GND COL_LINE dyn_comp_v1_0/vp nmos_MAG_784910779141
Xnmos_MAG_784910779141_4 nmos_MAG_784910779141_4/d nmos_MAG_784910779141_4/s dyn_comp_v1_0/vp
+ GND COL_LINE dyn_comp_v1_0/vp nmos_MAG_784910779141
Xnmos_MAG_784910779141_5 nmos_MAG_784910779141_5/d nmos_MAG_784910779141_5/s dyn_comp_v1_0/vp
+ GND COL_LINE dyn_comp_v1_0/vp nmos_MAG_784910779141
Xpmos_MAG_784910779140_0 dyn_comp_v1_0/vp VDD NCHARGE VDD pmos_MAG_784910779140
Xnmos_MAG_784910779141_6 nmos_MAG_784910779141_6/d nmos_MAG_784910779141_6/s dyn_comp_v1_0/vp
+ GND COL_LINE dyn_comp_v1_0/vp nmos_MAG_784910779141
Xpmos_MAG_784910779140_1 dyn_comp_v1_0/vp VDD NCHARGE VDD pmos_MAG_784910779140
Xnmos_MAG_784910779141_7 nmos_MAG_784910779141_7/d nmos_MAG_784910779141_7/s dyn_comp_v1_0/vp
+ GND COL_LINE dyn_comp_v1_0/vp nmos_MAG_784910779141
Xnmos_MAG_784910779141_8 nmos_MAG_784910779141_8/d nmos_MAG_784910779141_8/s dyn_comp_v1_0/vp
+ GND COL_LINE dyn_comp_v1_0/vp nmos_MAG_784910779141
Xpmos_MAG_784910779140_2 dyn_comp_v1_0/vp VDD NCHARGE VDD pmos_MAG_784910779140
Xpmos_MAG_784910779140_3 dyn_comp_v1_0/vp VDD NCHARGE VDD pmos_MAG_784910779140
Xnmos_MAG_784910779141_9 nmos_MAG_784910779141_9/d nmos_MAG_784910779141_9/s dyn_comp_v1_0/vp
+ GND COL_LINE dyn_comp_v1_0/vp nmos_MAG_784910779141
Xpmos_MAG_784910779140_4 dyn_comp_v1_0/vp VDD NCHARGE VDD pmos_MAG_784910779140
Xpmos_MAG_784910779140_5 dyn_comp_v1_0/vp VDD NCHARGE VDD pmos_MAG_784910779140
Xpmos_MAG_784910779140_6 dyn_comp_v1_0/vp VDD NCHARGE VDD pmos_MAG_784910779140
Xpmos_MAG_784910779140_7 dyn_comp_v1_0/vp VDD NCHARGE VDD pmos_MAG_784910779140
Xdyn_comp_v1_0 nDETECT VDD DETECT VTHRESH dyn_comp_v1_0/vp voutn GND dyn_comp_v1
Xnmos_MAG_784910779141_10 nmos_MAG_784910779141_10/d nmos_MAG_784910779141_10/s dyn_comp_v1_0/vp
+ GND COL_LINE dyn_comp_v1_0/vp nmos_MAG_784910779141
Xnmos_MAG_784910779141_11 nmos_MAG_784910779141_11/d nmos_MAG_784910779141_11/s dyn_comp_v1_0/vp
+ GND COL_LINE dyn_comp_v1_0/vp nmos_MAG_784910779141
Xnmos_MAG_784910779141_12 nmos_MAG_784910779141_12/d nmos_MAG_784910779141_12/s dyn_comp_v1_0/vp
+ GND COL_LINE dyn_comp_v1_0/vp nmos_MAG_784910779141
Xnmos_MAG_784910779141_13 nmos_MAG_784910779141_13/d nmos_MAG_784910779141_13/s dyn_comp_v1_0/vp
+ GND COL_LINE dyn_comp_v1_0/vp nmos_MAG_784910779141
Xnmos_MAG_784910779141_14 nmos_MAG_784910779141_14/d nmos_MAG_784910779141_14/s dyn_comp_v1_0/vp
+ GND COL_LINE dyn_comp_v1_0/vp nmos_MAG_784910779141
Xnmos_MAG_784910779141_15 nmos_MAG_784910779141_15/d nmos_MAG_784910779141_15/s dyn_comp_v1_0/vp
+ GND COL_LINE dyn_comp_v1_0/vp nmos_MAG_784910779141
.ends

.subckt col_periphery_1x2 pixRst1 COL_LINE0 COL_LINE1 nDETECT DETECT VDD VTHRESH pixRst0
+ voutn0 GND voutn1 NCHARGE
Xcol_periphery_0 VDD COL_LINE0 VTHRESH voutn0 pixRst0 nDETECT NCHARGE DETECT col_periphery_0/dyn_comp_v1_0/vp
+ GND col_periphery
Xcol_periphery_1 VDD COL_LINE1 VTHRESH voutn1 pixRst1 nDETECT NCHARGE DETECT col_periphery_1/dyn_comp_v1_0/vp
+ GND col_periphery
.ends

.subckt pixel_layout_tile_bot rowReadON<61> rowReadON<60> rowReadON<59> rowReadON<58>
+ rowReadON<57> rowReadON<56> rowReadON<55> rowReadON<54> rowReadON<53> rowReadON<52>
+ rowReadON<51> rowReadON<50> rowReadON<47> rowReadON<42> rowReadON<39> rowReadON<37>
+ rowReadON<36> rowReadON<33> rowReadON<32> rowReadON<31> rowReadOFF<63> rowReadOFF<62>
+ rowReadOFF<61> rowReadOFF<60> rowReadOFF<57> rowReadOFF<56> rowReadOFF<51> rowReadOFF<50>
+ rowReadOFF<49> rowReadOFF<48> rowReadOFF<46> rowReadOFF<45> rowReadOFF<44> rowReadOFF<43>
+ rowReadOFF<42> rowReadOFF<41> rowReadOFF<40> rowReadOFF<39> rowReadOFF<37> rowReadOFF<35>
+ rowReadOFF<34> rowReadON<21> rowReadON<20> rowReadON<19> rowReadON<18> rowReadON<17>
+ rowReadON<16> rowReadON<15> rowReadON<14> rowReadOFF<29> rowReadOFF<27> rowReadOFF<26>
+ rowReadOFF<25> rowReadOFF<24> rowReadOFF<21> rowReadOFF<20> rowReadON<7> rowReadON<6>
+ rowReadON<11> rowReadON<10> rowReadOFF<9> rowReadOFF<8> rowReadOFF<7> rowReadOFF<6>
+ rowReadOFF<5> rowReadOFF<4> rowReadON<3> rowReadOFF<3> rowReadOFF<2> GND nDETECT
+ voutn<7> pixRst<3> pixRst<4> pixRst<5> pixRst<6> pixRst<7> pixRst<0> voutn<10> voutn<9>
+ voutn<8> pixRst<10> pixRst<11> pixRst<12> pixRst<13> pixRst<8> pixRst<9> pixRst<14>
+ pixRst<29> pixRst<19> pixRst<20> pixRst<28> pixRst<27> voutn<28> pixRst<31> pixRst<30>
+ voutn<48> voutn<49> pixRst<39> pixRst<55> pixRst<42> pixRst<41> pixRst<49> pixRst<40>
+ pixRst<63> pixRst<44> pixRst<62> pixRst<61> pixRst<56> voutn<60> voutn<44> voutn<61>
+ voutn<62> voutn<63> m1_27543_n208# m1_22743_n208# rowReadON<41> rowReadON<40> m1_152343_n208#
+ m1_8343_n208# m1_89943_n208# m1_3543_n208# m1_128343_n208# m1_123543_n208# m1_61143_n208#
+ rowReadOFF<15> rowReadON<46> rowReadOFF<31> rowReadOFF<14> rowReadON<23> openDVS_pixel2x2_bot_91/GndD
+ rowReadOFF<30> rowReadON<22> m1_37143_n208# m1_32343_n208# pixRst<54> rowReadON<27>
+ openDVS_pixel2x2_bot_991/GndD pixRst<53> rowReadOFF<36> voutn<53> pixRst<18> voutn<16>
+ pixRst<17> rowReadON<26> voutn<51> openDVS_pixel2x2_bot_925/GndD openDVS_pixel2x2_bot_902/GndD
+ m1_99543_n208# rowReadOFF<53> rowReadOFF<38> pixRst<38> m1_94743_n208# pixRst<37>
+ voutn<36> rowReadOFF<52> openDVS_pixel2x2_bot_95/GndD openDVS_pixel2x2_bot_885/GndD
+ m1_133143_n208# openDVS_pixel2x2_bot_97/GndD m1_65943_n208# rowReadOFF<11> m1_109143_n208#
+ rowReadOFF<19> m1_104343_n208# rowReadON<49> rowReadOFF<10> rowReadOFF<18> pixRst<52>
+ pixRst<51> pixRst<16> rowReadON<48> voutn<34> voutn<15> openDVS_pixel2x2_bot_69/GndD
+ openDVS_pixel2x2_bot_7/GndD voutn<14> pixRst<36> pixRst<35> openDVS_pixel2x2_bot_937/GndD
+ rowReadOFF<1> openDVS_pixel2x2_bot_989/GndD m1_13143_n208# rowReadOFF<17> rowReadON<9>
+ openDVS_pixel2x2_bot_906/GndD rowReadOFF<0> openDVS_pixel2x2_bot_939/GndD pixRst<33>
+ rowReadOFF<55> rowReadOFF<16> rowReadON<8> pixRst<15> voutn<2> openDVS_pixel2x2_bot_99/GndD
+ rowReadON<13> openDVS_pixel2x2_bot_927/GndD rowReadOFF<54> voutn<17> m1_137943_n208#
+ pixRst<60> openDVS_pixel2x2_bot_888/GndD m1_75543_n208# rowReadON<12> pixRst<59>
+ voutn<56> voutn<24> m1_70743_n208# pixRst<23> openDVS_pixel2x2_bot_997/GndD voutn<57>
+ pixRst<26> pixRst<25> voutn<25> pixRst<50> voutn<13> openDVS_pixel2x2_bot_995/GndD
+ openDVS_pixel2x2_bot_6/GndD rowReadON<38> voutn<6> voutn<52> pixRst<48> pixRst<47>
+ openDVS_pixel2x2_bot_82/GndD voutn<12> m1_46743_n208# openDVS_pixel2x2_bot_929/GndD
+ m1_41943_n208# rowReadON<63> voutn<0> voutn<21> voutn<42> voutn<3> pixRst<34> voutn<50>
+ rowReadON<62> rowReadOFF<33> rowReadOFF<23> voutn<32> voutn<45> pixRst<32> voutn<55>
+ rowReadON<25> voutn<4> pixRst<43> rowReadOFF<28> rowReadOFF<32> m1_17943_n208# voutn<1>
+ rowReadOFF<22> voutn<33> voutn<58> openDVS_pixel2x2_bot_999/GndD rowReadON<24> voutn<11>
+ pixRst<2> voutn<5> voutn<26> pixRst<1> voutn<39> m1_147543_n208# pixRst<58> voutn<54>
+ voutn<38> pixRst<57> openDVS_pixel2x2_bot_78/GndD m1_85143_n208# voutn<59> m1_142743_n208#
+ rowReadON<1> pixRst<22> rowReadOFF<59> rowReadON<45> openDVS_pixel2x2_bot_923/GndD
+ pixRst<21> voutn<43> voutn<27> m1_80343_n208# openDVS_pixel2x2_bot_79/GndD openDVS_pixel2x2_bot_993/GndD
+ pixRst<24> rowReadON<0> openDVS_pixel2x2_bot_890/GndD rowReadOFF<58> rowReadON<44>
+ openDVS_pixel2x2_bot_882/GndD rowReadON<35> voutn<23> rowReadON<29> voutn<37> voutn<46>
+ voutn<31> openDVS_pixel2x2_bot_987/GndD voutn<22> rowReadOFF<13> pixRst<46> VTHRESH
+ voutn<29> pixRst<45> rowReadON<34> rowReadON<28> m1_118743_n208# PrSFBp voutn<30>
+ voutn<41> rowReadON<5> voutn<19> voutn<40> openDVS_pixel2x2_bot_886/GndD voutn<47>
+ rowReadOFF<12> openDVS_pixel2x2_bot_908/GndD m1_56343_n208# m1_113943_n208# rowReadON<30>
+ PrBp voutn<35> DETECT col_periphery_1x2_9/VDD voutn<20> m1_51543_n208# rowReadON<4>
+ voutn<18> rowReadON<2> DiffBn rowReadOFF<47> NCHARGE rowReadON<43> OffBn VDD VSUBS
+ OnBn RefrBp
XopenDVS_pixel2x2_bot_574 rowReadOFF<60> rowReadOFF<61> rowReadON<61> RefrBp PrBp
+ PrSFBp col_periphery_1x2_21/COL_LINE0 pixRst<26> pixRst<27> col_periphery_1x2_21/COL_LINE1
+ OffBn openDVS_pixel2x2_bot_574/vpd[2] openDVS_pixel2x2_bot_574/vpd[3] openDVS_pixel2x2_bot_574/vpd[1]
+ openDVS_pixel2x2_bot_574/vpd[0] rowReadON<60> openDVS_pixel2x2_bot_902/GndD DiffBn
+ VSUBS VDD OnBn openDVS_pixel2x2_bot
XopenDVS_pixel2x2_bot_596 rowReadOFF<62> rowReadOFF<63> rowReadON<63> RefrBp PrBp
+ PrSFBp col_periphery_1x2_20/COL_LINE0 pixRst<24> pixRst<25> col_periphery_1x2_20/COL_LINE1
+ OffBn openDVS_pixel2x2_bot_596/vpd[2] openDVS_pixel2x2_bot_596/vpd[3] openDVS_pixel2x2_bot_596/vpd[1]
+ openDVS_pixel2x2_bot_596/vpd[0] rowReadON<62> openDVS_pixel2x2_bot_886/GndD DiffBn
+ VSUBS VDD OnBn openDVS_pixel2x2_bot
XopenDVS_pixel2x2_bot_530 rowReadOFF<56> rowReadOFF<57> rowReadON<57> RefrBp PrBp
+ PrSFBp col_periphery_1x2_28/COL_LINE0 pixRst<8> pixRst<9> col_periphery_1x2_28/COL_LINE1
+ OffBn openDVS_pixel2x2_bot_530/vpd[2] openDVS_pixel2x2_bot_530/vpd[3] openDVS_pixel2x2_bot_530/vpd[1]
+ openDVS_pixel2x2_bot_530/vpd[0] rowReadON<56> openDVS_pixel2x2_bot_888/GndD DiffBn
+ VSUBS VDD OnBn openDVS_pixel2x2_bot
XopenDVS_pixel2x2_bot_541 rowReadOFF<62> rowReadOFF<63> rowReadON<63> RefrBp PrBp
+ PrSFBp col_periphery_1x2_28/COL_LINE0 pixRst<8> pixRst<9> col_periphery_1x2_28/COL_LINE1
+ OffBn openDVS_pixel2x2_bot_541/vpd[2] openDVS_pixel2x2_bot_541/vpd[3] openDVS_pixel2x2_bot_541/vpd[1]
+ openDVS_pixel2x2_bot_541/vpd[0] rowReadON<62> openDVS_pixel2x2_bot_886/GndD DiffBn
+ VSUBS VDD OnBn openDVS_pixel2x2_bot
XopenDVS_pixel2x2_bot_552 rowReadOFF<54> rowReadOFF<55> rowReadON<55> RefrBp PrBp
+ PrSFBp col_periphery_1x2_24/COL_LINE0 pixRst<0> pixRst<1> col_periphery_1x2_24/COL_LINE1
+ OffBn openDVS_pixel2x2_bot_552/vpd[2] openDVS_pixel2x2_bot_552/vpd[3] openDVS_pixel2x2_bot_552/vpd[1]
+ openDVS_pixel2x2_bot_552/vpd[0] rowReadON<54> openDVS_pixel2x2_bot_885/GndD DiffBn
+ VSUBS VDD OnBn openDVS_pixel2x2_bot
XopenDVS_pixel2x2_bot_585 rowReadOFF<48> rowReadOFF<49> rowReadON<49> RefrBp PrBp
+ PrSFBp col_periphery_1x2_20/COL_LINE0 pixRst<24> pixRst<25> col_periphery_1x2_20/COL_LINE1
+ OffBn openDVS_pixel2x2_bot_585/vpd[2] openDVS_pixel2x2_bot_585/vpd[3] openDVS_pixel2x2_bot_585/vpd[1]
+ openDVS_pixel2x2_bot_585/vpd[0] rowReadON<48> openDVS_pixel2x2_bot_927/GndD DiffBn
+ VSUBS VDD OnBn openDVS_pixel2x2_bot
XopenDVS_pixel2x2_bot_563 rowReadOFF<52> rowReadOFF<53> rowReadON<53> RefrBp PrBp
+ PrSFBp col_periphery_1x2_19/COL_LINE0 pixRst<22> pixRst<23> col_periphery_1x2_19/COL_LINE1
+ OffBn openDVS_pixel2x2_bot_563/vpd[2] openDVS_pixel2x2_bot_563/vpd[3] openDVS_pixel2x2_bot_563/vpd[1]
+ openDVS_pixel2x2_bot_563/vpd[0] rowReadON<52> openDVS_pixel2x2_bot_882/GndD DiffBn
+ VSUBS VDD OnBn openDVS_pixel2x2_bot
XopenDVS_pixel2x2_bot_393 rowReadOFF<40> rowReadOFF<41> rowReadON<41> RefrBp PrBp
+ PrSFBp col_periphery_1x2_19/COL_LINE0 pixRst<22> pixRst<23> col_periphery_1x2_19/COL_LINE1
+ OffBn openDVS_pixel2x2_bot_393/vpd[2] openDVS_pixel2x2_bot_393/vpd[3] openDVS_pixel2x2_bot_393/vpd[1]
+ openDVS_pixel2x2_bot_393/vpd[0] rowReadON<40> openDVS_pixel2x2_bot_906/GndD DiffBn
+ VSUBS VDD OnBn openDVS_pixel2x2_bot
XopenDVS_pixel2x2_bot_382 rowReadOFF<16> rowReadOFF<17> rowReadON<17> RefrBp PrBp
+ PrSFBp col_periphery_1x2_16/COL_LINE0 pixRst<16> pixRst<17> col_periphery_1x2_16/COL_LINE1
+ OffBn openDVS_pixel2x2_bot_382/vpd[2] openDVS_pixel2x2_bot_382/vpd[3] openDVS_pixel2x2_bot_382/vpd[1]
+ openDVS_pixel2x2_bot_382/vpd[0] rowReadON<16> openDVS_pixel2x2_bot_91/GndD DiffBn
+ VSUBS VDD OnBn openDVS_pixel2x2_bot
XopenDVS_pixel2x2_bot_360 rowReadOFF<8> rowReadOFF<9> rowReadON<9> RefrBp PrBp PrSFBp
+ col_periphery_1x2_24/COL_LINE0 pixRst<0> pixRst<1> col_periphery_1x2_24/COL_LINE1
+ OffBn openDVS_pixel2x2_bot_360/vpd[2] openDVS_pixel2x2_bot_360/vpd[3] openDVS_pixel2x2_bot_360/vpd[1]
+ openDVS_pixel2x2_bot_360/vpd[0] rowReadON<8> openDVS_pixel2x2_bot_939/GndD DiffBn
+ VSUBS VDD OnBn openDVS_pixel2x2_bot
XopenDVS_pixel2x2_bot_371 rowReadOFF<8> rowReadOFF<9> rowReadON<9> RefrBp PrBp PrSFBp
+ col_periphery_1x2_19/COL_LINE0 pixRst<22> pixRst<23> col_periphery_1x2_19/COL_LINE1
+ OffBn openDVS_pixel2x2_bot_371/vpd[2] openDVS_pixel2x2_bot_371/vpd[3] openDVS_pixel2x2_bot_371/vpd[1]
+ openDVS_pixel2x2_bot_371/vpd[0] rowReadON<8> openDVS_pixel2x2_bot_939/GndD DiffBn
+ VSUBS VDD OnBn openDVS_pixel2x2_bot
XopenDVS_pixel2x2_bot_190 rowReadOFF<12> rowReadOFF<13> rowReadON<13> RefrBp PrBp
+ PrSFBp col_periphery_1x2_14/COL_LINE0 pixRst<46> pixRst<47> col_periphery_1x2_14/COL_LINE1
+ OffBn openDVS_pixel2x2_bot_190/vpd[2] openDVS_pixel2x2_bot_190/vpd[3] openDVS_pixel2x2_bot_190/vpd[1]
+ openDVS_pixel2x2_bot_190/vpd[0] rowReadON<12> openDVS_pixel2x2_bot_79/GndD DiffBn
+ VSUBS VDD OnBn openDVS_pixel2x2_bot
XopenDVS_pixel2x2_bot_915 rowReadOFF<44> rowReadOFF<45> rowReadON<45> RefrBp PrBp
+ PrSFBp col_periphery_1x2_14/COL_LINE0 pixRst<46> pixRst<47> col_periphery_1x2_14/COL_LINE1
+ OffBn openDVS_pixel2x2_bot_915/vpd[2] openDVS_pixel2x2_bot_915/vpd[3] openDVS_pixel2x2_bot_915/vpd[1]
+ openDVS_pixel2x2_bot_915/vpd[0] rowReadON<44> openDVS_pixel2x2_bot_923/GndD DiffBn
+ VSUBS VDD OnBn openDVS_pixel2x2_bot
XopenDVS_pixel2x2_bot_926 rowReadOFF<48> rowReadOFF<49> rowReadON<49> RefrBp PrBp
+ PrSFBp col_periphery_1x2_14/COL_LINE0 pixRst<46> pixRst<47> col_periphery_1x2_14/COL_LINE1
+ OffBn openDVS_pixel2x2_bot_926/vpd[2] openDVS_pixel2x2_bot_926/vpd[3] openDVS_pixel2x2_bot_926/vpd[1]
+ openDVS_pixel2x2_bot_926/vpd[0] rowReadON<48> openDVS_pixel2x2_bot_927/GndD DiffBn
+ VSUBS VDD OnBn openDVS_pixel2x2_bot
XopenDVS_pixel2x2_bot_904 rowReadOFF<38> rowReadOFF<39> rowReadON<39> RefrBp PrBp
+ PrSFBp col_periphery_1x2_15/COL_LINE0 pixRst<48> pixRst<49> col_periphery_1x2_15/COL_LINE1
+ OffBn openDVS_pixel2x2_bot_904/vpd[2] openDVS_pixel2x2_bot_904/vpd[3] openDVS_pixel2x2_bot_904/vpd[1]
+ openDVS_pixel2x2_bot_904/vpd[0] rowReadON<38> openDVS_pixel2x2_bot_999/GndD DiffBn
+ VSUBS VDD OnBn openDVS_pixel2x2_bot
XopenDVS_pixel2x2_bot_959 rowReadOFF<26> rowReadOFF<27> rowReadON<27> RefrBp PrBp
+ PrSFBp col_periphery_1x2_27/COL_LINE0 pixRst<6> pixRst<7> col_periphery_1x2_27/COL_LINE1
+ OffBn openDVS_pixel2x2_bot_959/vpd[2] openDVS_pixel2x2_bot_959/vpd[3] openDVS_pixel2x2_bot_959/vpd[1]
+ openDVS_pixel2x2_bot_959/vpd[0] rowReadON<26> openDVS_pixel2x2_bot_987/GndD DiffBn
+ VSUBS VDD OnBn openDVS_pixel2x2_bot
XopenDVS_pixel2x2_bot_948 rowReadOFF<18> rowReadOFF<19> rowReadON<19> RefrBp PrBp
+ PrSFBp col_periphery_1x2_23/COL_LINE0 pixRst<30> pixRst<31> col_periphery_1x2_23/COL_LINE1
+ OffBn openDVS_pixel2x2_bot_948/vpd[2] openDVS_pixel2x2_bot_948/vpd[3] openDVS_pixel2x2_bot_948/vpd[1]
+ openDVS_pixel2x2_bot_948/vpd[0] rowReadON<18> openDVS_pixel2x2_bot_69/GndD DiffBn
+ VSUBS VDD OnBn openDVS_pixel2x2_bot
XopenDVS_pixel2x2_bot_937 rowReadOFF<6> rowReadOFF<7> rowReadON<7> RefrBp PrBp PrSFBp
+ col_periphery_1x2_9/COL_LINE0 pixRst<32> pixRst<33> col_periphery_1x2_9/COL_LINE1
+ OffBn openDVS_pixel2x2_bot_937/vpd[2] openDVS_pixel2x2_bot_937/vpd[3] openDVS_pixel2x2_bot_937/vpd[1]
+ openDVS_pixel2x2_bot_937/vpd[0] rowReadON<6> openDVS_pixel2x2_bot_937/GndD DiffBn
+ VSUBS VDD OnBn openDVS_pixel2x2_bot
XopenDVS_pixel2x2_bot_778 rowReadOFF<54> rowReadOFF<55> rowReadON<55> RefrBp PrBp
+ PrSFBp col_periphery_1x2_7/COL_LINE0 pixRst<40> pixRst<41> col_periphery_1x2_7/COL_LINE1
+ OffBn openDVS_pixel2x2_bot_778/vpd[2] openDVS_pixel2x2_bot_778/vpd[3] openDVS_pixel2x2_bot_778/vpd[1]
+ openDVS_pixel2x2_bot_778/vpd[0] rowReadON<54> openDVS_pixel2x2_bot_885/GndD DiffBn
+ VSUBS VDD OnBn openDVS_pixel2x2_bot
XopenDVS_pixel2x2_bot_789 rowReadOFF<50> rowReadOFF<51> rowReadON<51> RefrBp PrBp
+ PrSFBp col_periphery_1x2_13/COL_LINE0 pixRst<44> pixRst<45> col_periphery_1x2_13/COL_LINE1
+ OffBn openDVS_pixel2x2_bot_789/vpd[2] openDVS_pixel2x2_bot_789/vpd[3] openDVS_pixel2x2_bot_789/vpd[1]
+ openDVS_pixel2x2_bot_789/vpd[0] rowReadON<50> openDVS_pixel2x2_bot_929/GndD DiffBn
+ VSUBS VDD OnBn openDVS_pixel2x2_bot
XopenDVS_pixel2x2_bot_767 rowReadOFF<50> rowReadOFF<51> rowReadON<51> RefrBp PrBp
+ PrSFBp col_periphery_1x2_11/COL_LINE0 pixRst<36> pixRst<37> col_periphery_1x2_11/COL_LINE1
+ OffBn openDVS_pixel2x2_bot_767/vpd[2] openDVS_pixel2x2_bot_767/vpd[3] openDVS_pixel2x2_bot_767/vpd[1]
+ openDVS_pixel2x2_bot_767/vpd[0] rowReadON<50> openDVS_pixel2x2_bot_929/GndD DiffBn
+ VSUBS VDD OnBn openDVS_pixel2x2_bot
XopenDVS_pixel2x2_bot_701 rowReadOFF<36> rowReadOFF<37> rowReadON<37> RefrBp PrBp
+ PrSFBp col_periphery_1x2_3/COL_LINE0 pixRst<56> pixRst<57> col_periphery_1x2_3/COL_LINE1
+ OffBn openDVS_pixel2x2_bot_701/vpd[2] openDVS_pixel2x2_bot_701/vpd[3] openDVS_pixel2x2_bot_701/vpd[1]
+ openDVS_pixel2x2_bot_701/vpd[0] rowReadON<36> openDVS_pixel2x2_bot_997/GndD DiffBn
+ VSUBS VDD OnBn openDVS_pixel2x2_bot
XopenDVS_pixel2x2_bot_723 rowReadOFF<36> rowReadOFF<37> rowReadON<37> RefrBp PrBp
+ PrSFBp col_periphery_1x2_7/COL_LINE0 pixRst<40> pixRst<41> col_periphery_1x2_7/COL_LINE1
+ OffBn openDVS_pixel2x2_bot_723/vpd[2] openDVS_pixel2x2_bot_723/vpd[3] openDVS_pixel2x2_bot_723/vpd[1]
+ openDVS_pixel2x2_bot_723/vpd[0] rowReadON<36> openDVS_pixel2x2_bot_997/GndD DiffBn
+ VSUBS VDD OnBn openDVS_pixel2x2_bot
XopenDVS_pixel2x2_bot_745 rowReadOFF<38> rowReadOFF<39> rowReadON<39> RefrBp PrBp
+ PrSFBp col_periphery_1x2_7/COL_LINE0 pixRst<40> pixRst<41> col_periphery_1x2_7/COL_LINE1
+ OffBn openDVS_pixel2x2_bot_745/vpd[2] openDVS_pixel2x2_bot_745/vpd[3] openDVS_pixel2x2_bot_745/vpd[1]
+ openDVS_pixel2x2_bot_745/vpd[0] rowReadON<38> openDVS_pixel2x2_bot_999/GndD DiffBn
+ VSUBS VDD OnBn openDVS_pixel2x2_bot
XopenDVS_pixel2x2_bot_734 rowReadOFF<42> rowReadOFF<43> rowReadON<43> RefrBp PrBp
+ PrSFBp col_periphery_1x2_12/COL_LINE0 pixRst<38> pixRst<39> col_periphery_1x2_12/COL_LINE1
+ OffBn openDVS_pixel2x2_bot_734/vpd[2] openDVS_pixel2x2_bot_734/vpd[3] openDVS_pixel2x2_bot_734/vpd[1]
+ openDVS_pixel2x2_bot_734/vpd[0] rowReadON<42> openDVS_pixel2x2_bot_908/GndD DiffBn
+ VSUBS VDD OnBn openDVS_pixel2x2_bot
XopenDVS_pixel2x2_bot_756 rowReadOFF<42> rowReadOFF<43> rowReadON<43> RefrBp PrBp
+ PrSFBp col_periphery_1x2_10/COL_LINE0 pixRst<34> pixRst<35> col_periphery_1x2_10/COL_LINE1
+ OffBn openDVS_pixel2x2_bot_756/vpd[2] openDVS_pixel2x2_bot_756/vpd[3] openDVS_pixel2x2_bot_756/vpd[1]
+ openDVS_pixel2x2_bot_756/vpd[0] rowReadON<42> openDVS_pixel2x2_bot_908/GndD DiffBn
+ VSUBS VDD OnBn openDVS_pixel2x2_bot
XopenDVS_pixel2x2_bot_712 rowReadOFF<32> rowReadOFF<33> rowReadON<33> RefrBp PrBp
+ PrSFBp col_periphery_1x2_6/COL_LINE0 pixRst<62> pixRst<63> col_periphery_1x2_6/COL_LINE1
+ OffBn openDVS_pixel2x2_bot_712/vpd[2] openDVS_pixel2x2_bot_712/vpd[3] openDVS_pixel2x2_bot_712/vpd[1]
+ openDVS_pixel2x2_bot_712/vpd[0] rowReadON<32> openDVS_pixel2x2_bot_993/GndD DiffBn
+ VSUBS VDD OnBn openDVS_pixel2x2_bot
XopenDVS_pixel2x2_bot_575 rowReadOFF<60> rowReadOFF<61> rowReadON<61> RefrBp PrBp
+ PrSFBp col_periphery_1x2_22/COL_LINE0 pixRst<28> pixRst<29> col_periphery_1x2_22/COL_LINE1
+ OffBn openDVS_pixel2x2_bot_575/vpd[2] openDVS_pixel2x2_bot_575/vpd[3] openDVS_pixel2x2_bot_575/vpd[1]
+ openDVS_pixel2x2_bot_575/vpd[0] rowReadON<60> openDVS_pixel2x2_bot_902/GndD DiffBn
+ VSUBS VDD OnBn openDVS_pixel2x2_bot
XopenDVS_pixel2x2_bot_597 rowReadOFF<56> rowReadOFF<57> rowReadON<57> RefrBp PrBp
+ PrSFBp col_periphery_1x2_22/COL_LINE0 pixRst<28> pixRst<29> col_periphery_1x2_22/COL_LINE1
+ OffBn openDVS_pixel2x2_bot_597/vpd[2] openDVS_pixel2x2_bot_597/vpd[3] openDVS_pixel2x2_bot_597/vpd[1]
+ openDVS_pixel2x2_bot_597/vpd[0] rowReadON<56> openDVS_pixel2x2_bot_888/GndD DiffBn
+ VSUBS VDD OnBn openDVS_pixel2x2_bot
XopenDVS_pixel2x2_bot_531 rowReadOFF<56> rowReadOFF<57> rowReadON<57> RefrBp PrBp
+ PrSFBp col_periphery_1x2_29/COL_LINE0 pixRst<10> pixRst<11> col_periphery_1x2_29/COL_LINE1
+ OffBn openDVS_pixel2x2_bot_531/vpd[2] openDVS_pixel2x2_bot_531/vpd[3] openDVS_pixel2x2_bot_531/vpd[1]
+ openDVS_pixel2x2_bot_531/vpd[0] rowReadON<56> openDVS_pixel2x2_bot_888/GndD DiffBn
+ VSUBS VDD OnBn openDVS_pixel2x2_bot
XopenDVS_pixel2x2_bot_542 rowReadOFF<58> rowReadOFF<59> rowReadON<59> RefrBp PrBp
+ PrSFBp col_periphery_1x2_25/COL_LINE0 pixRst<2> pixRst<3> col_periphery_1x2_25/COL_LINE1
+ OffBn openDVS_pixel2x2_bot_542/vpd[2] openDVS_pixel2x2_bot_542/vpd[3] openDVS_pixel2x2_bot_542/vpd[1]
+ openDVS_pixel2x2_bot_542/vpd[0] rowReadON<58> openDVS_pixel2x2_bot_890/GndD DiffBn
+ VSUBS VDD OnBn openDVS_pixel2x2_bot
XopenDVS_pixel2x2_bot_520 rowReadOFF<56> rowReadOFF<57> rowReadON<57> RefrBp PrBp
+ PrSFBp col_periphery_1x2_25/COL_LINE0 pixRst<2> pixRst<3> col_periphery_1x2_25/COL_LINE1
+ OffBn openDVS_pixel2x2_bot_520/vpd[2] openDVS_pixel2x2_bot_520/vpd[3] openDVS_pixel2x2_bot_520/vpd[1]
+ openDVS_pixel2x2_bot_520/vpd[0] rowReadON<56> openDVS_pixel2x2_bot_888/GndD DiffBn
+ VSUBS VDD OnBn openDVS_pixel2x2_bot
XopenDVS_pixel2x2_bot_553 rowReadOFF<54> rowReadOFF<55> rowReadON<55> RefrBp PrBp
+ PrSFBp col_periphery_1x2_25/COL_LINE0 pixRst<2> pixRst<3> col_periphery_1x2_25/COL_LINE1
+ OffBn openDVS_pixel2x2_bot_553/vpd[2] openDVS_pixel2x2_bot_553/vpd[3] openDVS_pixel2x2_bot_553/vpd[1]
+ openDVS_pixel2x2_bot_553/vpd[0] rowReadON<54> openDVS_pixel2x2_bot_885/GndD DiffBn
+ VSUBS VDD OnBn openDVS_pixel2x2_bot
XopenDVS_pixel2x2_bot_586 rowReadOFF<48> rowReadOFF<49> rowReadON<49> RefrBp PrBp
+ PrSFBp col_periphery_1x2_21/COL_LINE0 pixRst<26> pixRst<27> col_periphery_1x2_21/COL_LINE1
+ OffBn openDVS_pixel2x2_bot_586/vpd[2] openDVS_pixel2x2_bot_586/vpd[3] openDVS_pixel2x2_bot_586/vpd[1]
+ openDVS_pixel2x2_bot_586/vpd[0] rowReadON<48> openDVS_pixel2x2_bot_927/GndD DiffBn
+ VSUBS VDD OnBn openDVS_pixel2x2_bot
XopenDVS_pixel2x2_bot_564 rowReadOFF<52> rowReadOFF<53> rowReadON<53> RefrBp PrBp
+ PrSFBp col_periphery_1x2_20/COL_LINE0 pixRst<24> pixRst<25> col_periphery_1x2_20/COL_LINE1
+ OffBn openDVS_pixel2x2_bot_564/vpd[2] openDVS_pixel2x2_bot_564/vpd[3] openDVS_pixel2x2_bot_564/vpd[1]
+ openDVS_pixel2x2_bot_564/vpd[0] rowReadON<52> openDVS_pixel2x2_bot_882/GndD DiffBn
+ VSUBS VDD OnBn openDVS_pixel2x2_bot
XopenDVS_pixel2x2_bot_394 rowReadOFF<40> rowReadOFF<41> rowReadON<41> RefrBp PrBp
+ PrSFBp col_periphery_1x2_20/COL_LINE0 pixRst<24> pixRst<25> col_periphery_1x2_20/COL_LINE1
+ OffBn openDVS_pixel2x2_bot_394/vpd[2] openDVS_pixel2x2_bot_394/vpd[3] openDVS_pixel2x2_bot_394/vpd[1]
+ openDVS_pixel2x2_bot_394/vpd[0] rowReadON<40> openDVS_pixel2x2_bot_906/GndD DiffBn
+ VSUBS VDD OnBn openDVS_pixel2x2_bot
XopenDVS_pixel2x2_bot_383 rowReadOFF<24> rowReadOFF<25> rowReadON<25> RefrBp PrBp
+ PrSFBp col_periphery_1x2_31/COL_LINE0 pixRst<14> pixRst<15> col_periphery_1x2_31/COL_LINE1
+ OffBn openDVS_pixel2x2_bot_383/vpd[2] openDVS_pixel2x2_bot_383/vpd[3] openDVS_pixel2x2_bot_383/vpd[1]
+ openDVS_pixel2x2_bot_383/vpd[0] rowReadON<24> openDVS_pixel2x2_bot_99/GndD DiffBn
+ VSUBS VDD OnBn openDVS_pixel2x2_bot
XopenDVS_pixel2x2_bot_361 rowReadOFF<8> rowReadOFF<9> rowReadON<9> RefrBp PrBp PrSFBp
+ col_periphery_1x2_25/COL_LINE0 pixRst<2> pixRst<3> col_periphery_1x2_25/COL_LINE1
+ OffBn openDVS_pixel2x2_bot_361/vpd[2] openDVS_pixel2x2_bot_361/vpd[3] openDVS_pixel2x2_bot_361/vpd[1]
+ openDVS_pixel2x2_bot_361/vpd[0] rowReadON<8> openDVS_pixel2x2_bot_939/GndD DiffBn
+ VSUBS VDD OnBn openDVS_pixel2x2_bot
XopenDVS_pixel2x2_bot_350 rowReadOFF<6> rowReadOFF<7> rowReadON<7> RefrBp PrBp PrSFBp
+ col_periphery_1x2_26/COL_LINE0 pixRst<4> pixRst<5> col_periphery_1x2_26/COL_LINE1
+ OffBn openDVS_pixel2x2_bot_350/vpd[2] openDVS_pixel2x2_bot_350/vpd[3] openDVS_pixel2x2_bot_350/vpd[1]
+ openDVS_pixel2x2_bot_350/vpd[0] rowReadON<6> openDVS_pixel2x2_bot_937/GndD DiffBn
+ VSUBS VDD OnBn openDVS_pixel2x2_bot
XopenDVS_pixel2x2_bot_372 rowReadOFF<8> rowReadOFF<9> rowReadON<9> RefrBp PrBp PrSFBp
+ col_periphery_1x2_20/COL_LINE0 pixRst<24> pixRst<25> col_periphery_1x2_20/COL_LINE1
+ OffBn openDVS_pixel2x2_bot_372/vpd[2] openDVS_pixel2x2_bot_372/vpd[3] openDVS_pixel2x2_bot_372/vpd[1]
+ openDVS_pixel2x2_bot_372/vpd[0] rowReadON<8> openDVS_pixel2x2_bot_939/GndD DiffBn
+ VSUBS VDD OnBn openDVS_pixel2x2_bot
XopenDVS_pixel2x2_bot_191 rowReadOFF<12> rowReadOFF<13> rowReadON<13> RefrBp PrBp
+ PrSFBp col_periphery_1x2_15/COL_LINE0 pixRst<48> pixRst<49> col_periphery_1x2_15/COL_LINE1
+ OffBn openDVS_pixel2x2_bot_191/vpd[2] openDVS_pixel2x2_bot_191/vpd[3] openDVS_pixel2x2_bot_191/vpd[1]
+ openDVS_pixel2x2_bot_191/vpd[0] rowReadON<12> openDVS_pixel2x2_bot_79/GndD DiffBn
+ VSUBS VDD OnBn openDVS_pixel2x2_bot
XopenDVS_pixel2x2_bot_180 rowReadOFF<8> rowReadOFF<9> rowReadON<9> RefrBp PrBp PrSFBp
+ col_periphery_1x2_6/COL_LINE0 pixRst<62> pixRst<63> col_periphery_1x2_6/COL_LINE1
+ OffBn openDVS_pixel2x2_bot_180/vpd[2] openDVS_pixel2x2_bot_180/vpd[3] openDVS_pixel2x2_bot_180/vpd[1]
+ openDVS_pixel2x2_bot_180/vpd[0] rowReadON<8> openDVS_pixel2x2_bot_939/GndD DiffBn
+ VSUBS VDD OnBn openDVS_pixel2x2_bot
XopenDVS_pixel2x2_bot_916 rowReadOFF<44> rowReadOFF<45> rowReadON<45> RefrBp PrBp
+ PrSFBp col_periphery_1x2_15/COL_LINE0 pixRst<48> pixRst<49> col_periphery_1x2_15/COL_LINE1
+ OffBn openDVS_pixel2x2_bot_916/vpd[2] openDVS_pixel2x2_bot_916/vpd[3] openDVS_pixel2x2_bot_916/vpd[1]
+ openDVS_pixel2x2_bot_916/vpd[0] rowReadON<44> openDVS_pixel2x2_bot_923/GndD DiffBn
+ VSUBS VDD OnBn openDVS_pixel2x2_bot
XopenDVS_pixel2x2_bot_927 rowReadOFF<48> rowReadOFF<49> rowReadON<49> RefrBp PrBp
+ PrSFBp col_periphery_1x2_15/COL_LINE0 pixRst<48> pixRst<49> col_periphery_1x2_15/COL_LINE1
+ OffBn openDVS_pixel2x2_bot_927/vpd[2] openDVS_pixel2x2_bot_927/vpd[3] openDVS_pixel2x2_bot_927/vpd[1]
+ openDVS_pixel2x2_bot_927/vpd[0] rowReadON<48> openDVS_pixel2x2_bot_927/GndD DiffBn
+ VSUBS VDD OnBn openDVS_pixel2x2_bot
XopenDVS_pixel2x2_bot_905 rowReadOFF<40> rowReadOFF<41> rowReadON<41> RefrBp PrBp
+ PrSFBp col_periphery_1x2_14/COL_LINE0 pixRst<46> pixRst<47> col_periphery_1x2_14/COL_LINE1
+ OffBn openDVS_pixel2x2_bot_905/vpd[2] openDVS_pixel2x2_bot_905/vpd[3] openDVS_pixel2x2_bot_905/vpd[1]
+ openDVS_pixel2x2_bot_905/vpd[0] rowReadON<40> openDVS_pixel2x2_bot_906/GndD DiffBn
+ VSUBS VDD OnBn openDVS_pixel2x2_bot
XopenDVS_pixel2x2_bot_949 rowReadOFF<18> rowReadOFF<19> rowReadON<19> RefrBp PrBp
+ PrSFBp col_periphery_1x2_9/COL_LINE0 pixRst<32> pixRst<33> col_periphery_1x2_9/COL_LINE1
+ OffBn openDVS_pixel2x2_bot_949/vpd[2] openDVS_pixel2x2_bot_949/vpd[3] openDVS_pixel2x2_bot_949/vpd[1]
+ openDVS_pixel2x2_bot_949/vpd[0] rowReadON<18> openDVS_pixel2x2_bot_69/GndD DiffBn
+ VSUBS VDD OnBn openDVS_pixel2x2_bot
XopenDVS_pixel2x2_bot_938 rowReadOFF<8> rowReadOFF<9> rowReadON<9> RefrBp PrBp PrSFBp
+ col_periphery_1x2_23/COL_LINE0 pixRst<30> pixRst<31> col_periphery_1x2_23/COL_LINE1
+ OffBn openDVS_pixel2x2_bot_938/vpd[2] openDVS_pixel2x2_bot_938/vpd[3] openDVS_pixel2x2_bot_938/vpd[1]
+ openDVS_pixel2x2_bot_938/vpd[0] rowReadON<8> openDVS_pixel2x2_bot_939/GndD DiffBn
+ VSUBS VDD OnBn openDVS_pixel2x2_bot
XopenDVS_pixel2x2_bot_779 rowReadOFF<54> rowReadOFF<55> rowReadON<55> RefrBp PrBp
+ PrSFBp col_periphery_1x2_8/COL_LINE0 pixRst<42> pixRst<43> col_periphery_1x2_8/COL_LINE1
+ OffBn openDVS_pixel2x2_bot_779/vpd[2] openDVS_pixel2x2_bot_779/vpd[3] openDVS_pixel2x2_bot_779/vpd[1]
+ openDVS_pixel2x2_bot_779/vpd[0] rowReadON<54> openDVS_pixel2x2_bot_885/GndD DiffBn
+ VSUBS VDD OnBn openDVS_pixel2x2_bot
XopenDVS_pixel2x2_bot_768 rowReadOFF<50> rowReadOFF<51> rowReadON<51> RefrBp PrBp
+ PrSFBp col_periphery_1x2_12/COL_LINE0 pixRst<38> pixRst<39> col_periphery_1x2_12/COL_LINE1
+ OffBn openDVS_pixel2x2_bot_768/vpd[2] openDVS_pixel2x2_bot_768/vpd[3] openDVS_pixel2x2_bot_768/vpd[1]
+ openDVS_pixel2x2_bot_768/vpd[0] rowReadON<50> openDVS_pixel2x2_bot_929/GndD DiffBn
+ VSUBS VDD OnBn openDVS_pixel2x2_bot
XopenDVS_pixel2x2_bot_713 rowReadOFF<42> rowReadOFF<43> rowReadON<43> RefrBp PrBp
+ PrSFBp col_periphery_1x2_6/COL_LINE0 pixRst<62> pixRst<63> col_periphery_1x2_6/COL_LINE1
+ OffBn openDVS_pixel2x2_bot_713/vpd[2] openDVS_pixel2x2_bot_713/vpd[3] openDVS_pixel2x2_bot_713/vpd[1]
+ openDVS_pixel2x2_bot_713/vpd[0] rowReadON<42> openDVS_pixel2x2_bot_908/GndD DiffBn
+ VSUBS VDD OnBn openDVS_pixel2x2_bot
XopenDVS_pixel2x2_bot_702 rowReadOFF<36> rowReadOFF<37> rowReadON<37> RefrBp PrBp
+ PrSFBp col_periphery_1x2_4/COL_LINE0 pixRst<58> pixRst<59> col_periphery_1x2_4/COL_LINE1
+ OffBn openDVS_pixel2x2_bot_702/vpd[2] openDVS_pixel2x2_bot_702/vpd[3] openDVS_pixel2x2_bot_702/vpd[1]
+ openDVS_pixel2x2_bot_702/vpd[0] rowReadON<36> openDVS_pixel2x2_bot_997/GndD DiffBn
+ VSUBS VDD OnBn openDVS_pixel2x2_bot
XopenDVS_pixel2x2_bot_746 rowReadOFF<38> rowReadOFF<39> rowReadON<39> RefrBp PrBp
+ PrSFBp col_periphery_1x2_8/COL_LINE0 pixRst<42> pixRst<43> col_periphery_1x2_8/COL_LINE1
+ OffBn openDVS_pixel2x2_bot_746/vpd[2] openDVS_pixel2x2_bot_746/vpd[3] openDVS_pixel2x2_bot_746/vpd[1]
+ openDVS_pixel2x2_bot_746/vpd[0] rowReadON<38> openDVS_pixel2x2_bot_999/GndD DiffBn
+ VSUBS VDD OnBn openDVS_pixel2x2_bot
XopenDVS_pixel2x2_bot_724 rowReadOFF<36> rowReadOFF<37> rowReadON<37> RefrBp PrBp
+ PrSFBp col_periphery_1x2_8/COL_LINE0 pixRst<42> pixRst<43> col_periphery_1x2_8/COL_LINE1
+ OffBn openDVS_pixel2x2_bot_724/vpd[2] openDVS_pixel2x2_bot_724/vpd[3] openDVS_pixel2x2_bot_724/vpd[1]
+ openDVS_pixel2x2_bot_724/vpd[0] rowReadON<36> openDVS_pixel2x2_bot_997/GndD DiffBn
+ VSUBS VDD OnBn openDVS_pixel2x2_bot
XopenDVS_pixel2x2_bot_735 rowReadOFF<42> rowReadOFF<43> rowReadON<43> RefrBp PrBp
+ PrSFBp col_periphery_1x2_7/COL_LINE0 pixRst<40> pixRst<41> col_periphery_1x2_7/COL_LINE1
+ OffBn openDVS_pixel2x2_bot_735/vpd[2] openDVS_pixel2x2_bot_735/vpd[3] openDVS_pixel2x2_bot_735/vpd[1]
+ openDVS_pixel2x2_bot_735/vpd[0] rowReadON<42> openDVS_pixel2x2_bot_908/GndD DiffBn
+ VSUBS VDD OnBn openDVS_pixel2x2_bot
XopenDVS_pixel2x2_bot_757 rowReadOFF<42> rowReadOFF<43> rowReadON<43> RefrBp PrBp
+ PrSFBp col_periphery_1x2_11/COL_LINE0 pixRst<36> pixRst<37> col_periphery_1x2_11/COL_LINE1
+ OffBn openDVS_pixel2x2_bot_757/vpd[2] openDVS_pixel2x2_bot_757/vpd[3] openDVS_pixel2x2_bot_757/vpd[1]
+ openDVS_pixel2x2_bot_757/vpd[0] rowReadON<42> openDVS_pixel2x2_bot_908/GndD DiffBn
+ VSUBS VDD OnBn openDVS_pixel2x2_bot
XopenDVS_pixel2x2_bot_532 rowReadOFF<56> rowReadOFF<57> rowReadON<57> RefrBp PrBp
+ PrSFBp col_periphery_1x2_30/COL_LINE0 pixRst<12> pixRst<13> col_periphery_1x2_30/COL_LINE1
+ OffBn openDVS_pixel2x2_bot_532/vpd[2] openDVS_pixel2x2_bot_532/vpd[3] openDVS_pixel2x2_bot_532/vpd[1]
+ openDVS_pixel2x2_bot_532/vpd[0] rowReadON<56> openDVS_pixel2x2_bot_888/GndD DiffBn
+ VSUBS VDD OnBn openDVS_pixel2x2_bot
XopenDVS_pixel2x2_bot_510 rowReadOFF<48> rowReadOFF<49> rowReadON<49> RefrBp PrBp
+ PrSFBp col_periphery_1x2_24/COL_LINE0 pixRst<0> pixRst<1> col_periphery_1x2_24/COL_LINE1
+ OffBn openDVS_pixel2x2_bot_510/vpd[2] openDVS_pixel2x2_bot_510/vpd[3] openDVS_pixel2x2_bot_510/vpd[1]
+ openDVS_pixel2x2_bot_510/vpd[0] rowReadON<48> openDVS_pixel2x2_bot_927/GndD DiffBn
+ VSUBS VDD OnBn openDVS_pixel2x2_bot
XopenDVS_pixel2x2_bot_521 rowReadOFF<48> rowReadOFF<49> rowReadON<49> RefrBp PrBp
+ PrSFBp col_periphery_1x2_25/COL_LINE0 pixRst<2> pixRst<3> col_periphery_1x2_25/COL_LINE1
+ OffBn openDVS_pixel2x2_bot_521/vpd[2] openDVS_pixel2x2_bot_521/vpd[3] openDVS_pixel2x2_bot_521/vpd[1]
+ openDVS_pixel2x2_bot_521/vpd[0] rowReadON<48> openDVS_pixel2x2_bot_927/GndD DiffBn
+ VSUBS VDD OnBn openDVS_pixel2x2_bot
XopenDVS_pixel2x2_bot_576 rowReadOFF<62> rowReadOFF<63> rowReadON<63> RefrBp PrBp
+ PrSFBp col_periphery_1x2_21/COL_LINE0 pixRst<26> pixRst<27> col_periphery_1x2_21/COL_LINE1
+ OffBn openDVS_pixel2x2_bot_576/vpd[2] openDVS_pixel2x2_bot_576/vpd[3] openDVS_pixel2x2_bot_576/vpd[1]
+ openDVS_pixel2x2_bot_576/vpd[0] rowReadON<62> openDVS_pixel2x2_bot_886/GndD DiffBn
+ VSUBS VDD OnBn openDVS_pixel2x2_bot
XopenDVS_pixel2x2_bot_543 rowReadOFF<58> rowReadOFF<59> rowReadON<59> RefrBp PrBp
+ PrSFBp col_periphery_1x2_26/COL_LINE0 pixRst<4> pixRst<5> col_periphery_1x2_26/COL_LINE1
+ OffBn openDVS_pixel2x2_bot_543/vpd[2] openDVS_pixel2x2_bot_543/vpd[3] openDVS_pixel2x2_bot_543/vpd[1]
+ openDVS_pixel2x2_bot_543/vpd[0] rowReadON<58> openDVS_pixel2x2_bot_890/GndD DiffBn
+ VSUBS VDD OnBn openDVS_pixel2x2_bot
XopenDVS_pixel2x2_bot_554 rowReadOFF<54> rowReadOFF<55> rowReadON<55> RefrBp PrBp
+ PrSFBp col_periphery_1x2_26/COL_LINE0 pixRst<4> pixRst<5> col_periphery_1x2_26/COL_LINE1
+ OffBn openDVS_pixel2x2_bot_554/vpd[2] openDVS_pixel2x2_bot_554/vpd[3] openDVS_pixel2x2_bot_554/vpd[1]
+ openDVS_pixel2x2_bot_554/vpd[0] rowReadON<54> openDVS_pixel2x2_bot_885/GndD DiffBn
+ VSUBS VDD OnBn openDVS_pixel2x2_bot
XopenDVS_pixel2x2_bot_587 rowReadOFF<48> rowReadOFF<49> rowReadON<49> RefrBp PrBp
+ PrSFBp col_periphery_1x2_22/COL_LINE0 pixRst<28> pixRst<29> col_periphery_1x2_22/COL_LINE1
+ OffBn openDVS_pixel2x2_bot_587/vpd[2] openDVS_pixel2x2_bot_587/vpd[3] openDVS_pixel2x2_bot_587/vpd[1]
+ openDVS_pixel2x2_bot_587/vpd[0] rowReadON<48> openDVS_pixel2x2_bot_927/GndD DiffBn
+ VSUBS VDD OnBn openDVS_pixel2x2_bot
XopenDVS_pixel2x2_bot_565 rowReadOFF<52> rowReadOFF<53> rowReadON<53> RefrBp PrBp
+ PrSFBp col_periphery_1x2_21/COL_LINE0 pixRst<26> pixRst<27> col_periphery_1x2_21/COL_LINE1
+ OffBn openDVS_pixel2x2_bot_565/vpd[2] openDVS_pixel2x2_bot_565/vpd[3] openDVS_pixel2x2_bot_565/vpd[1]
+ openDVS_pixel2x2_bot_565/vpd[0] rowReadON<52> openDVS_pixel2x2_bot_882/GndD DiffBn
+ VSUBS VDD OnBn openDVS_pixel2x2_bot
XopenDVS_pixel2x2_bot_598 rowReadOFF<46> rowReadOFF<47> rowReadON<47> RefrBp PrBp
+ PrSFBp col_periphery_1x2_17/COL_LINE0 pixRst<18> pixRst<19> col_periphery_1x2_17/COL_LINE1
+ OffBn openDVS_pixel2x2_bot_598/vpd[2] openDVS_pixel2x2_bot_598/vpd[3] openDVS_pixel2x2_bot_598/vpd[1]
+ openDVS_pixel2x2_bot_598/vpd[0] rowReadON<46> openDVS_pixel2x2_bot_925/GndD DiffBn
+ VSUBS VDD OnBn openDVS_pixel2x2_bot
XopenDVS_pixel2x2_bot_395 rowReadOFF<32> rowReadOFF<33> rowReadON<33> RefrBp PrBp
+ PrSFBp col_periphery_1x2_17/COL_LINE0 pixRst<18> pixRst<19> col_periphery_1x2_17/COL_LINE1
+ OffBn openDVS_pixel2x2_bot_395/vpd[2] openDVS_pixel2x2_bot_395/vpd[3] openDVS_pixel2x2_bot_395/vpd[1]
+ openDVS_pixel2x2_bot_395/vpd[0] rowReadON<32> openDVS_pixel2x2_bot_993/GndD DiffBn
+ VSUBS VDD OnBn openDVS_pixel2x2_bot
XopenDVS_pixel2x2_bot_384 rowReadOFF<24> rowReadOFF<25> rowReadON<25> RefrBp PrBp
+ PrSFBp col_periphery_1x2_16/COL_LINE0 pixRst<16> pixRst<17> col_periphery_1x2_16/COL_LINE1
+ OffBn openDVS_pixel2x2_bot_384/vpd[2] openDVS_pixel2x2_bot_384/vpd[3] openDVS_pixel2x2_bot_384/vpd[1]
+ openDVS_pixel2x2_bot_384/vpd[0] rowReadON<24> openDVS_pixel2x2_bot_99/GndD DiffBn
+ VSUBS VDD OnBn openDVS_pixel2x2_bot
XopenDVS_pixel2x2_bot_351 rowReadOFF<0> rowReadOFF<1> rowReadON<1> RefrBp PrBp PrSFBp
+ col_periphery_1x2_31/COL_LINE0 pixRst<14> pixRst<15> col_periphery_1x2_31/COL_LINE1
+ OffBn openDVS_pixel2x2_bot_351/vpd[2] openDVS_pixel2x2_bot_351/vpd[3] openDVS_pixel2x2_bot_351/vpd[1]
+ openDVS_pixel2x2_bot_351/vpd[0] rowReadON<0> GND DiffBn VSUBS VDD OnBn openDVS_pixel2x2_bot
XopenDVS_pixel2x2_bot_362 rowReadOFF<8> rowReadOFF<9> rowReadON<9> RefrBp PrBp PrSFBp
+ col_periphery_1x2_26/COL_LINE0 pixRst<4> pixRst<5> col_periphery_1x2_26/COL_LINE1
+ OffBn openDVS_pixel2x2_bot_362/vpd[2] openDVS_pixel2x2_bot_362/vpd[3] openDVS_pixel2x2_bot_362/vpd[1]
+ openDVS_pixel2x2_bot_362/vpd[0] rowReadON<8> openDVS_pixel2x2_bot_939/GndD DiffBn
+ VSUBS VDD OnBn openDVS_pixel2x2_bot
XopenDVS_pixel2x2_bot_340 rowReadOFF<6> rowReadOFF<7> rowReadON<7> RefrBp PrBp PrSFBp
+ col_periphery_1x2_20/COL_LINE0 pixRst<24> pixRst<25> col_periphery_1x2_20/COL_LINE1
+ OffBn openDVS_pixel2x2_bot_340/vpd[2] openDVS_pixel2x2_bot_340/vpd[3] openDVS_pixel2x2_bot_340/vpd[1]
+ openDVS_pixel2x2_bot_340/vpd[0] rowReadON<6> openDVS_pixel2x2_bot_937/GndD DiffBn
+ VSUBS VDD OnBn openDVS_pixel2x2_bot
XopenDVS_pixel2x2_bot_373 rowReadOFF<8> rowReadOFF<9> rowReadON<9> RefrBp PrBp PrSFBp
+ col_periphery_1x2_21/COL_LINE0 pixRst<26> pixRst<27> col_periphery_1x2_21/COL_LINE1
+ OffBn openDVS_pixel2x2_bot_373/vpd[2] openDVS_pixel2x2_bot_373/vpd[3] openDVS_pixel2x2_bot_373/vpd[1]
+ openDVS_pixel2x2_bot_373/vpd[0] rowReadON<8> openDVS_pixel2x2_bot_939/GndD DiffBn
+ VSUBS VDD OnBn openDVS_pixel2x2_bot
XopenDVS_pixel2x2_bot_181 rowReadOFF<16> rowReadOFF<17> rowReadON<17> RefrBp PrBp
+ PrSFBp col_periphery_1x2_15/COL_LINE0 pixRst<48> pixRst<49> col_periphery_1x2_15/COL_LINE1
+ OffBn openDVS_pixel2x2_bot_181/vpd[2] openDVS_pixel2x2_bot_181/vpd[3] openDVS_pixel2x2_bot_181/vpd[1]
+ openDVS_pixel2x2_bot_181/vpd[0] rowReadON<16> openDVS_pixel2x2_bot_91/GndD DiffBn
+ VSUBS VDD OnBn openDVS_pixel2x2_bot
XopenDVS_pixel2x2_bot_170 rowReadOFF<8> rowReadOFF<9> rowReadON<9> RefrBp PrBp PrSFBp
+ col_periphery_1x2_8/COL_LINE0 pixRst<42> pixRst<43> col_periphery_1x2_8/COL_LINE1
+ OffBn openDVS_pixel2x2_bot_170/vpd[2] openDVS_pixel2x2_bot_170/vpd[3] openDVS_pixel2x2_bot_170/vpd[1]
+ openDVS_pixel2x2_bot_170/vpd[0] rowReadON<8> openDVS_pixel2x2_bot_939/GndD DiffBn
+ VSUBS VDD OnBn openDVS_pixel2x2_bot
XopenDVS_pixel2x2_bot_192 rowReadOFF<2> rowReadOFF<3> rowReadON<3> RefrBp PrBp PrSFBp
+ col_periphery_1x2_14/COL_LINE0 pixRst<46> pixRst<47> col_periphery_1x2_14/COL_LINE1
+ OffBn openDVS_pixel2x2_bot_192/vpd[2] openDVS_pixel2x2_bot_192/vpd[3] openDVS_pixel2x2_bot_192/vpd[1]
+ openDVS_pixel2x2_bot_192/vpd[0] rowReadON<2> openDVS_pixel2x2_bot_7/GndD DiffBn
+ VSUBS VDD OnBn openDVS_pixel2x2_bot
XopenDVS_pixel2x2_bot_917 rowReadOFF<44> rowReadOFF<45> rowReadON<45> RefrBp PrBp
+ PrSFBp col_periphery_1x2_0/COL_LINE0 pixRst<50> pixRst<51> col_periphery_1x2_0/COL_LINE1
+ OffBn openDVS_pixel2x2_bot_917/vpd[2] openDVS_pixel2x2_bot_917/vpd[3] openDVS_pixel2x2_bot_917/vpd[1]
+ openDVS_pixel2x2_bot_917/vpd[0] rowReadON<44> openDVS_pixel2x2_bot_923/GndD DiffBn
+ VSUBS VDD OnBn openDVS_pixel2x2_bot
XopenDVS_pixel2x2_bot_928 rowReadOFF<50> rowReadOFF<51> rowReadON<51> RefrBp PrBp
+ PrSFBp col_periphery_1x2_14/COL_LINE0 pixRst<46> pixRst<47> col_periphery_1x2_14/COL_LINE1
+ OffBn openDVS_pixel2x2_bot_928/vpd[2] openDVS_pixel2x2_bot_928/vpd[3] openDVS_pixel2x2_bot_928/vpd[1]
+ openDVS_pixel2x2_bot_928/vpd[0] rowReadON<50> openDVS_pixel2x2_bot_929/GndD DiffBn
+ VSUBS VDD OnBn openDVS_pixel2x2_bot
XopenDVS_pixel2x2_bot_906 rowReadOFF<40> rowReadOFF<41> rowReadON<41> RefrBp PrBp
+ PrSFBp col_periphery_1x2_15/COL_LINE0 pixRst<48> pixRst<49> col_periphery_1x2_15/COL_LINE1
+ OffBn openDVS_pixel2x2_bot_906/vpd[2] openDVS_pixel2x2_bot_906/vpd[3] openDVS_pixel2x2_bot_906/vpd[1]
+ openDVS_pixel2x2_bot_906/vpd[0] rowReadON<40> openDVS_pixel2x2_bot_906/GndD DiffBn
+ VSUBS VDD OnBn openDVS_pixel2x2_bot
XopenDVS_pixel2x2_bot_939 rowReadOFF<8> rowReadOFF<9> rowReadON<9> RefrBp PrBp PrSFBp
+ col_periphery_1x2_9/COL_LINE0 pixRst<32> pixRst<33> col_periphery_1x2_9/COL_LINE1
+ OffBn openDVS_pixel2x2_bot_939/vpd[2] openDVS_pixel2x2_bot_939/vpd[3] openDVS_pixel2x2_bot_939/vpd[1]
+ openDVS_pixel2x2_bot_939/vpd[0] rowReadON<8> openDVS_pixel2x2_bot_939/GndD DiffBn
+ VSUBS VDD OnBn openDVS_pixel2x2_bot
XopenDVS_pixel2x2_bot_769 rowReadOFF<50> rowReadOFF<51> rowReadON<51> RefrBp PrBp
+ PrSFBp col_periphery_1x2_7/COL_LINE0 pixRst<40> pixRst<41> col_periphery_1x2_7/COL_LINE1
+ OffBn openDVS_pixel2x2_bot_769/vpd[2] openDVS_pixel2x2_bot_769/vpd[3] openDVS_pixel2x2_bot_769/vpd[1]
+ openDVS_pixel2x2_bot_769/vpd[0] rowReadON<50> openDVS_pixel2x2_bot_929/GndD DiffBn
+ VSUBS VDD OnBn openDVS_pixel2x2_bot
XopenDVS_pixel2x2_bot_703 rowReadOFF<36> rowReadOFF<37> rowReadON<37> RefrBp PrBp
+ PrSFBp col_periphery_1x2_5/COL_LINE0 pixRst<60> pixRst<61> col_periphery_1x2_5/COL_LINE1
+ OffBn openDVS_pixel2x2_bot_703/vpd[2] openDVS_pixel2x2_bot_703/vpd[3] openDVS_pixel2x2_bot_703/vpd[1]
+ openDVS_pixel2x2_bot_703/vpd[0] rowReadON<36> openDVS_pixel2x2_bot_997/GndD DiffBn
+ VSUBS VDD OnBn openDVS_pixel2x2_bot
XopenDVS_pixel2x2_bot_714 rowReadOFF<42> rowReadOFF<43> rowReadON<43> RefrBp PrBp
+ PrSFBp col_periphery_1x2_0/COL_LINE0 pixRst<50> pixRst<51> col_periphery_1x2_0/COL_LINE1
+ OffBn openDVS_pixel2x2_bot_714/vpd[2] openDVS_pixel2x2_bot_714/vpd[3] openDVS_pixel2x2_bot_714/vpd[1]
+ openDVS_pixel2x2_bot_714/vpd[0] rowReadON<42> openDVS_pixel2x2_bot_908/GndD DiffBn
+ VSUBS VDD OnBn openDVS_pixel2x2_bot
XopenDVS_pixel2x2_bot_747 rowReadOFF<38> rowReadOFF<39> rowReadON<39> RefrBp PrBp
+ PrSFBp col_periphery_1x2_13/COL_LINE0 pixRst<44> pixRst<45> col_periphery_1x2_13/COL_LINE1
+ OffBn openDVS_pixel2x2_bot_747/vpd[2] openDVS_pixel2x2_bot_747/vpd[3] openDVS_pixel2x2_bot_747/vpd[1]
+ openDVS_pixel2x2_bot_747/vpd[0] rowReadON<38> openDVS_pixel2x2_bot_999/GndD DiffBn
+ VSUBS VDD OnBn openDVS_pixel2x2_bot
XopenDVS_pixel2x2_bot_725 rowReadOFF<36> rowReadOFF<37> rowReadON<37> RefrBp PrBp
+ PrSFBp col_periphery_1x2_13/COL_LINE0 pixRst<44> pixRst<45> col_periphery_1x2_13/COL_LINE1
+ OffBn openDVS_pixel2x2_bot_725/vpd[2] openDVS_pixel2x2_bot_725/vpd[3] openDVS_pixel2x2_bot_725/vpd[1]
+ openDVS_pixel2x2_bot_725/vpd[0] rowReadON<36> openDVS_pixel2x2_bot_997/GndD DiffBn
+ VSUBS VDD OnBn openDVS_pixel2x2_bot
XopenDVS_pixel2x2_bot_736 rowReadOFF<38> rowReadOFF<39> rowReadON<39> RefrBp PrBp
+ PrSFBp col_periphery_1x2_10/COL_LINE0 pixRst<34> pixRst<35> col_periphery_1x2_10/COL_LINE1
+ OffBn openDVS_pixel2x2_bot_736/vpd[2] openDVS_pixel2x2_bot_736/vpd[3] openDVS_pixel2x2_bot_736/vpd[1]
+ openDVS_pixel2x2_bot_736/vpd[0] rowReadON<38> openDVS_pixel2x2_bot_999/GndD DiffBn
+ VSUBS VDD OnBn openDVS_pixel2x2_bot
XopenDVS_pixel2x2_bot_758 rowReadOFF<34> rowReadOFF<35> rowReadON<35> RefrBp PrBp
+ PrSFBp col_periphery_1x2_10/COL_LINE0 pixRst<34> pixRst<35> col_periphery_1x2_10/COL_LINE1
+ OffBn openDVS_pixel2x2_bot_758/vpd[2] openDVS_pixel2x2_bot_758/vpd[3] openDVS_pixel2x2_bot_758/vpd[1]
+ openDVS_pixel2x2_bot_758/vpd[0] rowReadON<34> openDVS_pixel2x2_bot_995/GndD DiffBn
+ VSUBS VDD OnBn openDVS_pixel2x2_bot
XopenDVS_pixel2x2_bot_577 rowReadOFF<62> rowReadOFF<63> rowReadON<63> RefrBp PrBp
+ PrSFBp col_periphery_1x2_22/COL_LINE0 pixRst<28> pixRst<29> col_periphery_1x2_22/COL_LINE1
+ OffBn openDVS_pixel2x2_bot_577/vpd[2] openDVS_pixel2x2_bot_577/vpd[3] openDVS_pixel2x2_bot_577/vpd[1]
+ openDVS_pixel2x2_bot_577/vpd[0] rowReadON<62> openDVS_pixel2x2_bot_886/GndD DiffBn
+ VSUBS VDD OnBn openDVS_pixel2x2_bot
XopenDVS_pixel2x2_bot_588 rowReadOFF<56> rowReadOFF<57> rowReadON<57> RefrBp PrBp
+ PrSFBp col_periphery_1x2_17/COL_LINE0 pixRst<18> pixRst<19> col_periphery_1x2_17/COL_LINE1
+ OffBn openDVS_pixel2x2_bot_588/vpd[2] openDVS_pixel2x2_bot_588/vpd[3] openDVS_pixel2x2_bot_588/vpd[1]
+ openDVS_pixel2x2_bot_588/vpd[0] rowReadON<56> openDVS_pixel2x2_bot_888/GndD DiffBn
+ VSUBS VDD OnBn openDVS_pixel2x2_bot
XopenDVS_pixel2x2_bot_500 rowReadOFF<60> rowReadOFF<61> rowReadON<61> RefrBp PrBp
+ PrSFBp col_periphery_1x2_30/COL_LINE0 pixRst<12> pixRst<13> col_periphery_1x2_30/COL_LINE1
+ OffBn openDVS_pixel2x2_bot_500/vpd[2] openDVS_pixel2x2_bot_500/vpd[3] openDVS_pixel2x2_bot_500/vpd[1]
+ openDVS_pixel2x2_bot_500/vpd[0] rowReadON<60> openDVS_pixel2x2_bot_902/GndD DiffBn
+ VSUBS VDD OnBn openDVS_pixel2x2_bot
XopenDVS_pixel2x2_bot_511 rowReadOFF<54> rowReadOFF<55> rowReadON<55> RefrBp PrBp
+ PrSFBp col_periphery_1x2_30/COL_LINE0 pixRst<12> pixRst<13> col_periphery_1x2_30/COL_LINE1
+ OffBn openDVS_pixel2x2_bot_511/vpd[2] openDVS_pixel2x2_bot_511/vpd[3] openDVS_pixel2x2_bot_511/vpd[1]
+ openDVS_pixel2x2_bot_511/vpd[0] rowReadON<54> openDVS_pixel2x2_bot_885/GndD DiffBn
+ VSUBS VDD OnBn openDVS_pixel2x2_bot
XopenDVS_pixel2x2_bot_544 rowReadOFF<58> rowReadOFF<59> rowReadON<59> RefrBp PrBp
+ PrSFBp col_periphery_1x2_27/COL_LINE0 pixRst<6> pixRst<7> col_periphery_1x2_27/COL_LINE1
+ OffBn openDVS_pixel2x2_bot_544/vpd[2] openDVS_pixel2x2_bot_544/vpd[3] openDVS_pixel2x2_bot_544/vpd[1]
+ openDVS_pixel2x2_bot_544/vpd[0] rowReadON<58> openDVS_pixel2x2_bot_890/GndD DiffBn
+ VSUBS VDD OnBn openDVS_pixel2x2_bot
XopenDVS_pixel2x2_bot_555 rowReadOFF<54> rowReadOFF<55> rowReadON<55> RefrBp PrBp
+ PrSFBp col_periphery_1x2_27/COL_LINE0 pixRst<6> pixRst<7> col_periphery_1x2_27/COL_LINE1
+ OffBn openDVS_pixel2x2_bot_555/vpd[2] openDVS_pixel2x2_bot_555/vpd[3] openDVS_pixel2x2_bot_555/vpd[1]
+ openDVS_pixel2x2_bot_555/vpd[0] rowReadON<54> openDVS_pixel2x2_bot_885/GndD DiffBn
+ VSUBS VDD OnBn openDVS_pixel2x2_bot
XopenDVS_pixel2x2_bot_566 rowReadOFF<52> rowReadOFF<53> rowReadON<53> RefrBp PrBp
+ PrSFBp col_periphery_1x2_22/COL_LINE0 pixRst<28> pixRst<29> col_periphery_1x2_22/COL_LINE1
+ OffBn openDVS_pixel2x2_bot_566/vpd[2] openDVS_pixel2x2_bot_566/vpd[3] openDVS_pixel2x2_bot_566/vpd[1]
+ openDVS_pixel2x2_bot_566/vpd[0] rowReadON<52> openDVS_pixel2x2_bot_882/GndD DiffBn
+ VSUBS VDD OnBn openDVS_pixel2x2_bot
XopenDVS_pixel2x2_bot_599 rowReadOFF<46> rowReadOFF<47> rowReadON<47> RefrBp PrBp
+ PrSFBp col_periphery_1x2_18/COL_LINE0 pixRst<20> pixRst<21> col_periphery_1x2_18/COL_LINE1
+ OffBn openDVS_pixel2x2_bot_599/vpd[2] openDVS_pixel2x2_bot_599/vpd[3] openDVS_pixel2x2_bot_599/vpd[1]
+ openDVS_pixel2x2_bot_599/vpd[0] rowReadON<46> openDVS_pixel2x2_bot_925/GndD DiffBn
+ VSUBS VDD OnBn openDVS_pixel2x2_bot
XopenDVS_pixel2x2_bot_533 rowReadOFF<50> rowReadOFF<51> rowReadON<51> RefrBp PrBp
+ PrSFBp col_periphery_1x2_27/COL_LINE0 pixRst<6> pixRst<7> col_periphery_1x2_27/COL_LINE1
+ OffBn openDVS_pixel2x2_bot_533/vpd[2] openDVS_pixel2x2_bot_533/vpd[3] openDVS_pixel2x2_bot_533/vpd[1]
+ openDVS_pixel2x2_bot_533/vpd[0] rowReadON<50> openDVS_pixel2x2_bot_929/GndD DiffBn
+ VSUBS VDD OnBn openDVS_pixel2x2_bot
XopenDVS_pixel2x2_bot_522 rowReadOFF<48> rowReadOFF<49> rowReadON<49> RefrBp PrBp
+ PrSFBp col_periphery_1x2_26/COL_LINE0 pixRst<4> pixRst<5> col_periphery_1x2_26/COL_LINE1
+ OffBn openDVS_pixel2x2_bot_522/vpd[2] openDVS_pixel2x2_bot_522/vpd[3] openDVS_pixel2x2_bot_522/vpd[1]
+ openDVS_pixel2x2_bot_522/vpd[0] rowReadON<48> openDVS_pixel2x2_bot_927/GndD DiffBn
+ VSUBS VDD OnBn openDVS_pixel2x2_bot
XopenDVS_pixel2x2_bot_396 rowReadOFF<32> rowReadOFF<33> rowReadON<33> RefrBp PrBp
+ PrSFBp col_periphery_1x2_18/COL_LINE0 pixRst<20> pixRst<21> col_periphery_1x2_18/COL_LINE1
+ OffBn openDVS_pixel2x2_bot_396/vpd[2] openDVS_pixel2x2_bot_396/vpd[3] openDVS_pixel2x2_bot_396/vpd[1]
+ openDVS_pixel2x2_bot_396/vpd[0] rowReadON<32> openDVS_pixel2x2_bot_993/GndD DiffBn
+ VSUBS VDD OnBn openDVS_pixel2x2_bot
XopenDVS_pixel2x2_bot_330 rowReadOFF<20> rowReadOFF<21> rowReadON<21> RefrBp PrBp
+ PrSFBp col_periphery_1x2_22/COL_LINE0 pixRst<28> pixRst<29> col_periphery_1x2_22/COL_LINE1
+ OffBn openDVS_pixel2x2_bot_330/vpd[2] openDVS_pixel2x2_bot_330/vpd[3] openDVS_pixel2x2_bot_330/vpd[1]
+ openDVS_pixel2x2_bot_330/vpd[0] rowReadON<20> openDVS_pixel2x2_bot_95/GndD DiffBn
+ VSUBS VDD OnBn openDVS_pixel2x2_bot
XopenDVS_pixel2x2_bot_385 rowReadOFF<18> rowReadOFF<19> rowReadON<19> RefrBp PrBp
+ PrSFBp col_periphery_1x2_31/COL_LINE0 pixRst<14> pixRst<15> col_periphery_1x2_31/COL_LINE1
+ OffBn openDVS_pixel2x2_bot_385/vpd[2] openDVS_pixel2x2_bot_385/vpd[3] openDVS_pixel2x2_bot_385/vpd[1]
+ openDVS_pixel2x2_bot_385/vpd[0] rowReadON<18> openDVS_pixel2x2_bot_69/GndD DiffBn
+ VSUBS VDD OnBn openDVS_pixel2x2_bot
XopenDVS_pixel2x2_bot_352 rowReadOFF<0> rowReadOFF<1> rowReadON<1> RefrBp PrBp PrSFBp
+ col_periphery_1x2_16/COL_LINE0 pixRst<16> pixRst<17> col_periphery_1x2_16/COL_LINE1
+ OffBn openDVS_pixel2x2_bot_352/vpd[2] openDVS_pixel2x2_bot_352/vpd[3] openDVS_pixel2x2_bot_352/vpd[1]
+ openDVS_pixel2x2_bot_352/vpd[0] rowReadON<0> GND DiffBn VSUBS VDD OnBn openDVS_pixel2x2_bot
XopenDVS_pixel2x2_bot_363 rowReadOFF<8> rowReadOFF<9> rowReadON<9> RefrBp PrBp PrSFBp
+ col_periphery_1x2_27/COL_LINE0 pixRst<6> pixRst<7> col_periphery_1x2_27/COL_LINE1
+ OffBn openDVS_pixel2x2_bot_363/vpd[2] openDVS_pixel2x2_bot_363/vpd[3] openDVS_pixel2x2_bot_363/vpd[1]
+ openDVS_pixel2x2_bot_363/vpd[0] rowReadON<8> openDVS_pixel2x2_bot_939/GndD DiffBn
+ VSUBS VDD OnBn openDVS_pixel2x2_bot
XopenDVS_pixel2x2_bot_341 rowReadOFF<6> rowReadOFF<7> rowReadON<7> RefrBp PrBp PrSFBp
+ col_periphery_1x2_21/COL_LINE0 pixRst<26> pixRst<27> col_periphery_1x2_21/COL_LINE1
+ OffBn openDVS_pixel2x2_bot_341/vpd[2] openDVS_pixel2x2_bot_341/vpd[3] openDVS_pixel2x2_bot_341/vpd[1]
+ openDVS_pixel2x2_bot_341/vpd[0] rowReadON<6> openDVS_pixel2x2_bot_937/GndD DiffBn
+ VSUBS VDD OnBn openDVS_pixel2x2_bot
XopenDVS_pixel2x2_bot_374 rowReadOFF<8> rowReadOFF<9> rowReadON<9> RefrBp PrBp PrSFBp
+ col_periphery_1x2_22/COL_LINE0 pixRst<28> pixRst<29> col_periphery_1x2_22/COL_LINE1
+ OffBn openDVS_pixel2x2_bot_374/vpd[2] openDVS_pixel2x2_bot_374/vpd[3] openDVS_pixel2x2_bot_374/vpd[1]
+ openDVS_pixel2x2_bot_374/vpd[0] rowReadON<8> openDVS_pixel2x2_bot_939/GndD DiffBn
+ VSUBS VDD OnBn openDVS_pixel2x2_bot
XopenDVS_pixel2x2_bot_160 rowReadOFF<22> rowReadOFF<23> rowReadON<23> RefrBp PrBp
+ PrSFBp col_periphery_1x2_15/COL_LINE0 pixRst<48> pixRst<49> col_periphery_1x2_15/COL_LINE1
+ OffBn openDVS_pixel2x2_bot_160/vpd[2] openDVS_pixel2x2_bot_160/vpd[3] openDVS_pixel2x2_bot_160/vpd[1]
+ openDVS_pixel2x2_bot_160/vpd[0] rowReadON<22> openDVS_pixel2x2_bot_97/GndD DiffBn
+ VSUBS VDD OnBn openDVS_pixel2x2_bot
XopenDVS_pixel2x2_bot_171 rowReadOFF<8> rowReadOFF<9> rowReadON<9> RefrBp PrBp PrSFBp
+ col_periphery_1x2_13/COL_LINE0 pixRst<44> pixRst<45> col_periphery_1x2_13/COL_LINE1
+ OffBn openDVS_pixel2x2_bot_171/vpd[2] openDVS_pixel2x2_bot_171/vpd[3] openDVS_pixel2x2_bot_171/vpd[1]
+ openDVS_pixel2x2_bot_171/vpd[0] rowReadON<8> openDVS_pixel2x2_bot_939/GndD DiffBn
+ VSUBS VDD OnBn openDVS_pixel2x2_bot
XopenDVS_pixel2x2_bot_182 rowReadOFF<10> rowReadOFF<11> rowReadON<11> RefrBp PrBp
+ PrSFBp col_periphery_1x2_14/COL_LINE0 pixRst<46> pixRst<47> col_periphery_1x2_14/COL_LINE1
+ OffBn openDVS_pixel2x2_bot_182/vpd[2] openDVS_pixel2x2_bot_182/vpd[3] openDVS_pixel2x2_bot_182/vpd[1]
+ openDVS_pixel2x2_bot_182/vpd[0] rowReadON<10> openDVS_pixel2x2_bot_82/GndD DiffBn
+ VSUBS VDD OnBn openDVS_pixel2x2_bot
XopenDVS_pixel2x2_bot_193 rowReadOFF<2> rowReadOFF<3> rowReadON<3> RefrBp PrBp PrSFBp
+ col_periphery_1x2_15/COL_LINE0 pixRst<48> pixRst<49> col_periphery_1x2_15/COL_LINE1
+ OffBn openDVS_pixel2x2_bot_193/vpd[2] openDVS_pixel2x2_bot_193/vpd[3] openDVS_pixel2x2_bot_193/vpd[1]
+ openDVS_pixel2x2_bot_193/vpd[0] rowReadON<2> openDVS_pixel2x2_bot_7/GndD DiffBn
+ VSUBS VDD OnBn openDVS_pixel2x2_bot
XopenDVS_pixel2x2_bot_918 rowReadOFF<44> rowReadOFF<45> rowReadON<45> RefrBp PrBp
+ PrSFBp col_periphery_1x2_1/COL_LINE0 pixRst<52> pixRst<53> col_periphery_1x2_1/COL_LINE1
+ OffBn openDVS_pixel2x2_bot_918/vpd[2] openDVS_pixel2x2_bot_918/vpd[3] openDVS_pixel2x2_bot_918/vpd[1]
+ openDVS_pixel2x2_bot_918/vpd[0] rowReadON<44> openDVS_pixel2x2_bot_923/GndD DiffBn
+ VSUBS VDD OnBn openDVS_pixel2x2_bot
XopenDVS_pixel2x2_bot_929 rowReadOFF<50> rowReadOFF<51> rowReadON<51> RefrBp PrBp
+ PrSFBp col_periphery_1x2_15/COL_LINE0 pixRst<48> pixRst<49> col_periphery_1x2_15/COL_LINE1
+ OffBn openDVS_pixel2x2_bot_929/vpd[2] openDVS_pixel2x2_bot_929/vpd[3] openDVS_pixel2x2_bot_929/vpd[1]
+ openDVS_pixel2x2_bot_929/vpd[0] rowReadON<50> openDVS_pixel2x2_bot_929/GndD DiffBn
+ VSUBS VDD OnBn openDVS_pixel2x2_bot
XopenDVS_pixel2x2_bot_907 rowReadOFF<42> rowReadOFF<43> rowReadON<43> RefrBp PrBp
+ PrSFBp col_periphery_1x2_14/COL_LINE0 pixRst<46> pixRst<47> col_periphery_1x2_14/COL_LINE1
+ OffBn openDVS_pixel2x2_bot_907/vpd[2] openDVS_pixel2x2_bot_907/vpd[3] openDVS_pixel2x2_bot_907/vpd[1]
+ openDVS_pixel2x2_bot_907/vpd[0] rowReadON<42> openDVS_pixel2x2_bot_908/GndD DiffBn
+ VSUBS VDD OnBn openDVS_pixel2x2_bot
XopenDVS_pixel2x2_bot_704 rowReadOFF<36> rowReadOFF<37> rowReadON<37> RefrBp PrBp
+ PrSFBp col_periphery_1x2_6/COL_LINE0 pixRst<62> pixRst<63> col_periphery_1x2_6/COL_LINE1
+ OffBn openDVS_pixel2x2_bot_704/vpd[2] openDVS_pixel2x2_bot_704/vpd[3] openDVS_pixel2x2_bot_704/vpd[1]
+ openDVS_pixel2x2_bot_704/vpd[0] rowReadON<36> openDVS_pixel2x2_bot_997/GndD DiffBn
+ VSUBS VDD OnBn openDVS_pixel2x2_bot
XopenDVS_pixel2x2_bot_715 rowReadOFF<42> rowReadOFF<43> rowReadON<43> RefrBp PrBp
+ PrSFBp col_periphery_1x2_1/COL_LINE0 pixRst<52> pixRst<53> col_periphery_1x2_1/COL_LINE1
+ OffBn openDVS_pixel2x2_bot_715/vpd[2] openDVS_pixel2x2_bot_715/vpd[3] openDVS_pixel2x2_bot_715/vpd[1]
+ openDVS_pixel2x2_bot_715/vpd[0] rowReadON<42> openDVS_pixel2x2_bot_908/GndD DiffBn
+ VSUBS VDD OnBn openDVS_pixel2x2_bot
XopenDVS_pixel2x2_bot_726 rowReadOFF<40> rowReadOFF<41> rowReadON<41> RefrBp PrBp
+ PrSFBp col_periphery_1x2_8/COL_LINE0 pixRst<42> pixRst<43> col_periphery_1x2_8/COL_LINE1
+ OffBn openDVS_pixel2x2_bot_726/vpd[2] openDVS_pixel2x2_bot_726/vpd[3] openDVS_pixel2x2_bot_726/vpd[1]
+ openDVS_pixel2x2_bot_726/vpd[0] rowReadON<40> openDVS_pixel2x2_bot_906/GndD DiffBn
+ VSUBS VDD OnBn openDVS_pixel2x2_bot
XopenDVS_pixel2x2_bot_737 rowReadOFF<38> rowReadOFF<39> rowReadON<39> RefrBp PrBp
+ PrSFBp col_periphery_1x2_11/COL_LINE0 pixRst<36> pixRst<37> col_periphery_1x2_11/COL_LINE1
+ OffBn openDVS_pixel2x2_bot_737/vpd[2] openDVS_pixel2x2_bot_737/vpd[3] openDVS_pixel2x2_bot_737/vpd[1]
+ openDVS_pixel2x2_bot_737/vpd[0] rowReadON<38> openDVS_pixel2x2_bot_999/GndD DiffBn
+ VSUBS VDD OnBn openDVS_pixel2x2_bot
XopenDVS_pixel2x2_bot_759 rowReadOFF<34> rowReadOFF<35> rowReadON<35> RefrBp PrBp
+ PrSFBp col_periphery_1x2_11/COL_LINE0 pixRst<36> pixRst<37> col_periphery_1x2_11/COL_LINE1
+ OffBn openDVS_pixel2x2_bot_759/vpd[2] openDVS_pixel2x2_bot_759/vpd[3] openDVS_pixel2x2_bot_759/vpd[1]
+ openDVS_pixel2x2_bot_759/vpd[0] rowReadON<34> openDVS_pixel2x2_bot_995/GndD DiffBn
+ VSUBS VDD OnBn openDVS_pixel2x2_bot
XopenDVS_pixel2x2_bot_748 rowReadOFF<32> rowReadOFF<33> rowReadON<33> RefrBp PrBp
+ PrSFBp col_periphery_1x2_10/COL_LINE0 pixRst<34> pixRst<35> col_periphery_1x2_10/COL_LINE1
+ OffBn openDVS_pixel2x2_bot_748/vpd[2] openDVS_pixel2x2_bot_748/vpd[3] openDVS_pixel2x2_bot_748/vpd[1]
+ openDVS_pixel2x2_bot_748/vpd[0] rowReadON<32> openDVS_pixel2x2_bot_993/GndD DiffBn
+ VSUBS VDD OnBn openDVS_pixel2x2_bot
XopenDVS_pixel2x2_bot_567 rowReadOFF<58> rowReadOFF<59> rowReadON<59> RefrBp PrBp
+ PrSFBp col_periphery_1x2_20/COL_LINE0 pixRst<24> pixRst<25> col_periphery_1x2_20/COL_LINE1
+ OffBn openDVS_pixel2x2_bot_567/vpd[2] openDVS_pixel2x2_bot_567/vpd[3] openDVS_pixel2x2_bot_567/vpd[1]
+ openDVS_pixel2x2_bot_567/vpd[0] rowReadON<58> openDVS_pixel2x2_bot_890/GndD DiffBn
+ VSUBS VDD OnBn openDVS_pixel2x2_bot
XopenDVS_pixel2x2_bot_589 rowReadOFF<56> rowReadOFF<57> rowReadON<57> RefrBp PrBp
+ PrSFBp col_periphery_1x2_18/COL_LINE0 pixRst<20> pixRst<21> col_periphery_1x2_18/COL_LINE1
+ OffBn openDVS_pixel2x2_bot_589/vpd[2] openDVS_pixel2x2_bot_589/vpd[3] openDVS_pixel2x2_bot_589/vpd[1]
+ openDVS_pixel2x2_bot_589/vpd[0] rowReadON<56> openDVS_pixel2x2_bot_888/GndD DiffBn
+ VSUBS VDD OnBn openDVS_pixel2x2_bot
XopenDVS_pixel2x2_bot_545 rowReadOFF<58> rowReadOFF<59> rowReadON<59> RefrBp PrBp
+ PrSFBp col_periphery_1x2_28/COL_LINE0 pixRst<8> pixRst<9> col_periphery_1x2_28/COL_LINE1
+ OffBn openDVS_pixel2x2_bot_545/vpd[2] openDVS_pixel2x2_bot_545/vpd[3] openDVS_pixel2x2_bot_545/vpd[1]
+ openDVS_pixel2x2_bot_545/vpd[0] rowReadON<58> openDVS_pixel2x2_bot_890/GndD DiffBn
+ VSUBS VDD OnBn openDVS_pixel2x2_bot
XopenDVS_pixel2x2_bot_556 rowReadOFF<54> rowReadOFF<55> rowReadON<55> RefrBp PrBp
+ PrSFBp col_periphery_1x2_28/COL_LINE0 pixRst<8> pixRst<9> col_periphery_1x2_28/COL_LINE1
+ OffBn openDVS_pixel2x2_bot_556/vpd[2] openDVS_pixel2x2_bot_556/vpd[3] openDVS_pixel2x2_bot_556/vpd[1]
+ openDVS_pixel2x2_bot_556/vpd[0] rowReadON<54> openDVS_pixel2x2_bot_885/GndD DiffBn
+ VSUBS VDD OnBn openDVS_pixel2x2_bot
XopenDVS_pixel2x2_bot_578 rowReadOFF<50> rowReadOFF<51> rowReadON<51> RefrBp PrBp
+ PrSFBp col_periphery_1x2_19/COL_LINE0 pixRst<22> pixRst<23> col_periphery_1x2_19/COL_LINE1
+ OffBn openDVS_pixel2x2_bot_578/vpd[2] openDVS_pixel2x2_bot_578/vpd[3] openDVS_pixel2x2_bot_578/vpd[1]
+ openDVS_pixel2x2_bot_578/vpd[0] rowReadON<50> openDVS_pixel2x2_bot_929/GndD DiffBn
+ VSUBS VDD OnBn openDVS_pixel2x2_bot
XopenDVS_pixel2x2_bot_534 rowReadOFF<50> rowReadOFF<51> rowReadON<51> RefrBp PrBp
+ PrSFBp col_periphery_1x2_28/COL_LINE0 pixRst<8> pixRst<9> col_periphery_1x2_28/COL_LINE1
+ OffBn openDVS_pixel2x2_bot_534/vpd[2] openDVS_pixel2x2_bot_534/vpd[3] openDVS_pixel2x2_bot_534/vpd[1]
+ openDVS_pixel2x2_bot_534/vpd[0] rowReadON<50> openDVS_pixel2x2_bot_929/GndD DiffBn
+ VSUBS VDD OnBn openDVS_pixel2x2_bot
XopenDVS_pixel2x2_bot_523 rowReadOFF<48> rowReadOFF<49> rowReadON<49> RefrBp PrBp
+ PrSFBp col_periphery_1x2_27/COL_LINE0 pixRst<6> pixRst<7> col_periphery_1x2_27/COL_LINE1
+ OffBn openDVS_pixel2x2_bot_523/vpd[2] openDVS_pixel2x2_bot_523/vpd[3] openDVS_pixel2x2_bot_523/vpd[1]
+ openDVS_pixel2x2_bot_523/vpd[0] rowReadON<48> openDVS_pixel2x2_bot_927/GndD DiffBn
+ VSUBS VDD OnBn openDVS_pixel2x2_bot
XopenDVS_pixel2x2_bot_501 rowReadOFF<52> rowReadOFF<53> rowReadON<53> RefrBp PrBp
+ PrSFBp col_periphery_1x2_24/COL_LINE0 pixRst<0> pixRst<1> col_periphery_1x2_24/COL_LINE1
+ OffBn openDVS_pixel2x2_bot_501/vpd[2] openDVS_pixel2x2_bot_501/vpd[3] openDVS_pixel2x2_bot_501/vpd[1]
+ openDVS_pixel2x2_bot_501/vpd[0] rowReadON<52> openDVS_pixel2x2_bot_882/GndD DiffBn
+ VSUBS VDD OnBn openDVS_pixel2x2_bot
XopenDVS_pixel2x2_bot_512 rowReadOFF<46> rowReadOFF<47> rowReadON<47> RefrBp PrBp
+ PrSFBp col_periphery_1x2_24/COL_LINE0 pixRst<0> pixRst<1> col_periphery_1x2_24/COL_LINE1
+ OffBn openDVS_pixel2x2_bot_512/vpd[2] openDVS_pixel2x2_bot_512/vpd[3] openDVS_pixel2x2_bot_512/vpd[1]
+ openDVS_pixel2x2_bot_512/vpd[0] rowReadON<46> openDVS_pixel2x2_bot_925/GndD DiffBn
+ VSUBS VDD OnBn openDVS_pixel2x2_bot
XopenDVS_pixel2x2_bot_397 rowReadOFF<32> rowReadOFF<33> rowReadON<33> RefrBp PrBp
+ PrSFBp col_periphery_1x2_19/COL_LINE0 pixRst<22> pixRst<23> col_periphery_1x2_19/COL_LINE1
+ OffBn openDVS_pixel2x2_bot_397/vpd[2] openDVS_pixel2x2_bot_397/vpd[3] openDVS_pixel2x2_bot_397/vpd[1]
+ openDVS_pixel2x2_bot_397/vpd[0] rowReadON<32> openDVS_pixel2x2_bot_993/GndD DiffBn
+ VSUBS VDD OnBn openDVS_pixel2x2_bot
XopenDVS_pixel2x2_bot_353 rowReadOFF<22> rowReadOFF<23> rowReadON<23> RefrBp PrBp
+ PrSFBp col_periphery_1x2_16/COL_LINE0 pixRst<16> pixRst<17> col_periphery_1x2_16/COL_LINE1
+ OffBn openDVS_pixel2x2_bot_353/vpd[2] openDVS_pixel2x2_bot_353/vpd[3] openDVS_pixel2x2_bot_353/vpd[1]
+ openDVS_pixel2x2_bot_353/vpd[0] rowReadON<22> openDVS_pixel2x2_bot_97/GndD DiffBn
+ VSUBS VDD OnBn openDVS_pixel2x2_bot
XopenDVS_pixel2x2_bot_320 rowReadOFF<20> rowReadOFF<21> rowReadON<21> RefrBp PrBp
+ PrSFBp col_periphery_1x2_18/COL_LINE0 pixRst<20> pixRst<21> col_periphery_1x2_18/COL_LINE1
+ OffBn openDVS_pixel2x2_bot_320/vpd[2] openDVS_pixel2x2_bot_320/vpd[3] openDVS_pixel2x2_bot_320/vpd[1]
+ openDVS_pixel2x2_bot_320/vpd[0] rowReadON<20> openDVS_pixel2x2_bot_95/GndD DiffBn
+ VSUBS VDD OnBn openDVS_pixel2x2_bot
XopenDVS_pixel2x2_bot_331 rowReadOFF<18> rowReadOFF<19> rowReadON<19> RefrBp PrBp
+ PrSFBp col_periphery_1x2_17/COL_LINE0 pixRst<18> pixRst<19> col_periphery_1x2_17/COL_LINE1
+ OffBn openDVS_pixel2x2_bot_331/vpd[2] openDVS_pixel2x2_bot_331/vpd[3] openDVS_pixel2x2_bot_331/vpd[1]
+ openDVS_pixel2x2_bot_331/vpd[0] rowReadON<18> openDVS_pixel2x2_bot_69/GndD DiffBn
+ VSUBS VDD OnBn openDVS_pixel2x2_bot
XopenDVS_pixel2x2_bot_386 rowReadOFF<18> rowReadOFF<19> rowReadON<19> RefrBp PrBp
+ PrSFBp col_periphery_1x2_16/COL_LINE0 pixRst<16> pixRst<17> col_periphery_1x2_16/COL_LINE1
+ OffBn openDVS_pixel2x2_bot_386/vpd[2] openDVS_pixel2x2_bot_386/vpd[3] openDVS_pixel2x2_bot_386/vpd[1]
+ openDVS_pixel2x2_bot_386/vpd[0] rowReadON<18> openDVS_pixel2x2_bot_69/GndD DiffBn
+ VSUBS VDD OnBn openDVS_pixel2x2_bot
XopenDVS_pixel2x2_bot_364 rowReadOFF<8> rowReadOFF<9> rowReadON<9> RefrBp PrBp PrSFBp
+ col_periphery_1x2_28/COL_LINE0 pixRst<8> pixRst<9> col_periphery_1x2_28/COL_LINE1
+ OffBn openDVS_pixel2x2_bot_364/vpd[2] openDVS_pixel2x2_bot_364/vpd[3] openDVS_pixel2x2_bot_364/vpd[1]
+ openDVS_pixel2x2_bot_364/vpd[0] rowReadON<8> openDVS_pixel2x2_bot_939/GndD DiffBn
+ VSUBS VDD OnBn openDVS_pixel2x2_bot
XopenDVS_pixel2x2_bot_375 rowReadOFF<10> rowReadOFF<11> rowReadON<11> RefrBp PrBp
+ PrSFBp col_periphery_1x2_31/COL_LINE0 pixRst<14> pixRst<15> col_periphery_1x2_31/COL_LINE1
+ OffBn openDVS_pixel2x2_bot_375/vpd[2] openDVS_pixel2x2_bot_375/vpd[3] openDVS_pixel2x2_bot_375/vpd[1]
+ openDVS_pixel2x2_bot_375/vpd[0] rowReadON<10> openDVS_pixel2x2_bot_82/GndD DiffBn
+ VSUBS VDD OnBn openDVS_pixel2x2_bot
XopenDVS_pixel2x2_bot_342 rowReadOFF<6> rowReadOFF<7> rowReadON<7> RefrBp PrBp PrSFBp
+ col_periphery_1x2_22/COL_LINE0 pixRst<28> pixRst<29> col_periphery_1x2_22/COL_LINE1
+ OffBn openDVS_pixel2x2_bot_342/vpd[2] openDVS_pixel2x2_bot_342/vpd[3] openDVS_pixel2x2_bot_342/vpd[1]
+ openDVS_pixel2x2_bot_342/vpd[0] rowReadON<6> openDVS_pixel2x2_bot_937/GndD DiffBn
+ VSUBS VDD OnBn openDVS_pixel2x2_bot
XopenDVS_pixel2x2_bot_194 rowReadOFF<22> rowReadOFF<23> rowReadON<23> RefrBp PrBp
+ PrSFBp col_periphery_1x2_14/COL_LINE0 pixRst<46> pixRst<47> col_periphery_1x2_14/COL_LINE1
+ OffBn openDVS_pixel2x2_bot_194/vpd[2] openDVS_pixel2x2_bot_194/vpd[3] openDVS_pixel2x2_bot_194/vpd[1]
+ openDVS_pixel2x2_bot_194/vpd[0] rowReadON<22> openDVS_pixel2x2_bot_97/GndD DiffBn
+ VSUBS VDD OnBn openDVS_pixel2x2_bot
XopenDVS_pixel2x2_bot_150 rowReadOFF<6> rowReadOFF<7> rowReadON<7> RefrBp PrBp PrSFBp
+ col_periphery_1x2_10/COL_LINE0 pixRst<34> pixRst<35> col_periphery_1x2_10/COL_LINE1
+ OffBn openDVS_pixel2x2_bot_150/vpd[2] openDVS_pixel2x2_bot_150/vpd[3] openDVS_pixel2x2_bot_150/vpd[1]
+ openDVS_pixel2x2_bot_150/vpd[0] rowReadON<6> openDVS_pixel2x2_bot_937/GndD DiffBn
+ VSUBS VDD OnBn openDVS_pixel2x2_bot
XopenDVS_pixel2x2_bot_172 rowReadOFF<8> rowReadOFF<9> rowReadON<9> RefrBp PrBp PrSFBp
+ col_periphery_1x2_14/COL_LINE0 pixRst<46> pixRst<47> col_periphery_1x2_14/COL_LINE1
+ OffBn openDVS_pixel2x2_bot_172/vpd[2] openDVS_pixel2x2_bot_172/vpd[3] openDVS_pixel2x2_bot_172/vpd[1]
+ openDVS_pixel2x2_bot_172/vpd[0] rowReadON<8> openDVS_pixel2x2_bot_939/GndD DiffBn
+ VSUBS VDD OnBn openDVS_pixel2x2_bot
XopenDVS_pixel2x2_bot_161 rowReadOFF<6> rowReadOFF<7> rowReadON<7> RefrBp PrBp PrSFBp
+ col_periphery_1x2_14/COL_LINE0 pixRst<46> pixRst<47> col_periphery_1x2_14/COL_LINE1
+ OffBn openDVS_pixel2x2_bot_161/vpd[2] openDVS_pixel2x2_bot_161/vpd[3] openDVS_pixel2x2_bot_161/vpd[1]
+ openDVS_pixel2x2_bot_161/vpd[0] rowReadON<6> openDVS_pixel2x2_bot_937/GndD DiffBn
+ VSUBS VDD OnBn openDVS_pixel2x2_bot
XopenDVS_pixel2x2_bot_183 rowReadOFF<10> rowReadOFF<11> rowReadON<11> RefrBp PrBp
+ PrSFBp col_periphery_1x2_15/COL_LINE0 pixRst<48> pixRst<49> col_periphery_1x2_15/COL_LINE1
+ OffBn openDVS_pixel2x2_bot_183/vpd[2] openDVS_pixel2x2_bot_183/vpd[3] openDVS_pixel2x2_bot_183/vpd[1]
+ openDVS_pixel2x2_bot_183/vpd[0] rowReadON<10> openDVS_pixel2x2_bot_82/GndD DiffBn
+ VSUBS VDD OnBn openDVS_pixel2x2_bot
XopenDVS_pixel2x2_bot_919 rowReadOFF<44> rowReadOFF<45> rowReadON<45> RefrBp PrBp
+ PrSFBp col_periphery_1x2_2/COL_LINE0 pixRst<54> pixRst<55> col_periphery_1x2_2/COL_LINE1
+ OffBn openDVS_pixel2x2_bot_919/vpd[2] openDVS_pixel2x2_bot_919/vpd[3] openDVS_pixel2x2_bot_919/vpd[1]
+ openDVS_pixel2x2_bot_919/vpd[0] rowReadON<44> openDVS_pixel2x2_bot_923/GndD DiffBn
+ VSUBS VDD OnBn openDVS_pixel2x2_bot
XopenDVS_pixel2x2_bot_908 rowReadOFF<42> rowReadOFF<43> rowReadON<43> RefrBp PrBp
+ PrSFBp col_periphery_1x2_15/COL_LINE0 pixRst<48> pixRst<49> col_periphery_1x2_15/COL_LINE1
+ OffBn openDVS_pixel2x2_bot_908/vpd[2] openDVS_pixel2x2_bot_908/vpd[3] openDVS_pixel2x2_bot_908/vpd[1]
+ openDVS_pixel2x2_bot_908/vpd[0] rowReadON<42> openDVS_pixel2x2_bot_908/GndD DiffBn
+ VSUBS VDD OnBn openDVS_pixel2x2_bot
XopenDVS_pixel2x2_bot_705 rowReadOFF<42> rowReadOFF<43> rowReadON<43> RefrBp PrBp
+ PrSFBp col_periphery_1x2_5/COL_LINE0 pixRst<60> pixRst<61> col_periphery_1x2_5/COL_LINE1
+ OffBn openDVS_pixel2x2_bot_705/vpd[2] openDVS_pixel2x2_bot_705/vpd[3] openDVS_pixel2x2_bot_705/vpd[1]
+ openDVS_pixel2x2_bot_705/vpd[0] rowReadON<42> openDVS_pixel2x2_bot_908/GndD DiffBn
+ VSUBS VDD OnBn openDVS_pixel2x2_bot
XopenDVS_pixel2x2_bot_727 rowReadOFF<40> rowReadOFF<41> rowReadON<41> RefrBp PrBp
+ PrSFBp col_periphery_1x2_13/COL_LINE0 pixRst<44> pixRst<45> col_periphery_1x2_13/COL_LINE1
+ OffBn openDVS_pixel2x2_bot_727/vpd[2] openDVS_pixel2x2_bot_727/vpd[3] openDVS_pixel2x2_bot_727/vpd[1]
+ openDVS_pixel2x2_bot_727/vpd[0] rowReadON<40> openDVS_pixel2x2_bot_906/GndD DiffBn
+ VSUBS VDD OnBn openDVS_pixel2x2_bot
XopenDVS_pixel2x2_bot_716 rowReadOFF<40> rowReadOFF<41> rowReadON<41> RefrBp PrBp
+ PrSFBp col_periphery_1x2_10/COL_LINE0 pixRst<34> pixRst<35> col_periphery_1x2_10/COL_LINE1
+ OffBn openDVS_pixel2x2_bot_716/vpd[2] openDVS_pixel2x2_bot_716/vpd[3] openDVS_pixel2x2_bot_716/vpd[1]
+ openDVS_pixel2x2_bot_716/vpd[0] rowReadON<40> openDVS_pixel2x2_bot_906/GndD DiffBn
+ VSUBS VDD OnBn openDVS_pixel2x2_bot
XopenDVS_pixel2x2_bot_749 rowReadOFF<32> rowReadOFF<33> rowReadON<33> RefrBp PrBp
+ PrSFBp col_periphery_1x2_11/COL_LINE0 pixRst<36> pixRst<37> col_periphery_1x2_11/COL_LINE1
+ OffBn openDVS_pixel2x2_bot_749/vpd[2] openDVS_pixel2x2_bot_749/vpd[3] openDVS_pixel2x2_bot_749/vpd[1]
+ openDVS_pixel2x2_bot_749/vpd[0] rowReadON<32> openDVS_pixel2x2_bot_993/GndD DiffBn
+ VSUBS VDD OnBn openDVS_pixel2x2_bot
XopenDVS_pixel2x2_bot_738 rowReadOFF<30> rowReadOFF<31> rowReadON<31> RefrBp PrBp
+ PrSFBp col_periphery_1x2_10/COL_LINE0 pixRst<34> pixRst<35> col_periphery_1x2_10/COL_LINE1
+ OffBn openDVS_pixel2x2_bot_738/vpd[2] openDVS_pixel2x2_bot_738/vpd[3] openDVS_pixel2x2_bot_738/vpd[1]
+ openDVS_pixel2x2_bot_738/vpd[0] rowReadON<30> openDVS_pixel2x2_bot_991/GndD DiffBn
+ VSUBS VDD OnBn openDVS_pixel2x2_bot
XopenDVS_pixel2x2_bot_568 rowReadOFF<58> rowReadOFF<59> rowReadON<59> RefrBp PrBp
+ PrSFBp col_periphery_1x2_21/COL_LINE0 pixRst<26> pixRst<27> col_periphery_1x2_21/COL_LINE1
+ OffBn openDVS_pixel2x2_bot_568/vpd[2] openDVS_pixel2x2_bot_568/vpd[3] openDVS_pixel2x2_bot_568/vpd[1]
+ openDVS_pixel2x2_bot_568/vpd[0] rowReadON<58> openDVS_pixel2x2_bot_890/GndD DiffBn
+ VSUBS VDD OnBn openDVS_pixel2x2_bot
XopenDVS_pixel2x2_bot_557 rowReadOFF<54> rowReadOFF<55> rowReadON<55> RefrBp PrBp
+ PrSFBp col_periphery_1x2_20/COL_LINE0 pixRst<24> pixRst<25> col_periphery_1x2_20/COL_LINE1
+ OffBn openDVS_pixel2x2_bot_557/vpd[2] openDVS_pixel2x2_bot_557/vpd[3] openDVS_pixel2x2_bot_557/vpd[1]
+ openDVS_pixel2x2_bot_557/vpd[0] rowReadON<54> openDVS_pixel2x2_bot_885/GndD DiffBn
+ VSUBS VDD OnBn openDVS_pixel2x2_bot
XopenDVS_pixel2x2_bot_546 rowReadOFF<58> rowReadOFF<59> rowReadON<59> RefrBp PrBp
+ PrSFBp col_periphery_1x2_29/COL_LINE0 pixRst<10> pixRst<11> col_periphery_1x2_29/COL_LINE1
+ OffBn openDVS_pixel2x2_bot_546/vpd[2] openDVS_pixel2x2_bot_546/vpd[3] openDVS_pixel2x2_bot_546/vpd[1]
+ openDVS_pixel2x2_bot_546/vpd[0] rowReadON<58> openDVS_pixel2x2_bot_890/GndD DiffBn
+ VSUBS VDD OnBn openDVS_pixel2x2_bot
XopenDVS_pixel2x2_bot_524 rowReadOFF<58> rowReadOFF<59> rowReadON<59> RefrBp PrBp
+ PrSFBp col_periphery_1x2_24/COL_LINE0 pixRst<0> pixRst<1> col_periphery_1x2_24/COL_LINE1
+ OffBn openDVS_pixel2x2_bot_524/vpd[2] openDVS_pixel2x2_bot_524/vpd[3] openDVS_pixel2x2_bot_524/vpd[1]
+ openDVS_pixel2x2_bot_524/vpd[0] rowReadON<58> openDVS_pixel2x2_bot_890/GndD DiffBn
+ VSUBS VDD OnBn openDVS_pixel2x2_bot
XopenDVS_pixel2x2_bot_579 rowReadOFF<50> rowReadOFF<51> rowReadON<51> RefrBp PrBp
+ PrSFBp col_periphery_1x2_20/COL_LINE0 pixRst<24> pixRst<25> col_periphery_1x2_20/COL_LINE1
+ OffBn openDVS_pixel2x2_bot_579/vpd[2] openDVS_pixel2x2_bot_579/vpd[3] openDVS_pixel2x2_bot_579/vpd[1]
+ openDVS_pixel2x2_bot_579/vpd[0] rowReadON<50> openDVS_pixel2x2_bot_929/GndD DiffBn
+ VSUBS VDD OnBn openDVS_pixel2x2_bot
XopenDVS_pixel2x2_bot_502 rowReadOFF<52> rowReadOFF<53> rowReadON<53> RefrBp PrBp
+ PrSFBp col_periphery_1x2_25/COL_LINE0 pixRst<2> pixRst<3> col_periphery_1x2_25/COL_LINE1
+ OffBn openDVS_pixel2x2_bot_502/vpd[2] openDVS_pixel2x2_bot_502/vpd[3] openDVS_pixel2x2_bot_502/vpd[1]
+ openDVS_pixel2x2_bot_502/vpd[0] rowReadON<52> openDVS_pixel2x2_bot_882/GndD DiffBn
+ VSUBS VDD OnBn openDVS_pixel2x2_bot
XopenDVS_pixel2x2_bot_535 rowReadOFF<50> rowReadOFF<51> rowReadON<51> RefrBp PrBp
+ PrSFBp col_periphery_1x2_24/COL_LINE0 pixRst<0> pixRst<1> col_periphery_1x2_24/COL_LINE1
+ OffBn openDVS_pixel2x2_bot_535/vpd[2] openDVS_pixel2x2_bot_535/vpd[3] openDVS_pixel2x2_bot_535/vpd[1]
+ openDVS_pixel2x2_bot_535/vpd[0] rowReadON<50> openDVS_pixel2x2_bot_929/GndD DiffBn
+ VSUBS VDD OnBn openDVS_pixel2x2_bot
XopenDVS_pixel2x2_bot_513 rowReadOFF<46> rowReadOFF<47> rowReadON<47> RefrBp PrBp
+ PrSFBp col_periphery_1x2_25/COL_LINE0 pixRst<2> pixRst<3> col_periphery_1x2_25/COL_LINE1
+ OffBn openDVS_pixel2x2_bot_513/vpd[2] openDVS_pixel2x2_bot_513/vpd[3] openDVS_pixel2x2_bot_513/vpd[1]
+ openDVS_pixel2x2_bot_513/vpd[0] rowReadON<46> openDVS_pixel2x2_bot_925/GndD DiffBn
+ VSUBS VDD OnBn openDVS_pixel2x2_bot
XopenDVS_pixel2x2_bot_398 rowReadOFF<32> rowReadOFF<33> rowReadON<33> RefrBp PrBp
+ PrSFBp col_periphery_1x2_20/COL_LINE0 pixRst<24> pixRst<25> col_periphery_1x2_20/COL_LINE1
+ OffBn openDVS_pixel2x2_bot_398/vpd[2] openDVS_pixel2x2_bot_398/vpd[3] openDVS_pixel2x2_bot_398/vpd[1]
+ openDVS_pixel2x2_bot_398/vpd[0] rowReadON<32> openDVS_pixel2x2_bot_993/GndD DiffBn
+ VSUBS VDD OnBn openDVS_pixel2x2_bot
XopenDVS_pixel2x2_bot_310 rowReadOFF<22> rowReadOFF<23> rowReadON<23> RefrBp PrBp
+ PrSFBp col_periphery_1x2_18/COL_LINE0 pixRst<20> pixRst<21> col_periphery_1x2_18/COL_LINE1
+ OffBn openDVS_pixel2x2_bot_310/vpd[2] openDVS_pixel2x2_bot_310/vpd[3] openDVS_pixel2x2_bot_310/vpd[1]
+ openDVS_pixel2x2_bot_310/vpd[0] rowReadON<22> openDVS_pixel2x2_bot_97/GndD DiffBn
+ VSUBS VDD OnBn openDVS_pixel2x2_bot
XopenDVS_pixel2x2_bot_332 rowReadOFF<18> rowReadOFF<19> rowReadON<19> RefrBp PrBp
+ PrSFBp col_periphery_1x2_18/COL_LINE0 pixRst<20> pixRst<21> col_periphery_1x2_18/COL_LINE1
+ OffBn openDVS_pixel2x2_bot_332/vpd[2] openDVS_pixel2x2_bot_332/vpd[3] openDVS_pixel2x2_bot_332/vpd[1]
+ openDVS_pixel2x2_bot_332/vpd[0] rowReadON<18> openDVS_pixel2x2_bot_69/GndD DiffBn
+ VSUBS VDD OnBn openDVS_pixel2x2_bot
XopenDVS_pixel2x2_bot_321 rowReadOFF<16> rowReadOFF<17> rowReadON<17> RefrBp PrBp
+ PrSFBp col_periphery_1x2_17/COL_LINE0 pixRst<18> pixRst<19> col_periphery_1x2_17/COL_LINE1
+ OffBn openDVS_pixel2x2_bot_321/vpd[2] openDVS_pixel2x2_bot_321/vpd[3] openDVS_pixel2x2_bot_321/vpd[1]
+ openDVS_pixel2x2_bot_321/vpd[0] rowReadON<16> openDVS_pixel2x2_bot_91/GndD DiffBn
+ VSUBS VDD OnBn openDVS_pixel2x2_bot
XopenDVS_pixel2x2_bot_387 rowReadOFF<20> rowReadOFF<21> rowReadON<21> RefrBp PrBp
+ PrSFBp col_periphery_1x2_31/COL_LINE0 pixRst<14> pixRst<15> col_periphery_1x2_31/COL_LINE1
+ OffBn openDVS_pixel2x2_bot_387/vpd[2] openDVS_pixel2x2_bot_387/vpd[3] openDVS_pixel2x2_bot_387/vpd[1]
+ openDVS_pixel2x2_bot_387/vpd[0] rowReadON<20> openDVS_pixel2x2_bot_95/GndD DiffBn
+ VSUBS VDD OnBn openDVS_pixel2x2_bot
XopenDVS_pixel2x2_bot_365 rowReadOFF<8> rowReadOFF<9> rowReadON<9> RefrBp PrBp PrSFBp
+ col_periphery_1x2_29/COL_LINE0 pixRst<10> pixRst<11> col_periphery_1x2_29/COL_LINE1
+ OffBn openDVS_pixel2x2_bot_365/vpd[2] openDVS_pixel2x2_bot_365/vpd[3] openDVS_pixel2x2_bot_365/vpd[1]
+ openDVS_pixel2x2_bot_365/vpd[0] rowReadON<8> openDVS_pixel2x2_bot_939/GndD DiffBn
+ VSUBS VDD OnBn openDVS_pixel2x2_bot
XopenDVS_pixel2x2_bot_354 rowReadOFF<2> rowReadOFF<3> rowReadON<3> RefrBp PrBp PrSFBp
+ col_periphery_1x2_31/COL_LINE0 pixRst<14> pixRst<15> col_periphery_1x2_31/COL_LINE1
+ OffBn openDVS_pixel2x2_bot_354/vpd[2] openDVS_pixel2x2_bot_354/vpd[3] openDVS_pixel2x2_bot_354/vpd[1]
+ openDVS_pixel2x2_bot_354/vpd[0] rowReadON<2> openDVS_pixel2x2_bot_7/GndD DiffBn
+ VSUBS VDD OnBn openDVS_pixel2x2_bot
XopenDVS_pixel2x2_bot_376 rowReadOFF<10> rowReadOFF<11> rowReadON<11> RefrBp PrBp
+ PrSFBp col_periphery_1x2_16/COL_LINE0 pixRst<16> pixRst<17> col_periphery_1x2_16/COL_LINE1
+ OffBn openDVS_pixel2x2_bot_376/vpd[2] openDVS_pixel2x2_bot_376/vpd[3] openDVS_pixel2x2_bot_376/vpd[1]
+ openDVS_pixel2x2_bot_376/vpd[0] rowReadON<10> openDVS_pixel2x2_bot_82/GndD DiffBn
+ VSUBS VDD OnBn openDVS_pixel2x2_bot
XopenDVS_pixel2x2_bot_343 rowReadOFF<6> rowReadOFF<7> rowReadON<7> RefrBp PrBp PrSFBp
+ col_periphery_1x2_17/COL_LINE0 pixRst<18> pixRst<19> col_periphery_1x2_17/COL_LINE1
+ OffBn openDVS_pixel2x2_bot_343/vpd[2] openDVS_pixel2x2_bot_343/vpd[3] openDVS_pixel2x2_bot_343/vpd[1]
+ openDVS_pixel2x2_bot_343/vpd[0] rowReadON<6> openDVS_pixel2x2_bot_937/GndD DiffBn
+ VSUBS VDD OnBn openDVS_pixel2x2_bot
XopenDVS_pixel2x2_bot_140 rowReadOFF<12> rowReadOFF<13> rowReadON<13> RefrBp PrBp
+ PrSFBp col_periphery_1x2_5/COL_LINE0 pixRst<60> pixRst<61> col_periphery_1x2_5/COL_LINE1
+ OffBn openDVS_pixel2x2_bot_140/vpd[2] openDVS_pixel2x2_bot_140/vpd[3] openDVS_pixel2x2_bot_140/vpd[1]
+ openDVS_pixel2x2_bot_140/vpd[0] rowReadON<12> openDVS_pixel2x2_bot_79/GndD DiffBn
+ VSUBS VDD OnBn openDVS_pixel2x2_bot
XopenDVS_pixel2x2_bot_151 rowReadOFF<6> rowReadOFF<7> rowReadON<7> RefrBp PrBp PrSFBp
+ col_periphery_1x2_11/COL_LINE0 pixRst<36> pixRst<37> col_periphery_1x2_11/COL_LINE1
+ OffBn openDVS_pixel2x2_bot_151/vpd[2] openDVS_pixel2x2_bot_151/vpd[3] openDVS_pixel2x2_bot_151/vpd[1]
+ openDVS_pixel2x2_bot_151/vpd[0] rowReadON<6> openDVS_pixel2x2_bot_937/GndD DiffBn
+ VSUBS VDD OnBn openDVS_pixel2x2_bot
XopenDVS_pixel2x2_bot_173 rowReadOFF<8> rowReadOFF<9> rowReadON<9> RefrBp PrBp PrSFBp
+ col_periphery_1x2_15/COL_LINE0 pixRst<48> pixRst<49> col_periphery_1x2_15/COL_LINE1
+ OffBn openDVS_pixel2x2_bot_173/vpd[2] openDVS_pixel2x2_bot_173/vpd[3] openDVS_pixel2x2_bot_173/vpd[1]
+ openDVS_pixel2x2_bot_173/vpd[0] rowReadON<8> openDVS_pixel2x2_bot_939/GndD DiffBn
+ VSUBS VDD OnBn openDVS_pixel2x2_bot
XopenDVS_pixel2x2_bot_162 rowReadOFF<6> rowReadOFF<7> rowReadON<7> RefrBp PrBp PrSFBp
+ col_periphery_1x2_15/COL_LINE0 pixRst<48> pixRst<49> col_periphery_1x2_15/COL_LINE1
+ OffBn openDVS_pixel2x2_bot_162/vpd[2] openDVS_pixel2x2_bot_162/vpd[3] openDVS_pixel2x2_bot_162/vpd[1]
+ openDVS_pixel2x2_bot_162/vpd[0] rowReadON<6> openDVS_pixel2x2_bot_937/GndD DiffBn
+ VSUBS VDD OnBn openDVS_pixel2x2_bot
XopenDVS_pixel2x2_bot_184 rowReadOFF<24> rowReadOFF<25> rowReadON<25> RefrBp PrBp
+ PrSFBp col_periphery_1x2_14/COL_LINE0 pixRst<46> pixRst<47> col_periphery_1x2_14/COL_LINE1
+ OffBn openDVS_pixel2x2_bot_184/vpd[2] openDVS_pixel2x2_bot_184/vpd[3] openDVS_pixel2x2_bot_184/vpd[1]
+ openDVS_pixel2x2_bot_184/vpd[0] rowReadON<24> openDVS_pixel2x2_bot_99/GndD DiffBn
+ VSUBS VDD OnBn openDVS_pixel2x2_bot
XopenDVS_pixel2x2_bot_195 rowReadOFF<4> rowReadOFF<5> rowReadON<5> RefrBp PrBp PrSFBp
+ col_periphery_1x2_20/COL_LINE0 pixRst<24> pixRst<25> col_periphery_1x2_20/COL_LINE1
+ OffBn openDVS_pixel2x2_bot_195/vpd[2] openDVS_pixel2x2_bot_195/vpd[3] openDVS_pixel2x2_bot_195/vpd[1]
+ openDVS_pixel2x2_bot_195/vpd[0] rowReadON<4> openDVS_pixel2x2_bot_6/GndD DiffBn
+ VSUBS VDD OnBn openDVS_pixel2x2_bot
XopenDVS_pixel2x2_bot_909 rowReadOFF<44> rowReadOFF<45> rowReadON<45> RefrBp PrBp
+ PrSFBp col_periphery_1x2_10/COL_LINE0 pixRst<34> pixRst<35> col_periphery_1x2_10/COL_LINE1
+ OffBn openDVS_pixel2x2_bot_909/vpd[2] openDVS_pixel2x2_bot_909/vpd[3] openDVS_pixel2x2_bot_909/vpd[1]
+ openDVS_pixel2x2_bot_909/vpd[0] rowReadON<44> openDVS_pixel2x2_bot_923/GndD DiffBn
+ VSUBS VDD OnBn openDVS_pixel2x2_bot
XopenDVS_pixel2x2_bot_717 rowReadOFF<40> rowReadOFF<41> rowReadON<41> RefrBp PrBp
+ PrSFBp col_periphery_1x2_11/COL_LINE0 pixRst<36> pixRst<37> col_periphery_1x2_11/COL_LINE1
+ OffBn openDVS_pixel2x2_bot_717/vpd[2] openDVS_pixel2x2_bot_717/vpd[3] openDVS_pixel2x2_bot_717/vpd[1]
+ openDVS_pixel2x2_bot_717/vpd[0] rowReadON<40> openDVS_pixel2x2_bot_906/GndD DiffBn
+ VSUBS VDD OnBn openDVS_pixel2x2_bot
XopenDVS_pixel2x2_bot_706 rowReadOFF<32> rowReadOFF<33> rowReadON<33> RefrBp PrBp
+ PrSFBp col_periphery_1x2_0/COL_LINE0 pixRst<50> pixRst<51> col_periphery_1x2_0/COL_LINE1
+ OffBn openDVS_pixel2x2_bot_706/vpd[2] openDVS_pixel2x2_bot_706/vpd[3] openDVS_pixel2x2_bot_706/vpd[1]
+ openDVS_pixel2x2_bot_706/vpd[0] rowReadON<32> openDVS_pixel2x2_bot_993/GndD DiffBn
+ VSUBS VDD OnBn openDVS_pixel2x2_bot
XopenDVS_pixel2x2_bot_739 rowReadOFF<30> rowReadOFF<31> rowReadON<31> RefrBp PrBp
+ PrSFBp col_periphery_1x2_11/COL_LINE0 pixRst<36> pixRst<37> col_periphery_1x2_11/COL_LINE1
+ OffBn openDVS_pixel2x2_bot_739/vpd[2] openDVS_pixel2x2_bot_739/vpd[3] openDVS_pixel2x2_bot_739/vpd[1]
+ openDVS_pixel2x2_bot_739/vpd[0] rowReadON<30> openDVS_pixel2x2_bot_991/GndD DiffBn
+ VSUBS VDD OnBn openDVS_pixel2x2_bot
XopenDVS_pixel2x2_bot_728 rowReadOFF<28> rowReadOFF<29> rowReadON<29> RefrBp PrBp
+ PrSFBp col_periphery_1x2_10/COL_LINE0 pixRst<34> pixRst<35> col_periphery_1x2_10/COL_LINE1
+ OffBn openDVS_pixel2x2_bot_728/vpd[2] openDVS_pixel2x2_bot_728/vpd[3] openDVS_pixel2x2_bot_728/vpd[1]
+ openDVS_pixel2x2_bot_728/vpd[0] rowReadON<28> openDVS_pixel2x2_bot_989/GndD DiffBn
+ VSUBS VDD OnBn openDVS_pixel2x2_bot
XopenDVS_pixel2x2_bot_558 rowReadOFF<54> rowReadOFF<55> rowReadON<55> RefrBp PrBp
+ PrSFBp col_periphery_1x2_21/COL_LINE0 pixRst<26> pixRst<27> col_periphery_1x2_21/COL_LINE1
+ OffBn openDVS_pixel2x2_bot_558/vpd[2] openDVS_pixel2x2_bot_558/vpd[3] openDVS_pixel2x2_bot_558/vpd[1]
+ openDVS_pixel2x2_bot_558/vpd[0] rowReadON<54> openDVS_pixel2x2_bot_885/GndD DiffBn
+ VSUBS VDD OnBn openDVS_pixel2x2_bot
XopenDVS_pixel2x2_bot_569 rowReadOFF<60> rowReadOFF<61> rowReadON<61> RefrBp PrBp
+ PrSFBp col_periphery_1x2_17/COL_LINE0 pixRst<18> pixRst<19> col_periphery_1x2_17/COL_LINE1
+ OffBn openDVS_pixel2x2_bot_569/vpd[2] openDVS_pixel2x2_bot_569/vpd[3] openDVS_pixel2x2_bot_569/vpd[1]
+ openDVS_pixel2x2_bot_569/vpd[0] rowReadON<60> openDVS_pixel2x2_bot_902/GndD DiffBn
+ VSUBS VDD OnBn openDVS_pixel2x2_bot
XopenDVS_pixel2x2_bot_547 rowReadOFF<58> rowReadOFF<59> rowReadON<59> RefrBp PrBp
+ PrSFBp col_periphery_1x2_30/COL_LINE0 pixRst<12> pixRst<13> col_periphery_1x2_30/COL_LINE1
+ OffBn openDVS_pixel2x2_bot_547/vpd[2] openDVS_pixel2x2_bot_547/vpd[3] openDVS_pixel2x2_bot_547/vpd[1]
+ openDVS_pixel2x2_bot_547/vpd[0] rowReadON<58> openDVS_pixel2x2_bot_890/GndD DiffBn
+ VSUBS VDD OnBn openDVS_pixel2x2_bot
XopenDVS_pixel2x2_bot_536 rowReadOFF<62> rowReadOFF<63> rowReadON<63> RefrBp PrBp
+ PrSFBp col_periphery_1x2_25/COL_LINE0 pixRst<2> pixRst<3> col_periphery_1x2_25/COL_LINE1
+ OffBn openDVS_pixel2x2_bot_536/vpd[2] openDVS_pixel2x2_bot_536/vpd[3] openDVS_pixel2x2_bot_536/vpd[1]
+ openDVS_pixel2x2_bot_536/vpd[0] rowReadON<62> openDVS_pixel2x2_bot_886/GndD DiffBn
+ VSUBS VDD OnBn openDVS_pixel2x2_bot
XopenDVS_pixel2x2_bot_525 rowReadOFF<48> rowReadOFF<49> rowReadON<49> RefrBp PrBp
+ PrSFBp col_periphery_1x2_28/COL_LINE0 pixRst<8> pixRst<9> col_periphery_1x2_28/COL_LINE1
+ OffBn openDVS_pixel2x2_bot_525/vpd[2] openDVS_pixel2x2_bot_525/vpd[3] openDVS_pixel2x2_bot_525/vpd[1]
+ openDVS_pixel2x2_bot_525/vpd[0] rowReadON<48> openDVS_pixel2x2_bot_927/GndD DiffBn
+ VSUBS VDD OnBn openDVS_pixel2x2_bot
XopenDVS_pixel2x2_bot_503 rowReadOFF<52> rowReadOFF<53> rowReadON<53> RefrBp PrBp
+ PrSFBp col_periphery_1x2_26/COL_LINE0 pixRst<4> pixRst<5> col_periphery_1x2_26/COL_LINE1
+ OffBn openDVS_pixel2x2_bot_503/vpd[2] openDVS_pixel2x2_bot_503/vpd[3] openDVS_pixel2x2_bot_503/vpd[1]
+ openDVS_pixel2x2_bot_503/vpd[0] rowReadON<52> openDVS_pixel2x2_bot_882/GndD DiffBn
+ VSUBS VDD OnBn openDVS_pixel2x2_bot
XopenDVS_pixel2x2_bot_514 rowReadOFF<46> rowReadOFF<47> rowReadON<47> RefrBp PrBp
+ PrSFBp col_periphery_1x2_26/COL_LINE0 pixRst<4> pixRst<5> col_periphery_1x2_26/COL_LINE1
+ OffBn openDVS_pixel2x2_bot_514/vpd[2] openDVS_pixel2x2_bot_514/vpd[3] openDVS_pixel2x2_bot_514/vpd[1]
+ openDVS_pixel2x2_bot_514/vpd[0] rowReadON<46> openDVS_pixel2x2_bot_925/GndD DiffBn
+ VSUBS VDD OnBn openDVS_pixel2x2_bot
XopenDVS_pixel2x2_bot_311 rowReadOFF<22> rowReadOFF<23> rowReadON<23> RefrBp PrBp
+ PrSFBp col_periphery_1x2_19/COL_LINE0 pixRst<22> pixRst<23> col_periphery_1x2_19/COL_LINE1
+ OffBn openDVS_pixel2x2_bot_311/vpd[2] openDVS_pixel2x2_bot_311/vpd[3] openDVS_pixel2x2_bot_311/vpd[1]
+ openDVS_pixel2x2_bot_311/vpd[0] rowReadON<22> openDVS_pixel2x2_bot_97/GndD DiffBn
+ VSUBS VDD OnBn openDVS_pixel2x2_bot
XopenDVS_pixel2x2_bot_399 rowReadOFF<30> rowReadOFF<31> rowReadON<31> RefrBp PrBp
+ PrSFBp col_periphery_1x2_17/COL_LINE0 pixRst<18> pixRst<19> col_periphery_1x2_17/COL_LINE1
+ OffBn openDVS_pixel2x2_bot_399/vpd[2] openDVS_pixel2x2_bot_399/vpd[3] openDVS_pixel2x2_bot_399/vpd[1]
+ openDVS_pixel2x2_bot_399/vpd[0] rowReadON<30> openDVS_pixel2x2_bot_991/GndD DiffBn
+ VSUBS VDD OnBn openDVS_pixel2x2_bot
XopenDVS_pixel2x2_bot_322 rowReadOFF<16> rowReadOFF<17> rowReadON<17> RefrBp PrBp
+ PrSFBp col_periphery_1x2_18/COL_LINE0 pixRst<20> pixRst<21> col_periphery_1x2_18/COL_LINE1
+ OffBn openDVS_pixel2x2_bot_322/vpd[2] openDVS_pixel2x2_bot_322/vpd[3] openDVS_pixel2x2_bot_322/vpd[1]
+ openDVS_pixel2x2_bot_322/vpd[0] rowReadON<16> openDVS_pixel2x2_bot_91/GndD DiffBn
+ VSUBS VDD OnBn openDVS_pixel2x2_bot
XopenDVS_pixel2x2_bot_333 rowReadOFF<18> rowReadOFF<19> rowReadON<19> RefrBp PrBp
+ PrSFBp col_periphery_1x2_19/COL_LINE0 pixRst<22> pixRst<23> col_periphery_1x2_19/COL_LINE1
+ OffBn openDVS_pixel2x2_bot_333/vpd[2] openDVS_pixel2x2_bot_333/vpd[3] openDVS_pixel2x2_bot_333/vpd[1]
+ openDVS_pixel2x2_bot_333/vpd[0] rowReadON<18> openDVS_pixel2x2_bot_69/GndD DiffBn
+ VSUBS VDD OnBn openDVS_pixel2x2_bot
XopenDVS_pixel2x2_bot_300 rowReadOFF<12> rowReadOFF<13> rowReadON<13> RefrBp PrBp
+ PrSFBp col_periphery_1x2_19/COL_LINE0 pixRst<22> pixRst<23> col_periphery_1x2_19/COL_LINE1
+ OffBn openDVS_pixel2x2_bot_300/vpd[2] openDVS_pixel2x2_bot_300/vpd[3] openDVS_pixel2x2_bot_300/vpd[1]
+ openDVS_pixel2x2_bot_300/vpd[0] rowReadON<12> openDVS_pixel2x2_bot_79/GndD DiffBn
+ VSUBS VDD OnBn openDVS_pixel2x2_bot
XopenDVS_pixel2x2_bot_388 rowReadOFF<20> rowReadOFF<21> rowReadON<21> RefrBp PrBp
+ PrSFBp col_periphery_1x2_16/COL_LINE0 pixRst<16> pixRst<17> col_periphery_1x2_16/COL_LINE1
+ OffBn openDVS_pixel2x2_bot_388/vpd[2] openDVS_pixel2x2_bot_388/vpd[3] openDVS_pixel2x2_bot_388/vpd[1]
+ openDVS_pixel2x2_bot_388/vpd[0] rowReadON<20> openDVS_pixel2x2_bot_95/GndD DiffBn
+ VSUBS VDD OnBn openDVS_pixel2x2_bot
XopenDVS_pixel2x2_bot_377 rowReadOFF<12> rowReadOFF<13> rowReadON<13> RefrBp PrBp
+ PrSFBp col_periphery_1x2_31/COL_LINE0 pixRst<14> pixRst<15> col_periphery_1x2_31/COL_LINE1
+ OffBn openDVS_pixel2x2_bot_377/vpd[2] openDVS_pixel2x2_bot_377/vpd[3] openDVS_pixel2x2_bot_377/vpd[1]
+ openDVS_pixel2x2_bot_377/vpd[0] rowReadON<12> openDVS_pixel2x2_bot_79/GndD DiffBn
+ VSUBS VDD OnBn openDVS_pixel2x2_bot
XopenDVS_pixel2x2_bot_344 rowReadOFF<6> rowReadOFF<7> rowReadON<7> RefrBp PrBp PrSFBp
+ col_periphery_1x2_27/COL_LINE0 pixRst<6> pixRst<7> col_periphery_1x2_27/COL_LINE1
+ OffBn openDVS_pixel2x2_bot_344/vpd[2] openDVS_pixel2x2_bot_344/vpd[3] openDVS_pixel2x2_bot_344/vpd[1]
+ openDVS_pixel2x2_bot_344/vpd[0] rowReadON<6> openDVS_pixel2x2_bot_937/GndD DiffBn
+ VSUBS VDD OnBn openDVS_pixel2x2_bot
XopenDVS_pixel2x2_bot_366 rowReadOFF<8> rowReadOFF<9> rowReadON<9> RefrBp PrBp PrSFBp
+ col_periphery_1x2_30/COL_LINE0 pixRst<12> pixRst<13> col_periphery_1x2_30/COL_LINE1
+ OffBn openDVS_pixel2x2_bot_366/vpd[2] openDVS_pixel2x2_bot_366/vpd[3] openDVS_pixel2x2_bot_366/vpd[1]
+ openDVS_pixel2x2_bot_366/vpd[0] rowReadON<8> openDVS_pixel2x2_bot_939/GndD DiffBn
+ VSUBS VDD OnBn openDVS_pixel2x2_bot
XopenDVS_pixel2x2_bot_355 rowReadOFF<2> rowReadOFF<3> rowReadON<3> RefrBp PrBp PrSFBp
+ col_periphery_1x2_16/COL_LINE0 pixRst<16> pixRst<17> col_periphery_1x2_16/COL_LINE1
+ OffBn openDVS_pixel2x2_bot_355/vpd[2] openDVS_pixel2x2_bot_355/vpd[3] openDVS_pixel2x2_bot_355/vpd[1]
+ openDVS_pixel2x2_bot_355/vpd[0] rowReadON<2> openDVS_pixel2x2_bot_7/GndD DiffBn
+ VSUBS VDD OnBn openDVS_pixel2x2_bot
XopenDVS_pixel2x2_bot_185 rowReadOFF<24> rowReadOFF<25> rowReadON<25> RefrBp PrBp
+ PrSFBp col_periphery_1x2_15/COL_LINE0 pixRst<48> pixRst<49> col_periphery_1x2_15/COL_LINE1
+ OffBn openDVS_pixel2x2_bot_185/vpd[2] openDVS_pixel2x2_bot_185/vpd[3] openDVS_pixel2x2_bot_185/vpd[1]
+ openDVS_pixel2x2_bot_185/vpd[0] rowReadON<24> openDVS_pixel2x2_bot_99/GndD DiffBn
+ VSUBS VDD OnBn openDVS_pixel2x2_bot
XopenDVS_pixel2x2_bot_130 rowReadOFF<18> rowReadOFF<19> rowReadON<19> RefrBp PrBp
+ PrSFBp col_periphery_1x2_0/COL_LINE0 pixRst<50> pixRst<51> col_periphery_1x2_0/COL_LINE1
+ OffBn openDVS_pixel2x2_bot_130/vpd[2] openDVS_pixel2x2_bot_130/vpd[3] openDVS_pixel2x2_bot_130/vpd[1]
+ openDVS_pixel2x2_bot_130/vpd[0] rowReadON<18> openDVS_pixel2x2_bot_69/GndD DiffBn
+ VSUBS VDD OnBn openDVS_pixel2x2_bot
XopenDVS_pixel2x2_bot_141 rowReadOFF<16> rowReadOFF<17> rowReadON<17> RefrBp PrBp
+ PrSFBp col_periphery_1x2_0/COL_LINE0 pixRst<50> pixRst<51> col_periphery_1x2_0/COL_LINE1
+ OffBn openDVS_pixel2x2_bot_141/vpd[2] openDVS_pixel2x2_bot_141/vpd[3] openDVS_pixel2x2_bot_141/vpd[1]
+ openDVS_pixel2x2_bot_141/vpd[0] rowReadON<16> openDVS_pixel2x2_bot_91/GndD DiffBn
+ VSUBS VDD OnBn openDVS_pixel2x2_bot
XopenDVS_pixel2x2_bot_163 rowReadOFF<20> rowReadOFF<21> rowReadON<21> RefrBp PrBp
+ PrSFBp col_periphery_1x2_14/COL_LINE0 pixRst<46> pixRst<47> col_periphery_1x2_14/COL_LINE1
+ OffBn openDVS_pixel2x2_bot_163/vpd[2] openDVS_pixel2x2_bot_163/vpd[3] openDVS_pixel2x2_bot_163/vpd[1]
+ openDVS_pixel2x2_bot_163/vpd[0] rowReadON<20> openDVS_pixel2x2_bot_95/GndD DiffBn
+ VSUBS VDD OnBn openDVS_pixel2x2_bot
XopenDVS_pixel2x2_bot_196 rowReadOFF<4> rowReadOFF<5> rowReadON<5> RefrBp PrBp PrSFBp
+ col_periphery_1x2_21/COL_LINE0 pixRst<26> pixRst<27> col_periphery_1x2_21/COL_LINE1
+ OffBn openDVS_pixel2x2_bot_196/vpd[2] openDVS_pixel2x2_bot_196/vpd[3] openDVS_pixel2x2_bot_196/vpd[1]
+ openDVS_pixel2x2_bot_196/vpd[0] rowReadON<4> openDVS_pixel2x2_bot_6/GndD DiffBn
+ VSUBS VDD OnBn openDVS_pixel2x2_bot
XopenDVS_pixel2x2_bot_152 rowReadOFF<6> rowReadOFF<7> rowReadON<7> RefrBp PrBp PrSFBp
+ col_periphery_1x2_12/COL_LINE0 pixRst<38> pixRst<39> col_periphery_1x2_12/COL_LINE1
+ OffBn openDVS_pixel2x2_bot_152/vpd[2] openDVS_pixel2x2_bot_152/vpd[3] openDVS_pixel2x2_bot_152/vpd[1]
+ openDVS_pixel2x2_bot_152/vpd[0] rowReadON<6> openDVS_pixel2x2_bot_937/GndD DiffBn
+ VSUBS VDD OnBn openDVS_pixel2x2_bot
XopenDVS_pixel2x2_bot_174 rowReadOFF<8> rowReadOFF<9> rowReadON<9> RefrBp PrBp PrSFBp
+ col_periphery_1x2_0/COL_LINE0 pixRst<50> pixRst<51> col_periphery_1x2_0/COL_LINE1
+ OffBn openDVS_pixel2x2_bot_174/vpd[2] openDVS_pixel2x2_bot_174/vpd[3] openDVS_pixel2x2_bot_174/vpd[1]
+ openDVS_pixel2x2_bot_174/vpd[0] rowReadON<8> openDVS_pixel2x2_bot_939/GndD DiffBn
+ VSUBS VDD OnBn openDVS_pixel2x2_bot
XopenDVS_pixel2x2_bot_718 rowReadOFF<40> rowReadOFF<41> rowReadON<41> RefrBp PrBp
+ PrSFBp col_periphery_1x2_12/COL_LINE0 pixRst<38> pixRst<39> col_periphery_1x2_12/COL_LINE1
+ OffBn openDVS_pixel2x2_bot_718/vpd[2] openDVS_pixel2x2_bot_718/vpd[3] openDVS_pixel2x2_bot_718/vpd[1]
+ openDVS_pixel2x2_bot_718/vpd[0] rowReadON<40> openDVS_pixel2x2_bot_906/GndD DiffBn
+ VSUBS VDD OnBn openDVS_pixel2x2_bot
XopenDVS_pixel2x2_bot_707 rowReadOFF<32> rowReadOFF<33> rowReadON<33> RefrBp PrBp
+ PrSFBp col_periphery_1x2_1/COL_LINE0 pixRst<52> pixRst<53> col_periphery_1x2_1/COL_LINE1
+ OffBn openDVS_pixel2x2_bot_707/vpd[2] openDVS_pixel2x2_bot_707/vpd[3] openDVS_pixel2x2_bot_707/vpd[1]
+ openDVS_pixel2x2_bot_707/vpd[0] rowReadON<32> openDVS_pixel2x2_bot_993/GndD DiffBn
+ VSUBS VDD OnBn openDVS_pixel2x2_bot
XopenDVS_pixel2x2_bot_729 rowReadOFF<28> rowReadOFF<29> rowReadON<29> RefrBp PrBp
+ PrSFBp col_periphery_1x2_11/COL_LINE0 pixRst<36> pixRst<37> col_periphery_1x2_11/COL_LINE1
+ OffBn openDVS_pixel2x2_bot_729/vpd[2] openDVS_pixel2x2_bot_729/vpd[3] openDVS_pixel2x2_bot_729/vpd[1]
+ openDVS_pixel2x2_bot_729/vpd[0] rowReadON<28> openDVS_pixel2x2_bot_989/GndD DiffBn
+ VSUBS VDD OnBn openDVS_pixel2x2_bot
XopenDVS_pixel2x2_bot_537 rowReadOFF<62> rowReadOFF<63> rowReadON<63> RefrBp PrBp
+ PrSFBp col_periphery_1x2_26/COL_LINE0 pixRst<4> pixRst<5> col_periphery_1x2_26/COL_LINE1
+ OffBn openDVS_pixel2x2_bot_537/vpd[2] openDVS_pixel2x2_bot_537/vpd[3] openDVS_pixel2x2_bot_537/vpd[1]
+ openDVS_pixel2x2_bot_537/vpd[0] rowReadON<62> openDVS_pixel2x2_bot_886/GndD DiffBn
+ VSUBS VDD OnBn openDVS_pixel2x2_bot
XopenDVS_pixel2x2_bot_526 rowReadOFF<48> rowReadOFF<49> rowReadON<49> RefrBp PrBp
+ PrSFBp col_periphery_1x2_29/COL_LINE0 pixRst<10> pixRst<11> col_periphery_1x2_29/COL_LINE1
+ OffBn openDVS_pixel2x2_bot_526/vpd[2] openDVS_pixel2x2_bot_526/vpd[3] openDVS_pixel2x2_bot_526/vpd[1]
+ openDVS_pixel2x2_bot_526/vpd[0] rowReadON<48> openDVS_pixel2x2_bot_927/GndD DiffBn
+ VSUBS VDD OnBn openDVS_pixel2x2_bot
XopenDVS_pixel2x2_bot_504 rowReadOFF<52> rowReadOFF<53> rowReadON<53> RefrBp PrBp
+ PrSFBp col_periphery_1x2_27/COL_LINE0 pixRst<6> pixRst<7> col_periphery_1x2_27/COL_LINE1
+ OffBn openDVS_pixel2x2_bot_504/vpd[2] openDVS_pixel2x2_bot_504/vpd[3] openDVS_pixel2x2_bot_504/vpd[1]
+ openDVS_pixel2x2_bot_504/vpd[0] rowReadON<52> openDVS_pixel2x2_bot_882/GndD DiffBn
+ VSUBS VDD OnBn openDVS_pixel2x2_bot
XopenDVS_pixel2x2_bot_515 rowReadOFF<46> rowReadOFF<47> rowReadON<47> RefrBp PrBp
+ PrSFBp col_periphery_1x2_27/COL_LINE0 pixRst<6> pixRst<7> col_periphery_1x2_27/COL_LINE1
+ OffBn openDVS_pixel2x2_bot_515/vpd[2] openDVS_pixel2x2_bot_515/vpd[3] openDVS_pixel2x2_bot_515/vpd[1]
+ openDVS_pixel2x2_bot_515/vpd[0] rowReadON<46> openDVS_pixel2x2_bot_925/GndD DiffBn
+ VSUBS VDD OnBn openDVS_pixel2x2_bot
XopenDVS_pixel2x2_bot_559 rowReadOFF<54> rowReadOFF<55> rowReadON<55> RefrBp PrBp
+ PrSFBp col_periphery_1x2_22/COL_LINE0 pixRst<28> pixRst<29> col_periphery_1x2_22/COL_LINE1
+ OffBn openDVS_pixel2x2_bot_559/vpd[2] openDVS_pixel2x2_bot_559/vpd[3] openDVS_pixel2x2_bot_559/vpd[1]
+ openDVS_pixel2x2_bot_559/vpd[0] rowReadON<54> openDVS_pixel2x2_bot_885/GndD DiffBn
+ VSUBS VDD OnBn openDVS_pixel2x2_bot
XopenDVS_pixel2x2_bot_548 rowReadOFF<62> rowReadOFF<63> rowReadON<63> RefrBp PrBp
+ PrSFBp col_periphery_1x2_29/COL_LINE0 pixRst<10> pixRst<11> col_periphery_1x2_29/COL_LINE1
+ OffBn openDVS_pixel2x2_bot_548/vpd[2] openDVS_pixel2x2_bot_548/vpd[3] openDVS_pixel2x2_bot_548/vpd[1]
+ openDVS_pixel2x2_bot_548/vpd[0] rowReadON<62> openDVS_pixel2x2_bot_886/GndD DiffBn
+ VSUBS VDD OnBn openDVS_pixel2x2_bot
XopenDVS_pixel2x2_bot_389 rowReadOFF<22> rowReadOFF<23> rowReadON<23> RefrBp PrBp
+ PrSFBp col_periphery_1x2_31/COL_LINE0 pixRst<14> pixRst<15> col_periphery_1x2_31/COL_LINE1
+ OffBn openDVS_pixel2x2_bot_389/vpd[2] openDVS_pixel2x2_bot_389/vpd[3] openDVS_pixel2x2_bot_389/vpd[1]
+ openDVS_pixel2x2_bot_389/vpd[0] rowReadON<22> openDVS_pixel2x2_bot_97/GndD DiffBn
+ VSUBS VDD OnBn openDVS_pixel2x2_bot
XopenDVS_pixel2x2_bot_301 rowReadOFF<12> rowReadOFF<13> rowReadON<13> RefrBp PrBp
+ PrSFBp col_periphery_1x2_20/COL_LINE0 pixRst<24> pixRst<25> col_periphery_1x2_20/COL_LINE1
+ OffBn openDVS_pixel2x2_bot_301/vpd[2] openDVS_pixel2x2_bot_301/vpd[3] openDVS_pixel2x2_bot_301/vpd[1]
+ openDVS_pixel2x2_bot_301/vpd[0] rowReadON<12> openDVS_pixel2x2_bot_79/GndD DiffBn
+ VSUBS VDD OnBn openDVS_pixel2x2_bot
XopenDVS_pixel2x2_bot_312 rowReadOFF<14> rowReadOFF<15> rowReadON<15> RefrBp PrBp
+ PrSFBp col_periphery_1x2_20/COL_LINE0 pixRst<24> pixRst<25> col_periphery_1x2_20/COL_LINE1
+ OffBn openDVS_pixel2x2_bot_312/vpd[2] openDVS_pixel2x2_bot_312/vpd[3] openDVS_pixel2x2_bot_312/vpd[1]
+ openDVS_pixel2x2_bot_312/vpd[0] rowReadON<14> openDVS_pixel2x2_bot_78/GndD DiffBn
+ VSUBS VDD OnBn openDVS_pixel2x2_bot
XopenDVS_pixel2x2_bot_334 rowReadOFF<18> rowReadOFF<19> rowReadON<19> RefrBp PrBp
+ PrSFBp col_periphery_1x2_20/COL_LINE0 pixRst<24> pixRst<25> col_periphery_1x2_20/COL_LINE1
+ OffBn openDVS_pixel2x2_bot_334/vpd[2] openDVS_pixel2x2_bot_334/vpd[3] openDVS_pixel2x2_bot_334/vpd[1]
+ openDVS_pixel2x2_bot_334/vpd[0] rowReadON<18> openDVS_pixel2x2_bot_69/GndD DiffBn
+ VSUBS VDD OnBn openDVS_pixel2x2_bot
XopenDVS_pixel2x2_bot_323 rowReadOFF<16> rowReadOFF<17> rowReadON<17> RefrBp PrBp
+ PrSFBp col_periphery_1x2_19/COL_LINE0 pixRst<22> pixRst<23> col_periphery_1x2_19/COL_LINE1
+ OffBn openDVS_pixel2x2_bot_323/vpd[2] openDVS_pixel2x2_bot_323/vpd[3] openDVS_pixel2x2_bot_323/vpd[1]
+ openDVS_pixel2x2_bot_323/vpd[0] rowReadON<16> openDVS_pixel2x2_bot_91/GndD DiffBn
+ VSUBS VDD OnBn openDVS_pixel2x2_bot
XopenDVS_pixel2x2_bot_378 rowReadOFF<12> rowReadOFF<13> rowReadON<13> RefrBp PrBp
+ PrSFBp col_periphery_1x2_16/COL_LINE0 pixRst<16> pixRst<17> col_periphery_1x2_16/COL_LINE1
+ OffBn openDVS_pixel2x2_bot_378/vpd[2] openDVS_pixel2x2_bot_378/vpd[3] openDVS_pixel2x2_bot_378/vpd[1]
+ openDVS_pixel2x2_bot_378/vpd[0] rowReadON<12> openDVS_pixel2x2_bot_79/GndD DiffBn
+ VSUBS VDD OnBn openDVS_pixel2x2_bot
XopenDVS_pixel2x2_bot_345 rowReadOFF<6> rowReadOFF<7> rowReadON<7> RefrBp PrBp PrSFBp
+ col_periphery_1x2_28/COL_LINE0 pixRst<8> pixRst<9> col_periphery_1x2_28/COL_LINE1
+ OffBn openDVS_pixel2x2_bot_345/vpd[2] openDVS_pixel2x2_bot_345/vpd[3] openDVS_pixel2x2_bot_345/vpd[1]
+ openDVS_pixel2x2_bot_345/vpd[0] rowReadON<6> openDVS_pixel2x2_bot_937/GndD DiffBn
+ VSUBS VDD OnBn openDVS_pixel2x2_bot
XopenDVS_pixel2x2_bot_367 rowReadOFF<8> rowReadOFF<9> rowReadON<9> RefrBp PrBp PrSFBp
+ col_periphery_1x2_31/COL_LINE0 pixRst<14> pixRst<15> col_periphery_1x2_31/COL_LINE1
+ OffBn openDVS_pixel2x2_bot_367/vpd[2] openDVS_pixel2x2_bot_367/vpd[3] openDVS_pixel2x2_bot_367/vpd[1]
+ openDVS_pixel2x2_bot_367/vpd[0] rowReadON<8> openDVS_pixel2x2_bot_939/GndD DiffBn
+ VSUBS VDD OnBn openDVS_pixel2x2_bot
XopenDVS_pixel2x2_bot_356 rowReadOFF<4> rowReadOFF<5> rowReadON<5> RefrBp PrBp PrSFBp
+ col_periphery_1x2_31/COL_LINE0 pixRst<14> pixRst<15> col_periphery_1x2_31/COL_LINE1
+ OffBn openDVS_pixel2x2_bot_356/vpd[2] openDVS_pixel2x2_bot_356/vpd[3] openDVS_pixel2x2_bot_356/vpd[1]
+ openDVS_pixel2x2_bot_356/vpd[0] rowReadON<4> openDVS_pixel2x2_bot_6/GndD DiffBn
+ VSUBS VDD OnBn openDVS_pixel2x2_bot
XopenDVS_pixel2x2_bot_890 rowReadOFF<58> rowReadOFF<59> rowReadON<59> RefrBp PrBp
+ PrSFBp col_periphery_1x2_15/COL_LINE0 pixRst<48> pixRst<49> col_periphery_1x2_15/COL_LINE1
+ OffBn openDVS_pixel2x2_bot_890/vpd[2] openDVS_pixel2x2_bot_890/vpd[3] openDVS_pixel2x2_bot_890/vpd[1]
+ openDVS_pixel2x2_bot_890/vpd[0] rowReadON<58> openDVS_pixel2x2_bot_890/GndD DiffBn
+ VSUBS VDD OnBn openDVS_pixel2x2_bot
XopenDVS_pixel2x2_bot_131 rowReadOFF<24> rowReadOFF<25> rowReadON<25> RefrBp PrBp
+ PrSFBp col_periphery_1x2_4/COL_LINE0 pixRst<58> pixRst<59> col_periphery_1x2_4/COL_LINE1
+ OffBn openDVS_pixel2x2_bot_131/vpd[2] openDVS_pixel2x2_bot_131/vpd[3] openDVS_pixel2x2_bot_131/vpd[1]
+ openDVS_pixel2x2_bot_131/vpd[0] rowReadON<24> openDVS_pixel2x2_bot_99/GndD DiffBn
+ VSUBS VDD OnBn openDVS_pixel2x2_bot
XopenDVS_pixel2x2_bot_142 rowReadOFF<16> rowReadOFF<17> rowReadON<17> RefrBp PrBp
+ PrSFBp col_periphery_1x2_1/COL_LINE0 pixRst<52> pixRst<53> col_periphery_1x2_1/COL_LINE1
+ OffBn openDVS_pixel2x2_bot_142/vpd[2] openDVS_pixel2x2_bot_142/vpd[3] openDVS_pixel2x2_bot_142/vpd[1]
+ openDVS_pixel2x2_bot_142/vpd[0] rowReadON<16> openDVS_pixel2x2_bot_91/GndD DiffBn
+ VSUBS VDD OnBn openDVS_pixel2x2_bot
XopenDVS_pixel2x2_bot_164 rowReadOFF<20> rowReadOFF<21> rowReadON<21> RefrBp PrBp
+ PrSFBp col_periphery_1x2_15/COL_LINE0 pixRst<48> pixRst<49> col_periphery_1x2_15/COL_LINE1
+ OffBn openDVS_pixel2x2_bot_164/vpd[2] openDVS_pixel2x2_bot_164/vpd[3] openDVS_pixel2x2_bot_164/vpd[1]
+ openDVS_pixel2x2_bot_164/vpd[0] rowReadON<20> openDVS_pixel2x2_bot_95/GndD DiffBn
+ VSUBS VDD OnBn openDVS_pixel2x2_bot
XopenDVS_pixel2x2_bot_186 rowReadOFF<18> rowReadOFF<19> rowReadON<19> RefrBp PrBp
+ PrSFBp col_periphery_1x2_14/COL_LINE0 pixRst<46> pixRst<47> col_periphery_1x2_14/COL_LINE1
+ OffBn openDVS_pixel2x2_bot_186/vpd[2] openDVS_pixel2x2_bot_186/vpd[3] openDVS_pixel2x2_bot_186/vpd[1]
+ openDVS_pixel2x2_bot_186/vpd[0] rowReadON<18> openDVS_pixel2x2_bot_69/GndD DiffBn
+ VSUBS VDD OnBn openDVS_pixel2x2_bot
XopenDVS_pixel2x2_bot_120 rowReadOFF<10> rowReadOFF<11> rowReadON<11> RefrBp PrBp
+ PrSFBp col_periphery_1x2_6/COL_LINE0 pixRst<62> pixRst<63> col_periphery_1x2_6/COL_LINE1
+ OffBn openDVS_pixel2x2_bot_120/vpd[2] openDVS_pixel2x2_bot_120/vpd[3] openDVS_pixel2x2_bot_120/vpd[1]
+ openDVS_pixel2x2_bot_120/vpd[0] rowReadON<10> openDVS_pixel2x2_bot_82/GndD DiffBn
+ VSUBS VDD OnBn openDVS_pixel2x2_bot
XopenDVS_pixel2x2_bot_175 rowReadOFF<8> rowReadOFF<9> rowReadON<9> RefrBp PrBp PrSFBp
+ col_periphery_1x2_1/COL_LINE0 pixRst<52> pixRst<53> col_periphery_1x2_1/COL_LINE1
+ OffBn openDVS_pixel2x2_bot_175/vpd[2] openDVS_pixel2x2_bot_175/vpd[3] openDVS_pixel2x2_bot_175/vpd[1]
+ openDVS_pixel2x2_bot_175/vpd[0] rowReadON<8> openDVS_pixel2x2_bot_939/GndD DiffBn
+ VSUBS VDD OnBn openDVS_pixel2x2_bot
XopenDVS_pixel2x2_bot_197 rowReadOFF<4> rowReadOFF<5> rowReadON<5> RefrBp PrBp PrSFBp
+ col_periphery_1x2_22/COL_LINE0 pixRst<28> pixRst<29> col_periphery_1x2_22/COL_LINE1
+ OffBn openDVS_pixel2x2_bot_197/vpd[2] openDVS_pixel2x2_bot_197/vpd[3] openDVS_pixel2x2_bot_197/vpd[1]
+ openDVS_pixel2x2_bot_197/vpd[0] rowReadON<4> openDVS_pixel2x2_bot_6/GndD DiffBn
+ VSUBS VDD OnBn openDVS_pixel2x2_bot
XopenDVS_pixel2x2_bot_153 rowReadOFF<6> rowReadOFF<7> rowReadON<7> RefrBp PrBp PrSFBp
+ col_periphery_1x2_7/COL_LINE0 pixRst<40> pixRst<41> col_periphery_1x2_7/COL_LINE1
+ OffBn openDVS_pixel2x2_bot_153/vpd[2] openDVS_pixel2x2_bot_153/vpd[3] openDVS_pixel2x2_bot_153/vpd[1]
+ openDVS_pixel2x2_bot_153/vpd[0] rowReadON<6> openDVS_pixel2x2_bot_937/GndD DiffBn
+ VSUBS VDD OnBn openDVS_pixel2x2_bot
XopenDVS_pixel2x2_bot_719 rowReadOFF<40> rowReadOFF<41> rowReadON<41> RefrBp PrBp
+ PrSFBp col_periphery_1x2_7/COL_LINE0 pixRst<40> pixRst<41> col_periphery_1x2_7/COL_LINE1
+ OffBn openDVS_pixel2x2_bot_719/vpd[2] openDVS_pixel2x2_bot_719/vpd[3] openDVS_pixel2x2_bot_719/vpd[1]
+ openDVS_pixel2x2_bot_719/vpd[0] rowReadON<40> openDVS_pixel2x2_bot_906/GndD DiffBn
+ VSUBS VDD OnBn openDVS_pixel2x2_bot
XopenDVS_pixel2x2_bot_708 rowReadOFF<32> rowReadOFF<33> rowReadON<33> RefrBp PrBp
+ PrSFBp col_periphery_1x2_2/COL_LINE0 pixRst<54> pixRst<55> col_periphery_1x2_2/COL_LINE1
+ OffBn openDVS_pixel2x2_bot_708/vpd[2] openDVS_pixel2x2_bot_708/vpd[3] openDVS_pixel2x2_bot_708/vpd[1]
+ openDVS_pixel2x2_bot_708/vpd[0] rowReadON<32> openDVS_pixel2x2_bot_993/GndD DiffBn
+ VSUBS VDD OnBn openDVS_pixel2x2_bot
XopenDVS_pixel2x2_bot_549 rowReadOFF<62> rowReadOFF<63> rowReadON<63> RefrBp PrBp
+ PrSFBp col_periphery_1x2_30/COL_LINE0 pixRst<12> pixRst<13> col_periphery_1x2_30/COL_LINE1
+ OffBn openDVS_pixel2x2_bot_549/vpd[2] openDVS_pixel2x2_bot_549/vpd[3] openDVS_pixel2x2_bot_549/vpd[1]
+ openDVS_pixel2x2_bot_549/vpd[0] rowReadON<62> openDVS_pixel2x2_bot_886/GndD DiffBn
+ VSUBS VDD OnBn openDVS_pixel2x2_bot
XopenDVS_pixel2x2_bot_538 rowReadOFF<62> rowReadOFF<63> rowReadON<63> RefrBp PrBp
+ PrSFBp col_periphery_1x2_27/COL_LINE0 pixRst<6> pixRst<7> col_periphery_1x2_27/COL_LINE1
+ OffBn openDVS_pixel2x2_bot_538/vpd[2] openDVS_pixel2x2_bot_538/vpd[3] openDVS_pixel2x2_bot_538/vpd[1]
+ openDVS_pixel2x2_bot_538/vpd[0] rowReadON<62> openDVS_pixel2x2_bot_886/GndD DiffBn
+ VSUBS VDD OnBn openDVS_pixel2x2_bot
XopenDVS_pixel2x2_bot_527 rowReadOFF<48> rowReadOFF<49> rowReadON<49> RefrBp PrBp
+ PrSFBp col_periphery_1x2_30/COL_LINE0 pixRst<12> pixRst<13> col_periphery_1x2_30/COL_LINE1
+ OffBn openDVS_pixel2x2_bot_527/vpd[2] openDVS_pixel2x2_bot_527/vpd[3] openDVS_pixel2x2_bot_527/vpd[1]
+ openDVS_pixel2x2_bot_527/vpd[0] rowReadON<48> openDVS_pixel2x2_bot_927/GndD DiffBn
+ VSUBS VDD OnBn openDVS_pixel2x2_bot
XopenDVS_pixel2x2_bot_505 rowReadOFF<52> rowReadOFF<53> rowReadON<53> RefrBp PrBp
+ PrSFBp col_periphery_1x2_28/COL_LINE0 pixRst<8> pixRst<9> col_periphery_1x2_28/COL_LINE1
+ OffBn openDVS_pixel2x2_bot_505/vpd[2] openDVS_pixel2x2_bot_505/vpd[3] openDVS_pixel2x2_bot_505/vpd[1]
+ openDVS_pixel2x2_bot_505/vpd[0] rowReadON<52> openDVS_pixel2x2_bot_882/GndD DiffBn
+ VSUBS VDD OnBn openDVS_pixel2x2_bot
XopenDVS_pixel2x2_bot_516 rowReadOFF<46> rowReadOFF<47> rowReadON<47> RefrBp PrBp
+ PrSFBp col_periphery_1x2_28/COL_LINE0 pixRst<8> pixRst<9> col_periphery_1x2_28/COL_LINE1
+ OffBn openDVS_pixel2x2_bot_516/vpd[2] openDVS_pixel2x2_bot_516/vpd[3] openDVS_pixel2x2_bot_516/vpd[1]
+ openDVS_pixel2x2_bot_516/vpd[0] rowReadON<46> openDVS_pixel2x2_bot_925/GndD DiffBn
+ VSUBS VDD OnBn openDVS_pixel2x2_bot
XopenDVS_pixel2x2_bot_335 rowReadOFF<24> rowReadOFF<25> rowReadON<25> RefrBp PrBp
+ PrSFBp col_periphery_1x2_22/COL_LINE0 pixRst<28> pixRst<29> col_periphery_1x2_22/COL_LINE1
+ OffBn openDVS_pixel2x2_bot_335/vpd[2] openDVS_pixel2x2_bot_335/vpd[3] openDVS_pixel2x2_bot_335/vpd[1]
+ openDVS_pixel2x2_bot_335/vpd[0] rowReadON<24> openDVS_pixel2x2_bot_99/GndD DiffBn
+ VSUBS VDD OnBn openDVS_pixel2x2_bot
XopenDVS_pixel2x2_bot_302 rowReadOFF<12> rowReadOFF<13> rowReadON<13> RefrBp PrBp
+ PrSFBp col_periphery_1x2_21/COL_LINE0 pixRst<26> pixRst<27> col_periphery_1x2_21/COL_LINE1
+ OffBn openDVS_pixel2x2_bot_302/vpd[2] openDVS_pixel2x2_bot_302/vpd[3] openDVS_pixel2x2_bot_302/vpd[1]
+ openDVS_pixel2x2_bot_302/vpd[0] rowReadON<12> openDVS_pixel2x2_bot_79/GndD DiffBn
+ VSUBS VDD OnBn openDVS_pixel2x2_bot
XopenDVS_pixel2x2_bot_313 rowReadOFF<14> rowReadOFF<15> rowReadON<15> RefrBp PrBp
+ PrSFBp col_periphery_1x2_21/COL_LINE0 pixRst<26> pixRst<27> col_periphery_1x2_21/COL_LINE1
+ OffBn openDVS_pixel2x2_bot_313/vpd[2] openDVS_pixel2x2_bot_313/vpd[3] openDVS_pixel2x2_bot_313/vpd[1]
+ openDVS_pixel2x2_bot_313/vpd[0] rowReadON<14> openDVS_pixel2x2_bot_78/GndD DiffBn
+ VSUBS VDD OnBn openDVS_pixel2x2_bot
XopenDVS_pixel2x2_bot_324 rowReadOFF<16> rowReadOFF<17> rowReadON<17> RefrBp PrBp
+ PrSFBp col_periphery_1x2_20/COL_LINE0 pixRst<24> pixRst<25> col_periphery_1x2_20/COL_LINE1
+ OffBn openDVS_pixel2x2_bot_324/vpd[2] openDVS_pixel2x2_bot_324/vpd[3] openDVS_pixel2x2_bot_324/vpd[1]
+ openDVS_pixel2x2_bot_324/vpd[0] rowReadON<16> openDVS_pixel2x2_bot_91/GndD DiffBn
+ VSUBS VDD OnBn openDVS_pixel2x2_bot
XopenDVS_pixel2x2_bot_379 rowReadOFF<14> rowReadOFF<15> rowReadON<15> RefrBp PrBp
+ PrSFBp col_periphery_1x2_31/COL_LINE0 pixRst<14> pixRst<15> col_periphery_1x2_31/COL_LINE1
+ OffBn openDVS_pixel2x2_bot_379/vpd[2] openDVS_pixel2x2_bot_379/vpd[3] openDVS_pixel2x2_bot_379/vpd[1]
+ openDVS_pixel2x2_bot_379/vpd[0] rowReadON<14> openDVS_pixel2x2_bot_78/GndD DiffBn
+ VSUBS VDD OnBn openDVS_pixel2x2_bot
XopenDVS_pixel2x2_bot_346 rowReadOFF<6> rowReadOFF<7> rowReadON<7> RefrBp PrBp PrSFBp
+ col_periphery_1x2_29/COL_LINE0 pixRst<10> pixRst<11> col_periphery_1x2_29/COL_LINE1
+ OffBn openDVS_pixel2x2_bot_346/vpd[2] openDVS_pixel2x2_bot_346/vpd[3] openDVS_pixel2x2_bot_346/vpd[1]
+ openDVS_pixel2x2_bot_346/vpd[0] rowReadON<6> openDVS_pixel2x2_bot_937/GndD DiffBn
+ VSUBS VDD OnBn openDVS_pixel2x2_bot
XopenDVS_pixel2x2_bot_368 rowReadOFF<8> rowReadOFF<9> rowReadON<9> RefrBp PrBp PrSFBp
+ col_periphery_1x2_16/COL_LINE0 pixRst<16> pixRst<17> col_periphery_1x2_16/COL_LINE1
+ OffBn openDVS_pixel2x2_bot_368/vpd[2] openDVS_pixel2x2_bot_368/vpd[3] openDVS_pixel2x2_bot_368/vpd[1]
+ openDVS_pixel2x2_bot_368/vpd[0] rowReadON<8> openDVS_pixel2x2_bot_939/GndD DiffBn
+ VSUBS VDD OnBn openDVS_pixel2x2_bot
XopenDVS_pixel2x2_bot_357 rowReadOFF<4> rowReadOFF<5> rowReadON<5> RefrBp PrBp PrSFBp
+ col_periphery_1x2_16/COL_LINE0 pixRst<16> pixRst<17> col_periphery_1x2_16/COL_LINE1
+ OffBn openDVS_pixel2x2_bot_357/vpd[2] openDVS_pixel2x2_bot_357/vpd[3] openDVS_pixel2x2_bot_357/vpd[1]
+ openDVS_pixel2x2_bot_357/vpd[0] rowReadON<4> openDVS_pixel2x2_bot_6/GndD DiffBn
+ VSUBS VDD OnBn openDVS_pixel2x2_bot
XopenDVS_pixel2x2_bot_880 rowReadOFF<60> rowReadOFF<61> rowReadON<61> RefrBp PrBp
+ PrSFBp col_periphery_1x2_3/COL_LINE0 pixRst<56> pixRst<57> col_periphery_1x2_3/COL_LINE1
+ OffBn openDVS_pixel2x2_bot_880/vpd[2] openDVS_pixel2x2_bot_880/vpd[3] openDVS_pixel2x2_bot_880/vpd[1]
+ openDVS_pixel2x2_bot_880/vpd[0] rowReadON<60> openDVS_pixel2x2_bot_902/GndD DiffBn
+ VSUBS VDD OnBn openDVS_pixel2x2_bot
XopenDVS_pixel2x2_bot_891 rowReadOFF<28> rowReadOFF<29> rowReadON<29> RefrBp PrBp
+ PrSFBp col_periphery_1x2_14/COL_LINE0 pixRst<46> pixRst<47> col_periphery_1x2_14/COL_LINE1
+ OffBn openDVS_pixel2x2_bot_891/vpd[2] openDVS_pixel2x2_bot_891/vpd[3] openDVS_pixel2x2_bot_891/vpd[1]
+ openDVS_pixel2x2_bot_891/vpd[0] rowReadON<28> openDVS_pixel2x2_bot_989/GndD DiffBn
+ VSUBS VDD OnBn openDVS_pixel2x2_bot
XopenDVS_pixel2x2_bot_110 rowReadOFF<14> rowReadOFF<15> rowReadON<15> RefrBp PrBp
+ PrSFBp col_periphery_1x2_6/COL_LINE0 pixRst<62> pixRst<63> col_periphery_1x2_6/COL_LINE1
+ OffBn openDVS_pixel2x2_bot_110/vpd[2] openDVS_pixel2x2_bot_110/vpd[3] openDVS_pixel2x2_bot_110/vpd[1]
+ openDVS_pixel2x2_bot_110/vpd[0] rowReadON<14> openDVS_pixel2x2_bot_78/GndD DiffBn
+ VSUBS VDD OnBn openDVS_pixel2x2_bot
XopenDVS_pixel2x2_bot_132 rowReadOFF<18> rowReadOFF<19> rowReadON<19> RefrBp PrBp
+ PrSFBp col_periphery_1x2_6/COL_LINE0 pixRst<62> pixRst<63> col_periphery_1x2_6/COL_LINE1
+ OffBn openDVS_pixel2x2_bot_132/vpd[2] openDVS_pixel2x2_bot_132/vpd[3] openDVS_pixel2x2_bot_132/vpd[1]
+ openDVS_pixel2x2_bot_132/vpd[0] rowReadON<18> openDVS_pixel2x2_bot_69/GndD DiffBn
+ VSUBS VDD OnBn openDVS_pixel2x2_bot
XopenDVS_pixel2x2_bot_121 rowReadOFF<20> rowReadOFF<21> rowReadON<21> RefrBp PrBp
+ PrSFBp col_periphery_1x2_0/COL_LINE0 pixRst<50> pixRst<51> col_periphery_1x2_0/COL_LINE1
+ OffBn openDVS_pixel2x2_bot_121/vpd[2] openDVS_pixel2x2_bot_121/vpd[3] openDVS_pixel2x2_bot_121/vpd[1]
+ openDVS_pixel2x2_bot_121/vpd[0] rowReadON<20> openDVS_pixel2x2_bot_95/GndD DiffBn
+ VSUBS VDD OnBn openDVS_pixel2x2_bot
XopenDVS_pixel2x2_bot_187 rowReadOFF<18> rowReadOFF<19> rowReadON<19> RefrBp PrBp
+ PrSFBp col_periphery_1x2_15/COL_LINE0 pixRst<48> pixRst<49> col_periphery_1x2_15/COL_LINE1
+ OffBn openDVS_pixel2x2_bot_187/vpd[2] openDVS_pixel2x2_bot_187/vpd[3] openDVS_pixel2x2_bot_187/vpd[1]
+ openDVS_pixel2x2_bot_187/vpd[0] rowReadON<18> openDVS_pixel2x2_bot_69/GndD DiffBn
+ VSUBS VDD OnBn openDVS_pixel2x2_bot
XopenDVS_pixel2x2_bot_165 rowReadOFF<16> rowReadOFF<17> rowReadON<17> RefrBp PrBp
+ PrSFBp col_periphery_1x2_14/COL_LINE0 pixRst<46> pixRst<47> col_periphery_1x2_14/COL_LINE1
+ OffBn openDVS_pixel2x2_bot_165/vpd[2] openDVS_pixel2x2_bot_165/vpd[3] openDVS_pixel2x2_bot_165/vpd[1]
+ openDVS_pixel2x2_bot_165/vpd[0] rowReadON<16> openDVS_pixel2x2_bot_91/GndD DiffBn
+ VSUBS VDD OnBn openDVS_pixel2x2_bot
XopenDVS_pixel2x2_bot_176 rowReadOFF<8> rowReadOFF<9> rowReadON<9> RefrBp PrBp PrSFBp
+ col_periphery_1x2_2/COL_LINE0 pixRst<54> pixRst<55> col_periphery_1x2_2/COL_LINE1
+ OffBn openDVS_pixel2x2_bot_176/vpd[2] openDVS_pixel2x2_bot_176/vpd[3] openDVS_pixel2x2_bot_176/vpd[1]
+ openDVS_pixel2x2_bot_176/vpd[0] rowReadON<8> openDVS_pixel2x2_bot_939/GndD DiffBn
+ VSUBS VDD OnBn openDVS_pixel2x2_bot
XopenDVS_pixel2x2_bot_198 rowReadOFF<4> rowReadOFF<5> rowReadON<5> RefrBp PrBp PrSFBp
+ col_periphery_1x2_17/COL_LINE0 pixRst<18> pixRst<19> col_periphery_1x2_17/COL_LINE1
+ OffBn openDVS_pixel2x2_bot_198/vpd[2] openDVS_pixel2x2_bot_198/vpd[3] openDVS_pixel2x2_bot_198/vpd[1]
+ openDVS_pixel2x2_bot_198/vpd[0] rowReadON<4> openDVS_pixel2x2_bot_6/GndD DiffBn
+ VSUBS VDD OnBn openDVS_pixel2x2_bot
XopenDVS_pixel2x2_bot_154 rowReadOFF<6> rowReadOFF<7> rowReadON<7> RefrBp PrBp PrSFBp
+ col_periphery_1x2_8/COL_LINE0 pixRst<42> pixRst<43> col_periphery_1x2_8/COL_LINE1
+ OffBn openDVS_pixel2x2_bot_154/vpd[2] openDVS_pixel2x2_bot_154/vpd[3] openDVS_pixel2x2_bot_154/vpd[1]
+ openDVS_pixel2x2_bot_154/vpd[0] rowReadON<6> openDVS_pixel2x2_bot_937/GndD DiffBn
+ VSUBS VDD OnBn openDVS_pixel2x2_bot
XopenDVS_pixel2x2_bot_143 rowReadOFF<6> rowReadOFF<7> rowReadON<7> RefrBp PrBp PrSFBp
+ col_periphery_1x2_0/COL_LINE0 pixRst<50> pixRst<51> col_periphery_1x2_0/COL_LINE1
+ OffBn openDVS_pixel2x2_bot_143/vpd[2] openDVS_pixel2x2_bot_143/vpd[3] openDVS_pixel2x2_bot_143/vpd[1]
+ openDVS_pixel2x2_bot_143/vpd[0] rowReadON<6> openDVS_pixel2x2_bot_937/GndD DiffBn
+ VSUBS VDD OnBn openDVS_pixel2x2_bot
XopenDVS_pixel2x2_bot_709 rowReadOFF<32> rowReadOFF<33> rowReadON<33> RefrBp PrBp
+ PrSFBp col_periphery_1x2_3/COL_LINE0 pixRst<56> pixRst<57> col_periphery_1x2_3/COL_LINE1
+ OffBn openDVS_pixel2x2_bot_709/vpd[2] openDVS_pixel2x2_bot_709/vpd[3] openDVS_pixel2x2_bot_709/vpd[1]
+ openDVS_pixel2x2_bot_709/vpd[0] rowReadON<32> openDVS_pixel2x2_bot_993/GndD DiffBn
+ VSUBS VDD OnBn openDVS_pixel2x2_bot
XopenDVS_pixel2x2_bot_506 rowReadOFF<54> rowReadOFF<55> rowReadON<55> RefrBp PrBp
+ PrSFBp col_periphery_1x2_29/COL_LINE0 pixRst<10> pixRst<11> col_periphery_1x2_29/COL_LINE1
+ OffBn openDVS_pixel2x2_bot_506/vpd[2] openDVS_pixel2x2_bot_506/vpd[3] openDVS_pixel2x2_bot_506/vpd[1]
+ openDVS_pixel2x2_bot_506/vpd[0] rowReadON<54> openDVS_pixel2x2_bot_885/GndD DiffBn
+ VSUBS VDD OnBn openDVS_pixel2x2_bot
XopenDVS_pixel2x2_bot_528 rowReadOFF<56> rowReadOFF<57> rowReadON<57> RefrBp PrBp
+ PrSFBp col_periphery_1x2_26/COL_LINE0 pixRst<4> pixRst<5> col_periphery_1x2_26/COL_LINE1
+ OffBn openDVS_pixel2x2_bot_528/vpd[2] openDVS_pixel2x2_bot_528/vpd[3] openDVS_pixel2x2_bot_528/vpd[1]
+ openDVS_pixel2x2_bot_528/vpd[0] rowReadON<56> openDVS_pixel2x2_bot_888/GndD DiffBn
+ VSUBS VDD OnBn openDVS_pixel2x2_bot
XopenDVS_pixel2x2_bot_517 rowReadOFF<46> rowReadOFF<47> rowReadON<47> RefrBp PrBp
+ PrSFBp col_periphery_1x2_29/COL_LINE0 pixRst<10> pixRst<11> col_periphery_1x2_29/COL_LINE1
+ OffBn openDVS_pixel2x2_bot_517/vpd[2] openDVS_pixel2x2_bot_517/vpd[3] openDVS_pixel2x2_bot_517/vpd[1]
+ openDVS_pixel2x2_bot_517/vpd[0] rowReadON<46> openDVS_pixel2x2_bot_925/GndD DiffBn
+ VSUBS VDD OnBn openDVS_pixel2x2_bot
XopenDVS_pixel2x2_bot_539 rowReadOFF<50> rowReadOFF<51> rowReadON<51> RefrBp PrBp
+ PrSFBp col_periphery_1x2_25/COL_LINE0 pixRst<2> pixRst<3> col_periphery_1x2_25/COL_LINE1
+ OffBn openDVS_pixel2x2_bot_539/vpd[2] openDVS_pixel2x2_bot_539/vpd[3] openDVS_pixel2x2_bot_539/vpd[1]
+ openDVS_pixel2x2_bot_539/vpd[0] rowReadON<50> openDVS_pixel2x2_bot_929/GndD DiffBn
+ VSUBS VDD OnBn openDVS_pixel2x2_bot
XopenDVS_pixel2x2_bot_303 rowReadOFF<12> rowReadOFF<13> rowReadON<13> RefrBp PrBp
+ PrSFBp col_periphery_1x2_22/COL_LINE0 pixRst<28> pixRst<29> col_periphery_1x2_22/COL_LINE1
+ OffBn openDVS_pixel2x2_bot_303/vpd[2] openDVS_pixel2x2_bot_303/vpd[3] openDVS_pixel2x2_bot_303/vpd[1]
+ openDVS_pixel2x2_bot_303/vpd[0] rowReadON<12> openDVS_pixel2x2_bot_79/GndD DiffBn
+ VSUBS VDD OnBn openDVS_pixel2x2_bot
XopenDVS_pixel2x2_bot_314 rowReadOFF<22> rowReadOFF<23> rowReadON<23> RefrBp PrBp
+ PrSFBp col_periphery_1x2_20/COL_LINE0 pixRst<24> pixRst<25> col_periphery_1x2_20/COL_LINE1
+ OffBn openDVS_pixel2x2_bot_314/vpd[2] openDVS_pixel2x2_bot_314/vpd[3] openDVS_pixel2x2_bot_314/vpd[1]
+ openDVS_pixel2x2_bot_314/vpd[0] rowReadON<22> openDVS_pixel2x2_bot_97/GndD DiffBn
+ VSUBS VDD OnBn openDVS_pixel2x2_bot
XopenDVS_pixel2x2_bot_325 rowReadOFF<16> rowReadOFF<17> rowReadON<17> RefrBp PrBp
+ PrSFBp col_periphery_1x2_21/COL_LINE0 pixRst<26> pixRst<27> col_periphery_1x2_21/COL_LINE1
+ OffBn openDVS_pixel2x2_bot_325/vpd[2] openDVS_pixel2x2_bot_325/vpd[3] openDVS_pixel2x2_bot_325/vpd[1]
+ openDVS_pixel2x2_bot_325/vpd[0] rowReadON<16> openDVS_pixel2x2_bot_91/GndD DiffBn
+ VSUBS VDD OnBn openDVS_pixel2x2_bot
XopenDVS_pixel2x2_bot_336 rowReadOFF<18> rowReadOFF<19> rowReadON<19> RefrBp PrBp
+ PrSFBp col_periphery_1x2_21/COL_LINE0 pixRst<26> pixRst<27> col_periphery_1x2_21/COL_LINE1
+ OffBn openDVS_pixel2x2_bot_336/vpd[2] openDVS_pixel2x2_bot_336/vpd[3] openDVS_pixel2x2_bot_336/vpd[1]
+ openDVS_pixel2x2_bot_336/vpd[0] rowReadON<18> openDVS_pixel2x2_bot_69/GndD DiffBn
+ VSUBS VDD OnBn openDVS_pixel2x2_bot
XopenDVS_pixel2x2_bot_347 rowReadOFF<6> rowReadOFF<7> rowReadON<7> RefrBp PrBp PrSFBp
+ col_periphery_1x2_30/COL_LINE0 pixRst<12> pixRst<13> col_periphery_1x2_30/COL_LINE1
+ OffBn openDVS_pixel2x2_bot_347/vpd[2] openDVS_pixel2x2_bot_347/vpd[3] openDVS_pixel2x2_bot_347/vpd[1]
+ openDVS_pixel2x2_bot_347/vpd[0] rowReadON<6> openDVS_pixel2x2_bot_937/GndD DiffBn
+ VSUBS VDD OnBn openDVS_pixel2x2_bot
XopenDVS_pixel2x2_bot_358 rowReadOFF<6> rowReadOFF<7> rowReadON<7> RefrBp PrBp PrSFBp
+ col_periphery_1x2_31/COL_LINE0 pixRst<14> pixRst<15> col_periphery_1x2_31/COL_LINE1
+ OffBn openDVS_pixel2x2_bot_358/vpd[2] openDVS_pixel2x2_bot_358/vpd[3] openDVS_pixel2x2_bot_358/vpd[1]
+ openDVS_pixel2x2_bot_358/vpd[0] rowReadON<6> openDVS_pixel2x2_bot_937/GndD DiffBn
+ VSUBS VDD OnBn openDVS_pixel2x2_bot
XopenDVS_pixel2x2_bot_369 rowReadOFF<8> rowReadOFF<9> rowReadON<9> RefrBp PrBp PrSFBp
+ col_periphery_1x2_17/COL_LINE0 pixRst<18> pixRst<19> col_periphery_1x2_17/COL_LINE1
+ OffBn openDVS_pixel2x2_bot_369/vpd[2] openDVS_pixel2x2_bot_369/vpd[3] openDVS_pixel2x2_bot_369/vpd[1]
+ openDVS_pixel2x2_bot_369/vpd[0] rowReadON<8> openDVS_pixel2x2_bot_939/GndD DiffBn
+ VSUBS VDD OnBn openDVS_pixel2x2_bot
XopenDVS_pixel2x2_bot_870 rowReadOFF<60> rowReadOFF<61> rowReadON<61> RefrBp PrBp
+ PrSFBp col_periphery_1x2_6/COL_LINE0 pixRst<62> pixRst<63> col_periphery_1x2_6/COL_LINE1
+ OffBn openDVS_pixel2x2_bot_870/vpd[2] openDVS_pixel2x2_bot_870/vpd[3] openDVS_pixel2x2_bot_870/vpd[1]
+ openDVS_pixel2x2_bot_870/vpd[0] rowReadON<60> openDVS_pixel2x2_bot_902/GndD DiffBn
+ VSUBS VDD OnBn openDVS_pixel2x2_bot
XopenDVS_pixel2x2_bot_881 rowReadOFF<52> rowReadOFF<53> rowReadON<53> RefrBp PrBp
+ PrSFBp col_periphery_1x2_14/COL_LINE0 pixRst<46> pixRst<47> col_periphery_1x2_14/COL_LINE1
+ OffBn openDVS_pixel2x2_bot_881/vpd[2] openDVS_pixel2x2_bot_881/vpd[3] openDVS_pixel2x2_bot_881/vpd[1]
+ openDVS_pixel2x2_bot_881/vpd[0] rowReadON<52> openDVS_pixel2x2_bot_882/GndD DiffBn
+ VSUBS VDD OnBn openDVS_pixel2x2_bot
XopenDVS_pixel2x2_bot_892 rowReadOFF<28> rowReadOFF<29> rowReadON<29> RefrBp PrBp
+ PrSFBp col_periphery_1x2_15/COL_LINE0 pixRst<48> pixRst<49> col_periphery_1x2_15/COL_LINE1
+ OffBn openDVS_pixel2x2_bot_892/vpd[2] openDVS_pixel2x2_bot_892/vpd[3] openDVS_pixel2x2_bot_892/vpd[1]
+ openDVS_pixel2x2_bot_892/vpd[0] rowReadON<28> openDVS_pixel2x2_bot_989/GndD DiffBn
+ VSUBS VDD OnBn openDVS_pixel2x2_bot
XopenDVS_pixel2x2_bot_133 rowReadOFF<24> rowReadOFF<25> rowReadON<25> RefrBp PrBp
+ PrSFBp col_periphery_1x2_1/COL_LINE0 pixRst<52> pixRst<53> col_periphery_1x2_1/COL_LINE1
+ OffBn openDVS_pixel2x2_bot_133/vpd[2] openDVS_pixel2x2_bot_133/vpd[3] openDVS_pixel2x2_bot_133/vpd[1]
+ openDVS_pixel2x2_bot_133/vpd[0] rowReadON<24> openDVS_pixel2x2_bot_99/GndD DiffBn
+ VSUBS VDD OnBn openDVS_pixel2x2_bot
XopenDVS_pixel2x2_bot_100 rowReadOFF<12> rowReadOFF<13> rowReadON<13> RefrBp PrBp
+ PrSFBp col_periphery_1x2_6/COL_LINE0 pixRst<62> pixRst<63> col_periphery_1x2_6/COL_LINE1
+ OffBn openDVS_pixel2x2_bot_100/vpd[2] openDVS_pixel2x2_bot_100/vpd[3] openDVS_pixel2x2_bot_100/vpd[1]
+ openDVS_pixel2x2_bot_100/vpd[0] rowReadON<12> openDVS_pixel2x2_bot_79/GndD DiffBn
+ VSUBS VDD OnBn openDVS_pixel2x2_bot
XopenDVS_pixel2x2_bot_122 rowReadOFF<20> rowReadOFF<21> rowReadON<21> RefrBp PrBp
+ PrSFBp col_periphery_1x2_1/COL_LINE0 pixRst<52> pixRst<53> col_periphery_1x2_1/COL_LINE1
+ OffBn openDVS_pixel2x2_bot_122/vpd[2] openDVS_pixel2x2_bot_122/vpd[3] openDVS_pixel2x2_bot_122/vpd[1]
+ openDVS_pixel2x2_bot_122/vpd[0] rowReadON<20> openDVS_pixel2x2_bot_95/GndD DiffBn
+ VSUBS VDD OnBn openDVS_pixel2x2_bot
XopenDVS_pixel2x2_bot_177 rowReadOFF<8> rowReadOFF<9> rowReadON<9> RefrBp PrBp PrSFBp
+ col_periphery_1x2_3/COL_LINE0 pixRst<56> pixRst<57> col_periphery_1x2_3/COL_LINE1
+ OffBn openDVS_pixel2x2_bot_177/vpd[2] openDVS_pixel2x2_bot_177/vpd[3] openDVS_pixel2x2_bot_177/vpd[1]
+ openDVS_pixel2x2_bot_177/vpd[0] rowReadON<8> openDVS_pixel2x2_bot_939/GndD DiffBn
+ VSUBS VDD OnBn openDVS_pixel2x2_bot
XopenDVS_pixel2x2_bot_111 rowReadOFF<10> rowReadOFF<11> rowReadON<11> RefrBp PrBp
+ PrSFBp col_periphery_1x2_2/COL_LINE0 pixRst<54> pixRst<55> col_periphery_1x2_2/COL_LINE1
+ OffBn openDVS_pixel2x2_bot_111/vpd[2] openDVS_pixel2x2_bot_111/vpd[3] openDVS_pixel2x2_bot_111/vpd[1]
+ openDVS_pixel2x2_bot_111/vpd[0] rowReadON<10> openDVS_pixel2x2_bot_82/GndD DiffBn
+ VSUBS VDD OnBn openDVS_pixel2x2_bot
XopenDVS_pixel2x2_bot_144 rowReadOFF<6> rowReadOFF<7> rowReadON<7> RefrBp PrBp PrSFBp
+ col_periphery_1x2_1/COL_LINE0 pixRst<52> pixRst<53> col_periphery_1x2_1/COL_LINE1
+ OffBn openDVS_pixel2x2_bot_144/vpd[2] openDVS_pixel2x2_bot_144/vpd[3] openDVS_pixel2x2_bot_144/vpd[1]
+ openDVS_pixel2x2_bot_144/vpd[0] rowReadON<6> openDVS_pixel2x2_bot_937/GndD DiffBn
+ VSUBS VDD OnBn openDVS_pixel2x2_bot
XopenDVS_pixel2x2_bot_188 rowReadOFF<0> rowReadOFF<1> rowReadON<1> RefrBp PrBp PrSFBp
+ col_periphery_1x2_14/COL_LINE0 pixRst<46> pixRst<47> col_periphery_1x2_14/COL_LINE1
+ OffBn openDVS_pixel2x2_bot_188/vpd[2] openDVS_pixel2x2_bot_188/vpd[3] openDVS_pixel2x2_bot_188/vpd[1]
+ openDVS_pixel2x2_bot_188/vpd[0] rowReadON<0> GND DiffBn VSUBS VDD OnBn openDVS_pixel2x2_bot
XopenDVS_pixel2x2_bot_199 rowReadOFF<2> rowReadOFF<3> rowReadON<3> RefrBp PrBp PrSFBp
+ col_periphery_1x2_17/COL_LINE0 pixRst<18> pixRst<19> col_periphery_1x2_17/COL_LINE1
+ OffBn openDVS_pixel2x2_bot_199/vpd[2] openDVS_pixel2x2_bot_199/vpd[3] openDVS_pixel2x2_bot_199/vpd[1]
+ openDVS_pixel2x2_bot_199/vpd[0] rowReadON<2> openDVS_pixel2x2_bot_7/GndD DiffBn
+ VSUBS VDD OnBn openDVS_pixel2x2_bot
XopenDVS_pixel2x2_bot_166 rowReadOFF<8> rowReadOFF<9> rowReadON<9> RefrBp PrBp PrSFBp
+ col_periphery_1x2_10/COL_LINE0 pixRst<34> pixRst<35> col_periphery_1x2_10/COL_LINE1
+ OffBn openDVS_pixel2x2_bot_166/vpd[2] openDVS_pixel2x2_bot_166/vpd[3] openDVS_pixel2x2_bot_166/vpd[1]
+ openDVS_pixel2x2_bot_166/vpd[0] rowReadON<8> openDVS_pixel2x2_bot_939/GndD DiffBn
+ VSUBS VDD OnBn openDVS_pixel2x2_bot
XopenDVS_pixel2x2_bot_155 rowReadOFF<6> rowReadOFF<7> rowReadON<7> RefrBp PrBp PrSFBp
+ col_periphery_1x2_13/COL_LINE0 pixRst<44> pixRst<45> col_periphery_1x2_13/COL_LINE1
+ OffBn openDVS_pixel2x2_bot_155/vpd[2] openDVS_pixel2x2_bot_155/vpd[3] openDVS_pixel2x2_bot_155/vpd[1]
+ openDVS_pixel2x2_bot_155/vpd[0] rowReadON<6> openDVS_pixel2x2_bot_937/GndD DiffBn
+ VSUBS VDD OnBn openDVS_pixel2x2_bot
XopenDVS_pixel2x2_bot_529 rowReadOFF<56> rowReadOFF<57> rowReadON<57> RefrBp PrBp
+ PrSFBp col_periphery_1x2_27/COL_LINE0 pixRst<6> pixRst<7> col_periphery_1x2_27/COL_LINE1
+ OffBn openDVS_pixel2x2_bot_529/vpd[2] openDVS_pixel2x2_bot_529/vpd[3] openDVS_pixel2x2_bot_529/vpd[1]
+ openDVS_pixel2x2_bot_529/vpd[0] rowReadON<56> openDVS_pixel2x2_bot_888/GndD DiffBn
+ VSUBS VDD OnBn openDVS_pixel2x2_bot
XopenDVS_pixel2x2_bot_507 rowReadOFF<62> rowReadOFF<63> rowReadON<63> RefrBp PrBp
+ PrSFBp col_periphery_1x2_24/COL_LINE0 pixRst<0> pixRst<1> col_periphery_1x2_24/COL_LINE1
+ OffBn openDVS_pixel2x2_bot_507/vpd[2] openDVS_pixel2x2_bot_507/vpd[3] openDVS_pixel2x2_bot_507/vpd[1]
+ openDVS_pixel2x2_bot_507/vpd[0] rowReadON<62> openDVS_pixel2x2_bot_886/GndD DiffBn
+ VSUBS VDD OnBn openDVS_pixel2x2_bot
XopenDVS_pixel2x2_bot_518 rowReadOFF<46> rowReadOFF<47> rowReadON<47> RefrBp PrBp
+ PrSFBp col_periphery_1x2_30/COL_LINE0 pixRst<12> pixRst<13> col_periphery_1x2_30/COL_LINE1
+ OffBn openDVS_pixel2x2_bot_518/vpd[2] openDVS_pixel2x2_bot_518/vpd[3] openDVS_pixel2x2_bot_518/vpd[1]
+ openDVS_pixel2x2_bot_518/vpd[0] rowReadON<46> openDVS_pixel2x2_bot_925/GndD DiffBn
+ VSUBS VDD OnBn openDVS_pixel2x2_bot
XopenDVS_pixel2x2_bot_315 rowReadOFF<22> rowReadOFF<23> rowReadON<23> RefrBp PrBp
+ PrSFBp col_periphery_1x2_21/COL_LINE0 pixRst<26> pixRst<27> col_periphery_1x2_21/COL_LINE1
+ OffBn openDVS_pixel2x2_bot_315/vpd[2] openDVS_pixel2x2_bot_315/vpd[3] openDVS_pixel2x2_bot_315/vpd[1]
+ openDVS_pixel2x2_bot_315/vpd[0] rowReadON<22> openDVS_pixel2x2_bot_97/GndD DiffBn
+ VSUBS VDD OnBn openDVS_pixel2x2_bot
XopenDVS_pixel2x2_bot_304 rowReadOFF<24> rowReadOFF<25> rowReadON<25> RefrBp PrBp
+ PrSFBp col_periphery_1x2_19/COL_LINE0 pixRst<22> pixRst<23> col_periphery_1x2_19/COL_LINE1
+ OffBn openDVS_pixel2x2_bot_304/vpd[2] openDVS_pixel2x2_bot_304/vpd[3] openDVS_pixel2x2_bot_304/vpd[1]
+ openDVS_pixel2x2_bot_304/vpd[0] rowReadON<24> openDVS_pixel2x2_bot_99/GndD DiffBn
+ VSUBS VDD OnBn openDVS_pixel2x2_bot
XopenDVS_pixel2x2_bot_326 rowReadOFF<16> rowReadOFF<17> rowReadON<17> RefrBp PrBp
+ PrSFBp col_periphery_1x2_22/COL_LINE0 pixRst<28> pixRst<29> col_periphery_1x2_22/COL_LINE1
+ OffBn openDVS_pixel2x2_bot_326/vpd[2] openDVS_pixel2x2_bot_326/vpd[3] openDVS_pixel2x2_bot_326/vpd[1]
+ openDVS_pixel2x2_bot_326/vpd[0] rowReadON<16> openDVS_pixel2x2_bot_91/GndD DiffBn
+ VSUBS VDD OnBn openDVS_pixel2x2_bot
XopenDVS_pixel2x2_bot_337 rowReadOFF<18> rowReadOFF<19> rowReadON<19> RefrBp PrBp
+ PrSFBp col_periphery_1x2_22/COL_LINE0 pixRst<28> pixRst<29> col_periphery_1x2_22/COL_LINE1
+ OffBn openDVS_pixel2x2_bot_337/vpd[2] openDVS_pixel2x2_bot_337/vpd[3] openDVS_pixel2x2_bot_337/vpd[1]
+ openDVS_pixel2x2_bot_337/vpd[0] rowReadON<18> openDVS_pixel2x2_bot_69/GndD DiffBn
+ VSUBS VDD OnBn openDVS_pixel2x2_bot
XopenDVS_pixel2x2_bot_348 rowReadOFF<6> rowReadOFF<7> rowReadON<7> RefrBp PrBp PrSFBp
+ col_periphery_1x2_24/COL_LINE0 pixRst<0> pixRst<1> col_periphery_1x2_24/COL_LINE1
+ OffBn openDVS_pixel2x2_bot_348/vpd[2] openDVS_pixel2x2_bot_348/vpd[3] openDVS_pixel2x2_bot_348/vpd[1]
+ openDVS_pixel2x2_bot_348/vpd[0] rowReadON<6> openDVS_pixel2x2_bot_937/GndD DiffBn
+ VSUBS VDD OnBn openDVS_pixel2x2_bot
XopenDVS_pixel2x2_bot_359 rowReadOFF<6> rowReadOFF<7> rowReadON<7> RefrBp PrBp PrSFBp
+ col_periphery_1x2_16/COL_LINE0 pixRst<16> pixRst<17> col_periphery_1x2_16/COL_LINE1
+ OffBn openDVS_pixel2x2_bot_359/vpd[2] openDVS_pixel2x2_bot_359/vpd[3] openDVS_pixel2x2_bot_359/vpd[1]
+ openDVS_pixel2x2_bot_359/vpd[0] rowReadON<6> openDVS_pixel2x2_bot_937/GndD DiffBn
+ VSUBS VDD OnBn openDVS_pixel2x2_bot
XopenDVS_pixel2x2_bot_871 rowReadOFF<62> rowReadOFF<63> rowReadON<63> RefrBp PrBp
+ PrSFBp col_periphery_1x2_5/COL_LINE0 pixRst<60> pixRst<61> col_periphery_1x2_5/COL_LINE1
+ OffBn openDVS_pixel2x2_bot_871/vpd[2] openDVS_pixel2x2_bot_871/vpd[3] openDVS_pixel2x2_bot_871/vpd[1]
+ openDVS_pixel2x2_bot_871/vpd[0] rowReadON<62> openDVS_pixel2x2_bot_886/GndD DiffBn
+ VSUBS VDD OnBn openDVS_pixel2x2_bot
XopenDVS_pixel2x2_bot_860 rowReadOFF<48> rowReadOFF<49> rowReadON<49> RefrBp PrBp
+ PrSFBp col_periphery_1x2_2/COL_LINE0 pixRst<54> pixRst<55> col_periphery_1x2_2/COL_LINE1
+ OffBn openDVS_pixel2x2_bot_860/vpd[2] openDVS_pixel2x2_bot_860/vpd[3] openDVS_pixel2x2_bot_860/vpd[1]
+ openDVS_pixel2x2_bot_860/vpd[0] rowReadON<48> openDVS_pixel2x2_bot_927/GndD DiffBn
+ VSUBS VDD OnBn openDVS_pixel2x2_bot
XopenDVS_pixel2x2_bot_882 rowReadOFF<52> rowReadOFF<53> rowReadON<53> RefrBp PrBp
+ PrSFBp col_periphery_1x2_15/COL_LINE0 pixRst<48> pixRst<49> col_periphery_1x2_15/COL_LINE1
+ OffBn openDVS_pixel2x2_bot_882/vpd[2] openDVS_pixel2x2_bot_882/vpd[3] openDVS_pixel2x2_bot_882/vpd[1]
+ openDVS_pixel2x2_bot_882/vpd[0] rowReadON<52> openDVS_pixel2x2_bot_882/GndD DiffBn
+ VSUBS VDD OnBn openDVS_pixel2x2_bot
XopenDVS_pixel2x2_bot_893 rowReadOFF<30> rowReadOFF<31> rowReadON<31> RefrBp PrBp
+ PrSFBp col_periphery_1x2_14/COL_LINE0 pixRst<46> pixRst<47> col_periphery_1x2_14/COL_LINE1
+ OffBn openDVS_pixel2x2_bot_893/vpd[2] openDVS_pixel2x2_bot_893/vpd[3] openDVS_pixel2x2_bot_893/vpd[1]
+ openDVS_pixel2x2_bot_893/vpd[0] rowReadON<30> openDVS_pixel2x2_bot_991/GndD DiffBn
+ VSUBS VDD OnBn openDVS_pixel2x2_bot
XopenDVS_pixel2x2_bot_134 rowReadOFF<24> rowReadOFF<25> rowReadON<25> RefrBp PrBp
+ PrSFBp col_periphery_1x2_2/COL_LINE0 pixRst<54> pixRst<55> col_periphery_1x2_2/COL_LINE1
+ OffBn openDVS_pixel2x2_bot_134/vpd[2] openDVS_pixel2x2_bot_134/vpd[3] openDVS_pixel2x2_bot_134/vpd[1]
+ openDVS_pixel2x2_bot_134/vpd[0] rowReadON<24> openDVS_pixel2x2_bot_99/GndD DiffBn
+ VSUBS VDD OnBn openDVS_pixel2x2_bot
XopenDVS_pixel2x2_bot_112 rowReadOFF<22> rowReadOFF<23> rowReadON<23> RefrBp PrBp
+ PrSFBp col_periphery_1x2_0/COL_LINE0 pixRst<50> pixRst<51> col_periphery_1x2_0/COL_LINE1
+ OffBn openDVS_pixel2x2_bot_112/vpd[2] openDVS_pixel2x2_bot_112/vpd[3] openDVS_pixel2x2_bot_112/vpd[1]
+ openDVS_pixel2x2_bot_112/vpd[0] rowReadON<22> openDVS_pixel2x2_bot_97/GndD DiffBn
+ VSUBS VDD OnBn openDVS_pixel2x2_bot
XopenDVS_pixel2x2_bot_123 rowReadOFF<20> rowReadOFF<21> rowReadON<21> RefrBp PrBp
+ PrSFBp col_periphery_1x2_2/COL_LINE0 pixRst<54> pixRst<55> col_periphery_1x2_2/COL_LINE1
+ OffBn openDVS_pixel2x2_bot_123/vpd[2] openDVS_pixel2x2_bot_123/vpd[3] openDVS_pixel2x2_bot_123/vpd[1]
+ openDVS_pixel2x2_bot_123/vpd[0] rowReadON<20> openDVS_pixel2x2_bot_95/GndD DiffBn
+ VSUBS VDD OnBn openDVS_pixel2x2_bot
XopenDVS_pixel2x2_bot_101 rowReadOFF<18> rowReadOFF<19> rowReadON<19> RefrBp PrBp
+ PrSFBp col_periphery_1x2_1/COL_LINE0 pixRst<52> pixRst<53> col_periphery_1x2_1/COL_LINE1
+ OffBn openDVS_pixel2x2_bot_101/vpd[2] openDVS_pixel2x2_bot_101/vpd[3] openDVS_pixel2x2_bot_101/vpd[1]
+ openDVS_pixel2x2_bot_101/vpd[0] rowReadON<18> openDVS_pixel2x2_bot_69/GndD DiffBn
+ VSUBS VDD OnBn openDVS_pixel2x2_bot
XopenDVS_pixel2x2_bot_178 rowReadOFF<8> rowReadOFF<9> rowReadON<9> RefrBp PrBp PrSFBp
+ col_periphery_1x2_4/COL_LINE0 pixRst<58> pixRst<59> col_periphery_1x2_4/COL_LINE1
+ OffBn openDVS_pixel2x2_bot_178/vpd[2] openDVS_pixel2x2_bot_178/vpd[3] openDVS_pixel2x2_bot_178/vpd[1]
+ openDVS_pixel2x2_bot_178/vpd[0] rowReadON<8> openDVS_pixel2x2_bot_939/GndD DiffBn
+ VSUBS VDD OnBn openDVS_pixel2x2_bot
XopenDVS_pixel2x2_bot_145 rowReadOFF<6> rowReadOFF<7> rowReadON<7> RefrBp PrBp PrSFBp
+ col_periphery_1x2_2/COL_LINE0 pixRst<54> pixRst<55> col_periphery_1x2_2/COL_LINE1
+ OffBn openDVS_pixel2x2_bot_145/vpd[2] openDVS_pixel2x2_bot_145/vpd[3] openDVS_pixel2x2_bot_145/vpd[1]
+ openDVS_pixel2x2_bot_145/vpd[0] rowReadON<6> openDVS_pixel2x2_bot_937/GndD DiffBn
+ VSUBS VDD OnBn openDVS_pixel2x2_bot
XopenDVS_pixel2x2_bot_189 rowReadOFF<0> rowReadOFF<1> rowReadON<1> RefrBp PrBp PrSFBp
+ col_periphery_1x2_15/COL_LINE0 pixRst<48> pixRst<49> col_periphery_1x2_15/COL_LINE1
+ OffBn openDVS_pixel2x2_bot_189/vpd[2] openDVS_pixel2x2_bot_189/vpd[3] openDVS_pixel2x2_bot_189/vpd[1]
+ openDVS_pixel2x2_bot_189/vpd[0] rowReadON<0> GND DiffBn VSUBS VDD OnBn openDVS_pixel2x2_bot
XopenDVS_pixel2x2_bot_167 rowReadOFF<8> rowReadOFF<9> rowReadON<9> RefrBp PrBp PrSFBp
+ col_periphery_1x2_11/COL_LINE0 pixRst<36> pixRst<37> col_periphery_1x2_11/COL_LINE1
+ OffBn openDVS_pixel2x2_bot_167/vpd[2] openDVS_pixel2x2_bot_167/vpd[3] openDVS_pixel2x2_bot_167/vpd[1]
+ openDVS_pixel2x2_bot_167/vpd[0] rowReadON<8> openDVS_pixel2x2_bot_939/GndD DiffBn
+ VSUBS VDD OnBn openDVS_pixel2x2_bot
XopenDVS_pixel2x2_bot_156 rowReadOFF<4> rowReadOFF<5> rowReadON<5> RefrBp PrBp PrSFBp
+ col_periphery_1x2_14/COL_LINE0 pixRst<46> pixRst<47> col_periphery_1x2_14/COL_LINE1
+ OffBn openDVS_pixel2x2_bot_156/vpd[2] openDVS_pixel2x2_bot_156/vpd[3] openDVS_pixel2x2_bot_156/vpd[1]
+ openDVS_pixel2x2_bot_156/vpd[0] rowReadON<4> openDVS_pixel2x2_bot_6/GndD DiffBn
+ VSUBS VDD OnBn openDVS_pixel2x2_bot
XopenDVS_pixel2x2_bot_690 rowReadOFF<30> rowReadOFF<31> rowReadON<31> RefrBp PrBp
+ PrSFBp col_periphery_1x2_1/COL_LINE0 pixRst<52> pixRst<53> col_periphery_1x2_1/COL_LINE1
+ OffBn openDVS_pixel2x2_bot_690/vpd[2] openDVS_pixel2x2_bot_690/vpd[3] openDVS_pixel2x2_bot_690/vpd[1]
+ openDVS_pixel2x2_bot_690/vpd[0] rowReadON<30> openDVS_pixel2x2_bot_991/GndD DiffBn
+ VSUBS VDD OnBn openDVS_pixel2x2_bot
XopenDVS_pixel2x2_bot_519 rowReadOFF<56> rowReadOFF<57> rowReadON<57> RefrBp PrBp
+ PrSFBp col_periphery_1x2_24/COL_LINE0 pixRst<0> pixRst<1> col_periphery_1x2_24/COL_LINE1
+ OffBn openDVS_pixel2x2_bot_519/vpd[2] openDVS_pixel2x2_bot_519/vpd[3] openDVS_pixel2x2_bot_519/vpd[1]
+ openDVS_pixel2x2_bot_519/vpd[0] rowReadON<56> openDVS_pixel2x2_bot_888/GndD DiffBn
+ VSUBS VDD OnBn openDVS_pixel2x2_bot
XopenDVS_pixel2x2_bot_508 rowReadOFF<52> rowReadOFF<53> rowReadON<53> RefrBp PrBp
+ PrSFBp col_periphery_1x2_29/COL_LINE0 pixRst<10> pixRst<11> col_periphery_1x2_29/COL_LINE1
+ OffBn openDVS_pixel2x2_bot_508/vpd[2] openDVS_pixel2x2_bot_508/vpd[3] openDVS_pixel2x2_bot_508/vpd[1]
+ openDVS_pixel2x2_bot_508/vpd[0] rowReadON<52> openDVS_pixel2x2_bot_882/GndD DiffBn
+ VSUBS VDD OnBn openDVS_pixel2x2_bot
Xcol_periphery_1x2_30 pixRst<13> col_periphery_1x2_30/COL_LINE0 col_periphery_1x2_30/COL_LINE1
+ nDETECT DETECT col_periphery_1x2_9/VDD VTHRESH pixRst<12> voutn<12> VSUBS voutn<13>
+ NCHARGE col_periphery_1x2
XopenDVS_pixel2x2_bot_305 rowReadOFF<24> rowReadOFF<25> rowReadON<25> RefrBp PrBp
+ PrSFBp col_periphery_1x2_20/COL_LINE0 pixRst<24> pixRst<25> col_periphery_1x2_20/COL_LINE1
+ OffBn openDVS_pixel2x2_bot_305/vpd[2] openDVS_pixel2x2_bot_305/vpd[3] openDVS_pixel2x2_bot_305/vpd[1]
+ openDVS_pixel2x2_bot_305/vpd[0] rowReadON<24> openDVS_pixel2x2_bot_99/GndD DiffBn
+ VSUBS VDD OnBn openDVS_pixel2x2_bot
XopenDVS_pixel2x2_bot_316 rowReadOFF<14> rowReadOFF<15> rowReadON<15> RefrBp PrBp
+ PrSFBp col_periphery_1x2_22/COL_LINE0 pixRst<28> pixRst<29> col_periphery_1x2_22/COL_LINE1
+ OffBn openDVS_pixel2x2_bot_316/vpd[2] openDVS_pixel2x2_bot_316/vpd[3] openDVS_pixel2x2_bot_316/vpd[1]
+ openDVS_pixel2x2_bot_316/vpd[0] rowReadON<14> openDVS_pixel2x2_bot_78/GndD DiffBn
+ VSUBS VDD OnBn openDVS_pixel2x2_bot
XopenDVS_pixel2x2_bot_327 rowReadOFF<20> rowReadOFF<21> rowReadON<21> RefrBp PrBp
+ PrSFBp col_periphery_1x2_19/COL_LINE0 pixRst<22> pixRst<23> col_periphery_1x2_19/COL_LINE1
+ OffBn openDVS_pixel2x2_bot_327/vpd[2] openDVS_pixel2x2_bot_327/vpd[3] openDVS_pixel2x2_bot_327/vpd[1]
+ openDVS_pixel2x2_bot_327/vpd[0] rowReadON<20> openDVS_pixel2x2_bot_95/GndD DiffBn
+ VSUBS VDD OnBn openDVS_pixel2x2_bot
XopenDVS_pixel2x2_bot_349 rowReadOFF<6> rowReadOFF<7> rowReadON<7> RefrBp PrBp PrSFBp
+ col_periphery_1x2_25/COL_LINE0 pixRst<2> pixRst<3> col_periphery_1x2_25/COL_LINE1
+ OffBn openDVS_pixel2x2_bot_349/vpd[2] openDVS_pixel2x2_bot_349/vpd[3] openDVS_pixel2x2_bot_349/vpd[1]
+ openDVS_pixel2x2_bot_349/vpd[0] rowReadON<6> openDVS_pixel2x2_bot_937/GndD DiffBn
+ VSUBS VDD OnBn openDVS_pixel2x2_bot
XopenDVS_pixel2x2_bot_338 rowReadOFF<6> rowReadOFF<7> rowReadON<7> RefrBp PrBp PrSFBp
+ col_periphery_1x2_18/COL_LINE0 pixRst<20> pixRst<21> col_periphery_1x2_18/COL_LINE1
+ OffBn openDVS_pixel2x2_bot_338/vpd[2] openDVS_pixel2x2_bot_338/vpd[3] openDVS_pixel2x2_bot_338/vpd[1]
+ openDVS_pixel2x2_bot_338/vpd[0] rowReadON<6> openDVS_pixel2x2_bot_937/GndD DiffBn
+ VSUBS VDD OnBn openDVS_pixel2x2_bot
XopenDVS_pixel2x2_bot_861 rowReadOFF<62> rowReadOFF<63> rowReadON<63> RefrBp PrBp
+ PrSFBp col_periphery_1x2_3/COL_LINE0 pixRst<56> pixRst<57> col_periphery_1x2_3/COL_LINE1
+ OffBn openDVS_pixel2x2_bot_861/vpd[2] openDVS_pixel2x2_bot_861/vpd[3] openDVS_pixel2x2_bot_861/vpd[1]
+ openDVS_pixel2x2_bot_861/vpd[0] rowReadON<62> openDVS_pixel2x2_bot_886/GndD DiffBn
+ VSUBS VDD OnBn openDVS_pixel2x2_bot
XopenDVS_pixel2x2_bot_883 rowReadOFF<62> rowReadOFF<63> rowReadON<63> RefrBp PrBp
+ PrSFBp col_periphery_1x2_14/COL_LINE0 pixRst<46> pixRst<47> col_periphery_1x2_14/COL_LINE1
+ OffBn openDVS_pixel2x2_bot_883/vpd[2] openDVS_pixel2x2_bot_883/vpd[3] openDVS_pixel2x2_bot_883/vpd[1]
+ openDVS_pixel2x2_bot_883/vpd[0] rowReadON<62> openDVS_pixel2x2_bot_886/GndD DiffBn
+ VSUBS VDD OnBn openDVS_pixel2x2_bot
XopenDVS_pixel2x2_bot_850 rowReadOFF<50> rowReadOFF<51> rowReadON<51> RefrBp PrBp
+ PrSFBp col_periphery_1x2_4/COL_LINE0 pixRst<58> pixRst<59> col_periphery_1x2_4/COL_LINE1
+ OffBn openDVS_pixel2x2_bot_850/vpd[2] openDVS_pixel2x2_bot_850/vpd[3] openDVS_pixel2x2_bot_850/vpd[1]
+ openDVS_pixel2x2_bot_850/vpd[0] rowReadON<50> openDVS_pixel2x2_bot_929/GndD DiffBn
+ VSUBS VDD OnBn openDVS_pixel2x2_bot
XopenDVS_pixel2x2_bot_872 rowReadOFF<50> rowReadOFF<51> rowReadON<51> RefrBp PrBp
+ PrSFBp col_periphery_1x2_1/COL_LINE0 pixRst<52> pixRst<53> col_periphery_1x2_1/COL_LINE1
+ OffBn openDVS_pixel2x2_bot_872/vpd[2] openDVS_pixel2x2_bot_872/vpd[3] openDVS_pixel2x2_bot_872/vpd[1]
+ openDVS_pixel2x2_bot_872/vpd[0] rowReadON<50> openDVS_pixel2x2_bot_929/GndD DiffBn
+ VSUBS VDD OnBn openDVS_pixel2x2_bot
XopenDVS_pixel2x2_bot_894 rowReadOFF<30> rowReadOFF<31> rowReadON<31> RefrBp PrBp
+ PrSFBp col_periphery_1x2_15/COL_LINE0 pixRst<48> pixRst<49> col_periphery_1x2_15/COL_LINE1
+ OffBn openDVS_pixel2x2_bot_894/vpd[2] openDVS_pixel2x2_bot_894/vpd[3] openDVS_pixel2x2_bot_894/vpd[1]
+ openDVS_pixel2x2_bot_894/vpd[0] rowReadON<30> openDVS_pixel2x2_bot_991/GndD DiffBn
+ VSUBS VDD OnBn openDVS_pixel2x2_bot
XopenDVS_pixel2x2_bot_113 rowReadOFF<22> rowReadOFF<23> rowReadON<23> RefrBp PrBp
+ PrSFBp col_periphery_1x2_1/COL_LINE0 pixRst<52> pixRst<53> col_periphery_1x2_1/COL_LINE1
+ OffBn openDVS_pixel2x2_bot_113/vpd[2] openDVS_pixel2x2_bot_113/vpd[3] openDVS_pixel2x2_bot_113/vpd[1]
+ openDVS_pixel2x2_bot_113/vpd[0] rowReadON<22> openDVS_pixel2x2_bot_97/GndD DiffBn
+ VSUBS VDD OnBn openDVS_pixel2x2_bot
XopenDVS_pixel2x2_bot_124 rowReadOFF<18> rowReadOFF<19> rowReadON<19> RefrBp PrBp
+ PrSFBp col_periphery_1x2_2/COL_LINE0 pixRst<54> pixRst<55> col_periphery_1x2_2/COL_LINE1
+ OffBn openDVS_pixel2x2_bot_124/vpd[2] openDVS_pixel2x2_bot_124/vpd[3] openDVS_pixel2x2_bot_124/vpd[1]
+ openDVS_pixel2x2_bot_124/vpd[0] rowReadON<18> openDVS_pixel2x2_bot_69/GndD DiffBn
+ VSUBS VDD OnBn openDVS_pixel2x2_bot
XopenDVS_pixel2x2_bot_135 rowReadOFF<12> rowReadOFF<13> rowReadON<13> RefrBp PrBp
+ PrSFBp col_periphery_1x2_0/COL_LINE0 pixRst<50> pixRst<51> col_periphery_1x2_0/COL_LINE1
+ OffBn openDVS_pixel2x2_bot_135/vpd[2] openDVS_pixel2x2_bot_135/vpd[3] openDVS_pixel2x2_bot_135/vpd[1]
+ openDVS_pixel2x2_bot_135/vpd[0] rowReadON<12> openDVS_pixel2x2_bot_79/GndD DiffBn
+ VSUBS VDD OnBn openDVS_pixel2x2_bot
XopenDVS_pixel2x2_bot_179 rowReadOFF<8> rowReadOFF<9> rowReadON<9> RefrBp PrBp PrSFBp
+ col_periphery_1x2_5/COL_LINE0 pixRst<60> pixRst<61> col_periphery_1x2_5/COL_LINE1
+ OffBn openDVS_pixel2x2_bot_179/vpd[2] openDVS_pixel2x2_bot_179/vpd[3] openDVS_pixel2x2_bot_179/vpd[1]
+ openDVS_pixel2x2_bot_179/vpd[0] rowReadON<8> openDVS_pixel2x2_bot_939/GndD DiffBn
+ VSUBS VDD OnBn openDVS_pixel2x2_bot
XopenDVS_pixel2x2_bot_146 rowReadOFF<6> rowReadOFF<7> rowReadON<7> RefrBp PrBp PrSFBp
+ col_periphery_1x2_3/COL_LINE0 pixRst<56> pixRst<57> col_periphery_1x2_3/COL_LINE1
+ OffBn openDVS_pixel2x2_bot_146/vpd[2] openDVS_pixel2x2_bot_146/vpd[3] openDVS_pixel2x2_bot_146/vpd[1]
+ openDVS_pixel2x2_bot_146/vpd[0] rowReadON<6> openDVS_pixel2x2_bot_937/GndD DiffBn
+ VSUBS VDD OnBn openDVS_pixel2x2_bot
XopenDVS_pixel2x2_bot_168 rowReadOFF<8> rowReadOFF<9> rowReadON<9> RefrBp PrBp PrSFBp
+ col_periphery_1x2_12/COL_LINE0 pixRst<38> pixRst<39> col_periphery_1x2_12/COL_LINE1
+ OffBn openDVS_pixel2x2_bot_168/vpd[2] openDVS_pixel2x2_bot_168/vpd[3] openDVS_pixel2x2_bot_168/vpd[1]
+ openDVS_pixel2x2_bot_168/vpd[0] rowReadON<8> openDVS_pixel2x2_bot_939/GndD DiffBn
+ VSUBS VDD OnBn openDVS_pixel2x2_bot
XopenDVS_pixel2x2_bot_157 rowReadOFF<4> rowReadOFF<5> rowReadON<5> RefrBp PrBp PrSFBp
+ col_periphery_1x2_15/COL_LINE0 pixRst<48> pixRst<49> col_periphery_1x2_15/COL_LINE1
+ OffBn openDVS_pixel2x2_bot_157/vpd[2] openDVS_pixel2x2_bot_157/vpd[3] openDVS_pixel2x2_bot_157/vpd[1]
+ openDVS_pixel2x2_bot_157/vpd[0] rowReadON<4> openDVS_pixel2x2_bot_6/GndD DiffBn
+ VSUBS VDD OnBn openDVS_pixel2x2_bot
XopenDVS_pixel2x2_bot_102 rowReadOFF<10> rowReadOFF<11> rowReadON<11> RefrBp PrBp
+ PrSFBp col_periphery_1x2_0/COL_LINE0 pixRst<50> pixRst<51> col_periphery_1x2_0/COL_LINE1
+ OffBn openDVS_pixel2x2_bot_102/vpd[2] openDVS_pixel2x2_bot_102/vpd[3] openDVS_pixel2x2_bot_102/vpd[1]
+ openDVS_pixel2x2_bot_102/vpd[0] rowReadON<10> openDVS_pixel2x2_bot_82/GndD DiffBn
+ VSUBS VDD OnBn openDVS_pixel2x2_bot
XopenDVS_pixel2x2_bot_680 rowReadOFF<34> rowReadOFF<35> rowReadON<35> RefrBp PrBp
+ PrSFBp col_periphery_1x2_6/COL_LINE0 pixRst<62> pixRst<63> col_periphery_1x2_6/COL_LINE1
+ OffBn openDVS_pixel2x2_bot_680/vpd[2] openDVS_pixel2x2_bot_680/vpd[3] openDVS_pixel2x2_bot_680/vpd[1]
+ openDVS_pixel2x2_bot_680/vpd[0] rowReadON<34> openDVS_pixel2x2_bot_995/GndD DiffBn
+ VSUBS VDD OnBn openDVS_pixel2x2_bot
XopenDVS_pixel2x2_bot_691 rowReadOFF<30> rowReadOFF<31> rowReadON<31> RefrBp PrBp
+ PrSFBp col_periphery_1x2_2/COL_LINE0 pixRst<54> pixRst<55> col_periphery_1x2_2/COL_LINE1
+ OffBn openDVS_pixel2x2_bot_691/vpd[2] openDVS_pixel2x2_bot_691/vpd[3] openDVS_pixel2x2_bot_691/vpd[1]
+ openDVS_pixel2x2_bot_691/vpd[0] rowReadON<30> openDVS_pixel2x2_bot_991/GndD DiffBn
+ VSUBS VDD OnBn openDVS_pixel2x2_bot
XopenDVS_pixel2x2_bot_1020 rowReadOFF<60> rowReadOFF<61> rowReadON<61> RefrBp PrBp
+ PrSFBp col_periphery_1x2_23/COL_LINE0 pixRst<30> pixRst<31> col_periphery_1x2_23/COL_LINE1
+ OffBn openDVS_pixel2x2_bot_1020/vpd[2] openDVS_pixel2x2_bot_1020/vpd[3] openDVS_pixel2x2_bot_1020/vpd[1]
+ openDVS_pixel2x2_bot_1020/vpd[0] rowReadON<60> openDVS_pixel2x2_bot_902/GndD DiffBn
+ VSUBS VDD OnBn openDVS_pixel2x2_bot
XopenDVS_pixel2x2_bot_509 rowReadOFF<52> rowReadOFF<53> rowReadON<53> RefrBp PrBp
+ PrSFBp col_periphery_1x2_30/COL_LINE0 pixRst<12> pixRst<13> col_periphery_1x2_30/COL_LINE1
+ OffBn openDVS_pixel2x2_bot_509/vpd[2] openDVS_pixel2x2_bot_509/vpd[3] openDVS_pixel2x2_bot_509/vpd[1]
+ openDVS_pixel2x2_bot_509/vpd[0] rowReadON<52> openDVS_pixel2x2_bot_882/GndD DiffBn
+ VSUBS VDD OnBn openDVS_pixel2x2_bot
Xcol_periphery_1x2_31 pixRst<15> col_periphery_1x2_31/COL_LINE0 col_periphery_1x2_31/COL_LINE1
+ nDETECT DETECT col_periphery_1x2_9/VDD VTHRESH pixRst<14> voutn<14> VSUBS voutn<15>
+ NCHARGE col_periphery_1x2
Xcol_periphery_1x2_20 pixRst<25> col_periphery_1x2_20/COL_LINE0 col_periphery_1x2_20/COL_LINE1
+ nDETECT DETECT col_periphery_1x2_9/VDD VTHRESH pixRst<24> voutn<24> VSUBS voutn<25>
+ NCHARGE col_periphery_1x2
XopenDVS_pixel2x2_bot_328 rowReadOFF<20> rowReadOFF<21> rowReadON<21> RefrBp PrBp
+ PrSFBp col_periphery_1x2_20/COL_LINE0 pixRst<24> pixRst<25> col_periphery_1x2_20/COL_LINE1
+ OffBn openDVS_pixel2x2_bot_328/vpd[2] openDVS_pixel2x2_bot_328/vpd[3] openDVS_pixel2x2_bot_328/vpd[1]
+ openDVS_pixel2x2_bot_328/vpd[0] rowReadON<20> openDVS_pixel2x2_bot_95/GndD DiffBn
+ VSUBS VDD OnBn openDVS_pixel2x2_bot
XopenDVS_pixel2x2_bot_306 rowReadOFF<14> rowReadOFF<15> rowReadON<15> RefrBp PrBp
+ PrSFBp col_periphery_1x2_17/COL_LINE0 pixRst<18> pixRst<19> col_periphery_1x2_17/COL_LINE1
+ OffBn openDVS_pixel2x2_bot_306/vpd[2] openDVS_pixel2x2_bot_306/vpd[3] openDVS_pixel2x2_bot_306/vpd[1]
+ openDVS_pixel2x2_bot_306/vpd[0] rowReadON<14> openDVS_pixel2x2_bot_78/GndD DiffBn
+ VSUBS VDD OnBn openDVS_pixel2x2_bot
XopenDVS_pixel2x2_bot_317 rowReadOFF<20> rowReadOFF<21> rowReadON<21> RefrBp PrBp
+ PrSFBp col_periphery_1x2_17/COL_LINE0 pixRst<18> pixRst<19> col_periphery_1x2_17/COL_LINE1
+ OffBn openDVS_pixel2x2_bot_317/vpd[2] openDVS_pixel2x2_bot_317/vpd[3] openDVS_pixel2x2_bot_317/vpd[1]
+ openDVS_pixel2x2_bot_317/vpd[0] rowReadON<20> openDVS_pixel2x2_bot_95/GndD DiffBn
+ VSUBS VDD OnBn openDVS_pixel2x2_bot
XopenDVS_pixel2x2_bot_339 rowReadOFF<6> rowReadOFF<7> rowReadON<7> RefrBp PrBp PrSFBp
+ col_periphery_1x2_19/COL_LINE0 pixRst<22> pixRst<23> col_periphery_1x2_19/COL_LINE1
+ OffBn openDVS_pixel2x2_bot_339/vpd[2] openDVS_pixel2x2_bot_339/vpd[3] openDVS_pixel2x2_bot_339/vpd[1]
+ openDVS_pixel2x2_bot_339/vpd[0] rowReadON<6> openDVS_pixel2x2_bot_937/GndD DiffBn
+ VSUBS VDD OnBn openDVS_pixel2x2_bot
XopenDVS_pixel2x2_bot_862 rowReadOFF<62> rowReadOFF<63> rowReadON<63> RefrBp PrBp
+ PrSFBp col_periphery_1x2_4/COL_LINE0 pixRst<58> pixRst<59> col_periphery_1x2_4/COL_LINE1
+ OffBn openDVS_pixel2x2_bot_862/vpd[2] openDVS_pixel2x2_bot_862/vpd[3] openDVS_pixel2x2_bot_862/vpd[1]
+ openDVS_pixel2x2_bot_862/vpd[0] rowReadON<62> openDVS_pixel2x2_bot_886/GndD DiffBn
+ VSUBS VDD OnBn openDVS_pixel2x2_bot
XopenDVS_pixel2x2_bot_884 rowReadOFF<54> rowReadOFF<55> rowReadON<55> RefrBp PrBp
+ PrSFBp col_periphery_1x2_14/COL_LINE0 pixRst<46> pixRst<47> col_periphery_1x2_14/COL_LINE1
+ OffBn openDVS_pixel2x2_bot_884/vpd[2] openDVS_pixel2x2_bot_884/vpd[3] openDVS_pixel2x2_bot_884/vpd[1]
+ openDVS_pixel2x2_bot_884/vpd[0] rowReadON<54> openDVS_pixel2x2_bot_885/GndD DiffBn
+ VSUBS VDD OnBn openDVS_pixel2x2_bot
XopenDVS_pixel2x2_bot_873 rowReadOFF<50> rowReadOFF<51> rowReadON<51> RefrBp PrBp
+ PrSFBp col_periphery_1x2_2/COL_LINE0 pixRst<54> pixRst<55> col_periphery_1x2_2/COL_LINE1
+ OffBn openDVS_pixel2x2_bot_873/vpd[2] openDVS_pixel2x2_bot_873/vpd[3] openDVS_pixel2x2_bot_873/vpd[1]
+ openDVS_pixel2x2_bot_873/vpd[0] rowReadON<50> openDVS_pixel2x2_bot_929/GndD DiffBn
+ VSUBS VDD OnBn openDVS_pixel2x2_bot
XopenDVS_pixel2x2_bot_840 rowReadOFF<50> rowReadOFF<51> rowReadON<51> RefrBp PrBp
+ PrSFBp col_periphery_1x2_3/COL_LINE0 pixRst<56> pixRst<57> col_periphery_1x2_3/COL_LINE1
+ OffBn openDVS_pixel2x2_bot_840/vpd[2] openDVS_pixel2x2_bot_840/vpd[3] openDVS_pixel2x2_bot_840/vpd[1]
+ openDVS_pixel2x2_bot_840/vpd[0] rowReadON<50> openDVS_pixel2x2_bot_929/GndD DiffBn
+ VSUBS VDD OnBn openDVS_pixel2x2_bot
XopenDVS_pixel2x2_bot_851 rowReadOFF<48> rowReadOFF<49> rowReadON<49> RefrBp PrBp
+ PrSFBp col_periphery_1x2_0/COL_LINE0 pixRst<50> pixRst<51> col_periphery_1x2_0/COL_LINE1
+ OffBn openDVS_pixel2x2_bot_851/vpd[2] openDVS_pixel2x2_bot_851/vpd[3] openDVS_pixel2x2_bot_851/vpd[1]
+ openDVS_pixel2x2_bot_851/vpd[0] rowReadON<48> openDVS_pixel2x2_bot_927/GndD DiffBn
+ VSUBS VDD OnBn openDVS_pixel2x2_bot
XopenDVS_pixel2x2_bot_895 rowReadOFF<32> rowReadOFF<33> rowReadON<33> RefrBp PrBp
+ PrSFBp col_periphery_1x2_14/COL_LINE0 pixRst<46> pixRst<47> col_periphery_1x2_14/COL_LINE1
+ OffBn openDVS_pixel2x2_bot_895/vpd[2] openDVS_pixel2x2_bot_895/vpd[3] openDVS_pixel2x2_bot_895/vpd[1]
+ openDVS_pixel2x2_bot_895/vpd[0] rowReadON<32> openDVS_pixel2x2_bot_993/GndD DiffBn
+ VSUBS VDD OnBn openDVS_pixel2x2_bot
XopenDVS_pixel2x2_bot_114 rowReadOFF<22> rowReadOFF<23> rowReadON<23> RefrBp PrBp
+ PrSFBp col_periphery_1x2_2/COL_LINE0 pixRst<54> pixRst<55> col_periphery_1x2_2/COL_LINE1
+ OffBn openDVS_pixel2x2_bot_114/vpd[2] openDVS_pixel2x2_bot_114/vpd[3] openDVS_pixel2x2_bot_114/vpd[1]
+ openDVS_pixel2x2_bot_114/vpd[0] rowReadON<22> openDVS_pixel2x2_bot_97/GndD DiffBn
+ VSUBS VDD OnBn openDVS_pixel2x2_bot
XopenDVS_pixel2x2_bot_125 rowReadOFF<18> rowReadOFF<19> rowReadON<19> RefrBp PrBp
+ PrSFBp col_periphery_1x2_3/COL_LINE0 pixRst<56> pixRst<57> col_periphery_1x2_3/COL_LINE1
+ OffBn openDVS_pixel2x2_bot_125/vpd[2] openDVS_pixel2x2_bot_125/vpd[3] openDVS_pixel2x2_bot_125/vpd[1]
+ openDVS_pixel2x2_bot_125/vpd[0] rowReadON<18> openDVS_pixel2x2_bot_69/GndD DiffBn
+ VSUBS VDD OnBn openDVS_pixel2x2_bot
XopenDVS_pixel2x2_bot_136 rowReadOFF<12> rowReadOFF<13> rowReadON<13> RefrBp PrBp
+ PrSFBp col_periphery_1x2_1/COL_LINE0 pixRst<52> pixRst<53> col_periphery_1x2_1/COL_LINE1
+ OffBn openDVS_pixel2x2_bot_136/vpd[2] openDVS_pixel2x2_bot_136/vpd[3] openDVS_pixel2x2_bot_136/vpd[1]
+ openDVS_pixel2x2_bot_136/vpd[0] rowReadON<12> openDVS_pixel2x2_bot_79/GndD DiffBn
+ VSUBS VDD OnBn openDVS_pixel2x2_bot
XopenDVS_pixel2x2_bot_158 rowReadOFF<14> rowReadOFF<15> rowReadON<15> RefrBp PrBp
+ PrSFBp col_periphery_1x2_14/COL_LINE0 pixRst<46> pixRst<47> col_periphery_1x2_14/COL_LINE1
+ OffBn openDVS_pixel2x2_bot_158/vpd[2] openDVS_pixel2x2_bot_158/vpd[3] openDVS_pixel2x2_bot_158/vpd[1]
+ openDVS_pixel2x2_bot_158/vpd[0] rowReadON<14> openDVS_pixel2x2_bot_78/GndD DiffBn
+ VSUBS VDD OnBn openDVS_pixel2x2_bot
XopenDVS_pixel2x2_bot_147 rowReadOFF<6> rowReadOFF<7> rowReadON<7> RefrBp PrBp PrSFBp
+ col_periphery_1x2_4/COL_LINE0 pixRst<58> pixRst<59> col_periphery_1x2_4/COL_LINE1
+ OffBn openDVS_pixel2x2_bot_147/vpd[2] openDVS_pixel2x2_bot_147/vpd[3] openDVS_pixel2x2_bot_147/vpd[1]
+ openDVS_pixel2x2_bot_147/vpd[0] rowReadON<6> openDVS_pixel2x2_bot_937/GndD DiffBn
+ VSUBS VDD OnBn openDVS_pixel2x2_bot
XopenDVS_pixel2x2_bot_103 rowReadOFF<10> rowReadOFF<11> rowReadON<11> RefrBp PrBp
+ PrSFBp col_periphery_1x2_1/COL_LINE0 pixRst<52> pixRst<53> col_periphery_1x2_1/COL_LINE1
+ OffBn openDVS_pixel2x2_bot_103/vpd[2] openDVS_pixel2x2_bot_103/vpd[3] openDVS_pixel2x2_bot_103/vpd[1]
+ openDVS_pixel2x2_bot_103/vpd[0] rowReadON<10> openDVS_pixel2x2_bot_82/GndD DiffBn
+ VSUBS VDD OnBn openDVS_pixel2x2_bot
XopenDVS_pixel2x2_bot_169 rowReadOFF<8> rowReadOFF<9> rowReadON<9> RefrBp PrBp PrSFBp
+ col_periphery_1x2_7/COL_LINE0 pixRst<40> pixRst<41> col_periphery_1x2_7/COL_LINE1
+ OffBn openDVS_pixel2x2_bot_169/vpd[2] openDVS_pixel2x2_bot_169/vpd[3] openDVS_pixel2x2_bot_169/vpd[1]
+ openDVS_pixel2x2_bot_169/vpd[0] rowReadON<8> openDVS_pixel2x2_bot_939/GndD DiffBn
+ VSUBS VDD OnBn openDVS_pixel2x2_bot
XopenDVS_pixel2x2_bot_670 rowReadOFF<34> rowReadOFF<35> rowReadON<35> RefrBp PrBp
+ PrSFBp col_periphery_1x2_3/COL_LINE0 pixRst<56> pixRst<57> col_periphery_1x2_3/COL_LINE1
+ OffBn openDVS_pixel2x2_bot_670/vpd[2] openDVS_pixel2x2_bot_670/vpd[3] openDVS_pixel2x2_bot_670/vpd[1]
+ openDVS_pixel2x2_bot_670/vpd[0] rowReadON<34> openDVS_pixel2x2_bot_995/GndD DiffBn
+ VSUBS VDD OnBn openDVS_pixel2x2_bot
XopenDVS_pixel2x2_bot_681 rowReadOFF<38> rowReadOFF<39> rowReadON<39> RefrBp PrBp
+ PrSFBp col_periphery_1x2_1/COL_LINE0 pixRst<52> pixRst<53> col_periphery_1x2_1/COL_LINE1
+ OffBn openDVS_pixel2x2_bot_681/vpd[2] openDVS_pixel2x2_bot_681/vpd[3] openDVS_pixel2x2_bot_681/vpd[1]
+ openDVS_pixel2x2_bot_681/vpd[0] rowReadON<38> openDVS_pixel2x2_bot_999/GndD DiffBn
+ VSUBS VDD OnBn openDVS_pixel2x2_bot
XopenDVS_pixel2x2_bot_692 rowReadOFF<30> rowReadOFF<31> rowReadON<31> RefrBp PrBp
+ PrSFBp col_periphery_1x2_3/COL_LINE0 pixRst<56> pixRst<57> col_periphery_1x2_3/COL_LINE1
+ OffBn openDVS_pixel2x2_bot_692/vpd[2] openDVS_pixel2x2_bot_692/vpd[3] openDVS_pixel2x2_bot_692/vpd[1]
+ openDVS_pixel2x2_bot_692/vpd[0] rowReadON<30> openDVS_pixel2x2_bot_991/GndD DiffBn
+ VSUBS VDD OnBn openDVS_pixel2x2_bot
XopenDVS_pixel2x2_bot_90 rowReadOFF<16> rowReadOFF<17> rowReadON<17> RefrBp PrBp PrSFBp
+ col_periphery_1x2_5/COL_LINE0 pixRst<60> pixRst<61> col_periphery_1x2_5/COL_LINE1
+ OffBn openDVS_pixel2x2_bot_90/vpd[2] openDVS_pixel2x2_bot_90/vpd[3] openDVS_pixel2x2_bot_90/vpd[1]
+ openDVS_pixel2x2_bot_90/vpd[0] rowReadON<16> openDVS_pixel2x2_bot_91/GndD DiffBn
+ VSUBS VDD OnBn openDVS_pixel2x2_bot
XopenDVS_pixel2x2_bot_1021 rowReadOFF<60> rowReadOFF<61> rowReadON<61> RefrBp PrBp
+ PrSFBp col_periphery_1x2_9/COL_LINE0 pixRst<32> pixRst<33> col_periphery_1x2_9/COL_LINE1
+ OffBn openDVS_pixel2x2_bot_1021/vpd[2] openDVS_pixel2x2_bot_1021/vpd[3] openDVS_pixel2x2_bot_1021/vpd[1]
+ openDVS_pixel2x2_bot_1021/vpd[0] rowReadON<60> openDVS_pixel2x2_bot_902/GndD DiffBn
+ VSUBS VDD OnBn openDVS_pixel2x2_bot
XopenDVS_pixel2x2_bot_1010 rowReadOFF<50> rowReadOFF<51> rowReadON<51> RefrBp PrBp
+ PrSFBp col_periphery_1x2_23/COL_LINE0 pixRst<30> pixRst<31> col_periphery_1x2_23/COL_LINE1
+ OffBn openDVS_pixel2x2_bot_1010/vpd[2] openDVS_pixel2x2_bot_1010/vpd[3] openDVS_pixel2x2_bot_1010/vpd[1]
+ openDVS_pixel2x2_bot_1010/vpd[0] rowReadON<50> openDVS_pixel2x2_bot_929/GndD DiffBn
+ VSUBS VDD OnBn openDVS_pixel2x2_bot
Xcol_periphery_1x2_21 pixRst<27> col_periphery_1x2_21/COL_LINE0 col_periphery_1x2_21/COL_LINE1
+ nDETECT DETECT col_periphery_1x2_9/VDD VTHRESH pixRst<26> voutn<26> VSUBS voutn<27>
+ NCHARGE col_periphery_1x2
Xcol_periphery_1x2_10 pixRst<35> col_periphery_1x2_10/COL_LINE0 col_periphery_1x2_10/COL_LINE1
+ nDETECT DETECT col_periphery_1x2_9/VDD VTHRESH pixRst<34> voutn<34> VSUBS voutn<35>
+ NCHARGE col_periphery_1x2
XopenDVS_pixel2x2_bot_318 rowReadOFF<22> rowReadOFF<23> rowReadON<23> RefrBp PrBp
+ PrSFBp col_periphery_1x2_22/COL_LINE0 pixRst<28> pixRst<29> col_periphery_1x2_22/COL_LINE1
+ OffBn openDVS_pixel2x2_bot_318/vpd[2] openDVS_pixel2x2_bot_318/vpd[3] openDVS_pixel2x2_bot_318/vpd[1]
+ openDVS_pixel2x2_bot_318/vpd[0] rowReadON<22> openDVS_pixel2x2_bot_97/GndD DiffBn
+ VSUBS VDD OnBn openDVS_pixel2x2_bot
XopenDVS_pixel2x2_bot_307 rowReadOFF<22> rowReadOFF<23> rowReadON<23> RefrBp PrBp
+ PrSFBp col_periphery_1x2_17/COL_LINE0 pixRst<18> pixRst<19> col_periphery_1x2_17/COL_LINE1
+ OffBn openDVS_pixel2x2_bot_307/vpd[2] openDVS_pixel2x2_bot_307/vpd[3] openDVS_pixel2x2_bot_307/vpd[1]
+ openDVS_pixel2x2_bot_307/vpd[0] rowReadON<22> openDVS_pixel2x2_bot_97/GndD DiffBn
+ VSUBS VDD OnBn openDVS_pixel2x2_bot
XopenDVS_pixel2x2_bot_329 rowReadOFF<20> rowReadOFF<21> rowReadON<21> RefrBp PrBp
+ PrSFBp col_periphery_1x2_21/COL_LINE0 pixRst<26> pixRst<27> col_periphery_1x2_21/COL_LINE1
+ OffBn openDVS_pixel2x2_bot_329/vpd[2] openDVS_pixel2x2_bot_329/vpd[3] openDVS_pixel2x2_bot_329/vpd[1]
+ openDVS_pixel2x2_bot_329/vpd[0] rowReadON<20> openDVS_pixel2x2_bot_95/GndD DiffBn
+ VSUBS VDD OnBn openDVS_pixel2x2_bot
XopenDVS_pixel2x2_bot_830 rowReadOFF<54> rowReadOFF<55> rowReadON<55> RefrBp PrBp
+ PrSFBp col_periphery_1x2_0/COL_LINE0 pixRst<50> pixRst<51> col_periphery_1x2_0/COL_LINE1
+ OffBn openDVS_pixel2x2_bot_830/vpd[2] openDVS_pixel2x2_bot_830/vpd[3] openDVS_pixel2x2_bot_830/vpd[1]
+ openDVS_pixel2x2_bot_830/vpd[0] rowReadON<54> openDVS_pixel2x2_bot_885/GndD DiffBn
+ VSUBS VDD OnBn openDVS_pixel2x2_bot
XopenDVS_pixel2x2_bot_841 rowReadOFF<56> rowReadOFF<57> rowReadON<57> RefrBp PrBp
+ PrSFBp col_periphery_1x2_0/COL_LINE0 pixRst<50> pixRst<51> col_periphery_1x2_0/COL_LINE1
+ OffBn openDVS_pixel2x2_bot_841/vpd[2] openDVS_pixel2x2_bot_841/vpd[3] openDVS_pixel2x2_bot_841/vpd[1]
+ openDVS_pixel2x2_bot_841/vpd[0] rowReadON<56> openDVS_pixel2x2_bot_888/GndD DiffBn
+ VSUBS VDD OnBn openDVS_pixel2x2_bot
XopenDVS_pixel2x2_bot_852 rowReadOFF<58> rowReadOFF<59> rowReadON<59> RefrBp PrBp
+ PrSFBp col_periphery_1x2_0/COL_LINE0 pixRst<50> pixRst<51> col_periphery_1x2_0/COL_LINE1
+ OffBn openDVS_pixel2x2_bot_852/vpd[2] openDVS_pixel2x2_bot_852/vpd[3] openDVS_pixel2x2_bot_852/vpd[1]
+ openDVS_pixel2x2_bot_852/vpd[0] rowReadON<58> openDVS_pixel2x2_bot_890/GndD DiffBn
+ VSUBS VDD OnBn openDVS_pixel2x2_bot
XopenDVS_pixel2x2_bot_885 rowReadOFF<54> rowReadOFF<55> rowReadON<55> RefrBp PrBp
+ PrSFBp col_periphery_1x2_15/COL_LINE0 pixRst<48> pixRst<49> col_periphery_1x2_15/COL_LINE1
+ OffBn openDVS_pixel2x2_bot_885/vpd[2] openDVS_pixel2x2_bot_885/vpd[3] openDVS_pixel2x2_bot_885/vpd[1]
+ openDVS_pixel2x2_bot_885/vpd[0] rowReadON<54> openDVS_pixel2x2_bot_885/GndD DiffBn
+ VSUBS VDD OnBn openDVS_pixel2x2_bot
XopenDVS_pixel2x2_bot_863 rowReadOFF<48> rowReadOFF<49> rowReadON<49> RefrBp PrBp
+ PrSFBp col_periphery_1x2_3/COL_LINE0 pixRst<56> pixRst<57> col_periphery_1x2_3/COL_LINE1
+ OffBn openDVS_pixel2x2_bot_863/vpd[2] openDVS_pixel2x2_bot_863/vpd[3] openDVS_pixel2x2_bot_863/vpd[1]
+ openDVS_pixel2x2_bot_863/vpd[0] rowReadON<48> openDVS_pixel2x2_bot_927/GndD DiffBn
+ VSUBS VDD OnBn openDVS_pixel2x2_bot
XopenDVS_pixel2x2_bot_874 rowReadOFF<46> rowReadOFF<47> rowReadON<47> RefrBp PrBp
+ PrSFBp col_periphery_1x2_0/COL_LINE0 pixRst<50> pixRst<51> col_periphery_1x2_0/COL_LINE1
+ OffBn openDVS_pixel2x2_bot_874/vpd[2] openDVS_pixel2x2_bot_874/vpd[3] openDVS_pixel2x2_bot_874/vpd[1]
+ openDVS_pixel2x2_bot_874/vpd[0] rowReadON<46> openDVS_pixel2x2_bot_925/GndD DiffBn
+ VSUBS VDD OnBn openDVS_pixel2x2_bot
XopenDVS_pixel2x2_bot_896 rowReadOFF<32> rowReadOFF<33> rowReadON<33> RefrBp PrBp
+ PrSFBp col_periphery_1x2_15/COL_LINE0 pixRst<48> pixRst<49> col_periphery_1x2_15/COL_LINE1
+ OffBn openDVS_pixel2x2_bot_896/vpd[2] openDVS_pixel2x2_bot_896/vpd[3] openDVS_pixel2x2_bot_896/vpd[1]
+ openDVS_pixel2x2_bot_896/vpd[0] rowReadON<32> openDVS_pixel2x2_bot_993/GndD DiffBn
+ VSUBS VDD OnBn openDVS_pixel2x2_bot
XopenDVS_pixel2x2_bot_115 rowReadOFF<22> rowReadOFF<23> rowReadON<23> RefrBp PrBp
+ PrSFBp col_periphery_1x2_3/COL_LINE0 pixRst<56> pixRst<57> col_periphery_1x2_3/COL_LINE1
+ OffBn openDVS_pixel2x2_bot_115/vpd[2] openDVS_pixel2x2_bot_115/vpd[3] openDVS_pixel2x2_bot_115/vpd[1]
+ openDVS_pixel2x2_bot_115/vpd[0] rowReadON<22> openDVS_pixel2x2_bot_97/GndD DiffBn
+ VSUBS VDD OnBn openDVS_pixel2x2_bot
XopenDVS_pixel2x2_bot_126 rowReadOFF<18> rowReadOFF<19> rowReadON<19> RefrBp PrBp
+ PrSFBp col_periphery_1x2_4/COL_LINE0 pixRst<58> pixRst<59> col_periphery_1x2_4/COL_LINE1
+ OffBn openDVS_pixel2x2_bot_126/vpd[2] openDVS_pixel2x2_bot_126/vpd[3] openDVS_pixel2x2_bot_126/vpd[1]
+ openDVS_pixel2x2_bot_126/vpd[0] rowReadON<18> openDVS_pixel2x2_bot_69/GndD DiffBn
+ VSUBS VDD OnBn openDVS_pixel2x2_bot
XopenDVS_pixel2x2_bot_137 rowReadOFF<12> rowReadOFF<13> rowReadON<13> RefrBp PrBp
+ PrSFBp col_periphery_1x2_2/COL_LINE0 pixRst<54> pixRst<55> col_periphery_1x2_2/COL_LINE1
+ OffBn openDVS_pixel2x2_bot_137/vpd[2] openDVS_pixel2x2_bot_137/vpd[3] openDVS_pixel2x2_bot_137/vpd[1]
+ openDVS_pixel2x2_bot_137/vpd[0] rowReadON<12> openDVS_pixel2x2_bot_79/GndD DiffBn
+ VSUBS VDD OnBn openDVS_pixel2x2_bot
XopenDVS_pixel2x2_bot_104 rowReadOFF<14> rowReadOFF<15> rowReadON<15> RefrBp PrBp
+ PrSFBp col_periphery_1x2_0/COL_LINE0 pixRst<50> pixRst<51> col_periphery_1x2_0/COL_LINE1
+ OffBn openDVS_pixel2x2_bot_104/vpd[2] openDVS_pixel2x2_bot_104/vpd[3] openDVS_pixel2x2_bot_104/vpd[1]
+ openDVS_pixel2x2_bot_104/vpd[0] rowReadON<14> openDVS_pixel2x2_bot_78/GndD DiffBn
+ VSUBS VDD OnBn openDVS_pixel2x2_bot
XopenDVS_pixel2x2_bot_159 rowReadOFF<14> rowReadOFF<15> rowReadON<15> RefrBp PrBp
+ PrSFBp col_periphery_1x2_15/COL_LINE0 pixRst<48> pixRst<49> col_periphery_1x2_15/COL_LINE1
+ OffBn openDVS_pixel2x2_bot_159/vpd[2] openDVS_pixel2x2_bot_159/vpd[3] openDVS_pixel2x2_bot_159/vpd[1]
+ openDVS_pixel2x2_bot_159/vpd[0] rowReadON<14> openDVS_pixel2x2_bot_78/GndD DiffBn
+ VSUBS VDD OnBn openDVS_pixel2x2_bot
XopenDVS_pixel2x2_bot_148 rowReadOFF<6> rowReadOFF<7> rowReadON<7> RefrBp PrBp PrSFBp
+ col_periphery_1x2_5/COL_LINE0 pixRst<60> pixRst<61> col_periphery_1x2_5/COL_LINE1
+ OffBn openDVS_pixel2x2_bot_148/vpd[2] openDVS_pixel2x2_bot_148/vpd[3] openDVS_pixel2x2_bot_148/vpd[1]
+ openDVS_pixel2x2_bot_148/vpd[0] rowReadON<6> openDVS_pixel2x2_bot_937/GndD DiffBn
+ VSUBS VDD OnBn openDVS_pixel2x2_bot
XopenDVS_pixel2x2_bot_671 rowReadOFF<34> rowReadOFF<35> rowReadON<35> RefrBp PrBp
+ PrSFBp col_periphery_1x2_4/COL_LINE0 pixRst<58> pixRst<59> col_periphery_1x2_4/COL_LINE1
+ OffBn openDVS_pixel2x2_bot_671/vpd[2] openDVS_pixel2x2_bot_671/vpd[3] openDVS_pixel2x2_bot_671/vpd[1]
+ openDVS_pixel2x2_bot_671/vpd[0] rowReadON<34> openDVS_pixel2x2_bot_995/GndD DiffBn
+ VSUBS VDD OnBn openDVS_pixel2x2_bot
XopenDVS_pixel2x2_bot_660 rowReadOFF<42> rowReadOFF<43> rowReadON<43> RefrBp PrBp
+ PrSFBp col_periphery_1x2_2/COL_LINE0 pixRst<54> pixRst<55> col_periphery_1x2_2/COL_LINE1
+ OffBn openDVS_pixel2x2_bot_660/vpd[2] openDVS_pixel2x2_bot_660/vpd[3] openDVS_pixel2x2_bot_660/vpd[1]
+ openDVS_pixel2x2_bot_660/vpd[0] rowReadON<42> openDVS_pixel2x2_bot_908/GndD DiffBn
+ VSUBS VDD OnBn openDVS_pixel2x2_bot
XopenDVS_pixel2x2_bot_682 rowReadOFF<38> rowReadOFF<39> rowReadON<39> RefrBp PrBp
+ PrSFBp col_periphery_1x2_2/COL_LINE0 pixRst<54> pixRst<55> col_periphery_1x2_2/COL_LINE1
+ OffBn openDVS_pixel2x2_bot_682/vpd[2] openDVS_pixel2x2_bot_682/vpd[3] openDVS_pixel2x2_bot_682/vpd[1]
+ openDVS_pixel2x2_bot_682/vpd[0] rowReadON<38> openDVS_pixel2x2_bot_999/GndD DiffBn
+ VSUBS VDD OnBn openDVS_pixel2x2_bot
XopenDVS_pixel2x2_bot_693 rowReadOFF<30> rowReadOFF<31> rowReadON<31> RefrBp PrBp
+ PrSFBp col_periphery_1x2_4/COL_LINE0 pixRst<58> pixRst<59> col_periphery_1x2_4/COL_LINE1
+ OffBn openDVS_pixel2x2_bot_693/vpd[2] openDVS_pixel2x2_bot_693/vpd[3] openDVS_pixel2x2_bot_693/vpd[1]
+ openDVS_pixel2x2_bot_693/vpd[0] rowReadON<30> openDVS_pixel2x2_bot_991/GndD DiffBn
+ VSUBS VDD OnBn openDVS_pixel2x2_bot
XopenDVS_pixel2x2_bot_80 rowReadOFF<24> rowReadOFF<25> rowReadON<25> RefrBp PrBp PrSFBp
+ col_periphery_1x2_10/COL_LINE0 pixRst<34> pixRst<35> col_periphery_1x2_10/COL_LINE1
+ OffBn openDVS_pixel2x2_bot_80/vpd[2] openDVS_pixel2x2_bot_80/vpd[3] openDVS_pixel2x2_bot_80/vpd[1]
+ openDVS_pixel2x2_bot_80/vpd[0] rowReadON<24> openDVS_pixel2x2_bot_99/GndD DiffBn
+ VSUBS VDD OnBn openDVS_pixel2x2_bot
XopenDVS_pixel2x2_bot_91 rowReadOFF<16> rowReadOFF<17> rowReadON<17> RefrBp PrBp PrSFBp
+ col_periphery_1x2_6/COL_LINE0 pixRst<62> pixRst<63> col_periphery_1x2_6/COL_LINE1
+ OffBn openDVS_pixel2x2_bot_91/vpd[2] openDVS_pixel2x2_bot_91/vpd[3] openDVS_pixel2x2_bot_91/vpd[1]
+ openDVS_pixel2x2_bot_91/vpd[0] rowReadON<16> openDVS_pixel2x2_bot_91/GndD DiffBn
+ VSUBS VDD OnBn openDVS_pixel2x2_bot
XopenDVS_pixel2x2_bot_1022 rowReadOFF<62> rowReadOFF<63> rowReadON<63> RefrBp PrBp
+ PrSFBp col_periphery_1x2_23/COL_LINE0 pixRst<30> pixRst<31> col_periphery_1x2_23/COL_LINE1
+ OffBn openDVS_pixel2x2_bot_1022/vpd[2] openDVS_pixel2x2_bot_1022/vpd[3] openDVS_pixel2x2_bot_1022/vpd[1]
+ openDVS_pixel2x2_bot_1022/vpd[0] rowReadON<62> openDVS_pixel2x2_bot_886/GndD DiffBn
+ VSUBS VDD OnBn openDVS_pixel2x2_bot
XopenDVS_pixel2x2_bot_1011 rowReadOFF<50> rowReadOFF<51> rowReadON<51> RefrBp PrBp
+ PrSFBp col_periphery_1x2_9/COL_LINE0 pixRst<32> pixRst<33> col_periphery_1x2_9/COL_LINE1
+ OffBn openDVS_pixel2x2_bot_1011/vpd[2] openDVS_pixel2x2_bot_1011/vpd[3] openDVS_pixel2x2_bot_1011/vpd[1]
+ openDVS_pixel2x2_bot_1011/vpd[0] rowReadON<50> openDVS_pixel2x2_bot_929/GndD DiffBn
+ VSUBS VDD OnBn openDVS_pixel2x2_bot
XopenDVS_pixel2x2_bot_1000 rowReadOFF<40> rowReadOFF<41> rowReadON<41> RefrBp PrBp
+ PrSFBp col_periphery_1x2_23/COL_LINE0 pixRst<30> pixRst<31> col_periphery_1x2_23/COL_LINE1
+ OffBn openDVS_pixel2x2_bot_1000/vpd[2] openDVS_pixel2x2_bot_1000/vpd[3] openDVS_pixel2x2_bot_1000/vpd[1]
+ openDVS_pixel2x2_bot_1000/vpd[0] rowReadON<40> openDVS_pixel2x2_bot_906/GndD DiffBn
+ VSUBS VDD OnBn openDVS_pixel2x2_bot
XopenDVS_pixel2x2_bot_490 rowReadOFF<28> rowReadOFF<29> rowReadON<29> RefrBp PrBp
+ PrSFBp col_periphery_1x2_24/COL_LINE0 pixRst<0> pixRst<1> col_periphery_1x2_24/COL_LINE1
+ OffBn openDVS_pixel2x2_bot_490/vpd[2] openDVS_pixel2x2_bot_490/vpd[3] openDVS_pixel2x2_bot_490/vpd[1]
+ openDVS_pixel2x2_bot_490/vpd[0] rowReadON<28> openDVS_pixel2x2_bot_989/GndD DiffBn
+ VSUBS VDD OnBn openDVS_pixel2x2_bot
Xcol_periphery_1x2_22 pixRst<29> col_periphery_1x2_22/COL_LINE0 col_periphery_1x2_22/COL_LINE1
+ nDETECT DETECT col_periphery_1x2_9/VDD VTHRESH pixRst<28> voutn<28> VSUBS voutn<29>
+ NCHARGE col_periphery_1x2
Xcol_periphery_1x2_11 pixRst<37> col_periphery_1x2_11/COL_LINE0 col_periphery_1x2_11/COL_LINE1
+ nDETECT DETECT col_periphery_1x2_9/VDD VTHRESH pixRst<36> voutn<36> VSUBS voutn<37>
+ NCHARGE col_periphery_1x2
XopenDVS_pixel2x2_bot_319 rowReadOFF<24> rowReadOFF<25> rowReadON<25> RefrBp PrBp
+ PrSFBp col_periphery_1x2_21/COL_LINE0 pixRst<26> pixRst<27> col_periphery_1x2_21/COL_LINE1
+ OffBn openDVS_pixel2x2_bot_319/vpd[2] openDVS_pixel2x2_bot_319/vpd[3] openDVS_pixel2x2_bot_319/vpd[1]
+ openDVS_pixel2x2_bot_319/vpd[0] rowReadON<24> openDVS_pixel2x2_bot_99/GndD DiffBn
+ VSUBS VDD OnBn openDVS_pixel2x2_bot
XopenDVS_pixel2x2_bot_308 rowReadOFF<14> rowReadOFF<15> rowReadON<15> RefrBp PrBp
+ PrSFBp col_periphery_1x2_18/COL_LINE0 pixRst<20> pixRst<21> col_periphery_1x2_18/COL_LINE1
+ OffBn openDVS_pixel2x2_bot_308/vpd[2] openDVS_pixel2x2_bot_308/vpd[3] openDVS_pixel2x2_bot_308/vpd[1]
+ openDVS_pixel2x2_bot_308/vpd[0] rowReadON<14> openDVS_pixel2x2_bot_78/GndD DiffBn
+ VSUBS VDD OnBn openDVS_pixel2x2_bot
XopenDVS_pixel2x2_bot_0 rowReadOFF<4> rowReadOFF<5> rowReadON<5> RefrBp PrBp PrSFBp
+ col_periphery_1x2_0/COL_LINE0 pixRst<50> pixRst<51> col_periphery_1x2_0/COL_LINE1
+ OffBn openDVS_pixel2x2_bot_0/vpd[2] openDVS_pixel2x2_bot_0/vpd[3] openDVS_pixel2x2_bot_0/vpd[1]
+ openDVS_pixel2x2_bot_0/vpd[0] rowReadON<4> openDVS_pixel2x2_bot_6/GndD DiffBn VSUBS
+ VDD OnBn openDVS_pixel2x2_bot
XopenDVS_pixel2x2_bot_831 rowReadOFF<54> rowReadOFF<55> rowReadON<55> RefrBp PrBp
+ PrSFBp col_periphery_1x2_1/COL_LINE0 pixRst<52> pixRst<53> col_periphery_1x2_1/COL_LINE1
+ OffBn openDVS_pixel2x2_bot_831/vpd[2] openDVS_pixel2x2_bot_831/vpd[3] openDVS_pixel2x2_bot_831/vpd[1]
+ openDVS_pixel2x2_bot_831/vpd[0] rowReadON<54> openDVS_pixel2x2_bot_885/GndD DiffBn
+ VSUBS VDD OnBn openDVS_pixel2x2_bot
XopenDVS_pixel2x2_bot_842 rowReadOFF<56> rowReadOFF<57> rowReadON<57> RefrBp PrBp
+ PrSFBp col_periphery_1x2_1/COL_LINE0 pixRst<52> pixRst<53> col_periphery_1x2_1/COL_LINE1
+ OffBn openDVS_pixel2x2_bot_842/vpd[2] openDVS_pixel2x2_bot_842/vpd[3] openDVS_pixel2x2_bot_842/vpd[1]
+ openDVS_pixel2x2_bot_842/vpd[0] rowReadON<56> openDVS_pixel2x2_bot_888/GndD DiffBn
+ VSUBS VDD OnBn openDVS_pixel2x2_bot
XopenDVS_pixel2x2_bot_853 rowReadOFF<58> rowReadOFF<59> rowReadON<59> RefrBp PrBp
+ PrSFBp col_periphery_1x2_1/COL_LINE0 pixRst<52> pixRst<53> col_periphery_1x2_1/COL_LINE1
+ OffBn openDVS_pixel2x2_bot_853/vpd[2] openDVS_pixel2x2_bot_853/vpd[3] openDVS_pixel2x2_bot_853/vpd[1]
+ openDVS_pixel2x2_bot_853/vpd[0] rowReadON<58> openDVS_pixel2x2_bot_890/GndD DiffBn
+ VSUBS VDD OnBn openDVS_pixel2x2_bot
XopenDVS_pixel2x2_bot_875 rowReadOFF<60> rowReadOFF<61> rowReadON<61> RefrBp PrBp
+ PrSFBp col_periphery_1x2_0/COL_LINE0 pixRst<50> pixRst<51> col_periphery_1x2_0/COL_LINE1
+ OffBn openDVS_pixel2x2_bot_875/vpd[2] openDVS_pixel2x2_bot_875/vpd[3] openDVS_pixel2x2_bot_875/vpd[1]
+ openDVS_pixel2x2_bot_875/vpd[0] rowReadON<60> openDVS_pixel2x2_bot_902/GndD DiffBn
+ VSUBS VDD OnBn openDVS_pixel2x2_bot
XopenDVS_pixel2x2_bot_864 rowReadOFF<48> rowReadOFF<49> rowReadON<49> RefrBp PrBp
+ PrSFBp col_periphery_1x2_4/COL_LINE0 pixRst<58> pixRst<59> col_periphery_1x2_4/COL_LINE1
+ OffBn openDVS_pixel2x2_bot_864/vpd[2] openDVS_pixel2x2_bot_864/vpd[3] openDVS_pixel2x2_bot_864/vpd[1]
+ openDVS_pixel2x2_bot_864/vpd[0] rowReadON<48> openDVS_pixel2x2_bot_927/GndD DiffBn
+ VSUBS VDD OnBn openDVS_pixel2x2_bot
XopenDVS_pixel2x2_bot_820 rowReadOFF<52> rowReadOFF<53> rowReadON<53> RefrBp PrBp
+ PrSFBp col_periphery_1x2_0/COL_LINE0 pixRst<50> pixRst<51> col_periphery_1x2_0/COL_LINE1
+ OffBn openDVS_pixel2x2_bot_820/vpd[2] openDVS_pixel2x2_bot_820/vpd[3] openDVS_pixel2x2_bot_820/vpd[1]
+ openDVS_pixel2x2_bot_820/vpd[0] rowReadON<52> openDVS_pixel2x2_bot_882/GndD DiffBn
+ VSUBS VDD OnBn openDVS_pixel2x2_bot
XopenDVS_pixel2x2_bot_886 rowReadOFF<62> rowReadOFF<63> rowReadON<63> RefrBp PrBp
+ PrSFBp col_periphery_1x2_15/COL_LINE0 pixRst<48> pixRst<49> col_periphery_1x2_15/COL_LINE1
+ OffBn openDVS_pixel2x2_bot_886/vpd[2] openDVS_pixel2x2_bot_886/vpd[3] openDVS_pixel2x2_bot_886/vpd[1]
+ openDVS_pixel2x2_bot_886/vpd[0] rowReadON<62> openDVS_pixel2x2_bot_886/GndD DiffBn
+ VSUBS VDD OnBn openDVS_pixel2x2_bot
XopenDVS_pixel2x2_bot_897 rowReadOFF<34> rowReadOFF<35> rowReadON<35> RefrBp PrBp
+ PrSFBp col_periphery_1x2_14/COL_LINE0 pixRst<46> pixRst<47> col_periphery_1x2_14/COL_LINE1
+ OffBn openDVS_pixel2x2_bot_897/vpd[2] openDVS_pixel2x2_bot_897/vpd[3] openDVS_pixel2x2_bot_897/vpd[1]
+ openDVS_pixel2x2_bot_897/vpd[0] rowReadON<34> openDVS_pixel2x2_bot_995/GndD DiffBn
+ VSUBS VDD OnBn openDVS_pixel2x2_bot
XopenDVS_pixel2x2_bot_116 rowReadOFF<22> rowReadOFF<23> rowReadON<23> RefrBp PrBp
+ PrSFBp col_periphery_1x2_4/COL_LINE0 pixRst<58> pixRst<59> col_periphery_1x2_4/COL_LINE1
+ OffBn openDVS_pixel2x2_bot_116/vpd[2] openDVS_pixel2x2_bot_116/vpd[3] openDVS_pixel2x2_bot_116/vpd[1]
+ openDVS_pixel2x2_bot_116/vpd[0] rowReadON<22> openDVS_pixel2x2_bot_97/GndD DiffBn
+ VSUBS VDD OnBn openDVS_pixel2x2_bot
XopenDVS_pixel2x2_bot_127 rowReadOFF<24> rowReadOFF<25> rowReadON<25> RefrBp PrBp
+ PrSFBp col_periphery_1x2_0/COL_LINE0 pixRst<50> pixRst<51> col_periphery_1x2_0/COL_LINE1
+ OffBn openDVS_pixel2x2_bot_127/vpd[2] openDVS_pixel2x2_bot_127/vpd[3] openDVS_pixel2x2_bot_127/vpd[1]
+ openDVS_pixel2x2_bot_127/vpd[0] rowReadON<24> openDVS_pixel2x2_bot_99/GndD DiffBn
+ VSUBS VDD OnBn openDVS_pixel2x2_bot
XopenDVS_pixel2x2_bot_138 rowReadOFF<12> rowReadOFF<13> rowReadON<13> RefrBp PrBp
+ PrSFBp col_periphery_1x2_3/COL_LINE0 pixRst<56> pixRst<57> col_periphery_1x2_3/COL_LINE1
+ OffBn openDVS_pixel2x2_bot_138/vpd[2] openDVS_pixel2x2_bot_138/vpd[3] openDVS_pixel2x2_bot_138/vpd[1]
+ openDVS_pixel2x2_bot_138/vpd[0] rowReadON<12> openDVS_pixel2x2_bot_79/GndD DiffBn
+ VSUBS VDD OnBn openDVS_pixel2x2_bot
XopenDVS_pixel2x2_bot_105 rowReadOFF<14> rowReadOFF<15> rowReadON<15> RefrBp PrBp
+ PrSFBp col_periphery_1x2_1/COL_LINE0 pixRst<52> pixRst<53> col_periphery_1x2_1/COL_LINE1
+ OffBn openDVS_pixel2x2_bot_105/vpd[2] openDVS_pixel2x2_bot_105/vpd[3] openDVS_pixel2x2_bot_105/vpd[1]
+ openDVS_pixel2x2_bot_105/vpd[0] rowReadON<14> openDVS_pixel2x2_bot_78/GndD DiffBn
+ VSUBS VDD OnBn openDVS_pixel2x2_bot
XopenDVS_pixel2x2_bot_149 rowReadOFF<6> rowReadOFF<7> rowReadON<7> RefrBp PrBp PrSFBp
+ col_periphery_1x2_6/COL_LINE0 pixRst<62> pixRst<63> col_periphery_1x2_6/COL_LINE1
+ OffBn openDVS_pixel2x2_bot_149/vpd[2] openDVS_pixel2x2_bot_149/vpd[3] openDVS_pixel2x2_bot_149/vpd[1]
+ openDVS_pixel2x2_bot_149/vpd[0] rowReadON<6> openDVS_pixel2x2_bot_937/GndD DiffBn
+ VSUBS VDD OnBn openDVS_pixel2x2_bot
XopenDVS_pixel2x2_bot_650 rowReadOFF<62> rowReadOFF<63> rowReadON<63> RefrBp PrBp
+ PrSFBp col_periphery_1x2_31/COL_LINE0 pixRst<14> pixRst<15> col_periphery_1x2_31/COL_LINE1
+ OffBn openDVS_pixel2x2_bot_650/vpd[2] openDVS_pixel2x2_bot_650/vpd[3] openDVS_pixel2x2_bot_650/vpd[1]
+ openDVS_pixel2x2_bot_650/vpd[0] rowReadON<62> openDVS_pixel2x2_bot_886/GndD DiffBn
+ VSUBS VDD OnBn openDVS_pixel2x2_bot
XopenDVS_pixel2x2_bot_661 rowReadOFF<42> rowReadOFF<43> rowReadON<43> RefrBp PrBp
+ PrSFBp col_periphery_1x2_3/COL_LINE0 pixRst<56> pixRst<57> col_periphery_1x2_3/COL_LINE1
+ OffBn openDVS_pixel2x2_bot_661/vpd[2] openDVS_pixel2x2_bot_661/vpd[3] openDVS_pixel2x2_bot_661/vpd[1]
+ openDVS_pixel2x2_bot_661/vpd[0] rowReadON<42> openDVS_pixel2x2_bot_908/GndD DiffBn
+ VSUBS VDD OnBn openDVS_pixel2x2_bot
XopenDVS_pixel2x2_bot_683 rowReadOFF<38> rowReadOFF<39> rowReadON<39> RefrBp PrBp
+ PrSFBp col_periphery_1x2_3/COL_LINE0 pixRst<56> pixRst<57> col_periphery_1x2_3/COL_LINE1
+ OffBn openDVS_pixel2x2_bot_683/vpd[2] openDVS_pixel2x2_bot_683/vpd[3] openDVS_pixel2x2_bot_683/vpd[1]
+ openDVS_pixel2x2_bot_683/vpd[0] rowReadON<38> openDVS_pixel2x2_bot_999/GndD DiffBn
+ VSUBS VDD OnBn openDVS_pixel2x2_bot
XopenDVS_pixel2x2_bot_694 rowReadOFF<30> rowReadOFF<31> rowReadON<31> RefrBp PrBp
+ PrSFBp col_periphery_1x2_5/COL_LINE0 pixRst<60> pixRst<61> col_periphery_1x2_5/COL_LINE1
+ OffBn openDVS_pixel2x2_bot_694/vpd[2] openDVS_pixel2x2_bot_694/vpd[3] openDVS_pixel2x2_bot_694/vpd[1]
+ openDVS_pixel2x2_bot_694/vpd[0] rowReadON<30> openDVS_pixel2x2_bot_991/GndD DiffBn
+ VSUBS VDD OnBn openDVS_pixel2x2_bot
XopenDVS_pixel2x2_bot_672 rowReadOFF<28> rowReadOFF<29> rowReadON<29> RefrBp PrBp
+ PrSFBp col_periphery_1x2_0/COL_LINE0 pixRst<50> pixRst<51> col_periphery_1x2_0/COL_LINE1
+ OffBn openDVS_pixel2x2_bot_672/vpd[2] openDVS_pixel2x2_bot_672/vpd[3] openDVS_pixel2x2_bot_672/vpd[1]
+ openDVS_pixel2x2_bot_672/vpd[0] rowReadON<28> openDVS_pixel2x2_bot_989/GndD DiffBn
+ VSUBS VDD OnBn openDVS_pixel2x2_bot
XopenDVS_pixel2x2_bot_70 rowReadOFF<20> rowReadOFF<21> rowReadON<21> RefrBp PrBp PrSFBp
+ col_periphery_1x2_10/COL_LINE0 pixRst<34> pixRst<35> col_periphery_1x2_10/COL_LINE1
+ OffBn openDVS_pixel2x2_bot_70/vpd[2] openDVS_pixel2x2_bot_70/vpd[3] openDVS_pixel2x2_bot_70/vpd[1]
+ openDVS_pixel2x2_bot_70/vpd[0] rowReadON<20> openDVS_pixel2x2_bot_95/GndD DiffBn
+ VSUBS VDD OnBn openDVS_pixel2x2_bot
XopenDVS_pixel2x2_bot_92 rowReadOFF<20> rowReadOFF<21> rowReadON<21> RefrBp PrBp PrSFBp
+ col_periphery_1x2_3/COL_LINE0 pixRst<56> pixRst<57> col_periphery_1x2_3/COL_LINE1
+ OffBn openDVS_pixel2x2_bot_92/vpd[2] openDVS_pixel2x2_bot_92/vpd[3] openDVS_pixel2x2_bot_92/vpd[1]
+ openDVS_pixel2x2_bot_92/vpd[0] rowReadON<20> openDVS_pixel2x2_bot_95/GndD DiffBn
+ VSUBS VDD OnBn openDVS_pixel2x2_bot
XopenDVS_pixel2x2_bot_81 rowReadOFF<10> rowReadOFF<11> rowReadON<11> RefrBp PrBp PrSFBp
+ col_periphery_1x2_10/COL_LINE0 pixRst<34> pixRst<35> col_periphery_1x2_10/COL_LINE1
+ OffBn openDVS_pixel2x2_bot_81/vpd[2] openDVS_pixel2x2_bot_81/vpd[3] openDVS_pixel2x2_bot_81/vpd[1]
+ openDVS_pixel2x2_bot_81/vpd[0] rowReadON<10> openDVS_pixel2x2_bot_82/GndD DiffBn
+ VSUBS VDD OnBn openDVS_pixel2x2_bot
XopenDVS_pixel2x2_bot_1023 rowReadOFF<62> rowReadOFF<63> rowReadON<63> RefrBp PrBp
+ PrSFBp col_periphery_1x2_9/COL_LINE0 pixRst<32> pixRst<33> col_periphery_1x2_9/COL_LINE1
+ OffBn openDVS_pixel2x2_bot_1023/vpd[2] openDVS_pixel2x2_bot_1023/vpd[3] openDVS_pixel2x2_bot_1023/vpd[1]
+ openDVS_pixel2x2_bot_1023/vpd[0] rowReadON<62> openDVS_pixel2x2_bot_886/GndD DiffBn
+ VSUBS VDD OnBn openDVS_pixel2x2_bot
XopenDVS_pixel2x2_bot_1012 rowReadOFF<52> rowReadOFF<53> rowReadON<53> RefrBp PrBp
+ PrSFBp col_periphery_1x2_23/COL_LINE0 pixRst<30> pixRst<31> col_periphery_1x2_23/COL_LINE1
+ OffBn openDVS_pixel2x2_bot_1012/vpd[2] openDVS_pixel2x2_bot_1012/vpd[3] openDVS_pixel2x2_bot_1012/vpd[1]
+ openDVS_pixel2x2_bot_1012/vpd[0] rowReadON<52> openDVS_pixel2x2_bot_882/GndD DiffBn
+ VSUBS VDD OnBn openDVS_pixel2x2_bot
XopenDVS_pixel2x2_bot_1001 rowReadOFF<40> rowReadOFF<41> rowReadON<41> RefrBp PrBp
+ PrSFBp col_periphery_1x2_9/COL_LINE0 pixRst<32> pixRst<33> col_periphery_1x2_9/COL_LINE1
+ OffBn openDVS_pixel2x2_bot_1001/vpd[2] openDVS_pixel2x2_bot_1001/vpd[3] openDVS_pixel2x2_bot_1001/vpd[1]
+ openDVS_pixel2x2_bot_1001/vpd[0] rowReadON<40> openDVS_pixel2x2_bot_906/GndD DiffBn
+ VSUBS VDD OnBn openDVS_pixel2x2_bot
XopenDVS_pixel2x2_bot_480 rowReadOFF<40> rowReadOFF<41> rowReadON<41> RefrBp PrBp
+ PrSFBp col_periphery_1x2_26/COL_LINE0 pixRst<4> pixRst<5> col_periphery_1x2_26/COL_LINE1
+ OffBn openDVS_pixel2x2_bot_480/vpd[2] openDVS_pixel2x2_bot_480/vpd[3] openDVS_pixel2x2_bot_480/vpd[1]
+ openDVS_pixel2x2_bot_480/vpd[0] rowReadON<40> openDVS_pixel2x2_bot_906/GndD DiffBn
+ VSUBS VDD OnBn openDVS_pixel2x2_bot
XopenDVS_pixel2x2_bot_491 rowReadOFF<28> rowReadOFF<29> rowReadON<29> RefrBp PrBp
+ PrSFBp col_periphery_1x2_25/COL_LINE0 pixRst<2> pixRst<3> col_periphery_1x2_25/COL_LINE1
+ OffBn openDVS_pixel2x2_bot_491/vpd[2] openDVS_pixel2x2_bot_491/vpd[3] openDVS_pixel2x2_bot_491/vpd[1]
+ openDVS_pixel2x2_bot_491/vpd[0] rowReadON<28> openDVS_pixel2x2_bot_989/GndD DiffBn
+ VSUBS VDD OnBn openDVS_pixel2x2_bot
XopenDVS_pixel2x2_bot_1 rowReadOFF<4> rowReadOFF<5> rowReadON<5> RefrBp PrBp PrSFBp
+ col_periphery_1x2_1/COL_LINE0 pixRst<52> pixRst<53> col_periphery_1x2_1/COL_LINE1
+ OffBn openDVS_pixel2x2_bot_1/vpd[2] openDVS_pixel2x2_bot_1/vpd[3] openDVS_pixel2x2_bot_1/vpd[1]
+ openDVS_pixel2x2_bot_1/vpd[0] rowReadON<4> openDVS_pixel2x2_bot_6/GndD DiffBn VSUBS
+ VDD OnBn openDVS_pixel2x2_bot
Xcol_periphery_1x2_23 pixRst<31> col_periphery_1x2_23/COL_LINE0 col_periphery_1x2_23/COL_LINE1
+ nDETECT DETECT col_periphery_1x2_9/VDD VTHRESH pixRst<30> voutn<30> VSUBS voutn<31>
+ NCHARGE col_periphery_1x2
Xcol_periphery_1x2_12 pixRst<39> col_periphery_1x2_12/COL_LINE0 col_periphery_1x2_12/COL_LINE1
+ nDETECT DETECT col_periphery_1x2_9/VDD VTHRESH pixRst<38> voutn<38> VSUBS voutn<39>
+ NCHARGE col_periphery_1x2
XopenDVS_pixel2x2_bot_309 rowReadOFF<14> rowReadOFF<15> rowReadON<15> RefrBp PrBp
+ PrSFBp col_periphery_1x2_19/COL_LINE0 pixRst<22> pixRst<23> col_periphery_1x2_19/COL_LINE1
+ OffBn openDVS_pixel2x2_bot_309/vpd[2] openDVS_pixel2x2_bot_309/vpd[3] openDVS_pixel2x2_bot_309/vpd[1]
+ openDVS_pixel2x2_bot_309/vpd[0] rowReadON<14> openDVS_pixel2x2_bot_78/GndD DiffBn
+ VSUBS VDD OnBn openDVS_pixel2x2_bot
XopenDVS_pixel2x2_bot_854 rowReadOFF<58> rowReadOFF<59> rowReadON<59> RefrBp PrBp
+ PrSFBp col_periphery_1x2_2/COL_LINE0 pixRst<54> pixRst<55> col_periphery_1x2_2/COL_LINE1
+ OffBn openDVS_pixel2x2_bot_854/vpd[2] openDVS_pixel2x2_bot_854/vpd[3] openDVS_pixel2x2_bot_854/vpd[1]
+ openDVS_pixel2x2_bot_854/vpd[0] rowReadON<58> openDVS_pixel2x2_bot_890/GndD DiffBn
+ VSUBS VDD OnBn openDVS_pixel2x2_bot
XopenDVS_pixel2x2_bot_832 rowReadOFF<54> rowReadOFF<55> rowReadON<55> RefrBp PrBp
+ PrSFBp col_periphery_1x2_2/COL_LINE0 pixRst<54> pixRst<55> col_periphery_1x2_2/COL_LINE1
+ OffBn openDVS_pixel2x2_bot_832/vpd[2] openDVS_pixel2x2_bot_832/vpd[3] openDVS_pixel2x2_bot_832/vpd[1]
+ openDVS_pixel2x2_bot_832/vpd[0] rowReadON<54> openDVS_pixel2x2_bot_885/GndD DiffBn
+ VSUBS VDD OnBn openDVS_pixel2x2_bot
XopenDVS_pixel2x2_bot_843 rowReadOFF<56> rowReadOFF<57> rowReadON<57> RefrBp PrBp
+ PrSFBp col_periphery_1x2_2/COL_LINE0 pixRst<54> pixRst<55> col_periphery_1x2_2/COL_LINE1
+ OffBn openDVS_pixel2x2_bot_843/vpd[2] openDVS_pixel2x2_bot_843/vpd[3] openDVS_pixel2x2_bot_843/vpd[1]
+ openDVS_pixel2x2_bot_843/vpd[0] rowReadON<56> openDVS_pixel2x2_bot_888/GndD DiffBn
+ VSUBS VDD OnBn openDVS_pixel2x2_bot
XopenDVS_pixel2x2_bot_876 rowReadOFF<60> rowReadOFF<61> rowReadON<61> RefrBp PrBp
+ PrSFBp col_periphery_1x2_1/COL_LINE0 pixRst<52> pixRst<53> col_periphery_1x2_1/COL_LINE1
+ OffBn openDVS_pixel2x2_bot_876/vpd[2] openDVS_pixel2x2_bot_876/vpd[3] openDVS_pixel2x2_bot_876/vpd[1]
+ openDVS_pixel2x2_bot_876/vpd[0] rowReadON<60> openDVS_pixel2x2_bot_902/GndD DiffBn
+ VSUBS VDD OnBn openDVS_pixel2x2_bot
XopenDVS_pixel2x2_bot_887 rowReadOFF<56> rowReadOFF<57> rowReadON<57> RefrBp PrBp
+ PrSFBp col_periphery_1x2_14/COL_LINE0 pixRst<46> pixRst<47> col_periphery_1x2_14/COL_LINE1
+ OffBn openDVS_pixel2x2_bot_887/vpd[2] openDVS_pixel2x2_bot_887/vpd[3] openDVS_pixel2x2_bot_887/vpd[1]
+ openDVS_pixel2x2_bot_887/vpd[0] rowReadON<56> openDVS_pixel2x2_bot_888/GndD DiffBn
+ VSUBS VDD OnBn openDVS_pixel2x2_bot
XopenDVS_pixel2x2_bot_810 rowReadOFF<58> rowReadOFF<59> rowReadON<59> RefrBp PrBp
+ PrSFBp col_periphery_1x2_11/COL_LINE0 pixRst<36> pixRst<37> col_periphery_1x2_11/COL_LINE1
+ OffBn openDVS_pixel2x2_bot_810/vpd[2] openDVS_pixel2x2_bot_810/vpd[3] openDVS_pixel2x2_bot_810/vpd[1]
+ openDVS_pixel2x2_bot_810/vpd[0] rowReadON<58> openDVS_pixel2x2_bot_890/GndD DiffBn
+ VSUBS VDD OnBn openDVS_pixel2x2_bot
XopenDVS_pixel2x2_bot_865 rowReadOFF<48> rowReadOFF<49> rowReadON<49> RefrBp PrBp
+ PrSFBp col_periphery_1x2_5/COL_LINE0 pixRst<60> pixRst<61> col_periphery_1x2_5/COL_LINE1
+ OffBn openDVS_pixel2x2_bot_865/vpd[2] openDVS_pixel2x2_bot_865/vpd[3] openDVS_pixel2x2_bot_865/vpd[1]
+ openDVS_pixel2x2_bot_865/vpd[0] rowReadON<48> openDVS_pixel2x2_bot_927/GndD DiffBn
+ VSUBS VDD OnBn openDVS_pixel2x2_bot
XopenDVS_pixel2x2_bot_821 rowReadOFF<52> rowReadOFF<53> rowReadON<53> RefrBp PrBp
+ PrSFBp col_periphery_1x2_1/COL_LINE0 pixRst<52> pixRst<53> col_periphery_1x2_1/COL_LINE1
+ OffBn openDVS_pixel2x2_bot_821/vpd[2] openDVS_pixel2x2_bot_821/vpd[3] openDVS_pixel2x2_bot_821/vpd[1]
+ openDVS_pixel2x2_bot_821/vpd[0] rowReadON<52> openDVS_pixel2x2_bot_882/GndD DiffBn
+ VSUBS VDD OnBn openDVS_pixel2x2_bot
XopenDVS_pixel2x2_bot_898 rowReadOFF<34> rowReadOFF<35> rowReadON<35> RefrBp PrBp
+ PrSFBp col_periphery_1x2_15/COL_LINE0 pixRst<48> pixRst<49> col_periphery_1x2_15/COL_LINE1
+ OffBn openDVS_pixel2x2_bot_898/vpd[2] openDVS_pixel2x2_bot_898/vpd[3] openDVS_pixel2x2_bot_898/vpd[1]
+ openDVS_pixel2x2_bot_898/vpd[0] rowReadON<34> openDVS_pixel2x2_bot_995/GndD DiffBn
+ VSUBS VDD OnBn openDVS_pixel2x2_bot
XopenDVS_pixel2x2_bot_128 rowReadOFF<18> rowReadOFF<19> rowReadON<19> RefrBp PrBp
+ PrSFBp col_periphery_1x2_5/COL_LINE0 pixRst<60> pixRst<61> col_periphery_1x2_5/COL_LINE1
+ OffBn openDVS_pixel2x2_bot_128/vpd[2] openDVS_pixel2x2_bot_128/vpd[3] openDVS_pixel2x2_bot_128/vpd[1]
+ openDVS_pixel2x2_bot_128/vpd[0] rowReadON<18> openDVS_pixel2x2_bot_69/GndD DiffBn
+ VSUBS VDD OnBn openDVS_pixel2x2_bot
XopenDVS_pixel2x2_bot_139 rowReadOFF<12> rowReadOFF<13> rowReadON<13> RefrBp PrBp
+ PrSFBp col_periphery_1x2_4/COL_LINE0 pixRst<58> pixRst<59> col_periphery_1x2_4/COL_LINE1
+ OffBn openDVS_pixel2x2_bot_139/vpd[2] openDVS_pixel2x2_bot_139/vpd[3] openDVS_pixel2x2_bot_139/vpd[1]
+ openDVS_pixel2x2_bot_139/vpd[0] rowReadON<12> openDVS_pixel2x2_bot_79/GndD DiffBn
+ VSUBS VDD OnBn openDVS_pixel2x2_bot
XopenDVS_pixel2x2_bot_106 rowReadOFF<14> rowReadOFF<15> rowReadON<15> RefrBp PrBp
+ PrSFBp col_periphery_1x2_2/COL_LINE0 pixRst<54> pixRst<55> col_periphery_1x2_2/COL_LINE1
+ OffBn openDVS_pixel2x2_bot_106/vpd[2] openDVS_pixel2x2_bot_106/vpd[3] openDVS_pixel2x2_bot_106/vpd[1]
+ openDVS_pixel2x2_bot_106/vpd[0] rowReadON<14> openDVS_pixel2x2_bot_78/GndD DiffBn
+ VSUBS VDD OnBn openDVS_pixel2x2_bot
XopenDVS_pixel2x2_bot_117 rowReadOFF<10> rowReadOFF<11> rowReadON<11> RefrBp PrBp
+ PrSFBp col_periphery_1x2_3/COL_LINE0 pixRst<56> pixRst<57> col_periphery_1x2_3/COL_LINE1
+ OffBn openDVS_pixel2x2_bot_117/vpd[2] openDVS_pixel2x2_bot_117/vpd[3] openDVS_pixel2x2_bot_117/vpd[1]
+ openDVS_pixel2x2_bot_117/vpd[0] rowReadON<10> openDVS_pixel2x2_bot_82/GndD DiffBn
+ VSUBS VDD OnBn openDVS_pixel2x2_bot
XopenDVS_pixel2x2_bot_651 rowReadOFF<62> rowReadOFF<63> rowReadON<63> RefrBp PrBp
+ PrSFBp col_periphery_1x2_16/COL_LINE0 pixRst<16> pixRst<17> col_periphery_1x2_16/COL_LINE1
+ OffBn openDVS_pixel2x2_bot_651/vpd[2] openDVS_pixel2x2_bot_651/vpd[3] openDVS_pixel2x2_bot_651/vpd[1]
+ openDVS_pixel2x2_bot_651/vpd[0] rowReadON<62> openDVS_pixel2x2_bot_886/GndD DiffBn
+ VSUBS VDD OnBn openDVS_pixel2x2_bot
XopenDVS_pixel2x2_bot_640 rowReadOFF<54> rowReadOFF<55> rowReadON<55> RefrBp PrBp
+ PrSFBp col_periphery_1x2_31/COL_LINE0 pixRst<14> pixRst<15> col_periphery_1x2_31/COL_LINE1
+ OffBn openDVS_pixel2x2_bot_640/vpd[2] openDVS_pixel2x2_bot_640/vpd[3] openDVS_pixel2x2_bot_640/vpd[1]
+ openDVS_pixel2x2_bot_640/vpd[0] rowReadON<54> openDVS_pixel2x2_bot_885/GndD DiffBn
+ VSUBS VDD OnBn openDVS_pixel2x2_bot
XopenDVS_pixel2x2_bot_684 rowReadOFF<38> rowReadOFF<39> rowReadON<39> RefrBp PrBp
+ PrSFBp col_periphery_1x2_4/COL_LINE0 pixRst<58> pixRst<59> col_periphery_1x2_4/COL_LINE1
+ OffBn openDVS_pixel2x2_bot_684/vpd[2] openDVS_pixel2x2_bot_684/vpd[3] openDVS_pixel2x2_bot_684/vpd[1]
+ openDVS_pixel2x2_bot_684/vpd[0] rowReadON<38> openDVS_pixel2x2_bot_999/GndD DiffBn
+ VSUBS VDD OnBn openDVS_pixel2x2_bot
XopenDVS_pixel2x2_bot_662 rowReadOFF<40> rowReadOFF<41> rowReadON<41> RefrBp PrBp
+ PrSFBp col_periphery_1x2_0/COL_LINE0 pixRst<50> pixRst<51> col_periphery_1x2_0/COL_LINE1
+ OffBn openDVS_pixel2x2_bot_662/vpd[2] openDVS_pixel2x2_bot_662/vpd[3] openDVS_pixel2x2_bot_662/vpd[1]
+ openDVS_pixel2x2_bot_662/vpd[0] rowReadON<40> openDVS_pixel2x2_bot_906/GndD DiffBn
+ VSUBS VDD OnBn openDVS_pixel2x2_bot
XopenDVS_pixel2x2_bot_695 rowReadOFF<30> rowReadOFF<31> rowReadON<31> RefrBp PrBp
+ PrSFBp col_periphery_1x2_6/COL_LINE0 pixRst<62> pixRst<63> col_periphery_1x2_6/COL_LINE1
+ OffBn openDVS_pixel2x2_bot_695/vpd[2] openDVS_pixel2x2_bot_695/vpd[3] openDVS_pixel2x2_bot_695/vpd[1]
+ openDVS_pixel2x2_bot_695/vpd[0] rowReadON<30> openDVS_pixel2x2_bot_991/GndD DiffBn
+ VSUBS VDD OnBn openDVS_pixel2x2_bot
XopenDVS_pixel2x2_bot_673 rowReadOFF<28> rowReadOFF<29> rowReadON<29> RefrBp PrBp
+ PrSFBp col_periphery_1x2_1/COL_LINE0 pixRst<52> pixRst<53> col_periphery_1x2_1/COL_LINE1
+ OffBn openDVS_pixel2x2_bot_673/vpd[2] openDVS_pixel2x2_bot_673/vpd[3] openDVS_pixel2x2_bot_673/vpd[1]
+ openDVS_pixel2x2_bot_673/vpd[0] rowReadON<28> openDVS_pixel2x2_bot_989/GndD DiffBn
+ VSUBS VDD OnBn openDVS_pixel2x2_bot
XopenDVS_pixel2x2_bot_60 rowReadOFF<24> rowReadOFF<25> rowReadON<25> RefrBp PrBp PrSFBp
+ col_periphery_1x2_13/COL_LINE0 pixRst<44> pixRst<45> col_periphery_1x2_13/COL_LINE1
+ OffBn openDVS_pixel2x2_bot_60/vpd[2] openDVS_pixel2x2_bot_60/vpd[3] openDVS_pixel2x2_bot_60/vpd[1]
+ openDVS_pixel2x2_bot_60/vpd[0] rowReadON<24> openDVS_pixel2x2_bot_99/GndD DiffBn
+ VSUBS VDD OnBn openDVS_pixel2x2_bot
XopenDVS_pixel2x2_bot_93 rowReadOFF<20> rowReadOFF<21> rowReadON<21> RefrBp PrBp PrSFBp
+ col_periphery_1x2_4/COL_LINE0 pixRst<58> pixRst<59> col_periphery_1x2_4/COL_LINE1
+ OffBn openDVS_pixel2x2_bot_93/vpd[2] openDVS_pixel2x2_bot_93/vpd[3] openDVS_pixel2x2_bot_93/vpd[1]
+ openDVS_pixel2x2_bot_93/vpd[0] rowReadON<20> openDVS_pixel2x2_bot_95/GndD DiffBn
+ VSUBS VDD OnBn openDVS_pixel2x2_bot
XopenDVS_pixel2x2_bot_71 rowReadOFF<14> rowReadOFF<15> rowReadON<15> RefrBp PrBp PrSFBp
+ col_periphery_1x2_10/COL_LINE0 pixRst<34> pixRst<35> col_periphery_1x2_10/COL_LINE1
+ OffBn openDVS_pixel2x2_bot_71/vpd[2] openDVS_pixel2x2_bot_71/vpd[3] openDVS_pixel2x2_bot_71/vpd[1]
+ openDVS_pixel2x2_bot_71/vpd[0] rowReadON<14> openDVS_pixel2x2_bot_78/GndD DiffBn
+ VSUBS VDD OnBn openDVS_pixel2x2_bot
XopenDVS_pixel2x2_bot_82 rowReadOFF<10> rowReadOFF<11> rowReadON<11> RefrBp PrBp PrSFBp
+ col_periphery_1x2_11/COL_LINE0 pixRst<36> pixRst<37> col_periphery_1x2_11/COL_LINE1
+ OffBn openDVS_pixel2x2_bot_82/vpd[2] openDVS_pixel2x2_bot_82/vpd[3] openDVS_pixel2x2_bot_82/vpd[1]
+ openDVS_pixel2x2_bot_82/vpd[0] rowReadON<10> openDVS_pixel2x2_bot_82/GndD DiffBn
+ VSUBS VDD OnBn openDVS_pixel2x2_bot
XopenDVS_pixel2x2_bot_1013 rowReadOFF<52> rowReadOFF<53> rowReadON<53> RefrBp PrBp
+ PrSFBp col_periphery_1x2_9/COL_LINE0 pixRst<32> pixRst<33> col_periphery_1x2_9/COL_LINE1
+ OffBn openDVS_pixel2x2_bot_1013/vpd[2] openDVS_pixel2x2_bot_1013/vpd[3] openDVS_pixel2x2_bot_1013/vpd[1]
+ openDVS_pixel2x2_bot_1013/vpd[0] rowReadON<52> openDVS_pixel2x2_bot_882/GndD DiffBn
+ VSUBS VDD OnBn openDVS_pixel2x2_bot
XopenDVS_pixel2x2_bot_1002 rowReadOFF<42> rowReadOFF<43> rowReadON<43> RefrBp PrBp
+ PrSFBp col_periphery_1x2_23/COL_LINE0 pixRst<30> pixRst<31> col_periphery_1x2_23/COL_LINE1
+ OffBn openDVS_pixel2x2_bot_1002/vpd[2] openDVS_pixel2x2_bot_1002/vpd[3] openDVS_pixel2x2_bot_1002/vpd[1]
+ openDVS_pixel2x2_bot_1002/vpd[0] rowReadON<42> openDVS_pixel2x2_bot_908/GndD DiffBn
+ VSUBS VDD OnBn openDVS_pixel2x2_bot
XopenDVS_pixel2x2_bot_481 rowReadOFF<40> rowReadOFF<41> rowReadON<41> RefrBp PrBp
+ PrSFBp col_periphery_1x2_27/COL_LINE0 pixRst<6> pixRst<7> col_periphery_1x2_27/COL_LINE1
+ OffBn openDVS_pixel2x2_bot_481/vpd[2] openDVS_pixel2x2_bot_481/vpd[3] openDVS_pixel2x2_bot_481/vpd[1]
+ openDVS_pixel2x2_bot_481/vpd[0] rowReadON<40> openDVS_pixel2x2_bot_906/GndD DiffBn
+ VSUBS VDD OnBn openDVS_pixel2x2_bot
XopenDVS_pixel2x2_bot_470 rowReadOFF<30> rowReadOFF<31> rowReadON<31> RefrBp PrBp
+ PrSFBp col_periphery_1x2_27/COL_LINE0 pixRst<6> pixRst<7> col_periphery_1x2_27/COL_LINE1
+ OffBn openDVS_pixel2x2_bot_470/vpd[2] openDVS_pixel2x2_bot_470/vpd[3] openDVS_pixel2x2_bot_470/vpd[1]
+ openDVS_pixel2x2_bot_470/vpd[0] rowReadON<30> openDVS_pixel2x2_bot_991/GndD DiffBn
+ VSUBS VDD OnBn openDVS_pixel2x2_bot
XopenDVS_pixel2x2_bot_492 rowReadOFF<28> rowReadOFF<29> rowReadON<29> RefrBp PrBp
+ PrSFBp col_periphery_1x2_26/COL_LINE0 pixRst<4> pixRst<5> col_periphery_1x2_26/COL_LINE1
+ OffBn openDVS_pixel2x2_bot_492/vpd[2] openDVS_pixel2x2_bot_492/vpd[3] openDVS_pixel2x2_bot_492/vpd[1]
+ openDVS_pixel2x2_bot_492/vpd[0] rowReadON<28> openDVS_pixel2x2_bot_989/GndD DiffBn
+ VSUBS VDD OnBn openDVS_pixel2x2_bot
XopenDVS_pixel2x2_bot_2 rowReadOFF<4> rowReadOFF<5> rowReadON<5> RefrBp PrBp PrSFBp
+ col_periphery_1x2_2/COL_LINE0 pixRst<54> pixRst<55> col_periphery_1x2_2/COL_LINE1
+ OffBn openDVS_pixel2x2_bot_2/vpd[2] openDVS_pixel2x2_bot_2/vpd[3] openDVS_pixel2x2_bot_2/vpd[1]
+ openDVS_pixel2x2_bot_2/vpd[0] rowReadON<4> openDVS_pixel2x2_bot_6/GndD DiffBn VSUBS
+ VDD OnBn openDVS_pixel2x2_bot
Xcol_periphery_1x2_24 pixRst<1> col_periphery_1x2_24/COL_LINE0 col_periphery_1x2_24/COL_LINE1
+ nDETECT DETECT col_periphery_1x2_9/VDD VTHRESH pixRst<0> voutn<0> VSUBS voutn<1>
+ NCHARGE col_periphery_1x2
Xcol_periphery_1x2_13 pixRst<45> col_periphery_1x2_13/COL_LINE0 col_periphery_1x2_13/COL_LINE1
+ nDETECT DETECT col_periphery_1x2_9/VDD VTHRESH pixRst<44> voutn<44> VSUBS voutn<45>
+ NCHARGE col_periphery_1x2
XopenDVS_pixel2x2_bot_855 rowReadOFF<58> rowReadOFF<59> rowReadON<59> RefrBp PrBp
+ PrSFBp col_periphery_1x2_3/COL_LINE0 pixRst<56> pixRst<57> col_periphery_1x2_3/COL_LINE1
+ OffBn openDVS_pixel2x2_bot_855/vpd[2] openDVS_pixel2x2_bot_855/vpd[3] openDVS_pixel2x2_bot_855/vpd[1]
+ openDVS_pixel2x2_bot_855/vpd[0] rowReadON<58> openDVS_pixel2x2_bot_890/GndD DiffBn
+ VSUBS VDD OnBn openDVS_pixel2x2_bot
XopenDVS_pixel2x2_bot_833 rowReadOFF<54> rowReadOFF<55> rowReadON<55> RefrBp PrBp
+ PrSFBp col_periphery_1x2_3/COL_LINE0 pixRst<56> pixRst<57> col_periphery_1x2_3/COL_LINE1
+ OffBn openDVS_pixel2x2_bot_833/vpd[2] openDVS_pixel2x2_bot_833/vpd[3] openDVS_pixel2x2_bot_833/vpd[1]
+ openDVS_pixel2x2_bot_833/vpd[0] rowReadON<54> openDVS_pixel2x2_bot_885/GndD DiffBn
+ VSUBS VDD OnBn openDVS_pixel2x2_bot
XopenDVS_pixel2x2_bot_844 rowReadOFF<56> rowReadOFF<57> rowReadON<57> RefrBp PrBp
+ PrSFBp col_periphery_1x2_3/COL_LINE0 pixRst<56> pixRst<57> col_periphery_1x2_3/COL_LINE1
+ OffBn openDVS_pixel2x2_bot_844/vpd[2] openDVS_pixel2x2_bot_844/vpd[3] openDVS_pixel2x2_bot_844/vpd[1]
+ openDVS_pixel2x2_bot_844/vpd[0] rowReadON<56> openDVS_pixel2x2_bot_888/GndD DiffBn
+ VSUBS VDD OnBn openDVS_pixel2x2_bot
XopenDVS_pixel2x2_bot_888 rowReadOFF<56> rowReadOFF<57> rowReadON<57> RefrBp PrBp
+ PrSFBp col_periphery_1x2_15/COL_LINE0 pixRst<48> pixRst<49> col_periphery_1x2_15/COL_LINE1
+ OffBn openDVS_pixel2x2_bot_888/vpd[2] openDVS_pixel2x2_bot_888/vpd[3] openDVS_pixel2x2_bot_888/vpd[1]
+ openDVS_pixel2x2_bot_888/vpd[0] rowReadON<56> openDVS_pixel2x2_bot_888/GndD DiffBn
+ VSUBS VDD OnBn openDVS_pixel2x2_bot
XopenDVS_pixel2x2_bot_800 rowReadOFF<62> rowReadOFF<63> rowReadON<63> RefrBp PrBp
+ PrSFBp col_periphery_1x2_8/COL_LINE0 pixRst<42> pixRst<43> col_periphery_1x2_8/COL_LINE1
+ OffBn openDVS_pixel2x2_bot_800/vpd[2] openDVS_pixel2x2_bot_800/vpd[3] openDVS_pixel2x2_bot_800/vpd[1]
+ openDVS_pixel2x2_bot_800/vpd[0] rowReadON<62> openDVS_pixel2x2_bot_886/GndD DiffBn
+ VSUBS VDD OnBn openDVS_pixel2x2_bot
XopenDVS_pixel2x2_bot_811 rowReadOFF<58> rowReadOFF<59> rowReadON<59> RefrBp PrBp
+ PrSFBp col_periphery_1x2_12/COL_LINE0 pixRst<38> pixRst<39> col_periphery_1x2_12/COL_LINE1
+ OffBn openDVS_pixel2x2_bot_811/vpd[2] openDVS_pixel2x2_bot_811/vpd[3] openDVS_pixel2x2_bot_811/vpd[1]
+ openDVS_pixel2x2_bot_811/vpd[0] rowReadON<58> openDVS_pixel2x2_bot_890/GndD DiffBn
+ VSUBS VDD OnBn openDVS_pixel2x2_bot
XopenDVS_pixel2x2_bot_866 rowReadOFF<48> rowReadOFF<49> rowReadON<49> RefrBp PrBp
+ PrSFBp col_periphery_1x2_6/COL_LINE0 pixRst<62> pixRst<63> col_periphery_1x2_6/COL_LINE1
+ OffBn openDVS_pixel2x2_bot_866/vpd[2] openDVS_pixel2x2_bot_866/vpd[3] openDVS_pixel2x2_bot_866/vpd[1]
+ openDVS_pixel2x2_bot_866/vpd[0] rowReadON<48> openDVS_pixel2x2_bot_927/GndD DiffBn
+ VSUBS VDD OnBn openDVS_pixel2x2_bot
XopenDVS_pixel2x2_bot_822 rowReadOFF<52> rowReadOFF<53> rowReadON<53> RefrBp PrBp
+ PrSFBp col_periphery_1x2_2/COL_LINE0 pixRst<54> pixRst<55> col_periphery_1x2_2/COL_LINE1
+ OffBn openDVS_pixel2x2_bot_822/vpd[2] openDVS_pixel2x2_bot_822/vpd[3] openDVS_pixel2x2_bot_822/vpd[1]
+ openDVS_pixel2x2_bot_822/vpd[0] rowReadON<52> openDVS_pixel2x2_bot_882/GndD DiffBn
+ VSUBS VDD OnBn openDVS_pixel2x2_bot
XopenDVS_pixel2x2_bot_877 rowReadOFF<46> rowReadOFF<47> rowReadON<47> RefrBp PrBp
+ PrSFBp col_periphery_1x2_1/COL_LINE0 pixRst<52> pixRst<53> col_periphery_1x2_1/COL_LINE1
+ OffBn openDVS_pixel2x2_bot_877/vpd[2] openDVS_pixel2x2_bot_877/vpd[3] openDVS_pixel2x2_bot_877/vpd[1]
+ openDVS_pixel2x2_bot_877/vpd[0] rowReadON<46> openDVS_pixel2x2_bot_925/GndD DiffBn
+ VSUBS VDD OnBn openDVS_pixel2x2_bot
XopenDVS_pixel2x2_bot_899 rowReadOFF<36> rowReadOFF<37> rowReadON<37> RefrBp PrBp
+ PrSFBp col_periphery_1x2_14/COL_LINE0 pixRst<46> pixRst<47> col_periphery_1x2_14/COL_LINE1
+ OffBn openDVS_pixel2x2_bot_899/vpd[2] openDVS_pixel2x2_bot_899/vpd[3] openDVS_pixel2x2_bot_899/vpd[1]
+ openDVS_pixel2x2_bot_899/vpd[0] rowReadON<36> openDVS_pixel2x2_bot_997/GndD DiffBn
+ VSUBS VDD OnBn openDVS_pixel2x2_bot
XopenDVS_pixel2x2_bot_630 rowReadOFF<44> rowReadOFF<45> rowReadON<45> RefrBp PrBp
+ PrSFBp col_periphery_1x2_21/COL_LINE0 pixRst<26> pixRst<27> col_periphery_1x2_21/COL_LINE1
+ OffBn openDVS_pixel2x2_bot_630/vpd[2] openDVS_pixel2x2_bot_630/vpd[3] openDVS_pixel2x2_bot_630/vpd[1]
+ openDVS_pixel2x2_bot_630/vpd[0] rowReadON<44> openDVS_pixel2x2_bot_923/GndD DiffBn
+ VSUBS VDD OnBn openDVS_pixel2x2_bot
XopenDVS_pixel2x2_bot_129 rowReadOFF<24> rowReadOFF<25> rowReadON<25> RefrBp PrBp
+ PrSFBp col_periphery_1x2_3/COL_LINE0 pixRst<56> pixRst<57> col_periphery_1x2_3/COL_LINE1
+ OffBn openDVS_pixel2x2_bot_129/vpd[2] openDVS_pixel2x2_bot_129/vpd[3] openDVS_pixel2x2_bot_129/vpd[1]
+ openDVS_pixel2x2_bot_129/vpd[0] rowReadON<24> openDVS_pixel2x2_bot_99/GndD DiffBn
+ VSUBS VDD OnBn openDVS_pixel2x2_bot
XopenDVS_pixel2x2_bot_641 rowReadOFF<32> rowReadOFF<33> rowReadON<33> RefrBp PrBp
+ PrSFBp col_periphery_1x2_31/COL_LINE0 pixRst<14> pixRst<15> col_periphery_1x2_31/COL_LINE1
+ OffBn openDVS_pixel2x2_bot_641/vpd[2] openDVS_pixel2x2_bot_641/vpd[3] openDVS_pixel2x2_bot_641/vpd[1]
+ openDVS_pixel2x2_bot_641/vpd[0] rowReadON<32> openDVS_pixel2x2_bot_993/GndD DiffBn
+ VSUBS VDD OnBn openDVS_pixel2x2_bot
XopenDVS_pixel2x2_bot_107 rowReadOFF<14> rowReadOFF<15> rowReadON<15> RefrBp PrBp
+ PrSFBp col_periphery_1x2_3/COL_LINE0 pixRst<56> pixRst<57> col_periphery_1x2_3/COL_LINE1
+ OffBn openDVS_pixel2x2_bot_107/vpd[2] openDVS_pixel2x2_bot_107/vpd[3] openDVS_pixel2x2_bot_107/vpd[1]
+ openDVS_pixel2x2_bot_107/vpd[0] rowReadON<14> openDVS_pixel2x2_bot_78/GndD DiffBn
+ VSUBS VDD OnBn openDVS_pixel2x2_bot
XopenDVS_pixel2x2_bot_118 rowReadOFF<10> rowReadOFF<11> rowReadON<11> RefrBp PrBp
+ PrSFBp col_periphery_1x2_4/COL_LINE0 pixRst<58> pixRst<59> col_periphery_1x2_4/COL_LINE1
+ OffBn openDVS_pixel2x2_bot_118/vpd[2] openDVS_pixel2x2_bot_118/vpd[3] openDVS_pixel2x2_bot_118/vpd[1]
+ openDVS_pixel2x2_bot_118/vpd[0] rowReadON<10> openDVS_pixel2x2_bot_82/GndD DiffBn
+ VSUBS VDD OnBn openDVS_pixel2x2_bot
XopenDVS_pixel2x2_bot_652 rowReadOFF<56> rowReadOFF<57> rowReadON<57> RefrBp PrBp
+ PrSFBp col_periphery_1x2_31/COL_LINE0 pixRst<14> pixRst<15> col_periphery_1x2_31/COL_LINE1
+ OffBn openDVS_pixel2x2_bot_652/vpd[2] openDVS_pixel2x2_bot_652/vpd[3] openDVS_pixel2x2_bot_652/vpd[1]
+ openDVS_pixel2x2_bot_652/vpd[0] rowReadON<56> openDVS_pixel2x2_bot_888/GndD DiffBn
+ VSUBS VDD OnBn openDVS_pixel2x2_bot
XopenDVS_pixel2x2_bot_696 rowReadOFF<40> rowReadOFF<41> rowReadON<41> RefrBp PrBp
+ PrSFBp col_periphery_1x2_6/COL_LINE0 pixRst<62> pixRst<63> col_periphery_1x2_6/COL_LINE1
+ OffBn openDVS_pixel2x2_bot_696/vpd[2] openDVS_pixel2x2_bot_696/vpd[3] openDVS_pixel2x2_bot_696/vpd[1]
+ openDVS_pixel2x2_bot_696/vpd[0] rowReadON<40> openDVS_pixel2x2_bot_906/GndD DiffBn
+ VSUBS VDD OnBn openDVS_pixel2x2_bot
XopenDVS_pixel2x2_bot_685 rowReadOFF<38> rowReadOFF<39> rowReadON<39> RefrBp PrBp
+ PrSFBp col_periphery_1x2_5/COL_LINE0 pixRst<60> pixRst<61> col_periphery_1x2_5/COL_LINE1
+ OffBn openDVS_pixel2x2_bot_685/vpd[2] openDVS_pixel2x2_bot_685/vpd[3] openDVS_pixel2x2_bot_685/vpd[1]
+ openDVS_pixel2x2_bot_685/vpd[0] rowReadON<38> openDVS_pixel2x2_bot_999/GndD DiffBn
+ VSUBS VDD OnBn openDVS_pixel2x2_bot
XopenDVS_pixel2x2_bot_663 rowReadOFF<40> rowReadOFF<41> rowReadON<41> RefrBp PrBp
+ PrSFBp col_periphery_1x2_1/COL_LINE0 pixRst<52> pixRst<53> col_periphery_1x2_1/COL_LINE1
+ OffBn openDVS_pixel2x2_bot_663/vpd[2] openDVS_pixel2x2_bot_663/vpd[3] openDVS_pixel2x2_bot_663/vpd[1]
+ openDVS_pixel2x2_bot_663/vpd[0] rowReadON<40> openDVS_pixel2x2_bot_906/GndD DiffBn
+ VSUBS VDD OnBn openDVS_pixel2x2_bot
XopenDVS_pixel2x2_bot_674 rowReadOFF<28> rowReadOFF<29> rowReadON<29> RefrBp PrBp
+ PrSFBp col_periphery_1x2_2/COL_LINE0 pixRst<54> pixRst<55> col_periphery_1x2_2/COL_LINE1
+ OffBn openDVS_pixel2x2_bot_674/vpd[2] openDVS_pixel2x2_bot_674/vpd[3] openDVS_pixel2x2_bot_674/vpd[1]
+ openDVS_pixel2x2_bot_674/vpd[0] rowReadON<28> openDVS_pixel2x2_bot_989/GndD DiffBn
+ VSUBS VDD OnBn openDVS_pixel2x2_bot
XopenDVS_pixel2x2_bot_61 rowReadOFF<22> rowReadOFF<23> rowReadON<23> RefrBp PrBp PrSFBp
+ col_periphery_1x2_8/COL_LINE0 pixRst<42> pixRst<43> col_periphery_1x2_8/COL_LINE1
+ OffBn openDVS_pixel2x2_bot_61/vpd[2] openDVS_pixel2x2_bot_61/vpd[3] openDVS_pixel2x2_bot_61/vpd[1]
+ openDVS_pixel2x2_bot_61/vpd[0] rowReadON<22> openDVS_pixel2x2_bot_97/GndD DiffBn
+ VSUBS VDD OnBn openDVS_pixel2x2_bot
XopenDVS_pixel2x2_bot_94 rowReadOFF<20> rowReadOFF<21> rowReadON<21> RefrBp PrBp PrSFBp
+ col_periphery_1x2_5/COL_LINE0 pixRst<60> pixRst<61> col_periphery_1x2_5/COL_LINE1
+ OffBn openDVS_pixel2x2_bot_94/vpd[2] openDVS_pixel2x2_bot_94/vpd[3] openDVS_pixel2x2_bot_94/vpd[1]
+ openDVS_pixel2x2_bot_94/vpd[0] rowReadON<20> openDVS_pixel2x2_bot_95/GndD DiffBn
+ VSUBS VDD OnBn openDVS_pixel2x2_bot
XopenDVS_pixel2x2_bot_50 rowReadOFF<12> rowReadOFF<13> rowReadON<13> RefrBp PrBp PrSFBp
+ col_periphery_1x2_8/COL_LINE0 pixRst<42> pixRst<43> col_periphery_1x2_8/COL_LINE1
+ OffBn openDVS_pixel2x2_bot_50/vpd[2] openDVS_pixel2x2_bot_50/vpd[3] openDVS_pixel2x2_bot_50/vpd[1]
+ openDVS_pixel2x2_bot_50/vpd[0] rowReadON<12> openDVS_pixel2x2_bot_79/GndD DiffBn
+ VSUBS VDD OnBn openDVS_pixel2x2_bot
XopenDVS_pixel2x2_bot_72 rowReadOFF<14> rowReadOFF<15> rowReadON<15> RefrBp PrBp PrSFBp
+ col_periphery_1x2_11/COL_LINE0 pixRst<36> pixRst<37> col_periphery_1x2_11/COL_LINE1
+ OffBn openDVS_pixel2x2_bot_72/vpd[2] openDVS_pixel2x2_bot_72/vpd[3] openDVS_pixel2x2_bot_72/vpd[1]
+ openDVS_pixel2x2_bot_72/vpd[0] rowReadON<14> openDVS_pixel2x2_bot_78/GndD DiffBn
+ VSUBS VDD OnBn openDVS_pixel2x2_bot
XopenDVS_pixel2x2_bot_83 rowReadOFF<16> rowReadOFF<17> rowReadON<17> RefrBp PrBp PrSFBp
+ col_periphery_1x2_10/COL_LINE0 pixRst<34> pixRst<35> col_periphery_1x2_10/COL_LINE1
+ OffBn openDVS_pixel2x2_bot_83/vpd[2] openDVS_pixel2x2_bot_83/vpd[3] openDVS_pixel2x2_bot_83/vpd[1]
+ openDVS_pixel2x2_bot_83/vpd[0] rowReadON<16> openDVS_pixel2x2_bot_91/GndD DiffBn
+ VSUBS VDD OnBn openDVS_pixel2x2_bot
XopenDVS_pixel2x2_bot_1014 rowReadOFF<54> rowReadOFF<55> rowReadON<55> RefrBp PrBp
+ PrSFBp col_periphery_1x2_23/COL_LINE0 pixRst<30> pixRst<31> col_periphery_1x2_23/COL_LINE1
+ OffBn openDVS_pixel2x2_bot_1014/vpd[2] openDVS_pixel2x2_bot_1014/vpd[3] openDVS_pixel2x2_bot_1014/vpd[1]
+ openDVS_pixel2x2_bot_1014/vpd[0] rowReadON<54> openDVS_pixel2x2_bot_885/GndD DiffBn
+ VSUBS VDD OnBn openDVS_pixel2x2_bot
XopenDVS_pixel2x2_bot_1003 rowReadOFF<42> rowReadOFF<43> rowReadON<43> RefrBp PrBp
+ PrSFBp col_periphery_1x2_9/COL_LINE0 pixRst<32> pixRst<33> col_periphery_1x2_9/COL_LINE1
+ OffBn openDVS_pixel2x2_bot_1003/vpd[2] openDVS_pixel2x2_bot_1003/vpd[3] openDVS_pixel2x2_bot_1003/vpd[1]
+ openDVS_pixel2x2_bot_1003/vpd[0] rowReadON<42> openDVS_pixel2x2_bot_908/GndD DiffBn
+ VSUBS VDD OnBn openDVS_pixel2x2_bot
XopenDVS_pixel2x2_bot_460 rowReadOFF<36> rowReadOFF<37> rowReadON<37> RefrBp PrBp
+ PrSFBp col_periphery_1x2_30/COL_LINE0 pixRst<12> pixRst<13> col_periphery_1x2_30/COL_LINE1
+ OffBn openDVS_pixel2x2_bot_460/vpd[2] openDVS_pixel2x2_bot_460/vpd[3] openDVS_pixel2x2_bot_460/vpd[1]
+ openDVS_pixel2x2_bot_460/vpd[0] rowReadON<36> openDVS_pixel2x2_bot_997/GndD DiffBn
+ VSUBS VDD OnBn openDVS_pixel2x2_bot
XopenDVS_pixel2x2_bot_482 rowReadOFF<36> rowReadOFF<37> rowReadON<37> RefrBp PrBp
+ PrSFBp col_periphery_1x2_24/COL_LINE0 pixRst<0> pixRst<1> col_periphery_1x2_24/COL_LINE1
+ OffBn openDVS_pixel2x2_bot_482/vpd[2] openDVS_pixel2x2_bot_482/vpd[3] openDVS_pixel2x2_bot_482/vpd[1]
+ openDVS_pixel2x2_bot_482/vpd[0] rowReadON<36> openDVS_pixel2x2_bot_997/GndD DiffBn
+ VSUBS VDD OnBn openDVS_pixel2x2_bot
XopenDVS_pixel2x2_bot_471 rowReadOFF<30> rowReadOFF<31> rowReadON<31> RefrBp PrBp
+ PrSFBp col_periphery_1x2_28/COL_LINE0 pixRst<8> pixRst<9> col_periphery_1x2_28/COL_LINE1
+ OffBn openDVS_pixel2x2_bot_471/vpd[2] openDVS_pixel2x2_bot_471/vpd[3] openDVS_pixel2x2_bot_471/vpd[1]
+ openDVS_pixel2x2_bot_471/vpd[0] rowReadON<30> openDVS_pixel2x2_bot_991/GndD DiffBn
+ VSUBS VDD OnBn openDVS_pixel2x2_bot
XopenDVS_pixel2x2_bot_493 rowReadOFF<28> rowReadOFF<29> rowReadON<29> RefrBp PrBp
+ PrSFBp col_periphery_1x2_27/COL_LINE0 pixRst<6> pixRst<7> col_periphery_1x2_27/COL_LINE1
+ OffBn openDVS_pixel2x2_bot_493/vpd[2] openDVS_pixel2x2_bot_493/vpd[3] openDVS_pixel2x2_bot_493/vpd[1]
+ openDVS_pixel2x2_bot_493/vpd[0] rowReadON<28> openDVS_pixel2x2_bot_989/GndD DiffBn
+ VSUBS VDD OnBn openDVS_pixel2x2_bot
XopenDVS_pixel2x2_bot_290 rowReadOFF<10> rowReadOFF<11> rowReadON<11> RefrBp PrBp
+ PrSFBp col_periphery_1x2_17/COL_LINE0 pixRst<18> pixRst<19> col_periphery_1x2_17/COL_LINE1
+ OffBn openDVS_pixel2x2_bot_290/vpd[2] openDVS_pixel2x2_bot_290/vpd[3] openDVS_pixel2x2_bot_290/vpd[1]
+ openDVS_pixel2x2_bot_290/vpd[0] rowReadON<10> openDVS_pixel2x2_bot_82/GndD DiffBn
+ VSUBS VDD OnBn openDVS_pixel2x2_bot
XopenDVS_pixel2x2_bot_3 rowReadOFF<4> rowReadOFF<5> rowReadON<5> RefrBp PrBp PrSFBp
+ col_periphery_1x2_3/COL_LINE0 pixRst<56> pixRst<57> col_periphery_1x2_3/COL_LINE1
+ OffBn openDVS_pixel2x2_bot_3/vpd[2] openDVS_pixel2x2_bot_3/vpd[3] openDVS_pixel2x2_bot_3/vpd[1]
+ openDVS_pixel2x2_bot_3/vpd[0] rowReadON<4> openDVS_pixel2x2_bot_6/GndD DiffBn VSUBS
+ VDD OnBn openDVS_pixel2x2_bot
Xcol_periphery_1x2_25 pixRst<3> col_periphery_1x2_25/COL_LINE0 col_periphery_1x2_25/COL_LINE1
+ nDETECT DETECT col_periphery_1x2_9/VDD VTHRESH pixRst<2> voutn<2> VSUBS voutn<3>
+ NCHARGE col_periphery_1x2
Xcol_periphery_1x2_14 pixRst<47> col_periphery_1x2_14/COL_LINE0 col_periphery_1x2_14/COL_LINE1
+ nDETECT DETECT col_periphery_1x2_9/VDD VTHRESH pixRst<46> voutn<46> VSUBS voutn<47>
+ NCHARGE col_periphery_1x2
XopenDVS_pixel2x2_bot_834 rowReadOFF<54> rowReadOFF<55> rowReadON<55> RefrBp PrBp
+ PrSFBp col_periphery_1x2_4/COL_LINE0 pixRst<58> pixRst<59> col_periphery_1x2_4/COL_LINE1
+ OffBn openDVS_pixel2x2_bot_834/vpd[2] openDVS_pixel2x2_bot_834/vpd[3] openDVS_pixel2x2_bot_834/vpd[1]
+ openDVS_pixel2x2_bot_834/vpd[0] rowReadON<54> openDVS_pixel2x2_bot_885/GndD DiffBn
+ VSUBS VDD OnBn openDVS_pixel2x2_bot
XopenDVS_pixel2x2_bot_845 rowReadOFF<56> rowReadOFF<57> rowReadON<57> RefrBp PrBp
+ PrSFBp col_periphery_1x2_4/COL_LINE0 pixRst<58> pixRst<59> col_periphery_1x2_4/COL_LINE1
+ OffBn openDVS_pixel2x2_bot_845/vpd[2] openDVS_pixel2x2_bot_845/vpd[3] openDVS_pixel2x2_bot_845/vpd[1]
+ openDVS_pixel2x2_bot_845/vpd[0] rowReadON<56> openDVS_pixel2x2_bot_888/GndD DiffBn
+ VSUBS VDD OnBn openDVS_pixel2x2_bot
XopenDVS_pixel2x2_bot_856 rowReadOFF<58> rowReadOFF<59> rowReadON<59> RefrBp PrBp
+ PrSFBp col_periphery_1x2_4/COL_LINE0 pixRst<58> pixRst<59> col_periphery_1x2_4/COL_LINE1
+ OffBn openDVS_pixel2x2_bot_856/vpd[2] openDVS_pixel2x2_bot_856/vpd[3] openDVS_pixel2x2_bot_856/vpd[1]
+ openDVS_pixel2x2_bot_856/vpd[0] rowReadON<58> openDVS_pixel2x2_bot_890/GndD DiffBn
+ VSUBS VDD OnBn openDVS_pixel2x2_bot
XopenDVS_pixel2x2_bot_889 rowReadOFF<58> rowReadOFF<59> rowReadON<59> RefrBp PrBp
+ PrSFBp col_periphery_1x2_14/COL_LINE0 pixRst<46> pixRst<47> col_periphery_1x2_14/COL_LINE1
+ OffBn openDVS_pixel2x2_bot_889/vpd[2] openDVS_pixel2x2_bot_889/vpd[3] openDVS_pixel2x2_bot_889/vpd[1]
+ openDVS_pixel2x2_bot_889/vpd[0] rowReadON<58> openDVS_pixel2x2_bot_890/GndD DiffBn
+ VSUBS VDD OnBn openDVS_pixel2x2_bot
XopenDVS_pixel2x2_bot_812 rowReadOFF<58> rowReadOFF<59> rowReadON<59> RefrBp PrBp
+ PrSFBp col_periphery_1x2_7/COL_LINE0 pixRst<40> pixRst<41> col_periphery_1x2_7/COL_LINE1
+ OffBn openDVS_pixel2x2_bot_812/vpd[2] openDVS_pixel2x2_bot_812/vpd[3] openDVS_pixel2x2_bot_812/vpd[1]
+ openDVS_pixel2x2_bot_812/vpd[0] rowReadON<58> openDVS_pixel2x2_bot_890/GndD DiffBn
+ VSUBS VDD OnBn openDVS_pixel2x2_bot
XopenDVS_pixel2x2_bot_867 rowReadOFF<50> rowReadOFF<51> rowReadON<51> RefrBp PrBp
+ PrSFBp col_periphery_1x2_5/COL_LINE0 pixRst<60> pixRst<61> col_periphery_1x2_5/COL_LINE1
+ OffBn openDVS_pixel2x2_bot_867/vpd[2] openDVS_pixel2x2_bot_867/vpd[3] openDVS_pixel2x2_bot_867/vpd[1]
+ openDVS_pixel2x2_bot_867/vpd[0] rowReadON<50> openDVS_pixel2x2_bot_929/GndD DiffBn
+ VSUBS VDD OnBn openDVS_pixel2x2_bot
XopenDVS_pixel2x2_bot_823 rowReadOFF<52> rowReadOFF<53> rowReadON<53> RefrBp PrBp
+ PrSFBp col_periphery_1x2_3/COL_LINE0 pixRst<56> pixRst<57> col_periphery_1x2_3/COL_LINE1
+ OffBn openDVS_pixel2x2_bot_823/vpd[2] openDVS_pixel2x2_bot_823/vpd[3] openDVS_pixel2x2_bot_823/vpd[1]
+ openDVS_pixel2x2_bot_823/vpd[0] rowReadON<52> openDVS_pixel2x2_bot_882/GndD DiffBn
+ VSUBS VDD OnBn openDVS_pixel2x2_bot
XopenDVS_pixel2x2_bot_878 rowReadOFF<46> rowReadOFF<47> rowReadON<47> RefrBp PrBp
+ PrSFBp col_periphery_1x2_2/COL_LINE0 pixRst<54> pixRst<55> col_periphery_1x2_2/COL_LINE1
+ OffBn openDVS_pixel2x2_bot_878/vpd[2] openDVS_pixel2x2_bot_878/vpd[3] openDVS_pixel2x2_bot_878/vpd[1]
+ openDVS_pixel2x2_bot_878/vpd[0] rowReadON<46> openDVS_pixel2x2_bot_925/GndD DiffBn
+ VSUBS VDD OnBn openDVS_pixel2x2_bot
XopenDVS_pixel2x2_bot_801 rowReadOFF<52> rowReadOFF<53> rowReadON<53> RefrBp PrBp
+ PrSFBp col_periphery_1x2_10/COL_LINE0 pixRst<34> pixRst<35> col_periphery_1x2_10/COL_LINE1
+ OffBn openDVS_pixel2x2_bot_801/vpd[2] openDVS_pixel2x2_bot_801/vpd[3] openDVS_pixel2x2_bot_801/vpd[1]
+ openDVS_pixel2x2_bot_801/vpd[0] rowReadON<52> openDVS_pixel2x2_bot_882/GndD DiffBn
+ VSUBS VDD OnBn openDVS_pixel2x2_bot
XopenDVS_pixel2x2_bot_108 rowReadOFF<14> rowReadOFF<15> rowReadON<15> RefrBp PrBp
+ PrSFBp col_periphery_1x2_4/COL_LINE0 pixRst<58> pixRst<59> col_periphery_1x2_4/COL_LINE1
+ OffBn openDVS_pixel2x2_bot_108/vpd[2] openDVS_pixel2x2_bot_108/vpd[3] openDVS_pixel2x2_bot_108/vpd[1]
+ openDVS_pixel2x2_bot_108/vpd[0] rowReadON<14> openDVS_pixel2x2_bot_78/GndD DiffBn
+ VSUBS VDD OnBn openDVS_pixel2x2_bot
XopenDVS_pixel2x2_bot_119 rowReadOFF<10> rowReadOFF<11> rowReadON<11> RefrBp PrBp
+ PrSFBp col_periphery_1x2_5/COL_LINE0 pixRst<60> pixRst<61> col_periphery_1x2_5/COL_LINE1
+ OffBn openDVS_pixel2x2_bot_119/vpd[2] openDVS_pixel2x2_bot_119/vpd[3] openDVS_pixel2x2_bot_119/vpd[1]
+ openDVS_pixel2x2_bot_119/vpd[0] rowReadON<10> openDVS_pixel2x2_bot_82/GndD DiffBn
+ VSUBS VDD OnBn openDVS_pixel2x2_bot
XopenDVS_pixel2x2_bot_653 rowReadOFF<56> rowReadOFF<57> rowReadON<57> RefrBp PrBp
+ PrSFBp col_periphery_1x2_16/COL_LINE0 pixRst<16> pixRst<17> col_periphery_1x2_16/COL_LINE1
+ OffBn openDVS_pixel2x2_bot_653/vpd[2] openDVS_pixel2x2_bot_653/vpd[3] openDVS_pixel2x2_bot_653/vpd[1]
+ openDVS_pixel2x2_bot_653/vpd[0] rowReadON<56> openDVS_pixel2x2_bot_888/GndD DiffBn
+ VSUBS VDD OnBn openDVS_pixel2x2_bot
XopenDVS_pixel2x2_bot_620 rowReadOFF<44> rowReadOFF<45> rowReadON<45> RefrBp PrBp
+ PrSFBp col_periphery_1x2_27/COL_LINE0 pixRst<6> pixRst<7> col_periphery_1x2_27/COL_LINE1
+ OffBn openDVS_pixel2x2_bot_620/vpd[2] openDVS_pixel2x2_bot_620/vpd[3] openDVS_pixel2x2_bot_620/vpd[1]
+ openDVS_pixel2x2_bot_620/vpd[0] rowReadON<44> openDVS_pixel2x2_bot_923/GndD DiffBn
+ VSUBS VDD OnBn openDVS_pixel2x2_bot
XopenDVS_pixel2x2_bot_686 rowReadOFF<38> rowReadOFF<39> rowReadON<39> RefrBp PrBp
+ PrSFBp col_periphery_1x2_6/COL_LINE0 pixRst<62> pixRst<63> col_periphery_1x2_6/COL_LINE1
+ OffBn openDVS_pixel2x2_bot_686/vpd[2] openDVS_pixel2x2_bot_686/vpd[3] openDVS_pixel2x2_bot_686/vpd[1]
+ openDVS_pixel2x2_bot_686/vpd[0] rowReadON<38> openDVS_pixel2x2_bot_999/GndD DiffBn
+ VSUBS VDD OnBn openDVS_pixel2x2_bot
XopenDVS_pixel2x2_bot_697 rowReadOFF<42> rowReadOFF<43> rowReadON<43> RefrBp PrBp
+ PrSFBp col_periphery_1x2_4/COL_LINE0 pixRst<58> pixRst<59> col_periphery_1x2_4/COL_LINE1
+ OffBn openDVS_pixel2x2_bot_697/vpd[2] openDVS_pixel2x2_bot_697/vpd[3] openDVS_pixel2x2_bot_697/vpd[1]
+ openDVS_pixel2x2_bot_697/vpd[0] rowReadON<42> openDVS_pixel2x2_bot_908/GndD DiffBn
+ VSUBS VDD OnBn openDVS_pixel2x2_bot
XopenDVS_pixel2x2_bot_664 rowReadOFF<40> rowReadOFF<41> rowReadON<41> RefrBp PrBp
+ PrSFBp col_periphery_1x2_2/COL_LINE0 pixRst<54> pixRst<55> col_periphery_1x2_2/COL_LINE1
+ OffBn openDVS_pixel2x2_bot_664/vpd[2] openDVS_pixel2x2_bot_664/vpd[3] openDVS_pixel2x2_bot_664/vpd[1]
+ openDVS_pixel2x2_bot_664/vpd[0] rowReadON<40> openDVS_pixel2x2_bot_906/GndD DiffBn
+ VSUBS VDD OnBn openDVS_pixel2x2_bot
XopenDVS_pixel2x2_bot_675 rowReadOFF<28> rowReadOFF<29> rowReadON<29> RefrBp PrBp
+ PrSFBp col_periphery_1x2_3/COL_LINE0 pixRst<56> pixRst<57> col_periphery_1x2_3/COL_LINE1
+ OffBn openDVS_pixel2x2_bot_675/vpd[2] openDVS_pixel2x2_bot_675/vpd[3] openDVS_pixel2x2_bot_675/vpd[1]
+ openDVS_pixel2x2_bot_675/vpd[0] rowReadON<28> openDVS_pixel2x2_bot_989/GndD DiffBn
+ VSUBS VDD OnBn openDVS_pixel2x2_bot
XopenDVS_pixel2x2_bot_62 rowReadOFF<22> rowReadOFF<23> rowReadON<23> RefrBp PrBp PrSFBp
+ col_periphery_1x2_13/COL_LINE0 pixRst<44> pixRst<45> col_periphery_1x2_13/COL_LINE1
+ OffBn openDVS_pixel2x2_bot_62/vpd[2] openDVS_pixel2x2_bot_62/vpd[3] openDVS_pixel2x2_bot_62/vpd[1]
+ openDVS_pixel2x2_bot_62/vpd[0] rowReadON<22> openDVS_pixel2x2_bot_97/GndD DiffBn
+ VSUBS VDD OnBn openDVS_pixel2x2_bot
XopenDVS_pixel2x2_bot_642 rowReadOFF<32> rowReadOFF<33> rowReadON<33> RefrBp PrBp
+ PrSFBp col_periphery_1x2_16/COL_LINE0 pixRst<16> pixRst<17> col_periphery_1x2_16/COL_LINE1
+ OffBn openDVS_pixel2x2_bot_642/vpd[2] openDVS_pixel2x2_bot_642/vpd[3] openDVS_pixel2x2_bot_642/vpd[1]
+ openDVS_pixel2x2_bot_642/vpd[0] rowReadON<32> openDVS_pixel2x2_bot_993/GndD DiffBn
+ VSUBS VDD OnBn openDVS_pixel2x2_bot
XopenDVS_pixel2x2_bot_631 rowReadOFF<28> rowReadOFF<29> rowReadON<29> RefrBp PrBp
+ PrSFBp col_periphery_1x2_31/COL_LINE0 pixRst<14> pixRst<15> col_periphery_1x2_31/COL_LINE1
+ OffBn openDVS_pixel2x2_bot_631/vpd[2] openDVS_pixel2x2_bot_631/vpd[3] openDVS_pixel2x2_bot_631/vpd[1]
+ openDVS_pixel2x2_bot_631/vpd[0] rowReadON<28> openDVS_pixel2x2_bot_989/GndD DiffBn
+ VSUBS VDD OnBn openDVS_pixel2x2_bot
XopenDVS_pixel2x2_bot_95 rowReadOFF<20> rowReadOFF<21> rowReadON<21> RefrBp PrBp PrSFBp
+ col_periphery_1x2_6/COL_LINE0 pixRst<62> pixRst<63> col_periphery_1x2_6/COL_LINE1
+ OffBn openDVS_pixel2x2_bot_95/vpd[2] openDVS_pixel2x2_bot_95/vpd[3] openDVS_pixel2x2_bot_95/vpd[1]
+ openDVS_pixel2x2_bot_95/vpd[0] rowReadON<20> openDVS_pixel2x2_bot_95/GndD DiffBn
+ VSUBS VDD OnBn openDVS_pixel2x2_bot
XopenDVS_pixel2x2_bot_40 rowReadOFF<16> rowReadOFF<17> rowReadON<17> RefrBp PrBp PrSFBp
+ col_periphery_1x2_13/COL_LINE0 pixRst<44> pixRst<45> col_periphery_1x2_13/COL_LINE1
+ OffBn openDVS_pixel2x2_bot_40/vpd[2] openDVS_pixel2x2_bot_40/vpd[3] openDVS_pixel2x2_bot_40/vpd[1]
+ openDVS_pixel2x2_bot_40/vpd[0] rowReadON<16> openDVS_pixel2x2_bot_91/GndD DiffBn
+ VSUBS VDD OnBn openDVS_pixel2x2_bot
XopenDVS_pixel2x2_bot_51 rowReadOFF<12> rowReadOFF<13> rowReadON<13> RefrBp PrBp PrSFBp
+ col_periphery_1x2_13/COL_LINE0 pixRst<44> pixRst<45> col_periphery_1x2_13/COL_LINE1
+ OffBn openDVS_pixel2x2_bot_51/vpd[2] openDVS_pixel2x2_bot_51/vpd[3] openDVS_pixel2x2_bot_51/vpd[1]
+ openDVS_pixel2x2_bot_51/vpd[0] rowReadON<12> openDVS_pixel2x2_bot_79/GndD DiffBn
+ VSUBS VDD OnBn openDVS_pixel2x2_bot
XopenDVS_pixel2x2_bot_73 rowReadOFF<20> rowReadOFF<21> rowReadON<21> RefrBp PrBp PrSFBp
+ col_periphery_1x2_11/COL_LINE0 pixRst<36> pixRst<37> col_periphery_1x2_11/COL_LINE1
+ OffBn openDVS_pixel2x2_bot_73/vpd[2] openDVS_pixel2x2_bot_73/vpd[3] openDVS_pixel2x2_bot_73/vpd[1]
+ openDVS_pixel2x2_bot_73/vpd[0] rowReadON<20> openDVS_pixel2x2_bot_95/GndD DiffBn
+ VSUBS VDD OnBn openDVS_pixel2x2_bot
XopenDVS_pixel2x2_bot_84 rowReadOFF<16> rowReadOFF<17> rowReadON<17> RefrBp PrBp PrSFBp
+ col_periphery_1x2_11/COL_LINE0 pixRst<36> pixRst<37> col_periphery_1x2_11/COL_LINE1
+ OffBn openDVS_pixel2x2_bot_84/vpd[2] openDVS_pixel2x2_bot_84/vpd[3] openDVS_pixel2x2_bot_84/vpd[1]
+ openDVS_pixel2x2_bot_84/vpd[0] rowReadON<16> openDVS_pixel2x2_bot_91/GndD DiffBn
+ VSUBS VDD OnBn openDVS_pixel2x2_bot
XopenDVS_pixel2x2_bot_1015 rowReadOFF<54> rowReadOFF<55> rowReadON<55> RefrBp PrBp
+ PrSFBp col_periphery_1x2_9/COL_LINE0 pixRst<32> pixRst<33> col_periphery_1x2_9/COL_LINE1
+ OffBn openDVS_pixel2x2_bot_1015/vpd[2] openDVS_pixel2x2_bot_1015/vpd[3] openDVS_pixel2x2_bot_1015/vpd[1]
+ openDVS_pixel2x2_bot_1015/vpd[0] rowReadON<54> openDVS_pixel2x2_bot_885/GndD DiffBn
+ VSUBS VDD OnBn openDVS_pixel2x2_bot
XopenDVS_pixel2x2_bot_494 rowReadOFF<60> rowReadOFF<61> rowReadON<61> RefrBp PrBp
+ PrSFBp col_periphery_1x2_24/COL_LINE0 pixRst<0> pixRst<1> col_periphery_1x2_24/COL_LINE1
+ OffBn openDVS_pixel2x2_bot_494/vpd[2] openDVS_pixel2x2_bot_494/vpd[3] openDVS_pixel2x2_bot_494/vpd[1]
+ openDVS_pixel2x2_bot_494/vpd[0] rowReadON<60> openDVS_pixel2x2_bot_902/GndD DiffBn
+ VSUBS VDD OnBn openDVS_pixel2x2_bot
XopenDVS_pixel2x2_bot_1004 rowReadOFF<44> rowReadOFF<45> rowReadON<45> RefrBp PrBp
+ PrSFBp col_periphery_1x2_23/COL_LINE0 pixRst<30> pixRst<31> col_periphery_1x2_23/COL_LINE1
+ OffBn openDVS_pixel2x2_bot_1004/vpd[2] openDVS_pixel2x2_bot_1004/vpd[3] openDVS_pixel2x2_bot_1004/vpd[1]
+ openDVS_pixel2x2_bot_1004/vpd[0] rowReadON<44> openDVS_pixel2x2_bot_923/GndD DiffBn
+ VSUBS VDD OnBn openDVS_pixel2x2_bot
XopenDVS_pixel2x2_bot_461 rowReadOFF<40> rowReadOFF<41> rowReadON<41> RefrBp PrBp
+ PrSFBp col_periphery_1x2_28/COL_LINE0 pixRst<8> pixRst<9> col_periphery_1x2_28/COL_LINE1
+ OffBn openDVS_pixel2x2_bot_461/vpd[2] openDVS_pixel2x2_bot_461/vpd[3] openDVS_pixel2x2_bot_461/vpd[1]
+ openDVS_pixel2x2_bot_461/vpd[0] rowReadON<40> openDVS_pixel2x2_bot_906/GndD DiffBn
+ VSUBS VDD OnBn openDVS_pixel2x2_bot
XopenDVS_pixel2x2_bot_450 rowReadOFF<42> rowReadOFF<43> rowReadON<43> RefrBp PrBp
+ PrSFBp col_periphery_1x2_24/COL_LINE0 pixRst<0> pixRst<1> col_periphery_1x2_24/COL_LINE1
+ OffBn openDVS_pixel2x2_bot_450/vpd[2] openDVS_pixel2x2_bot_450/vpd[3] openDVS_pixel2x2_bot_450/vpd[1]
+ openDVS_pixel2x2_bot_450/vpd[0] rowReadON<42> openDVS_pixel2x2_bot_908/GndD DiffBn
+ VSUBS VDD OnBn openDVS_pixel2x2_bot
XopenDVS_pixel2x2_bot_483 rowReadOFF<36> rowReadOFF<37> rowReadON<37> RefrBp PrBp
+ PrSFBp col_periphery_1x2_25/COL_LINE0 pixRst<2> pixRst<3> col_periphery_1x2_25/COL_LINE1
+ OffBn openDVS_pixel2x2_bot_483/vpd[2] openDVS_pixel2x2_bot_483/vpd[3] openDVS_pixel2x2_bot_483/vpd[1]
+ openDVS_pixel2x2_bot_483/vpd[0] rowReadON<36> openDVS_pixel2x2_bot_997/GndD DiffBn
+ VSUBS VDD OnBn openDVS_pixel2x2_bot
XopenDVS_pixel2x2_bot_472 rowReadOFF<30> rowReadOFF<31> rowReadON<31> RefrBp PrBp
+ PrSFBp col_periphery_1x2_29/COL_LINE0 pixRst<10> pixRst<11> col_periphery_1x2_29/COL_LINE1
+ OffBn openDVS_pixel2x2_bot_472/vpd[2] openDVS_pixel2x2_bot_472/vpd[3] openDVS_pixel2x2_bot_472/vpd[1]
+ openDVS_pixel2x2_bot_472/vpd[0] rowReadON<30> openDVS_pixel2x2_bot_991/GndD DiffBn
+ VSUBS VDD OnBn openDVS_pixel2x2_bot
XopenDVS_pixel2x2_bot_280 rowReadOFF<24> rowReadOFF<25> rowReadON<25> RefrBp PrBp
+ PrSFBp col_periphery_1x2_24/COL_LINE0 pixRst<0> pixRst<1> col_periphery_1x2_24/COL_LINE1
+ OffBn openDVS_pixel2x2_bot_280/vpd[2] openDVS_pixel2x2_bot_280/vpd[3] openDVS_pixel2x2_bot_280/vpd[1]
+ openDVS_pixel2x2_bot_280/vpd[0] rowReadON<24> openDVS_pixel2x2_bot_99/GndD DiffBn
+ VSUBS VDD OnBn openDVS_pixel2x2_bot
XopenDVS_pixel2x2_bot_291 rowReadOFF<10> rowReadOFF<11> rowReadON<11> RefrBp PrBp
+ PrSFBp col_periphery_1x2_18/COL_LINE0 pixRst<20> pixRst<21> col_periphery_1x2_18/COL_LINE1
+ OffBn openDVS_pixel2x2_bot_291/vpd[2] openDVS_pixel2x2_bot_291/vpd[3] openDVS_pixel2x2_bot_291/vpd[1]
+ openDVS_pixel2x2_bot_291/vpd[0] rowReadON<10> openDVS_pixel2x2_bot_82/GndD DiffBn
+ VSUBS VDD OnBn openDVS_pixel2x2_bot
Xcol_periphery_1x2_26 pixRst<5> col_periphery_1x2_26/COL_LINE0 col_periphery_1x2_26/COL_LINE1
+ nDETECT DETECT col_periphery_1x2_9/VDD VTHRESH pixRst<4> voutn<4> VSUBS voutn<5>
+ NCHARGE col_periphery_1x2
Xcol_periphery_1x2_15 pixRst<49> col_periphery_1x2_15/COL_LINE0 col_periphery_1x2_15/COL_LINE1
+ nDETECT DETECT col_periphery_1x2_9/VDD VTHRESH pixRst<48> voutn<48> VSUBS voutn<49>
+ NCHARGE col_periphery_1x2
XopenDVS_pixel2x2_bot_4 rowReadOFF<4> rowReadOFF<5> rowReadON<5> RefrBp PrBp PrSFBp
+ col_periphery_1x2_4/COL_LINE0 pixRst<58> pixRst<59> col_periphery_1x2_4/COL_LINE1
+ OffBn openDVS_pixel2x2_bot_4/vpd[2] openDVS_pixel2x2_bot_4/vpd[3] openDVS_pixel2x2_bot_4/vpd[1]
+ openDVS_pixel2x2_bot_4/vpd[0] rowReadON<4> openDVS_pixel2x2_bot_6/GndD DiffBn VSUBS
+ VDD OnBn openDVS_pixel2x2_bot
XopenDVS_pixel2x2_bot_835 rowReadOFF<54> rowReadOFF<55> rowReadON<55> RefrBp PrBp
+ PrSFBp col_periphery_1x2_5/COL_LINE0 pixRst<60> pixRst<61> col_periphery_1x2_5/COL_LINE1
+ OffBn openDVS_pixel2x2_bot_835/vpd[2] openDVS_pixel2x2_bot_835/vpd[3] openDVS_pixel2x2_bot_835/vpd[1]
+ openDVS_pixel2x2_bot_835/vpd[0] rowReadON<54> openDVS_pixel2x2_bot_885/GndD DiffBn
+ VSUBS VDD OnBn openDVS_pixel2x2_bot
XopenDVS_pixel2x2_bot_846 rowReadOFF<56> rowReadOFF<57> rowReadON<57> RefrBp PrBp
+ PrSFBp col_periphery_1x2_5/COL_LINE0 pixRst<60> pixRst<61> col_periphery_1x2_5/COL_LINE1
+ OffBn openDVS_pixel2x2_bot_846/vpd[2] openDVS_pixel2x2_bot_846/vpd[3] openDVS_pixel2x2_bot_846/vpd[1]
+ openDVS_pixel2x2_bot_846/vpd[0] rowReadON<56> openDVS_pixel2x2_bot_888/GndD DiffBn
+ VSUBS VDD OnBn openDVS_pixel2x2_bot
XopenDVS_pixel2x2_bot_857 rowReadOFF<58> rowReadOFF<59> rowReadON<59> RefrBp PrBp
+ PrSFBp col_periphery_1x2_5/COL_LINE0 pixRst<60> pixRst<61> col_periphery_1x2_5/COL_LINE1
+ OffBn openDVS_pixel2x2_bot_857/vpd[2] openDVS_pixel2x2_bot_857/vpd[3] openDVS_pixel2x2_bot_857/vpd[1]
+ openDVS_pixel2x2_bot_857/vpd[0] rowReadON<58> openDVS_pixel2x2_bot_890/GndD DiffBn
+ VSUBS VDD OnBn openDVS_pixel2x2_bot
XopenDVS_pixel2x2_bot_879 rowReadOFF<60> rowReadOFF<61> rowReadON<61> RefrBp PrBp
+ PrSFBp col_periphery_1x2_2/COL_LINE0 pixRst<54> pixRst<55> col_periphery_1x2_2/COL_LINE1
+ OffBn openDVS_pixel2x2_bot_879/vpd[2] openDVS_pixel2x2_bot_879/vpd[3] openDVS_pixel2x2_bot_879/vpd[1]
+ openDVS_pixel2x2_bot_879/vpd[0] rowReadON<60> openDVS_pixel2x2_bot_902/GndD DiffBn
+ VSUBS VDD OnBn openDVS_pixel2x2_bot
XopenDVS_pixel2x2_bot_813 rowReadOFF<58> rowReadOFF<59> rowReadON<59> RefrBp PrBp
+ PrSFBp col_periphery_1x2_8/COL_LINE0 pixRst<42> pixRst<43> col_periphery_1x2_8/COL_LINE1
+ OffBn openDVS_pixel2x2_bot_813/vpd[2] openDVS_pixel2x2_bot_813/vpd[3] openDVS_pixel2x2_bot_813/vpd[1]
+ openDVS_pixel2x2_bot_813/vpd[0] rowReadON<58> openDVS_pixel2x2_bot_890/GndD DiffBn
+ VSUBS VDD OnBn openDVS_pixel2x2_bot
XopenDVS_pixel2x2_bot_868 rowReadOFF<50> rowReadOFF<51> rowReadON<51> RefrBp PrBp
+ PrSFBp col_periphery_1x2_6/COL_LINE0 pixRst<62> pixRst<63> col_periphery_1x2_6/COL_LINE1
+ OffBn openDVS_pixel2x2_bot_868/vpd[2] openDVS_pixel2x2_bot_868/vpd[3] openDVS_pixel2x2_bot_868/vpd[1]
+ openDVS_pixel2x2_bot_868/vpd[0] rowReadON<50> openDVS_pixel2x2_bot_929/GndD DiffBn
+ VSUBS VDD OnBn openDVS_pixel2x2_bot
XopenDVS_pixel2x2_bot_824 rowReadOFF<52> rowReadOFF<53> rowReadON<53> RefrBp PrBp
+ PrSFBp col_periphery_1x2_4/COL_LINE0 pixRst<58> pixRst<59> col_periphery_1x2_4/COL_LINE1
+ OffBn openDVS_pixel2x2_bot_824/vpd[2] openDVS_pixel2x2_bot_824/vpd[3] openDVS_pixel2x2_bot_824/vpd[1]
+ openDVS_pixel2x2_bot_824/vpd[0] rowReadON<52> openDVS_pixel2x2_bot_882/GndD DiffBn
+ VSUBS VDD OnBn openDVS_pixel2x2_bot
XopenDVS_pixel2x2_bot_802 rowReadOFF<52> rowReadOFF<53> rowReadON<53> RefrBp PrBp
+ PrSFBp col_periphery_1x2_11/COL_LINE0 pixRst<36> pixRst<37> col_periphery_1x2_11/COL_LINE1
+ OffBn openDVS_pixel2x2_bot_802/vpd[2] openDVS_pixel2x2_bot_802/vpd[3] openDVS_pixel2x2_bot_802/vpd[1]
+ openDVS_pixel2x2_bot_802/vpd[0] rowReadON<52> openDVS_pixel2x2_bot_882/GndD DiffBn
+ VSUBS VDD OnBn openDVS_pixel2x2_bot
XopenDVS_pixel2x2_bot_109 rowReadOFF<14> rowReadOFF<15> rowReadON<15> RefrBp PrBp
+ PrSFBp col_periphery_1x2_5/COL_LINE0 pixRst<60> pixRst<61> col_periphery_1x2_5/COL_LINE1
+ OffBn openDVS_pixel2x2_bot_109/vpd[2] openDVS_pixel2x2_bot_109/vpd[3] openDVS_pixel2x2_bot_109/vpd[1]
+ openDVS_pixel2x2_bot_109/vpd[0] rowReadON<14> openDVS_pixel2x2_bot_78/GndD DiffBn
+ VSUBS VDD OnBn openDVS_pixel2x2_bot
XopenDVS_pixel2x2_bot_610 rowReadOFF<54> rowReadOFF<55> rowReadON<55> RefrBp PrBp
+ PrSFBp col_periphery_1x2_19/COL_LINE0 pixRst<22> pixRst<23> col_periphery_1x2_19/COL_LINE1
+ OffBn openDVS_pixel2x2_bot_610/vpd[2] openDVS_pixel2x2_bot_610/vpd[3] openDVS_pixel2x2_bot_610/vpd[1]
+ openDVS_pixel2x2_bot_610/vpd[0] rowReadON<54> openDVS_pixel2x2_bot_885/GndD DiffBn
+ VSUBS VDD OnBn openDVS_pixel2x2_bot
XopenDVS_pixel2x2_bot_643 rowReadOFF<54> rowReadOFF<55> rowReadON<55> RefrBp PrBp
+ PrSFBp col_periphery_1x2_16/COL_LINE0 pixRst<16> pixRst<17> col_periphery_1x2_16/COL_LINE1
+ OffBn openDVS_pixel2x2_bot_643/vpd[2] openDVS_pixel2x2_bot_643/vpd[3] openDVS_pixel2x2_bot_643/vpd[1]
+ openDVS_pixel2x2_bot_643/vpd[0] rowReadON<54> openDVS_pixel2x2_bot_885/GndD DiffBn
+ VSUBS VDD OnBn openDVS_pixel2x2_bot
XopenDVS_pixel2x2_bot_621 rowReadOFF<44> rowReadOFF<45> rowReadON<45> RefrBp PrBp
+ PrSFBp col_periphery_1x2_28/COL_LINE0 pixRst<8> pixRst<9> col_periphery_1x2_28/COL_LINE1
+ OffBn openDVS_pixel2x2_bot_621/vpd[2] openDVS_pixel2x2_bot_621/vpd[3] openDVS_pixel2x2_bot_621/vpd[1]
+ openDVS_pixel2x2_bot_621/vpd[0] rowReadON<44> openDVS_pixel2x2_bot_923/GndD DiffBn
+ VSUBS VDD OnBn openDVS_pixel2x2_bot
XopenDVS_pixel2x2_bot_687 rowReadOFF<40> rowReadOFF<41> rowReadON<41> RefrBp PrBp
+ PrSFBp col_periphery_1x2_4/COL_LINE0 pixRst<58> pixRst<59> col_periphery_1x2_4/COL_LINE1
+ OffBn openDVS_pixel2x2_bot_687/vpd[2] openDVS_pixel2x2_bot_687/vpd[3] openDVS_pixel2x2_bot_687/vpd[1]
+ openDVS_pixel2x2_bot_687/vpd[0] rowReadON<40> openDVS_pixel2x2_bot_906/GndD DiffBn
+ VSUBS VDD OnBn openDVS_pixel2x2_bot
XopenDVS_pixel2x2_bot_665 rowReadOFF<40> rowReadOFF<41> rowReadON<41> RefrBp PrBp
+ PrSFBp col_periphery_1x2_3/COL_LINE0 pixRst<56> pixRst<57> col_periphery_1x2_3/COL_LINE1
+ OffBn openDVS_pixel2x2_bot_665/vpd[2] openDVS_pixel2x2_bot_665/vpd[3] openDVS_pixel2x2_bot_665/vpd[1]
+ openDVS_pixel2x2_bot_665/vpd[0] rowReadON<40> openDVS_pixel2x2_bot_906/GndD DiffBn
+ VSUBS VDD OnBn openDVS_pixel2x2_bot
XopenDVS_pixel2x2_bot_698 rowReadOFF<36> rowReadOFF<37> rowReadON<37> RefrBp PrBp
+ PrSFBp col_periphery_1x2_0/COL_LINE0 pixRst<50> pixRst<51> col_periphery_1x2_0/COL_LINE1
+ OffBn openDVS_pixel2x2_bot_698/vpd[2] openDVS_pixel2x2_bot_698/vpd[3] openDVS_pixel2x2_bot_698/vpd[1]
+ openDVS_pixel2x2_bot_698/vpd[0] rowReadON<36> openDVS_pixel2x2_bot_997/GndD DiffBn
+ VSUBS VDD OnBn openDVS_pixel2x2_bot
XopenDVS_pixel2x2_bot_654 rowReadOFF<38> rowReadOFF<39> rowReadON<39> RefrBp PrBp
+ PrSFBp col_periphery_1x2_31/COL_LINE0 pixRst<14> pixRst<15> col_periphery_1x2_31/COL_LINE1
+ OffBn openDVS_pixel2x2_bot_654/vpd[2] openDVS_pixel2x2_bot_654/vpd[3] openDVS_pixel2x2_bot_654/vpd[1]
+ openDVS_pixel2x2_bot_654/vpd[0] rowReadON<38> openDVS_pixel2x2_bot_999/GndD DiffBn
+ VSUBS VDD OnBn openDVS_pixel2x2_bot
XopenDVS_pixel2x2_bot_96 rowReadOFF<22> rowReadOFF<23> rowReadON<23> RefrBp PrBp PrSFBp
+ col_periphery_1x2_5/COL_LINE0 pixRst<60> pixRst<61> col_periphery_1x2_5/COL_LINE1
+ OffBn openDVS_pixel2x2_bot_96/vpd[2] openDVS_pixel2x2_bot_96/vpd[3] openDVS_pixel2x2_bot_96/vpd[1]
+ openDVS_pixel2x2_bot_96/vpd[0] rowReadON<22> openDVS_pixel2x2_bot_97/GndD DiffBn
+ VSUBS VDD OnBn openDVS_pixel2x2_bot
XopenDVS_pixel2x2_bot_676 rowReadOFF<28> rowReadOFF<29> rowReadON<29> RefrBp PrBp
+ PrSFBp col_periphery_1x2_4/COL_LINE0 pixRst<58> pixRst<59> col_periphery_1x2_4/COL_LINE1
+ OffBn openDVS_pixel2x2_bot_676/vpd[2] openDVS_pixel2x2_bot_676/vpd[3] openDVS_pixel2x2_bot_676/vpd[1]
+ openDVS_pixel2x2_bot_676/vpd[0] rowReadON<28> openDVS_pixel2x2_bot_989/GndD DiffBn
+ VSUBS VDD OnBn openDVS_pixel2x2_bot
XopenDVS_pixel2x2_bot_52 rowReadOFF<22> rowReadOFF<23> rowReadON<23> RefrBp PrBp PrSFBp
+ col_periphery_1x2_11/COL_LINE0 pixRst<36> pixRst<37> col_periphery_1x2_11/COL_LINE1
+ OffBn openDVS_pixel2x2_bot_52/vpd[2] openDVS_pixel2x2_bot_52/vpd[3] openDVS_pixel2x2_bot_52/vpd[1]
+ openDVS_pixel2x2_bot_52/vpd[0] rowReadON<22> openDVS_pixel2x2_bot_97/GndD DiffBn
+ VSUBS VDD OnBn openDVS_pixel2x2_bot
XopenDVS_pixel2x2_bot_632 rowReadOFF<28> rowReadOFF<29> rowReadON<29> RefrBp PrBp
+ PrSFBp col_periphery_1x2_16/COL_LINE0 pixRst<16> pixRst<17> col_periphery_1x2_16/COL_LINE1
+ OffBn openDVS_pixel2x2_bot_632/vpd[2] openDVS_pixel2x2_bot_632/vpd[3] openDVS_pixel2x2_bot_632/vpd[1]
+ openDVS_pixel2x2_bot_632/vpd[0] rowReadON<28> openDVS_pixel2x2_bot_989/GndD DiffBn
+ VSUBS VDD OnBn openDVS_pixel2x2_bot
XopenDVS_pixel2x2_bot_63 rowReadOFF<14> rowReadOFF<15> rowReadON<15> RefrBp PrBp PrSFBp
+ col_periphery_1x2_8/COL_LINE0 pixRst<42> pixRst<43> col_periphery_1x2_8/COL_LINE1
+ OffBn openDVS_pixel2x2_bot_63/vpd[2] openDVS_pixel2x2_bot_63/vpd[3] openDVS_pixel2x2_bot_63/vpd[1]
+ openDVS_pixel2x2_bot_63/vpd[0] rowReadON<14> openDVS_pixel2x2_bot_78/GndD DiffBn
+ VSUBS VDD OnBn openDVS_pixel2x2_bot
XopenDVS_pixel2x2_bot_74 rowReadOFF<20> rowReadOFF<21> rowReadON<21> RefrBp PrBp PrSFBp
+ col_periphery_1x2_12/COL_LINE0 pixRst<38> pixRst<39> col_periphery_1x2_12/COL_LINE1
+ OffBn openDVS_pixel2x2_bot_74/vpd[2] openDVS_pixel2x2_bot_74/vpd[3] openDVS_pixel2x2_bot_74/vpd[1]
+ openDVS_pixel2x2_bot_74/vpd[0] rowReadON<20> openDVS_pixel2x2_bot_95/GndD DiffBn
+ VSUBS VDD OnBn openDVS_pixel2x2_bot
XopenDVS_pixel2x2_bot_85 rowReadOFF<16> rowReadOFF<17> rowReadON<17> RefrBp PrBp PrSFBp
+ col_periphery_1x2_12/COL_LINE0 pixRst<38> pixRst<39> col_periphery_1x2_12/COL_LINE1
+ OffBn openDVS_pixel2x2_bot_85/vpd[2] openDVS_pixel2x2_bot_85/vpd[3] openDVS_pixel2x2_bot_85/vpd[1]
+ openDVS_pixel2x2_bot_85/vpd[0] rowReadON<16> openDVS_pixel2x2_bot_91/GndD DiffBn
+ VSUBS VDD OnBn openDVS_pixel2x2_bot
XopenDVS_pixel2x2_bot_41 rowReadOFF<10> rowReadOFF<11> rowReadON<11> RefrBp PrBp PrSFBp
+ col_periphery_1x2_12/COL_LINE0 pixRst<38> pixRst<39> col_periphery_1x2_12/COL_LINE1
+ OffBn openDVS_pixel2x2_bot_41/vpd[2] openDVS_pixel2x2_bot_41/vpd[3] openDVS_pixel2x2_bot_41/vpd[1]
+ openDVS_pixel2x2_bot_41/vpd[0] rowReadON<10> openDVS_pixel2x2_bot_82/GndD DiffBn
+ VSUBS VDD OnBn openDVS_pixel2x2_bot
XopenDVS_pixel2x2_bot_30 rowReadOFF<4> rowReadOFF<5> rowReadON<5> RefrBp PrBp PrSFBp
+ col_periphery_1x2_8/COL_LINE0 pixRst<42> pixRst<43> col_periphery_1x2_8/COL_LINE1
+ OffBn openDVS_pixel2x2_bot_30/vpd[2] openDVS_pixel2x2_bot_30/vpd[3] openDVS_pixel2x2_bot_30/vpd[1]
+ openDVS_pixel2x2_bot_30/vpd[0] rowReadON<4> openDVS_pixel2x2_bot_6/GndD DiffBn VSUBS
+ VDD OnBn openDVS_pixel2x2_bot
XopenDVS_pixel2x2_bot_1016 rowReadOFF<56> rowReadOFF<57> rowReadON<57> RefrBp PrBp
+ PrSFBp col_periphery_1x2_23/COL_LINE0 pixRst<30> pixRst<31> col_periphery_1x2_23/COL_LINE1
+ OffBn openDVS_pixel2x2_bot_1016/vpd[2] openDVS_pixel2x2_bot_1016/vpd[3] openDVS_pixel2x2_bot_1016/vpd[1]
+ openDVS_pixel2x2_bot_1016/vpd[0] rowReadON<56> openDVS_pixel2x2_bot_888/GndD DiffBn
+ VSUBS VDD OnBn openDVS_pixel2x2_bot
XopenDVS_pixel2x2_bot_1005 rowReadOFF<44> rowReadOFF<45> rowReadON<45> RefrBp PrBp
+ PrSFBp col_periphery_1x2_9/COL_LINE0 pixRst<32> pixRst<33> col_periphery_1x2_9/COL_LINE1
+ OffBn openDVS_pixel2x2_bot_1005/vpd[2] openDVS_pixel2x2_bot_1005/vpd[3] openDVS_pixel2x2_bot_1005/vpd[1]
+ openDVS_pixel2x2_bot_1005/vpd[0] rowReadON<44> openDVS_pixel2x2_bot_923/GndD DiffBn
+ VSUBS VDD OnBn openDVS_pixel2x2_bot
XopenDVS_pixel2x2_bot_495 rowReadOFF<60> rowReadOFF<61> rowReadON<61> RefrBp PrBp
+ PrSFBp col_periphery_1x2_25/COL_LINE0 pixRst<2> pixRst<3> col_periphery_1x2_25/COL_LINE1
+ OffBn openDVS_pixel2x2_bot_495/vpd[2] openDVS_pixel2x2_bot_495/vpd[3] openDVS_pixel2x2_bot_495/vpd[1]
+ openDVS_pixel2x2_bot_495/vpd[0] rowReadON<60> openDVS_pixel2x2_bot_902/GndD DiffBn
+ VSUBS VDD OnBn openDVS_pixel2x2_bot
XopenDVS_pixel2x2_bot_462 rowReadOFF<40> rowReadOFF<41> rowReadON<41> RefrBp PrBp
+ PrSFBp col_periphery_1x2_29/COL_LINE0 pixRst<10> pixRst<11> col_periphery_1x2_29/COL_LINE1
+ OffBn openDVS_pixel2x2_bot_462/vpd[2] openDVS_pixel2x2_bot_462/vpd[3] openDVS_pixel2x2_bot_462/vpd[1]
+ openDVS_pixel2x2_bot_462/vpd[0] rowReadON<40> openDVS_pixel2x2_bot_906/GndD DiffBn
+ VSUBS VDD OnBn openDVS_pixel2x2_bot
XopenDVS_pixel2x2_bot_451 rowReadOFF<42> rowReadOFF<43> rowReadON<43> RefrBp PrBp
+ PrSFBp col_periphery_1x2_25/COL_LINE0 pixRst<2> pixRst<3> col_periphery_1x2_25/COL_LINE1
+ OffBn openDVS_pixel2x2_bot_451/vpd[2] openDVS_pixel2x2_bot_451/vpd[3] openDVS_pixel2x2_bot_451/vpd[1]
+ openDVS_pixel2x2_bot_451/vpd[0] rowReadON<42> openDVS_pixel2x2_bot_908/GndD DiffBn
+ VSUBS VDD OnBn openDVS_pixel2x2_bot
XopenDVS_pixel2x2_bot_484 rowReadOFF<34> rowReadOFF<35> rowReadON<35> RefrBp PrBp
+ PrSFBp col_periphery_1x2_24/COL_LINE0 pixRst<0> pixRst<1> col_periphery_1x2_24/COL_LINE1
+ OffBn openDVS_pixel2x2_bot_484/vpd[2] openDVS_pixel2x2_bot_484/vpd[3] openDVS_pixel2x2_bot_484/vpd[1]
+ openDVS_pixel2x2_bot_484/vpd[0] rowReadON<34> openDVS_pixel2x2_bot_995/GndD DiffBn
+ VSUBS VDD OnBn openDVS_pixel2x2_bot
XopenDVS_pixel2x2_bot_473 rowReadOFF<30> rowReadOFF<31> rowReadON<31> RefrBp PrBp
+ PrSFBp col_periphery_1x2_30/COL_LINE0 pixRst<12> pixRst<13> col_periphery_1x2_30/COL_LINE1
+ OffBn openDVS_pixel2x2_bot_473/vpd[2] openDVS_pixel2x2_bot_473/vpd[3] openDVS_pixel2x2_bot_473/vpd[1]
+ openDVS_pixel2x2_bot_473/vpd[0] rowReadON<30> openDVS_pixel2x2_bot_991/GndD DiffBn
+ VSUBS VDD OnBn openDVS_pixel2x2_bot
XopenDVS_pixel2x2_bot_440 rowReadOFF<28> rowReadOFF<29> rowReadON<29> RefrBp PrBp
+ PrSFBp col_periphery_1x2_30/COL_LINE0 pixRst<12> pixRst<13> col_periphery_1x2_30/COL_LINE1
+ OffBn openDVS_pixel2x2_bot_440/vpd[2] openDVS_pixel2x2_bot_440/vpd[3] openDVS_pixel2x2_bot_440/vpd[1]
+ openDVS_pixel2x2_bot_440/vpd[0] rowReadON<28> openDVS_pixel2x2_bot_989/GndD DiffBn
+ VSUBS VDD OnBn openDVS_pixel2x2_bot
XopenDVS_pixel2x2_bot_270 rowReadOFF<20> rowReadOFF<21> rowReadON<21> RefrBp PrBp
+ PrSFBp col_periphery_1x2_28/COL_LINE0 pixRst<8> pixRst<9> col_periphery_1x2_28/COL_LINE1
+ OffBn openDVS_pixel2x2_bot_270/vpd[2] openDVS_pixel2x2_bot_270/vpd[3] openDVS_pixel2x2_bot_270/vpd[1]
+ openDVS_pixel2x2_bot_270/vpd[0] rowReadON<20> openDVS_pixel2x2_bot_95/GndD DiffBn
+ VSUBS VDD OnBn openDVS_pixel2x2_bot
XopenDVS_pixel2x2_bot_281 rowReadOFF<10> rowReadOFF<11> rowReadON<11> RefrBp PrBp
+ PrSFBp col_periphery_1x2_24/COL_LINE0 pixRst<0> pixRst<1> col_periphery_1x2_24/COL_LINE1
+ OffBn openDVS_pixel2x2_bot_281/vpd[2] openDVS_pixel2x2_bot_281/vpd[3] openDVS_pixel2x2_bot_281/vpd[1]
+ openDVS_pixel2x2_bot_281/vpd[0] rowReadON<10> openDVS_pixel2x2_bot_82/GndD DiffBn
+ VSUBS VDD OnBn openDVS_pixel2x2_bot
XopenDVS_pixel2x2_bot_292 rowReadOFF<10> rowReadOFF<11> rowReadON<11> RefrBp PrBp
+ PrSFBp col_periphery_1x2_19/COL_LINE0 pixRst<22> pixRst<23> col_periphery_1x2_19/COL_LINE1
+ OffBn openDVS_pixel2x2_bot_292/vpd[2] openDVS_pixel2x2_bot_292/vpd[3] openDVS_pixel2x2_bot_292/vpd[1]
+ openDVS_pixel2x2_bot_292/vpd[0] rowReadON<10> openDVS_pixel2x2_bot_82/GndD DiffBn
+ VSUBS VDD OnBn openDVS_pixel2x2_bot
Xcol_periphery_1x2_16 pixRst<17> col_periphery_1x2_16/COL_LINE0 col_periphery_1x2_16/COL_LINE1
+ nDETECT DETECT col_periphery_1x2_9/VDD VTHRESH pixRst<16> voutn<16> VSUBS voutn<17>
+ NCHARGE col_periphery_1x2
Xcol_periphery_1x2_27 pixRst<7> col_periphery_1x2_27/COL_LINE0 col_periphery_1x2_27/COL_LINE1
+ nDETECT DETECT col_periphery_1x2_9/VDD VTHRESH pixRst<6> voutn<6> VSUBS voutn<7>
+ NCHARGE col_periphery_1x2
XopenDVS_pixel2x2_bot_5 rowReadOFF<4> rowReadOFF<5> rowReadON<5> RefrBp PrBp PrSFBp
+ col_periphery_1x2_5/COL_LINE0 pixRst<60> pixRst<61> col_periphery_1x2_5/COL_LINE1
+ OffBn openDVS_pixel2x2_bot_5/vpd[2] openDVS_pixel2x2_bot_5/vpd[3] openDVS_pixel2x2_bot_5/vpd[1]
+ openDVS_pixel2x2_bot_5/vpd[0] rowReadON<4> openDVS_pixel2x2_bot_6/GndD DiffBn VSUBS
+ VDD OnBn openDVS_pixel2x2_bot
XopenDVS_pixel2x2_bot_836 rowReadOFF<54> rowReadOFF<55> rowReadON<55> RefrBp PrBp
+ PrSFBp col_periphery_1x2_6/COL_LINE0 pixRst<62> pixRst<63> col_periphery_1x2_6/COL_LINE1
+ OffBn openDVS_pixel2x2_bot_836/vpd[2] openDVS_pixel2x2_bot_836/vpd[3] openDVS_pixel2x2_bot_836/vpd[1]
+ openDVS_pixel2x2_bot_836/vpd[0] rowReadON<54> openDVS_pixel2x2_bot_885/GndD DiffBn
+ VSUBS VDD OnBn openDVS_pixel2x2_bot
XopenDVS_pixel2x2_bot_847 rowReadOFF<56> rowReadOFF<57> rowReadON<57> RefrBp PrBp
+ PrSFBp col_periphery_1x2_6/COL_LINE0 pixRst<62> pixRst<63> col_periphery_1x2_6/COL_LINE1
+ OffBn openDVS_pixel2x2_bot_847/vpd[2] openDVS_pixel2x2_bot_847/vpd[3] openDVS_pixel2x2_bot_847/vpd[1]
+ openDVS_pixel2x2_bot_847/vpd[0] rowReadON<56> openDVS_pixel2x2_bot_888/GndD DiffBn
+ VSUBS VDD OnBn openDVS_pixel2x2_bot
XopenDVS_pixel2x2_bot_858 rowReadOFF<58> rowReadOFF<59> rowReadON<59> RefrBp PrBp
+ PrSFBp col_periphery_1x2_6/COL_LINE0 pixRst<62> pixRst<63> col_periphery_1x2_6/COL_LINE1
+ OffBn openDVS_pixel2x2_bot_858/vpd[2] openDVS_pixel2x2_bot_858/vpd[3] openDVS_pixel2x2_bot_858/vpd[1]
+ openDVS_pixel2x2_bot_858/vpd[0] rowReadON<58> openDVS_pixel2x2_bot_890/GndD DiffBn
+ VSUBS VDD OnBn openDVS_pixel2x2_bot
XopenDVS_pixel2x2_bot_814 rowReadOFF<58> rowReadOFF<59> rowReadON<59> RefrBp PrBp
+ PrSFBp col_periphery_1x2_13/COL_LINE0 pixRst<44> pixRst<45> col_periphery_1x2_13/COL_LINE1
+ OffBn openDVS_pixel2x2_bot_814/vpd[2] openDVS_pixel2x2_bot_814/vpd[3] openDVS_pixel2x2_bot_814/vpd[1]
+ openDVS_pixel2x2_bot_814/vpd[0] rowReadON<58> openDVS_pixel2x2_bot_890/GndD DiffBn
+ VSUBS VDD OnBn openDVS_pixel2x2_bot
XopenDVS_pixel2x2_bot_825 rowReadOFF<52> rowReadOFF<53> rowReadON<53> RefrBp PrBp
+ PrSFBp col_periphery_1x2_5/COL_LINE0 pixRst<60> pixRst<61> col_periphery_1x2_5/COL_LINE1
+ OffBn openDVS_pixel2x2_bot_825/vpd[2] openDVS_pixel2x2_bot_825/vpd[3] openDVS_pixel2x2_bot_825/vpd[1]
+ openDVS_pixel2x2_bot_825/vpd[0] rowReadON<52> openDVS_pixel2x2_bot_882/GndD DiffBn
+ VSUBS VDD OnBn openDVS_pixel2x2_bot
XopenDVS_pixel2x2_bot_869 rowReadOFF<50> rowReadOFF<51> rowReadON<51> RefrBp PrBp
+ PrSFBp col_periphery_1x2_0/COL_LINE0 pixRst<50> pixRst<51> col_periphery_1x2_0/COL_LINE1
+ OffBn openDVS_pixel2x2_bot_869/vpd[2] openDVS_pixel2x2_bot_869/vpd[3] openDVS_pixel2x2_bot_869/vpd[1]
+ openDVS_pixel2x2_bot_869/vpd[0] rowReadON<50> openDVS_pixel2x2_bot_929/GndD DiffBn
+ VSUBS VDD OnBn openDVS_pixel2x2_bot
XopenDVS_pixel2x2_bot_803 rowReadOFF<46> rowReadOFF<47> rowReadON<47> RefrBp PrBp
+ PrSFBp col_periphery_1x2_10/COL_LINE0 pixRst<34> pixRst<35> col_periphery_1x2_10/COL_LINE1
+ OffBn openDVS_pixel2x2_bot_803/vpd[2] openDVS_pixel2x2_bot_803/vpd[3] openDVS_pixel2x2_bot_803/vpd[1]
+ openDVS_pixel2x2_bot_803/vpd[0] rowReadON<46> openDVS_pixel2x2_bot_925/GndD DiffBn
+ VSUBS VDD OnBn openDVS_pixel2x2_bot
XopenDVS_pixel2x2_bot_633 rowReadOFF<44> rowReadOFF<45> rowReadON<45> RefrBp PrBp
+ PrSFBp col_periphery_1x2_22/COL_LINE0 pixRst<28> pixRst<29> col_periphery_1x2_22/COL_LINE1
+ OffBn openDVS_pixel2x2_bot_633/vpd[2] openDVS_pixel2x2_bot_633/vpd[3] openDVS_pixel2x2_bot_633/vpd[1]
+ openDVS_pixel2x2_bot_633/vpd[0] rowReadON<44> openDVS_pixel2x2_bot_923/GndD DiffBn
+ VSUBS VDD OnBn openDVS_pixel2x2_bot
XopenDVS_pixel2x2_bot_600 rowReadOFF<46> rowReadOFF<47> rowReadON<47> RefrBp PrBp
+ PrSFBp col_periphery_1x2_19/COL_LINE0 pixRst<22> pixRst<23> col_periphery_1x2_19/COL_LINE1
+ OffBn openDVS_pixel2x2_bot_600/vpd[2] openDVS_pixel2x2_bot_600/vpd[3] openDVS_pixel2x2_bot_600/vpd[1]
+ openDVS_pixel2x2_bot_600/vpd[0] rowReadON<46> openDVS_pixel2x2_bot_925/GndD DiffBn
+ VSUBS VDD OnBn openDVS_pixel2x2_bot
XopenDVS_pixel2x2_bot_622 rowReadOFF<44> rowReadOFF<45> rowReadON<45> RefrBp PrBp
+ PrSFBp col_periphery_1x2_29/COL_LINE0 pixRst<10> pixRst<11> col_periphery_1x2_29/COL_LINE1
+ OffBn openDVS_pixel2x2_bot_622/vpd[2] openDVS_pixel2x2_bot_622/vpd[3] openDVS_pixel2x2_bot_622/vpd[1]
+ openDVS_pixel2x2_bot_622/vpd[0] rowReadON<44> openDVS_pixel2x2_bot_923/GndD DiffBn
+ VSUBS VDD OnBn openDVS_pixel2x2_bot
XopenDVS_pixel2x2_bot_688 rowReadOFF<40> rowReadOFF<41> rowReadON<41> RefrBp PrBp
+ PrSFBp col_periphery_1x2_5/COL_LINE0 pixRst<60> pixRst<61> col_periphery_1x2_5/COL_LINE1
+ OffBn openDVS_pixel2x2_bot_688/vpd[2] openDVS_pixel2x2_bot_688/vpd[3] openDVS_pixel2x2_bot_688/vpd[1]
+ openDVS_pixel2x2_bot_688/vpd[0] rowReadON<40> openDVS_pixel2x2_bot_906/GndD DiffBn
+ VSUBS VDD OnBn openDVS_pixel2x2_bot
XopenDVS_pixel2x2_bot_699 rowReadOFF<36> rowReadOFF<37> rowReadON<37> RefrBp PrBp
+ PrSFBp col_periphery_1x2_1/COL_LINE0 pixRst<52> pixRst<53> col_periphery_1x2_1/COL_LINE1
+ OffBn openDVS_pixel2x2_bot_699/vpd[2] openDVS_pixel2x2_bot_699/vpd[3] openDVS_pixel2x2_bot_699/vpd[1]
+ openDVS_pixel2x2_bot_699/vpd[0] rowReadON<36> openDVS_pixel2x2_bot_997/GndD DiffBn
+ VSUBS VDD OnBn openDVS_pixel2x2_bot
XopenDVS_pixel2x2_bot_666 rowReadOFF<38> rowReadOFF<39> rowReadON<39> RefrBp PrBp
+ PrSFBp col_periphery_1x2_0/COL_LINE0 pixRst<50> pixRst<51> col_periphery_1x2_0/COL_LINE1
+ OffBn openDVS_pixel2x2_bot_666/vpd[2] openDVS_pixel2x2_bot_666/vpd[3] openDVS_pixel2x2_bot_666/vpd[1]
+ openDVS_pixel2x2_bot_666/vpd[0] rowReadON<38> openDVS_pixel2x2_bot_999/GndD DiffBn
+ VSUBS VDD OnBn openDVS_pixel2x2_bot
XopenDVS_pixel2x2_bot_655 rowReadOFF<38> rowReadOFF<39> rowReadON<39> RefrBp PrBp
+ PrSFBp col_periphery_1x2_16/COL_LINE0 pixRst<16> pixRst<17> col_periphery_1x2_16/COL_LINE1
+ OffBn openDVS_pixel2x2_bot_655/vpd[2] openDVS_pixel2x2_bot_655/vpd[3] openDVS_pixel2x2_bot_655/vpd[1]
+ openDVS_pixel2x2_bot_655/vpd[0] rowReadON<38> openDVS_pixel2x2_bot_999/GndD DiffBn
+ VSUBS VDD OnBn openDVS_pixel2x2_bot
XopenDVS_pixel2x2_bot_611 rowReadOFF<42> rowReadOFF<43> rowReadON<43> RefrBp PrBp
+ PrSFBp col_periphery_1x2_31/COL_LINE0 pixRst<14> pixRst<15> col_periphery_1x2_31/COL_LINE1
+ OffBn openDVS_pixel2x2_bot_611/vpd[2] openDVS_pixel2x2_bot_611/vpd[3] openDVS_pixel2x2_bot_611/vpd[1]
+ openDVS_pixel2x2_bot_611/vpd[0] rowReadON<42> openDVS_pixel2x2_bot_908/GndD DiffBn
+ VSUBS VDD OnBn openDVS_pixel2x2_bot
XopenDVS_pixel2x2_bot_644 rowReadOFF<34> rowReadOFF<35> rowReadON<35> RefrBp PrBp
+ PrSFBp col_periphery_1x2_31/COL_LINE0 pixRst<14> pixRst<15> col_periphery_1x2_31/COL_LINE1
+ OffBn openDVS_pixel2x2_bot_644/vpd[2] openDVS_pixel2x2_bot_644/vpd[3] openDVS_pixel2x2_bot_644/vpd[1]
+ openDVS_pixel2x2_bot_644/vpd[0] rowReadON<34> openDVS_pixel2x2_bot_995/GndD DiffBn
+ VSUBS VDD OnBn openDVS_pixel2x2_bot
XopenDVS_pixel2x2_bot_677 rowReadOFF<28> rowReadOFF<29> rowReadON<29> RefrBp PrBp
+ PrSFBp col_periphery_1x2_5/COL_LINE0 pixRst<60> pixRst<61> col_periphery_1x2_5/COL_LINE1
+ OffBn openDVS_pixel2x2_bot_677/vpd[2] openDVS_pixel2x2_bot_677/vpd[3] openDVS_pixel2x2_bot_677/vpd[1]
+ openDVS_pixel2x2_bot_677/vpd[0] rowReadON<28> openDVS_pixel2x2_bot_989/GndD DiffBn
+ VSUBS VDD OnBn openDVS_pixel2x2_bot
XopenDVS_pixel2x2_bot_53 rowReadOFF<22> rowReadOFF<23> rowReadON<23> RefrBp PrBp PrSFBp
+ col_periphery_1x2_12/COL_LINE0 pixRst<38> pixRst<39> col_periphery_1x2_12/COL_LINE1
+ OffBn openDVS_pixel2x2_bot_53/vpd[2] openDVS_pixel2x2_bot_53/vpd[3] openDVS_pixel2x2_bot_53/vpd[1]
+ openDVS_pixel2x2_bot_53/vpd[0] rowReadON<22> openDVS_pixel2x2_bot_97/GndD DiffBn
+ VSUBS VDD OnBn openDVS_pixel2x2_bot
XopenDVS_pixel2x2_bot_75 rowReadOFF<20> rowReadOFF<21> rowReadON<21> RefrBp PrBp PrSFBp
+ col_periphery_1x2_7/COL_LINE0 pixRst<40> pixRst<41> col_periphery_1x2_7/COL_LINE1
+ OffBn openDVS_pixel2x2_bot_75/vpd[2] openDVS_pixel2x2_bot_75/vpd[3] openDVS_pixel2x2_bot_75/vpd[1]
+ openDVS_pixel2x2_bot_75/vpd[0] rowReadON<20> openDVS_pixel2x2_bot_95/GndD DiffBn
+ VSUBS VDD OnBn openDVS_pixel2x2_bot
XopenDVS_pixel2x2_bot_64 rowReadOFF<18> rowReadOFF<19> rowReadON<19> RefrBp PrBp PrSFBp
+ col_periphery_1x2_10/COL_LINE0 pixRst<34> pixRst<35> col_periphery_1x2_10/COL_LINE1
+ OffBn openDVS_pixel2x2_bot_64/vpd[2] openDVS_pixel2x2_bot_64/vpd[3] openDVS_pixel2x2_bot_64/vpd[1]
+ openDVS_pixel2x2_bot_64/vpd[0] rowReadON<18> openDVS_pixel2x2_bot_69/GndD DiffBn
+ VSUBS VDD OnBn openDVS_pixel2x2_bot
XopenDVS_pixel2x2_bot_20 rowReadOFF<2> rowReadOFF<3> rowReadON<3> RefrBp PrBp PrSFBp
+ col_periphery_1x2_1/COL_LINE0 pixRst<52> pixRst<53> col_periphery_1x2_1/COL_LINE1
+ OffBn openDVS_pixel2x2_bot_20/vpd[2] openDVS_pixel2x2_bot_20/vpd[3] openDVS_pixel2x2_bot_20/vpd[1]
+ openDVS_pixel2x2_bot_20/vpd[0] rowReadON<2> openDVS_pixel2x2_bot_7/GndD DiffBn VSUBS
+ VDD OnBn openDVS_pixel2x2_bot
XopenDVS_pixel2x2_bot_42 rowReadOFF<10> rowReadOFF<11> rowReadON<11> RefrBp PrBp PrSFBp
+ col_periphery_1x2_7/COL_LINE0 pixRst<40> pixRst<41> col_periphery_1x2_7/COL_LINE1
+ OffBn openDVS_pixel2x2_bot_42/vpd[2] openDVS_pixel2x2_bot_42/vpd[3] openDVS_pixel2x2_bot_42/vpd[1]
+ openDVS_pixel2x2_bot_42/vpd[0] rowReadON<10> openDVS_pixel2x2_bot_82/GndD DiffBn
+ VSUBS VDD OnBn openDVS_pixel2x2_bot
XopenDVS_pixel2x2_bot_31 rowReadOFF<4> rowReadOFF<5> rowReadON<5> RefrBp PrBp PrSFBp
+ col_periphery_1x2_13/COL_LINE0 pixRst<44> pixRst<45> col_periphery_1x2_13/COL_LINE1
+ OffBn openDVS_pixel2x2_bot_31/vpd[2] openDVS_pixel2x2_bot_31/vpd[3] openDVS_pixel2x2_bot_31/vpd[1]
+ openDVS_pixel2x2_bot_31/vpd[0] rowReadON<4> openDVS_pixel2x2_bot_6/GndD DiffBn VSUBS
+ VDD OnBn openDVS_pixel2x2_bot
XopenDVS_pixel2x2_bot_97 rowReadOFF<22> rowReadOFF<23> rowReadON<23> RefrBp PrBp PrSFBp
+ col_periphery_1x2_6/COL_LINE0 pixRst<62> pixRst<63> col_periphery_1x2_6/COL_LINE1
+ OffBn openDVS_pixel2x2_bot_97/vpd[2] openDVS_pixel2x2_bot_97/vpd[3] openDVS_pixel2x2_bot_97/vpd[1]
+ openDVS_pixel2x2_bot_97/vpd[0] rowReadON<22> openDVS_pixel2x2_bot_97/GndD DiffBn
+ VSUBS VDD OnBn openDVS_pixel2x2_bot
XopenDVS_pixel2x2_bot_86 rowReadOFF<16> rowReadOFF<17> rowReadON<17> RefrBp PrBp PrSFBp
+ col_periphery_1x2_7/COL_LINE0 pixRst<40> pixRst<41> col_periphery_1x2_7/COL_LINE1
+ OffBn openDVS_pixel2x2_bot_86/vpd[2] openDVS_pixel2x2_bot_86/vpd[3] openDVS_pixel2x2_bot_86/vpd[1]
+ openDVS_pixel2x2_bot_86/vpd[0] rowReadON<16> openDVS_pixel2x2_bot_91/GndD DiffBn
+ VSUBS VDD OnBn openDVS_pixel2x2_bot
XopenDVS_pixel2x2_bot_1017 rowReadOFF<56> rowReadOFF<57> rowReadON<57> RefrBp PrBp
+ PrSFBp col_periphery_1x2_9/COL_LINE0 pixRst<32> pixRst<33> col_periphery_1x2_9/COL_LINE1
+ OffBn openDVS_pixel2x2_bot_1017/vpd[2] openDVS_pixel2x2_bot_1017/vpd[3] openDVS_pixel2x2_bot_1017/vpd[1]
+ openDVS_pixel2x2_bot_1017/vpd[0] rowReadON<56> openDVS_pixel2x2_bot_888/GndD DiffBn
+ VSUBS VDD OnBn openDVS_pixel2x2_bot
XopenDVS_pixel2x2_bot_1006 rowReadOFF<46> rowReadOFF<47> rowReadON<47> RefrBp PrBp
+ PrSFBp col_periphery_1x2_23/COL_LINE0 pixRst<30> pixRst<31> col_periphery_1x2_23/COL_LINE1
+ OffBn openDVS_pixel2x2_bot_1006/vpd[2] openDVS_pixel2x2_bot_1006/vpd[3] openDVS_pixel2x2_bot_1006/vpd[1]
+ openDVS_pixel2x2_bot_1006/vpd[0] rowReadON<46> openDVS_pixel2x2_bot_925/GndD DiffBn
+ VSUBS VDD OnBn openDVS_pixel2x2_bot
XopenDVS_pixel2x2_bot_496 rowReadOFF<60> rowReadOFF<61> rowReadON<61> RefrBp PrBp
+ PrSFBp col_periphery_1x2_26/COL_LINE0 pixRst<4> pixRst<5> col_periphery_1x2_26/COL_LINE1
+ OffBn openDVS_pixel2x2_bot_496/vpd[2] openDVS_pixel2x2_bot_496/vpd[3] openDVS_pixel2x2_bot_496/vpd[1]
+ openDVS_pixel2x2_bot_496/vpd[0] rowReadON<60> openDVS_pixel2x2_bot_902/GndD DiffBn
+ VSUBS VDD OnBn openDVS_pixel2x2_bot
XopenDVS_pixel2x2_bot_430 rowReadOFF<38> rowReadOFF<39> rowReadON<39> RefrBp PrBp
+ PrSFBp col_periphery_1x2_22/COL_LINE0 pixRst<28> pixRst<29> col_periphery_1x2_22/COL_LINE1
+ OffBn openDVS_pixel2x2_bot_430/vpd[2] openDVS_pixel2x2_bot_430/vpd[3] openDVS_pixel2x2_bot_430/vpd[1]
+ openDVS_pixel2x2_bot_430/vpd[0] rowReadON<38> openDVS_pixel2x2_bot_999/GndD DiffBn
+ VSUBS VDD OnBn openDVS_pixel2x2_bot
XopenDVS_pixel2x2_bot_463 rowReadOFF<40> rowReadOFF<41> rowReadON<41> RefrBp PrBp
+ PrSFBp col_periphery_1x2_30/COL_LINE0 pixRst<12> pixRst<13> col_periphery_1x2_30/COL_LINE1
+ OffBn openDVS_pixel2x2_bot_463/vpd[2] openDVS_pixel2x2_bot_463/vpd[3] openDVS_pixel2x2_bot_463/vpd[1]
+ openDVS_pixel2x2_bot_463/vpd[0] rowReadON<40> openDVS_pixel2x2_bot_906/GndD DiffBn
+ VSUBS VDD OnBn openDVS_pixel2x2_bot
XopenDVS_pixel2x2_bot_441 rowReadOFF<34> rowReadOFF<35> rowReadON<35> RefrBp PrBp
+ PrSFBp col_periphery_1x2_30/COL_LINE0 pixRst<12> pixRst<13> col_periphery_1x2_30/COL_LINE1
+ OffBn openDVS_pixel2x2_bot_441/vpd[2] openDVS_pixel2x2_bot_441/vpd[3] openDVS_pixel2x2_bot_441/vpd[1]
+ openDVS_pixel2x2_bot_441/vpd[0] rowReadON<34> openDVS_pixel2x2_bot_995/GndD DiffBn
+ VSUBS VDD OnBn openDVS_pixel2x2_bot
XopenDVS_pixel2x2_bot_452 rowReadOFF<42> rowReadOFF<43> rowReadON<43> RefrBp PrBp
+ PrSFBp col_periphery_1x2_26/COL_LINE0 pixRst<4> pixRst<5> col_periphery_1x2_26/COL_LINE1
+ OffBn openDVS_pixel2x2_bot_452/vpd[2] openDVS_pixel2x2_bot_452/vpd[3] openDVS_pixel2x2_bot_452/vpd[1]
+ openDVS_pixel2x2_bot_452/vpd[0] rowReadON<42> openDVS_pixel2x2_bot_908/GndD DiffBn
+ VSUBS VDD OnBn openDVS_pixel2x2_bot
XopenDVS_pixel2x2_bot_474 rowReadOFF<38> rowReadOFF<39> rowReadON<39> RefrBp PrBp
+ PrSFBp col_periphery_1x2_25/COL_LINE0 pixRst<2> pixRst<3> col_periphery_1x2_25/COL_LINE1
+ OffBn openDVS_pixel2x2_bot_474/vpd[2] openDVS_pixel2x2_bot_474/vpd[3] openDVS_pixel2x2_bot_474/vpd[1]
+ openDVS_pixel2x2_bot_474/vpd[0] rowReadON<38> openDVS_pixel2x2_bot_999/GndD DiffBn
+ VSUBS VDD OnBn openDVS_pixel2x2_bot
XopenDVS_pixel2x2_bot_485 rowReadOFF<34> rowReadOFF<35> rowReadON<35> RefrBp PrBp
+ PrSFBp col_periphery_1x2_25/COL_LINE0 pixRst<2> pixRst<3> col_periphery_1x2_25/COL_LINE1
+ OffBn openDVS_pixel2x2_bot_485/vpd[2] openDVS_pixel2x2_bot_485/vpd[3] openDVS_pixel2x2_bot_485/vpd[1]
+ openDVS_pixel2x2_bot_485/vpd[0] rowReadON<34> openDVS_pixel2x2_bot_995/GndD DiffBn
+ VSUBS VDD OnBn openDVS_pixel2x2_bot
XopenDVS_pixel2x2_bot_271 rowReadOFF<20> rowReadOFF<21> rowReadON<21> RefrBp PrBp
+ PrSFBp col_periphery_1x2_29/COL_LINE0 pixRst<10> pixRst<11> col_periphery_1x2_29/COL_LINE1
+ OffBn openDVS_pixel2x2_bot_271/vpd[2] openDVS_pixel2x2_bot_271/vpd[3] openDVS_pixel2x2_bot_271/vpd[1]
+ openDVS_pixel2x2_bot_271/vpd[0] rowReadON<20> openDVS_pixel2x2_bot_95/GndD DiffBn
+ VSUBS VDD OnBn openDVS_pixel2x2_bot
XopenDVS_pixel2x2_bot_260 rowReadOFF<14> rowReadOFF<15> rowReadON<15> RefrBp PrBp
+ PrSFBp col_periphery_1x2_25/COL_LINE0 pixRst<2> pixRst<3> col_periphery_1x2_25/COL_LINE1
+ OffBn openDVS_pixel2x2_bot_260/vpd[2] openDVS_pixel2x2_bot_260/vpd[3] openDVS_pixel2x2_bot_260/vpd[1]
+ openDVS_pixel2x2_bot_260/vpd[0] rowReadON<14> openDVS_pixel2x2_bot_78/GndD DiffBn
+ VSUBS VDD OnBn openDVS_pixel2x2_bot
XopenDVS_pixel2x2_bot_282 rowReadOFF<10> rowReadOFF<11> rowReadON<11> RefrBp PrBp
+ PrSFBp col_periphery_1x2_25/COL_LINE0 pixRst<2> pixRst<3> col_periphery_1x2_25/COL_LINE1
+ OffBn openDVS_pixel2x2_bot_282/vpd[2] openDVS_pixel2x2_bot_282/vpd[3] openDVS_pixel2x2_bot_282/vpd[1]
+ openDVS_pixel2x2_bot_282/vpd[0] rowReadON<10> openDVS_pixel2x2_bot_82/GndD DiffBn
+ VSUBS VDD OnBn openDVS_pixel2x2_bot
XopenDVS_pixel2x2_bot_293 rowReadOFF<10> rowReadOFF<11> rowReadON<11> RefrBp PrBp
+ PrSFBp col_periphery_1x2_20/COL_LINE0 pixRst<24> pixRst<25> col_periphery_1x2_20/COL_LINE1
+ OffBn openDVS_pixel2x2_bot_293/vpd[2] openDVS_pixel2x2_bot_293/vpd[3] openDVS_pixel2x2_bot_293/vpd[1]
+ openDVS_pixel2x2_bot_293/vpd[0] rowReadON<10> openDVS_pixel2x2_bot_82/GndD DiffBn
+ VSUBS VDD OnBn openDVS_pixel2x2_bot
XopenDVS_pixel2x2_bot_6 rowReadOFF<4> rowReadOFF<5> rowReadON<5> RefrBp PrBp PrSFBp
+ col_periphery_1x2_6/COL_LINE0 pixRst<62> pixRst<63> col_periphery_1x2_6/COL_LINE1
+ OffBn openDVS_pixel2x2_bot_6/vpd[2] openDVS_pixel2x2_bot_6/vpd[3] openDVS_pixel2x2_bot_6/vpd[1]
+ openDVS_pixel2x2_bot_6/vpd[0] rowReadON<4> openDVS_pixel2x2_bot_6/GndD DiffBn VSUBS
+ VDD OnBn openDVS_pixel2x2_bot
Xcol_periphery_1x2_17 pixRst<19> col_periphery_1x2_17/COL_LINE0 col_periphery_1x2_17/COL_LINE1
+ nDETECT DETECT col_periphery_1x2_9/VDD VTHRESH pixRst<18> voutn<18> VSUBS voutn<19>
+ NCHARGE col_periphery_1x2
Xcol_periphery_1x2_28 pixRst<9> col_periphery_1x2_28/COL_LINE0 col_periphery_1x2_28/COL_LINE1
+ nDETECT DETECT col_periphery_1x2_9/VDD VTHRESH pixRst<8> voutn<8> VSUBS voutn<9>
+ NCHARGE col_periphery_1x2
XopenDVS_pixel2x2_bot_848 rowReadOFF<62> rowReadOFF<63> rowReadON<63> RefrBp PrBp
+ PrSFBp col_periphery_1x2_1/COL_LINE0 pixRst<52> pixRst<53> col_periphery_1x2_1/COL_LINE1
+ OffBn openDVS_pixel2x2_bot_848/vpd[2] openDVS_pixel2x2_bot_848/vpd[3] openDVS_pixel2x2_bot_848/vpd[1]
+ openDVS_pixel2x2_bot_848/vpd[0] rowReadON<62> openDVS_pixel2x2_bot_886/GndD DiffBn
+ VSUBS VDD OnBn openDVS_pixel2x2_bot
XopenDVS_pixel2x2_bot_826 rowReadOFF<52> rowReadOFF<53> rowReadON<53> RefrBp PrBp
+ PrSFBp col_periphery_1x2_6/COL_LINE0 pixRst<62> pixRst<63> col_periphery_1x2_6/COL_LINE1
+ OffBn openDVS_pixel2x2_bot_826/vpd[2] openDVS_pixel2x2_bot_826/vpd[3] openDVS_pixel2x2_bot_826/vpd[1]
+ openDVS_pixel2x2_bot_826/vpd[0] rowReadON<52> openDVS_pixel2x2_bot_882/GndD DiffBn
+ VSUBS VDD OnBn openDVS_pixel2x2_bot
XopenDVS_pixel2x2_bot_837 rowReadOFF<46> rowReadOFF<47> rowReadON<47> RefrBp PrBp
+ PrSFBp col_periphery_1x2_6/COL_LINE0 pixRst<62> pixRst<63> col_periphery_1x2_6/COL_LINE1
+ OffBn openDVS_pixel2x2_bot_837/vpd[2] openDVS_pixel2x2_bot_837/vpd[3] openDVS_pixel2x2_bot_837/vpd[1]
+ openDVS_pixel2x2_bot_837/vpd[0] rowReadON<46> openDVS_pixel2x2_bot_925/GndD DiffBn
+ VSUBS VDD OnBn openDVS_pixel2x2_bot
XopenDVS_pixel2x2_bot_859 rowReadOFF<48> rowReadOFF<49> rowReadON<49> RefrBp PrBp
+ PrSFBp col_periphery_1x2_1/COL_LINE0 pixRst<52> pixRst<53> col_periphery_1x2_1/COL_LINE1
+ OffBn openDVS_pixel2x2_bot_859/vpd[2] openDVS_pixel2x2_bot_859/vpd[3] openDVS_pixel2x2_bot_859/vpd[1]
+ openDVS_pixel2x2_bot_859/vpd[0] rowReadON<48> openDVS_pixel2x2_bot_927/GndD DiffBn
+ VSUBS VDD OnBn openDVS_pixel2x2_bot
XopenDVS_pixel2x2_bot_815 rowReadOFF<52> rowReadOFF<53> rowReadON<53> RefrBp PrBp
+ PrSFBp col_periphery_1x2_12/COL_LINE0 pixRst<38> pixRst<39> col_periphery_1x2_12/COL_LINE1
+ OffBn openDVS_pixel2x2_bot_815/vpd[2] openDVS_pixel2x2_bot_815/vpd[3] openDVS_pixel2x2_bot_815/vpd[1]
+ openDVS_pixel2x2_bot_815/vpd[0] rowReadON<52> openDVS_pixel2x2_bot_882/GndD DiffBn
+ VSUBS VDD OnBn openDVS_pixel2x2_bot
XopenDVS_pixel2x2_bot_804 rowReadOFF<46> rowReadOFF<47> rowReadON<47> RefrBp PrBp
+ PrSFBp col_periphery_1x2_11/COL_LINE0 pixRst<36> pixRst<37> col_periphery_1x2_11/COL_LINE1
+ OffBn openDVS_pixel2x2_bot_804/vpd[2] openDVS_pixel2x2_bot_804/vpd[3] openDVS_pixel2x2_bot_804/vpd[1]
+ openDVS_pixel2x2_bot_804/vpd[0] rowReadON<46> openDVS_pixel2x2_bot_925/GndD DiffBn
+ VSUBS VDD OnBn openDVS_pixel2x2_bot
XopenDVS_pixel2x2_bot_634 rowReadOFF<58> rowReadOFF<59> rowReadON<59> RefrBp PrBp
+ PrSFBp col_periphery_1x2_31/COL_LINE0 pixRst<14> pixRst<15> col_periphery_1x2_31/COL_LINE1
+ OffBn openDVS_pixel2x2_bot_634/vpd[2] openDVS_pixel2x2_bot_634/vpd[3] openDVS_pixel2x2_bot_634/vpd[1]
+ openDVS_pixel2x2_bot_634/vpd[0] rowReadON<58> openDVS_pixel2x2_bot_890/GndD DiffBn
+ VSUBS VDD OnBn openDVS_pixel2x2_bot
XopenDVS_pixel2x2_bot_601 rowReadOFF<46> rowReadOFF<47> rowReadON<47> RefrBp PrBp
+ PrSFBp col_periphery_1x2_20/COL_LINE0 pixRst<24> pixRst<25> col_periphery_1x2_20/COL_LINE1
+ OffBn openDVS_pixel2x2_bot_601/vpd[2] openDVS_pixel2x2_bot_601/vpd[3] openDVS_pixel2x2_bot_601/vpd[1]
+ openDVS_pixel2x2_bot_601/vpd[0] rowReadON<46> openDVS_pixel2x2_bot_925/GndD DiffBn
+ VSUBS VDD OnBn openDVS_pixel2x2_bot
XopenDVS_pixel2x2_bot_656 rowReadOFF<50> rowReadOFF<51> rowReadON<51> RefrBp PrBp
+ PrSFBp col_periphery_1x2_31/COL_LINE0 pixRst<14> pixRst<15> col_periphery_1x2_31/COL_LINE1
+ OffBn openDVS_pixel2x2_bot_656/vpd[2] openDVS_pixel2x2_bot_656/vpd[3] openDVS_pixel2x2_bot_656/vpd[1]
+ openDVS_pixel2x2_bot_656/vpd[0] rowReadON<50> openDVS_pixel2x2_bot_929/GndD DiffBn
+ VSUBS VDD OnBn openDVS_pixel2x2_bot
XopenDVS_pixel2x2_bot_623 rowReadOFF<44> rowReadOFF<45> rowReadON<45> RefrBp PrBp
+ PrSFBp col_periphery_1x2_30/COL_LINE0 pixRst<12> pixRst<13> col_periphery_1x2_30/COL_LINE1
+ OffBn openDVS_pixel2x2_bot_623/vpd[2] openDVS_pixel2x2_bot_623/vpd[3] openDVS_pixel2x2_bot_623/vpd[1]
+ openDVS_pixel2x2_bot_623/vpd[0] rowReadON<44> openDVS_pixel2x2_bot_923/GndD DiffBn
+ VSUBS VDD OnBn openDVS_pixel2x2_bot
XopenDVS_pixel2x2_bot_667 rowReadOFF<34> rowReadOFF<35> rowReadON<35> RefrBp PrBp
+ PrSFBp col_periphery_1x2_0/COL_LINE0 pixRst<50> pixRst<51> col_periphery_1x2_0/COL_LINE1
+ OffBn openDVS_pixel2x2_bot_667/vpd[2] openDVS_pixel2x2_bot_667/vpd[3] openDVS_pixel2x2_bot_667/vpd[1]
+ openDVS_pixel2x2_bot_667/vpd[0] rowReadON<34> openDVS_pixel2x2_bot_995/GndD DiffBn
+ VSUBS VDD OnBn openDVS_pixel2x2_bot
XopenDVS_pixel2x2_bot_612 rowReadOFF<42> rowReadOFF<43> rowReadON<43> RefrBp PrBp
+ PrSFBp col_periphery_1x2_16/COL_LINE0 pixRst<16> pixRst<17> col_periphery_1x2_16/COL_LINE1
+ OffBn openDVS_pixel2x2_bot_612/vpd[2] openDVS_pixel2x2_bot_612/vpd[3] openDVS_pixel2x2_bot_612/vpd[1]
+ openDVS_pixel2x2_bot_612/vpd[0] rowReadON<42> openDVS_pixel2x2_bot_908/GndD DiffBn
+ VSUBS VDD OnBn openDVS_pixel2x2_bot
XopenDVS_pixel2x2_bot_645 rowReadOFF<34> rowReadOFF<35> rowReadON<35> RefrBp PrBp
+ PrSFBp col_periphery_1x2_16/COL_LINE0 pixRst<16> pixRst<17> col_periphery_1x2_16/COL_LINE1
+ OffBn openDVS_pixel2x2_bot_645/vpd[2] openDVS_pixel2x2_bot_645/vpd[3] openDVS_pixel2x2_bot_645/vpd[1]
+ openDVS_pixel2x2_bot_645/vpd[0] rowReadON<34> openDVS_pixel2x2_bot_995/GndD DiffBn
+ VSUBS VDD OnBn openDVS_pixel2x2_bot
XopenDVS_pixel2x2_bot_678 rowReadOFF<28> rowReadOFF<29> rowReadON<29> RefrBp PrBp
+ PrSFBp col_periphery_1x2_6/COL_LINE0 pixRst<62> pixRst<63> col_periphery_1x2_6/COL_LINE1
+ OffBn openDVS_pixel2x2_bot_678/vpd[2] openDVS_pixel2x2_bot_678/vpd[3] openDVS_pixel2x2_bot_678/vpd[1]
+ openDVS_pixel2x2_bot_678/vpd[0] rowReadON<28> openDVS_pixel2x2_bot_989/GndD DiffBn
+ VSUBS VDD OnBn openDVS_pixel2x2_bot
XopenDVS_pixel2x2_bot_689 rowReadOFF<30> rowReadOFF<31> rowReadON<31> RefrBp PrBp
+ PrSFBp col_periphery_1x2_0/COL_LINE0 pixRst<50> pixRst<51> col_periphery_1x2_0/COL_LINE1
+ OffBn openDVS_pixel2x2_bot_689/vpd[2] openDVS_pixel2x2_bot_689/vpd[3] openDVS_pixel2x2_bot_689/vpd[1]
+ openDVS_pixel2x2_bot_689/vpd[0] rowReadON<30> openDVS_pixel2x2_bot_991/GndD DiffBn
+ VSUBS VDD OnBn openDVS_pixel2x2_bot
XopenDVS_pixel2x2_bot_98 rowReadOFF<24> rowReadOFF<25> rowReadON<25> RefrBp PrBp PrSFBp
+ col_periphery_1x2_5/COL_LINE0 pixRst<60> pixRst<61> col_periphery_1x2_5/COL_LINE1
+ OffBn openDVS_pixel2x2_bot_98/vpd[2] openDVS_pixel2x2_bot_98/vpd[3] openDVS_pixel2x2_bot_98/vpd[1]
+ openDVS_pixel2x2_bot_98/vpd[0] rowReadON<24> openDVS_pixel2x2_bot_99/GndD DiffBn
+ VSUBS VDD OnBn openDVS_pixel2x2_bot
XopenDVS_pixel2x2_bot_87 rowReadOFF<16> rowReadOFF<17> rowReadON<17> RefrBp PrBp PrSFBp
+ col_periphery_1x2_2/COL_LINE0 pixRst<54> pixRst<55> col_periphery_1x2_2/COL_LINE1
+ OffBn openDVS_pixel2x2_bot_87/vpd[2] openDVS_pixel2x2_bot_87/vpd[3] openDVS_pixel2x2_bot_87/vpd[1]
+ openDVS_pixel2x2_bot_87/vpd[0] rowReadON<16> openDVS_pixel2x2_bot_91/GndD DiffBn
+ VSUBS VDD OnBn openDVS_pixel2x2_bot
XopenDVS_pixel2x2_bot_76 rowReadOFF<20> rowReadOFF<21> rowReadON<21> RefrBp PrBp PrSFBp
+ col_periphery_1x2_8/COL_LINE0 pixRst<42> pixRst<43> col_periphery_1x2_8/COL_LINE1
+ OffBn openDVS_pixel2x2_bot_76/vpd[2] openDVS_pixel2x2_bot_76/vpd[3] openDVS_pixel2x2_bot_76/vpd[1]
+ openDVS_pixel2x2_bot_76/vpd[0] rowReadON<20> openDVS_pixel2x2_bot_95/GndD DiffBn
+ VSUBS VDD OnBn openDVS_pixel2x2_bot
XopenDVS_pixel2x2_bot_54 rowReadOFF<14> rowReadOFF<15> rowReadON<15> RefrBp PrBp PrSFBp
+ col_periphery_1x2_13/COL_LINE0 pixRst<44> pixRst<45> col_periphery_1x2_13/COL_LINE1
+ OffBn openDVS_pixel2x2_bot_54/vpd[2] openDVS_pixel2x2_bot_54/vpd[3] openDVS_pixel2x2_bot_54/vpd[1]
+ openDVS_pixel2x2_bot_54/vpd[0] rowReadON<14> openDVS_pixel2x2_bot_78/GndD DiffBn
+ VSUBS VDD OnBn openDVS_pixel2x2_bot
XopenDVS_pixel2x2_bot_65 rowReadOFF<18> rowReadOFF<19> rowReadON<19> RefrBp PrBp PrSFBp
+ col_periphery_1x2_11/COL_LINE0 pixRst<36> pixRst<37> col_periphery_1x2_11/COL_LINE1
+ OffBn openDVS_pixel2x2_bot_65/vpd[2] openDVS_pixel2x2_bot_65/vpd[3] openDVS_pixel2x2_bot_65/vpd[1]
+ openDVS_pixel2x2_bot_65/vpd[0] rowReadON<18> openDVS_pixel2x2_bot_69/GndD DiffBn
+ VSUBS VDD OnBn openDVS_pixel2x2_bot
XopenDVS_pixel2x2_bot_21 rowReadOFF<0> rowReadOFF<1> rowReadON<1> RefrBp PrBp PrSFBp
+ col_periphery_1x2_11/COL_LINE0 pixRst<36> pixRst<37> col_periphery_1x2_11/COL_LINE1
+ OffBn openDVS_pixel2x2_bot_21/vpd[2] openDVS_pixel2x2_bot_21/vpd[3] openDVS_pixel2x2_bot_21/vpd[1]
+ openDVS_pixel2x2_bot_21/vpd[0] rowReadON<0> GND DiffBn VSUBS VDD OnBn openDVS_pixel2x2_bot
XopenDVS_pixel2x2_bot_10 rowReadOFF<0> rowReadOFF<1> rowReadON<1> RefrBp PrBp PrSFBp
+ col_periphery_1x2_2/COL_LINE0 pixRst<54> pixRst<55> col_periphery_1x2_2/COL_LINE1
+ OffBn openDVS_pixel2x2_bot_10/vpd[2] openDVS_pixel2x2_bot_10/vpd[3] openDVS_pixel2x2_bot_10/vpd[1]
+ openDVS_pixel2x2_bot_10/vpd[0] rowReadON<0> GND DiffBn VSUBS VDD OnBn openDVS_pixel2x2_bot
XopenDVS_pixel2x2_bot_32 rowReadOFF<4> rowReadOFF<5> rowReadON<5> RefrBp PrBp PrSFBp
+ col_periphery_1x2_10/COL_LINE0 pixRst<34> pixRst<35> col_periphery_1x2_10/COL_LINE1
+ OffBn openDVS_pixel2x2_bot_32/vpd[2] openDVS_pixel2x2_bot_32/vpd[3] openDVS_pixel2x2_bot_32/vpd[1]
+ openDVS_pixel2x2_bot_32/vpd[0] rowReadON<4> openDVS_pixel2x2_bot_6/GndD DiffBn VSUBS
+ VDD OnBn openDVS_pixel2x2_bot
XopenDVS_pixel2x2_bot_43 rowReadOFF<10> rowReadOFF<11> rowReadON<11> RefrBp PrBp PrSFBp
+ col_periphery_1x2_8/COL_LINE0 pixRst<42> pixRst<43> col_periphery_1x2_8/COL_LINE1
+ OffBn openDVS_pixel2x2_bot_43/vpd[2] openDVS_pixel2x2_bot_43/vpd[3] openDVS_pixel2x2_bot_43/vpd[1]
+ openDVS_pixel2x2_bot_43/vpd[0] rowReadON<10> openDVS_pixel2x2_bot_82/GndD DiffBn
+ VSUBS VDD OnBn openDVS_pixel2x2_bot
XopenDVS_pixel2x2_bot_1018 rowReadOFF<58> rowReadOFF<59> rowReadON<59> RefrBp PrBp
+ PrSFBp col_periphery_1x2_23/COL_LINE0 pixRst<30> pixRst<31> col_periphery_1x2_23/COL_LINE1
+ OffBn openDVS_pixel2x2_bot_1018/vpd[2] openDVS_pixel2x2_bot_1018/vpd[3] openDVS_pixel2x2_bot_1018/vpd[1]
+ openDVS_pixel2x2_bot_1018/vpd[0] rowReadON<58> openDVS_pixel2x2_bot_890/GndD DiffBn
+ VSUBS VDD OnBn openDVS_pixel2x2_bot
XopenDVS_pixel2x2_bot_1007 rowReadOFF<46> rowReadOFF<47> rowReadON<47> RefrBp PrBp
+ PrSFBp col_periphery_1x2_9/COL_LINE0 pixRst<32> pixRst<33> col_periphery_1x2_9/COL_LINE1
+ OffBn openDVS_pixel2x2_bot_1007/vpd[2] openDVS_pixel2x2_bot_1007/vpd[3] openDVS_pixel2x2_bot_1007/vpd[1]
+ openDVS_pixel2x2_bot_1007/vpd[0] rowReadON<46> openDVS_pixel2x2_bot_925/GndD DiffBn
+ VSUBS VDD OnBn openDVS_pixel2x2_bot
XopenDVS_pixel2x2_bot_497 rowReadOFF<60> rowReadOFF<61> rowReadON<61> RefrBp PrBp
+ PrSFBp col_periphery_1x2_27/COL_LINE0 pixRst<6> pixRst<7> col_periphery_1x2_27/COL_LINE1
+ OffBn openDVS_pixel2x2_bot_497/vpd[2] openDVS_pixel2x2_bot_497/vpd[3] openDVS_pixel2x2_bot_497/vpd[1]
+ openDVS_pixel2x2_bot_497/vpd[0] rowReadON<60> openDVS_pixel2x2_bot_902/GndD DiffBn
+ VSUBS VDD OnBn openDVS_pixel2x2_bot
XopenDVS_pixel2x2_bot_431 rowReadOFF<40> rowReadOFF<41> rowReadON<41> RefrBp PrBp
+ PrSFBp col_periphery_1x2_21/COL_LINE0 pixRst<26> pixRst<27> col_periphery_1x2_21/COL_LINE1
+ OffBn openDVS_pixel2x2_bot_431/vpd[2] openDVS_pixel2x2_bot_431/vpd[3] openDVS_pixel2x2_bot_431/vpd[1]
+ openDVS_pixel2x2_bot_431/vpd[0] rowReadON<40> openDVS_pixel2x2_bot_906/GndD DiffBn
+ VSUBS VDD OnBn openDVS_pixel2x2_bot
XopenDVS_pixel2x2_bot_453 rowReadOFF<42> rowReadOFF<43> rowReadON<43> RefrBp PrBp
+ PrSFBp col_periphery_1x2_27/COL_LINE0 pixRst<6> pixRst<7> col_periphery_1x2_27/COL_LINE1
+ OffBn openDVS_pixel2x2_bot_453/vpd[2] openDVS_pixel2x2_bot_453/vpd[3] openDVS_pixel2x2_bot_453/vpd[1]
+ openDVS_pixel2x2_bot_453/vpd[0] rowReadON<42> openDVS_pixel2x2_bot_908/GndD DiffBn
+ VSUBS VDD OnBn openDVS_pixel2x2_bot
XopenDVS_pixel2x2_bot_442 rowReadOFF<36> rowReadOFF<37> rowReadON<37> RefrBp PrBp
+ PrSFBp col_periphery_1x2_26/COL_LINE0 pixRst<4> pixRst<5> col_periphery_1x2_26/COL_LINE1
+ OffBn openDVS_pixel2x2_bot_442/vpd[2] openDVS_pixel2x2_bot_442/vpd[3] openDVS_pixel2x2_bot_442/vpd[1]
+ openDVS_pixel2x2_bot_442/vpd[0] rowReadON<36> openDVS_pixel2x2_bot_997/GndD DiffBn
+ VSUBS VDD OnBn openDVS_pixel2x2_bot
XopenDVS_pixel2x2_bot_475 rowReadOFF<38> rowReadOFF<39> rowReadON<39> RefrBp PrBp
+ PrSFBp col_periphery_1x2_26/COL_LINE0 pixRst<4> pixRst<5> col_periphery_1x2_26/COL_LINE1
+ OffBn openDVS_pixel2x2_bot_475/vpd[2] openDVS_pixel2x2_bot_475/vpd[3] openDVS_pixel2x2_bot_475/vpd[1]
+ openDVS_pixel2x2_bot_475/vpd[0] rowReadON<38> openDVS_pixel2x2_bot_999/GndD DiffBn
+ VSUBS VDD OnBn openDVS_pixel2x2_bot
XopenDVS_pixel2x2_bot_486 rowReadOFF<34> rowReadOFF<35> rowReadON<35> RefrBp PrBp
+ PrSFBp col_periphery_1x2_26/COL_LINE0 pixRst<4> pixRst<5> col_periphery_1x2_26/COL_LINE1
+ OffBn openDVS_pixel2x2_bot_486/vpd[2] openDVS_pixel2x2_bot_486/vpd[3] openDVS_pixel2x2_bot_486/vpd[1]
+ openDVS_pixel2x2_bot_486/vpd[0] rowReadON<34> openDVS_pixel2x2_bot_995/GndD DiffBn
+ VSUBS VDD OnBn openDVS_pixel2x2_bot
XopenDVS_pixel2x2_bot_464 rowReadOFF<40> rowReadOFF<41> rowReadON<41> RefrBp PrBp
+ PrSFBp col_periphery_1x2_24/COL_LINE0 pixRst<0> pixRst<1> col_periphery_1x2_24/COL_LINE1
+ OffBn openDVS_pixel2x2_bot_464/vpd[2] openDVS_pixel2x2_bot_464/vpd[3] openDVS_pixel2x2_bot_464/vpd[1]
+ openDVS_pixel2x2_bot_464/vpd[0] rowReadON<40> openDVS_pixel2x2_bot_906/GndD DiffBn
+ VSUBS VDD OnBn openDVS_pixel2x2_bot
XopenDVS_pixel2x2_bot_420 rowReadOFF<28> rowReadOFF<29> rowReadON<29> RefrBp PrBp
+ PrSFBp col_periphery_1x2_22/COL_LINE0 pixRst<28> pixRst<29> col_periphery_1x2_22/COL_LINE1
+ OffBn openDVS_pixel2x2_bot_420/vpd[2] openDVS_pixel2x2_bot_420/vpd[3] openDVS_pixel2x2_bot_420/vpd[1]
+ openDVS_pixel2x2_bot_420/vpd[0] rowReadON<28> openDVS_pixel2x2_bot_989/GndD DiffBn
+ VSUBS VDD OnBn openDVS_pixel2x2_bot
XopenDVS_pixel2x2_bot_272 rowReadOFF<20> rowReadOFF<21> rowReadON<21> RefrBp PrBp
+ PrSFBp col_periphery_1x2_30/COL_LINE0 pixRst<12> pixRst<13> col_periphery_1x2_30/COL_LINE1
+ OffBn openDVS_pixel2x2_bot_272/vpd[2] openDVS_pixel2x2_bot_272/vpd[3] openDVS_pixel2x2_bot_272/vpd[1]
+ openDVS_pixel2x2_bot_272/vpd[0] rowReadON<20> openDVS_pixel2x2_bot_95/GndD DiffBn
+ VSUBS VDD OnBn openDVS_pixel2x2_bot
XopenDVS_pixel2x2_bot_261 rowReadOFF<14> rowReadOFF<15> rowReadON<15> RefrBp PrBp
+ PrSFBp col_periphery_1x2_26/COL_LINE0 pixRst<4> pixRst<5> col_periphery_1x2_26/COL_LINE1
+ OffBn openDVS_pixel2x2_bot_261/vpd[2] openDVS_pixel2x2_bot_261/vpd[3] openDVS_pixel2x2_bot_261/vpd[1]
+ openDVS_pixel2x2_bot_261/vpd[0] rowReadON<14> openDVS_pixel2x2_bot_78/GndD DiffBn
+ VSUBS VDD OnBn openDVS_pixel2x2_bot
XopenDVS_pixel2x2_bot_250 rowReadOFF<20> rowReadOFF<21> rowReadON<21> RefrBp PrBp
+ PrSFBp col_periphery_1x2_24/COL_LINE0 pixRst<0> pixRst<1> col_periphery_1x2_24/COL_LINE1
+ OffBn openDVS_pixel2x2_bot_250/vpd[2] openDVS_pixel2x2_bot_250/vpd[3] openDVS_pixel2x2_bot_250/vpd[1]
+ openDVS_pixel2x2_bot_250/vpd[0] rowReadON<20> openDVS_pixel2x2_bot_95/GndD DiffBn
+ VSUBS VDD OnBn openDVS_pixel2x2_bot
XopenDVS_pixel2x2_bot_283 rowReadOFF<10> rowReadOFF<11> rowReadON<11> RefrBp PrBp
+ PrSFBp col_periphery_1x2_26/COL_LINE0 pixRst<4> pixRst<5> col_periphery_1x2_26/COL_LINE1
+ OffBn openDVS_pixel2x2_bot_283/vpd[2] openDVS_pixel2x2_bot_283/vpd[3] openDVS_pixel2x2_bot_283/vpd[1]
+ openDVS_pixel2x2_bot_283/vpd[0] rowReadON<10> openDVS_pixel2x2_bot_82/GndD DiffBn
+ VSUBS VDD OnBn openDVS_pixel2x2_bot
XopenDVS_pixel2x2_bot_294 rowReadOFF<10> rowReadOFF<11> rowReadON<11> RefrBp PrBp
+ PrSFBp col_periphery_1x2_21/COL_LINE0 pixRst<26> pixRst<27> col_periphery_1x2_21/COL_LINE1
+ OffBn openDVS_pixel2x2_bot_294/vpd[2] openDVS_pixel2x2_bot_294/vpd[3] openDVS_pixel2x2_bot_294/vpd[1]
+ openDVS_pixel2x2_bot_294/vpd[0] rowReadON<10> openDVS_pixel2x2_bot_82/GndD DiffBn
+ VSUBS VDD OnBn openDVS_pixel2x2_bot
XopenDVS_pixel2x2_bot_7 rowReadOFF<2> rowReadOFF<3> rowReadON<3> RefrBp PrBp PrSFBp
+ col_periphery_1x2_2/COL_LINE0 pixRst<54> pixRst<55> col_periphery_1x2_2/COL_LINE1
+ OffBn openDVS_pixel2x2_bot_7/vpd[2] openDVS_pixel2x2_bot_7/vpd[3] openDVS_pixel2x2_bot_7/vpd[1]
+ openDVS_pixel2x2_bot_7/vpd[0] rowReadON<2> openDVS_pixel2x2_bot_7/GndD DiffBn VSUBS
+ VDD OnBn openDVS_pixel2x2_bot
Xcol_periphery_1x2_18 pixRst<21> col_periphery_1x2_18/COL_LINE0 col_periphery_1x2_18/COL_LINE1
+ nDETECT DETECT col_periphery_1x2_9/VDD VTHRESH pixRst<20> voutn<20> VSUBS voutn<21>
+ NCHARGE col_periphery_1x2
Xcol_periphery_1x2_29 pixRst<11> col_periphery_1x2_29/COL_LINE0 col_periphery_1x2_29/COL_LINE1
+ nDETECT DETECT col_periphery_1x2_9/VDD VTHRESH pixRst<10> voutn<10> VSUBS voutn<11>
+ NCHARGE col_periphery_1x2
XopenDVS_pixel2x2_bot_827 rowReadOFF<60> rowReadOFF<61> rowReadON<61> RefrBp PrBp
+ PrSFBp col_periphery_1x2_4/COL_LINE0 pixRst<58> pixRst<59> col_periphery_1x2_4/COL_LINE1
+ OffBn openDVS_pixel2x2_bot_827/vpd[2] openDVS_pixel2x2_bot_827/vpd[3] openDVS_pixel2x2_bot_827/vpd[1]
+ openDVS_pixel2x2_bot_827/vpd[0] rowReadON<60> openDVS_pixel2x2_bot_902/GndD DiffBn
+ VSUBS VDD OnBn openDVS_pixel2x2_bot
XopenDVS_pixel2x2_bot_849 rowReadOFF<62> rowReadOFF<63> rowReadON<63> RefrBp PrBp
+ PrSFBp col_periphery_1x2_2/COL_LINE0 pixRst<54> pixRst<55> col_periphery_1x2_2/COL_LINE1
+ OffBn openDVS_pixel2x2_bot_849/vpd[2] openDVS_pixel2x2_bot_849/vpd[3] openDVS_pixel2x2_bot_849/vpd[1]
+ openDVS_pixel2x2_bot_849/vpd[0] rowReadON<62> openDVS_pixel2x2_bot_886/GndD DiffBn
+ VSUBS VDD OnBn openDVS_pixel2x2_bot
XopenDVS_pixel2x2_bot_838 rowReadOFF<62> rowReadOFF<63> rowReadON<63> RefrBp PrBp
+ PrSFBp col_periphery_1x2_0/COL_LINE0 pixRst<50> pixRst<51> col_periphery_1x2_0/COL_LINE1
+ OffBn openDVS_pixel2x2_bot_838/vpd[2] openDVS_pixel2x2_bot_838/vpd[3] openDVS_pixel2x2_bot_838/vpd[1]
+ openDVS_pixel2x2_bot_838/vpd[0] rowReadON<62> openDVS_pixel2x2_bot_886/GndD DiffBn
+ VSUBS VDD OnBn openDVS_pixel2x2_bot
XopenDVS_pixel2x2_bot_816 rowReadOFF<52> rowReadOFF<53> rowReadON<53> RefrBp PrBp
+ PrSFBp col_periphery_1x2_7/COL_LINE0 pixRst<40> pixRst<41> col_periphery_1x2_7/COL_LINE1
+ OffBn openDVS_pixel2x2_bot_816/vpd[2] openDVS_pixel2x2_bot_816/vpd[3] openDVS_pixel2x2_bot_816/vpd[1]
+ openDVS_pixel2x2_bot_816/vpd[0] rowReadON<52> openDVS_pixel2x2_bot_882/GndD DiffBn
+ VSUBS VDD OnBn openDVS_pixel2x2_bot
XopenDVS_pixel2x2_bot_805 rowReadOFF<46> rowReadOFF<47> rowReadON<47> RefrBp PrBp
+ PrSFBp col_periphery_1x2_12/COL_LINE0 pixRst<38> pixRst<39> col_periphery_1x2_12/COL_LINE1
+ OffBn openDVS_pixel2x2_bot_805/vpd[2] openDVS_pixel2x2_bot_805/vpd[3] openDVS_pixel2x2_bot_805/vpd[1]
+ openDVS_pixel2x2_bot_805/vpd[0] rowReadON<46> openDVS_pixel2x2_bot_925/GndD DiffBn
+ VSUBS VDD OnBn openDVS_pixel2x2_bot
XopenDVS_pixel2x2_bot_635 rowReadOFF<58> rowReadOFF<59> rowReadON<59> RefrBp PrBp
+ PrSFBp col_periphery_1x2_16/COL_LINE0 pixRst<16> pixRst<17> col_periphery_1x2_16/COL_LINE1
+ OffBn openDVS_pixel2x2_bot_635/vpd[2] openDVS_pixel2x2_bot_635/vpd[3] openDVS_pixel2x2_bot_635/vpd[1]
+ openDVS_pixel2x2_bot_635/vpd[0] rowReadON<58> openDVS_pixel2x2_bot_890/GndD DiffBn
+ VSUBS VDD OnBn openDVS_pixel2x2_bot
XopenDVS_pixel2x2_bot_602 rowReadOFF<46> rowReadOFF<47> rowReadON<47> RefrBp PrBp
+ PrSFBp col_periphery_1x2_21/COL_LINE0 pixRst<26> pixRst<27> col_periphery_1x2_21/COL_LINE1
+ OffBn openDVS_pixel2x2_bot_602/vpd[2] openDVS_pixel2x2_bot_602/vpd[3] openDVS_pixel2x2_bot_602/vpd[1]
+ openDVS_pixel2x2_bot_602/vpd[0] rowReadON<46> openDVS_pixel2x2_bot_925/GndD DiffBn
+ VSUBS VDD OnBn openDVS_pixel2x2_bot
XopenDVS_pixel2x2_bot_657 rowReadOFF<50> rowReadOFF<51> rowReadON<51> RefrBp PrBp
+ PrSFBp col_periphery_1x2_16/COL_LINE0 pixRst<16> pixRst<17> col_periphery_1x2_16/COL_LINE1
+ OffBn openDVS_pixel2x2_bot_657/vpd[2] openDVS_pixel2x2_bot_657/vpd[3] openDVS_pixel2x2_bot_657/vpd[1]
+ openDVS_pixel2x2_bot_657/vpd[0] rowReadON<50> openDVS_pixel2x2_bot_929/GndD DiffBn
+ VSUBS VDD OnBn openDVS_pixel2x2_bot
XopenDVS_pixel2x2_bot_613 rowReadOFF<52> rowReadOFF<53> rowReadON<53> RefrBp PrBp
+ PrSFBp col_periphery_1x2_31/COL_LINE0 pixRst<14> pixRst<15> col_periphery_1x2_31/COL_LINE1
+ OffBn openDVS_pixel2x2_bot_613/vpd[2] openDVS_pixel2x2_bot_613/vpd[3] openDVS_pixel2x2_bot_613/vpd[1]
+ openDVS_pixel2x2_bot_613/vpd[0] rowReadON<52> openDVS_pixel2x2_bot_882/GndD DiffBn
+ VSUBS VDD OnBn openDVS_pixel2x2_bot
XopenDVS_pixel2x2_bot_624 rowReadOFF<44> rowReadOFF<45> rowReadON<45> RefrBp PrBp
+ PrSFBp col_periphery_1x2_31/COL_LINE0 pixRst<14> pixRst<15> col_periphery_1x2_31/COL_LINE1
+ OffBn openDVS_pixel2x2_bot_624/vpd[2] openDVS_pixel2x2_bot_624/vpd[3] openDVS_pixel2x2_bot_624/vpd[1]
+ openDVS_pixel2x2_bot_624/vpd[0] rowReadON<44> openDVS_pixel2x2_bot_923/GndD DiffBn
+ VSUBS VDD OnBn openDVS_pixel2x2_bot
XopenDVS_pixel2x2_bot_646 rowReadOFF<48> rowReadOFF<49> rowReadON<49> RefrBp PrBp
+ PrSFBp col_periphery_1x2_31/COL_LINE0 pixRst<14> pixRst<15> col_periphery_1x2_31/COL_LINE1
+ OffBn openDVS_pixel2x2_bot_646/vpd[2] openDVS_pixel2x2_bot_646/vpd[3] openDVS_pixel2x2_bot_646/vpd[1]
+ openDVS_pixel2x2_bot_646/vpd[0] rowReadON<48> openDVS_pixel2x2_bot_927/GndD DiffBn
+ VSUBS VDD OnBn openDVS_pixel2x2_bot
XopenDVS_pixel2x2_bot_679 rowReadOFF<34> rowReadOFF<35> rowReadON<35> RefrBp PrBp
+ PrSFBp col_periphery_1x2_5/COL_LINE0 pixRst<60> pixRst<61> col_periphery_1x2_5/COL_LINE1
+ OffBn openDVS_pixel2x2_bot_679/vpd[2] openDVS_pixel2x2_bot_679/vpd[3] openDVS_pixel2x2_bot_679/vpd[1]
+ openDVS_pixel2x2_bot_679/vpd[0] rowReadON<34> openDVS_pixel2x2_bot_995/GndD DiffBn
+ VSUBS VDD OnBn openDVS_pixel2x2_bot
XopenDVS_pixel2x2_bot_668 rowReadOFF<34> rowReadOFF<35> rowReadON<35> RefrBp PrBp
+ PrSFBp col_periphery_1x2_1/COL_LINE0 pixRst<52> pixRst<53> col_periphery_1x2_1/COL_LINE1
+ OffBn openDVS_pixel2x2_bot_668/vpd[2] openDVS_pixel2x2_bot_668/vpd[3] openDVS_pixel2x2_bot_668/vpd[1]
+ openDVS_pixel2x2_bot_668/vpd[0] rowReadON<34> openDVS_pixel2x2_bot_995/GndD DiffBn
+ VSUBS VDD OnBn openDVS_pixel2x2_bot
XopenDVS_pixel2x2_bot_99 rowReadOFF<24> rowReadOFF<25> rowReadON<25> RefrBp PrBp PrSFBp
+ col_periphery_1x2_6/COL_LINE0 pixRst<62> pixRst<63> col_periphery_1x2_6/COL_LINE1
+ OffBn openDVS_pixel2x2_bot_99/vpd[2] openDVS_pixel2x2_bot_99/vpd[3] openDVS_pixel2x2_bot_99/vpd[1]
+ openDVS_pixel2x2_bot_99/vpd[0] rowReadON<24> openDVS_pixel2x2_bot_99/GndD DiffBn
+ VSUBS VDD OnBn openDVS_pixel2x2_bot
XopenDVS_pixel2x2_bot_55 rowReadOFF<24> rowReadOFF<25> rowReadON<25> RefrBp PrBp PrSFBp
+ col_periphery_1x2_11/COL_LINE0 pixRst<36> pixRst<37> col_periphery_1x2_11/COL_LINE1
+ OffBn openDVS_pixel2x2_bot_55/vpd[2] openDVS_pixel2x2_bot_55/vpd[3] openDVS_pixel2x2_bot_55/vpd[1]
+ openDVS_pixel2x2_bot_55/vpd[0] rowReadON<24> openDVS_pixel2x2_bot_99/GndD DiffBn
+ VSUBS VDD OnBn openDVS_pixel2x2_bot
XopenDVS_pixel2x2_bot_88 rowReadOFF<16> rowReadOFF<17> rowReadON<17> RefrBp PrBp PrSFBp
+ col_periphery_1x2_3/COL_LINE0 pixRst<56> pixRst<57> col_periphery_1x2_3/COL_LINE1
+ OffBn openDVS_pixel2x2_bot_88/vpd[2] openDVS_pixel2x2_bot_88/vpd[3] openDVS_pixel2x2_bot_88/vpd[1]
+ openDVS_pixel2x2_bot_88/vpd[0] rowReadON<16> openDVS_pixel2x2_bot_91/GndD DiffBn
+ VSUBS VDD OnBn openDVS_pixel2x2_bot
XopenDVS_pixel2x2_bot_77 rowReadOFF<20> rowReadOFF<21> rowReadON<21> RefrBp PrBp PrSFBp
+ col_periphery_1x2_13/COL_LINE0 pixRst<44> pixRst<45> col_periphery_1x2_13/COL_LINE1
+ OffBn openDVS_pixel2x2_bot_77/vpd[2] openDVS_pixel2x2_bot_77/vpd[3] openDVS_pixel2x2_bot_77/vpd[1]
+ openDVS_pixel2x2_bot_77/vpd[0] rowReadON<20> openDVS_pixel2x2_bot_95/GndD DiffBn
+ VSUBS VDD OnBn openDVS_pixel2x2_bot
XopenDVS_pixel2x2_bot_66 rowReadOFF<18> rowReadOFF<19> rowReadON<19> RefrBp PrBp PrSFBp
+ col_periphery_1x2_12/COL_LINE0 pixRst<38> pixRst<39> col_periphery_1x2_12/COL_LINE1
+ OffBn openDVS_pixel2x2_bot_66/vpd[2] openDVS_pixel2x2_bot_66/vpd[3] openDVS_pixel2x2_bot_66/vpd[1]
+ openDVS_pixel2x2_bot_66/vpd[0] rowReadON<18> openDVS_pixel2x2_bot_69/GndD DiffBn
+ VSUBS VDD OnBn openDVS_pixel2x2_bot
XopenDVS_pixel2x2_bot_22 rowReadOFF<0> rowReadOFF<1> rowReadON<1> RefrBp PrBp PrSFBp
+ col_periphery_1x2_12/COL_LINE0 pixRst<38> pixRst<39> col_periphery_1x2_12/COL_LINE1
+ OffBn openDVS_pixel2x2_bot_22/vpd[2] openDVS_pixel2x2_bot_22/vpd[3] openDVS_pixel2x2_bot_22/vpd[1]
+ openDVS_pixel2x2_bot_22/vpd[0] rowReadON<0> GND DiffBn VSUBS VDD OnBn openDVS_pixel2x2_bot
XopenDVS_pixel2x2_bot_11 rowReadOFF<0> rowReadOFF<1> rowReadON<1> RefrBp PrBp PrSFBp
+ col_periphery_1x2_3/COL_LINE0 pixRst<56> pixRst<57> col_periphery_1x2_3/COL_LINE1
+ OffBn openDVS_pixel2x2_bot_11/vpd[2] openDVS_pixel2x2_bot_11/vpd[3] openDVS_pixel2x2_bot_11/vpd[1]
+ openDVS_pixel2x2_bot_11/vpd[0] rowReadON<0> GND DiffBn VSUBS VDD OnBn openDVS_pixel2x2_bot
XopenDVS_pixel2x2_bot_33 rowReadOFF<2> rowReadOFF<3> rowReadON<3> RefrBp PrBp PrSFBp
+ col_periphery_1x2_10/COL_LINE0 pixRst<34> pixRst<35> col_periphery_1x2_10/COL_LINE1
+ OffBn openDVS_pixel2x2_bot_33/vpd[2] openDVS_pixel2x2_bot_33/vpd[3] openDVS_pixel2x2_bot_33/vpd[1]
+ openDVS_pixel2x2_bot_33/vpd[0] rowReadON<2> openDVS_pixel2x2_bot_7/GndD DiffBn VSUBS
+ VDD OnBn openDVS_pixel2x2_bot
XopenDVS_pixel2x2_bot_44 rowReadOFF<10> rowReadOFF<11> rowReadON<11> RefrBp PrBp PrSFBp
+ col_periphery_1x2_13/COL_LINE0 pixRst<44> pixRst<45> col_periphery_1x2_13/COL_LINE1
+ OffBn openDVS_pixel2x2_bot_44/vpd[2] openDVS_pixel2x2_bot_44/vpd[3] openDVS_pixel2x2_bot_44/vpd[1]
+ openDVS_pixel2x2_bot_44/vpd[0] rowReadON<10> openDVS_pixel2x2_bot_82/GndD DiffBn
+ VSUBS VDD OnBn openDVS_pixel2x2_bot
XopenDVS_pixel2x2_bot_1019 rowReadOFF<58> rowReadOFF<59> rowReadON<59> RefrBp PrBp
+ PrSFBp col_periphery_1x2_9/COL_LINE0 pixRst<32> pixRst<33> col_periphery_1x2_9/COL_LINE1
+ OffBn openDVS_pixel2x2_bot_1019/vpd[2] openDVS_pixel2x2_bot_1019/vpd[3] openDVS_pixel2x2_bot_1019/vpd[1]
+ openDVS_pixel2x2_bot_1019/vpd[0] rowReadON<58> openDVS_pixel2x2_bot_890/GndD DiffBn
+ VSUBS VDD OnBn openDVS_pixel2x2_bot
XopenDVS_pixel2x2_bot_1008 rowReadOFF<48> rowReadOFF<49> rowReadON<49> RefrBp PrBp
+ PrSFBp col_periphery_1x2_23/COL_LINE0 pixRst<30> pixRst<31> col_periphery_1x2_23/COL_LINE1
+ OffBn openDVS_pixel2x2_bot_1008/vpd[2] openDVS_pixel2x2_bot_1008/vpd[3] openDVS_pixel2x2_bot_1008/vpd[1]
+ openDVS_pixel2x2_bot_1008/vpd[0] rowReadON<48> openDVS_pixel2x2_bot_927/GndD DiffBn
+ VSUBS VDD OnBn openDVS_pixel2x2_bot
XopenDVS_pixel2x2_bot_498 rowReadOFF<60> rowReadOFF<61> rowReadON<61> RefrBp PrBp
+ PrSFBp col_periphery_1x2_28/COL_LINE0 pixRst<8> pixRst<9> col_periphery_1x2_28/COL_LINE1
+ OffBn openDVS_pixel2x2_bot_498/vpd[2] openDVS_pixel2x2_bot_498/vpd[3] openDVS_pixel2x2_bot_498/vpd[1]
+ openDVS_pixel2x2_bot_498/vpd[0] rowReadON<60> openDVS_pixel2x2_bot_902/GndD DiffBn
+ VSUBS VDD OnBn openDVS_pixel2x2_bot
XopenDVS_pixel2x2_bot_432 rowReadOFF<40> rowReadOFF<41> rowReadON<41> RefrBp PrBp
+ PrSFBp col_periphery_1x2_22/COL_LINE0 pixRst<28> pixRst<29> col_periphery_1x2_22/COL_LINE1
+ OffBn openDVS_pixel2x2_bot_432/vpd[2] openDVS_pixel2x2_bot_432/vpd[3] openDVS_pixel2x2_bot_432/vpd[1]
+ openDVS_pixel2x2_bot_432/vpd[0] rowReadON<40> openDVS_pixel2x2_bot_906/GndD DiffBn
+ VSUBS VDD OnBn openDVS_pixel2x2_bot
XopenDVS_pixel2x2_bot_421 rowReadOFF<34> rowReadOFF<35> rowReadON<35> RefrBp PrBp
+ PrSFBp col_periphery_1x2_17/COL_LINE0 pixRst<18> pixRst<19> col_periphery_1x2_17/COL_LINE1
+ OffBn openDVS_pixel2x2_bot_421/vpd[2] openDVS_pixel2x2_bot_421/vpd[3] openDVS_pixel2x2_bot_421/vpd[1]
+ openDVS_pixel2x2_bot_421/vpd[0] rowReadON<34> openDVS_pixel2x2_bot_995/GndD DiffBn
+ VSUBS VDD OnBn openDVS_pixel2x2_bot
XopenDVS_pixel2x2_bot_454 rowReadOFF<42> rowReadOFF<43> rowReadON<43> RefrBp PrBp
+ PrSFBp col_periphery_1x2_28/COL_LINE0 pixRst<8> pixRst<9> col_periphery_1x2_28/COL_LINE1
+ OffBn openDVS_pixel2x2_bot_454/vpd[2] openDVS_pixel2x2_bot_454/vpd[3] openDVS_pixel2x2_bot_454/vpd[1]
+ openDVS_pixel2x2_bot_454/vpd[0] rowReadON<42> openDVS_pixel2x2_bot_908/GndD DiffBn
+ VSUBS VDD OnBn openDVS_pixel2x2_bot
XopenDVS_pixel2x2_bot_443 rowReadOFF<36> rowReadOFF<37> rowReadON<37> RefrBp PrBp
+ PrSFBp col_periphery_1x2_27/COL_LINE0 pixRst<6> pixRst<7> col_periphery_1x2_27/COL_LINE1
+ OffBn openDVS_pixel2x2_bot_443/vpd[2] openDVS_pixel2x2_bot_443/vpd[3] openDVS_pixel2x2_bot_443/vpd[1]
+ openDVS_pixel2x2_bot_443/vpd[0] rowReadON<36> openDVS_pixel2x2_bot_997/GndD DiffBn
+ VSUBS VDD OnBn openDVS_pixel2x2_bot
XopenDVS_pixel2x2_bot_476 rowReadOFF<38> rowReadOFF<39> rowReadON<39> RefrBp PrBp
+ PrSFBp col_periphery_1x2_27/COL_LINE0 pixRst<6> pixRst<7> col_periphery_1x2_27/COL_LINE1
+ OffBn openDVS_pixel2x2_bot_476/vpd[2] openDVS_pixel2x2_bot_476/vpd[3] openDVS_pixel2x2_bot_476/vpd[1]
+ openDVS_pixel2x2_bot_476/vpd[0] rowReadON<38> openDVS_pixel2x2_bot_999/GndD DiffBn
+ VSUBS VDD OnBn openDVS_pixel2x2_bot
XopenDVS_pixel2x2_bot_487 rowReadOFF<34> rowReadOFF<35> rowReadON<35> RefrBp PrBp
+ PrSFBp col_periphery_1x2_27/COL_LINE0 pixRst<6> pixRst<7> col_periphery_1x2_27/COL_LINE1
+ OffBn openDVS_pixel2x2_bot_487/vpd[2] openDVS_pixel2x2_bot_487/vpd[3] openDVS_pixel2x2_bot_487/vpd[1]
+ openDVS_pixel2x2_bot_487/vpd[0] rowReadON<34> openDVS_pixel2x2_bot_995/GndD DiffBn
+ VSUBS VDD OnBn openDVS_pixel2x2_bot
XopenDVS_pixel2x2_bot_465 rowReadOFF<40> rowReadOFF<41> rowReadON<41> RefrBp PrBp
+ PrSFBp col_periphery_1x2_25/COL_LINE0 pixRst<2> pixRst<3> col_periphery_1x2_25/COL_LINE1
+ OffBn openDVS_pixel2x2_bot_465/vpd[2] openDVS_pixel2x2_bot_465/vpd[3] openDVS_pixel2x2_bot_465/vpd[1]
+ openDVS_pixel2x2_bot_465/vpd[0] rowReadON<40> openDVS_pixel2x2_bot_906/GndD DiffBn
+ VSUBS VDD OnBn openDVS_pixel2x2_bot
XopenDVS_pixel2x2_bot_410 rowReadOFF<28> rowReadOFF<29> rowReadON<29> RefrBp PrBp
+ PrSFBp col_periphery_1x2_18/COL_LINE0 pixRst<20> pixRst<21> col_periphery_1x2_18/COL_LINE1
+ OffBn openDVS_pixel2x2_bot_410/vpd[2] openDVS_pixel2x2_bot_410/vpd[3] openDVS_pixel2x2_bot_410/vpd[1]
+ openDVS_pixel2x2_bot_410/vpd[0] rowReadON<28> openDVS_pixel2x2_bot_989/GndD DiffBn
+ VSUBS VDD OnBn openDVS_pixel2x2_bot
XopenDVS_pixel2x2_bot_273 rowReadOFF<22> rowReadOFF<23> rowReadON<23> RefrBp PrBp
+ PrSFBp col_periphery_1x2_28/COL_LINE0 pixRst<8> pixRst<9> col_periphery_1x2_28/COL_LINE1
+ OffBn openDVS_pixel2x2_bot_273/vpd[2] openDVS_pixel2x2_bot_273/vpd[3] openDVS_pixel2x2_bot_273/vpd[1]
+ openDVS_pixel2x2_bot_273/vpd[0] rowReadON<22> openDVS_pixel2x2_bot_97/GndD DiffBn
+ VSUBS VDD OnBn openDVS_pixel2x2_bot
XopenDVS_pixel2x2_bot_240 rowReadOFF<24> rowReadOFF<25> rowReadON<25> RefrBp PrBp
+ PrSFBp col_periphery_1x2_25/COL_LINE0 pixRst<2> pixRst<3> col_periphery_1x2_25/COL_LINE1
+ OffBn openDVS_pixel2x2_bot_240/vpd[2] openDVS_pixel2x2_bot_240/vpd[3] openDVS_pixel2x2_bot_240/vpd[1]
+ openDVS_pixel2x2_bot_240/vpd[0] rowReadON<24> openDVS_pixel2x2_bot_99/GndD DiffBn
+ VSUBS VDD OnBn openDVS_pixel2x2_bot
XopenDVS_pixel2x2_bot_262 rowReadOFF<14> rowReadOFF<15> rowReadON<15> RefrBp PrBp
+ PrSFBp col_periphery_1x2_27/COL_LINE0 pixRst<6> pixRst<7> col_periphery_1x2_27/COL_LINE1
+ OffBn openDVS_pixel2x2_bot_262/vpd[2] openDVS_pixel2x2_bot_262/vpd[3] openDVS_pixel2x2_bot_262/vpd[1]
+ openDVS_pixel2x2_bot_262/vpd[0] rowReadON<14> openDVS_pixel2x2_bot_78/GndD DiffBn
+ VSUBS VDD OnBn openDVS_pixel2x2_bot
XopenDVS_pixel2x2_bot_251 rowReadOFF<20> rowReadOFF<21> rowReadON<21> RefrBp PrBp
+ PrSFBp col_periphery_1x2_25/COL_LINE0 pixRst<2> pixRst<3> col_periphery_1x2_25/COL_LINE1
+ OffBn openDVS_pixel2x2_bot_251/vpd[2] openDVS_pixel2x2_bot_251/vpd[3] openDVS_pixel2x2_bot_251/vpd[1]
+ openDVS_pixel2x2_bot_251/vpd[0] rowReadON<20> openDVS_pixel2x2_bot_95/GndD DiffBn
+ VSUBS VDD OnBn openDVS_pixel2x2_bot
XopenDVS_pixel2x2_bot_284 rowReadOFF<10> rowReadOFF<11> rowReadON<11> RefrBp PrBp
+ PrSFBp col_periphery_1x2_27/COL_LINE0 pixRst<6> pixRst<7> col_periphery_1x2_27/COL_LINE1
+ OffBn openDVS_pixel2x2_bot_284/vpd[2] openDVS_pixel2x2_bot_284/vpd[3] openDVS_pixel2x2_bot_284/vpd[1]
+ openDVS_pixel2x2_bot_284/vpd[0] rowReadON<10> openDVS_pixel2x2_bot_82/GndD DiffBn
+ VSUBS VDD OnBn openDVS_pixel2x2_bot
XopenDVS_pixel2x2_bot_295 rowReadOFF<10> rowReadOFF<11> rowReadON<11> RefrBp PrBp
+ PrSFBp col_periphery_1x2_22/COL_LINE0 pixRst<28> pixRst<29> col_periphery_1x2_22/COL_LINE1
+ OffBn openDVS_pixel2x2_bot_295/vpd[2] openDVS_pixel2x2_bot_295/vpd[3] openDVS_pixel2x2_bot_295/vpd[1]
+ openDVS_pixel2x2_bot_295/vpd[0] rowReadON<10> openDVS_pixel2x2_bot_82/GndD DiffBn
+ VSUBS VDD OnBn openDVS_pixel2x2_bot
Xcol_periphery_1x2_19 pixRst<23> col_periphery_1x2_19/COL_LINE0 col_periphery_1x2_19/COL_LINE1
+ nDETECT DETECT col_periphery_1x2_9/VDD VTHRESH pixRst<22> voutn<22> VSUBS voutn<23>
+ NCHARGE col_periphery_1x2
XopenDVS_pixel2x2_bot_8 rowReadOFF<0> rowReadOFF<1> rowReadON<1> RefrBp PrBp PrSFBp
+ col_periphery_1x2_0/COL_LINE0 pixRst<50> pixRst<51> col_periphery_1x2_0/COL_LINE1
+ OffBn openDVS_pixel2x2_bot_8/vpd[2] openDVS_pixel2x2_bot_8/vpd[3] openDVS_pixel2x2_bot_8/vpd[1]
+ openDVS_pixel2x2_bot_8/vpd[0] rowReadON<0> GND DiffBn VSUBS VDD OnBn openDVS_pixel2x2_bot
XopenDVS_pixel2x2_bot_839 rowReadOFF<62> rowReadOFF<63> rowReadON<63> RefrBp PrBp
+ PrSFBp col_periphery_1x2_6/COL_LINE0 pixRst<62> pixRst<63> col_periphery_1x2_6/COL_LINE1
+ OffBn openDVS_pixel2x2_bot_839/vpd[2] openDVS_pixel2x2_bot_839/vpd[3] openDVS_pixel2x2_bot_839/vpd[1]
+ openDVS_pixel2x2_bot_839/vpd[0] rowReadON<62> openDVS_pixel2x2_bot_886/GndD DiffBn
+ VSUBS VDD OnBn openDVS_pixel2x2_bot
XopenDVS_pixel2x2_bot_828 rowReadOFF<60> rowReadOFF<61> rowReadON<61> RefrBp PrBp
+ PrSFBp col_periphery_1x2_5/COL_LINE0 pixRst<60> pixRst<61> col_periphery_1x2_5/COL_LINE1
+ OffBn openDVS_pixel2x2_bot_828/vpd[2] openDVS_pixel2x2_bot_828/vpd[3] openDVS_pixel2x2_bot_828/vpd[1]
+ openDVS_pixel2x2_bot_828/vpd[0] rowReadON<60> openDVS_pixel2x2_bot_902/GndD DiffBn
+ VSUBS VDD OnBn openDVS_pixel2x2_bot
XopenDVS_pixel2x2_bot_817 rowReadOFF<52> rowReadOFF<53> rowReadON<53> RefrBp PrBp
+ PrSFBp col_periphery_1x2_8/COL_LINE0 pixRst<42> pixRst<43> col_periphery_1x2_8/COL_LINE1
+ OffBn openDVS_pixel2x2_bot_817/vpd[2] openDVS_pixel2x2_bot_817/vpd[3] openDVS_pixel2x2_bot_817/vpd[1]
+ openDVS_pixel2x2_bot_817/vpd[0] rowReadON<52> openDVS_pixel2x2_bot_882/GndD DiffBn
+ VSUBS VDD OnBn openDVS_pixel2x2_bot
XopenDVS_pixel2x2_bot_806 rowReadOFF<46> rowReadOFF<47> rowReadON<47> RefrBp PrBp
+ PrSFBp col_periphery_1x2_7/COL_LINE0 pixRst<40> pixRst<41> col_periphery_1x2_7/COL_LINE1
+ OffBn openDVS_pixel2x2_bot_806/vpd[2] openDVS_pixel2x2_bot_806/vpd[3] openDVS_pixel2x2_bot_806/vpd[1]
+ openDVS_pixel2x2_bot_806/vpd[0] rowReadON<46> openDVS_pixel2x2_bot_925/GndD DiffBn
+ VSUBS VDD OnBn openDVS_pixel2x2_bot
XopenDVS_pixel2x2_bot_603 rowReadOFF<46> rowReadOFF<47> rowReadON<47> RefrBp PrBp
+ PrSFBp col_periphery_1x2_22/COL_LINE0 pixRst<28> pixRst<29> col_periphery_1x2_22/COL_LINE1
+ OffBn openDVS_pixel2x2_bot_603/vpd[2] openDVS_pixel2x2_bot_603/vpd[3] openDVS_pixel2x2_bot_603/vpd[1]
+ openDVS_pixel2x2_bot_603/vpd[0] rowReadON<46> openDVS_pixel2x2_bot_925/GndD DiffBn
+ VSUBS VDD OnBn openDVS_pixel2x2_bot
XopenDVS_pixel2x2_bot_614 rowReadOFF<52> rowReadOFF<53> rowReadON<53> RefrBp PrBp
+ PrSFBp col_periphery_1x2_16/COL_LINE0 pixRst<16> pixRst<17> col_periphery_1x2_16/COL_LINE1
+ OffBn openDVS_pixel2x2_bot_614/vpd[2] openDVS_pixel2x2_bot_614/vpd[3] openDVS_pixel2x2_bot_614/vpd[1]
+ openDVS_pixel2x2_bot_614/vpd[0] rowReadON<52> openDVS_pixel2x2_bot_882/GndD DiffBn
+ VSUBS VDD OnBn openDVS_pixel2x2_bot
XopenDVS_pixel2x2_bot_625 rowReadOFF<44> rowReadOFF<45> rowReadON<45> RefrBp PrBp
+ PrSFBp col_periphery_1x2_16/COL_LINE0 pixRst<16> pixRst<17> col_periphery_1x2_16/COL_LINE1
+ OffBn openDVS_pixel2x2_bot_625/vpd[2] openDVS_pixel2x2_bot_625/vpd[3] openDVS_pixel2x2_bot_625/vpd[1]
+ openDVS_pixel2x2_bot_625/vpd[0] rowReadON<44> openDVS_pixel2x2_bot_923/GndD DiffBn
+ VSUBS VDD OnBn openDVS_pixel2x2_bot
XopenDVS_pixel2x2_bot_647 rowReadOFF<48> rowReadOFF<49> rowReadON<49> RefrBp PrBp
+ PrSFBp col_periphery_1x2_16/COL_LINE0 pixRst<16> pixRst<17> col_periphery_1x2_16/COL_LINE1
+ OffBn openDVS_pixel2x2_bot_647/vpd[2] openDVS_pixel2x2_bot_647/vpd[3] openDVS_pixel2x2_bot_647/vpd[1]
+ openDVS_pixel2x2_bot_647/vpd[0] rowReadON<48> openDVS_pixel2x2_bot_927/GndD DiffBn
+ VSUBS VDD OnBn openDVS_pixel2x2_bot
XopenDVS_pixel2x2_bot_669 rowReadOFF<34> rowReadOFF<35> rowReadON<35> RefrBp PrBp
+ PrSFBp col_periphery_1x2_2/COL_LINE0 pixRst<54> pixRst<55> col_periphery_1x2_2/COL_LINE1
+ OffBn openDVS_pixel2x2_bot_669/vpd[2] openDVS_pixel2x2_bot_669/vpd[3] openDVS_pixel2x2_bot_669/vpd[1]
+ openDVS_pixel2x2_bot_669/vpd[0] rowReadON<34> openDVS_pixel2x2_bot_995/GndD DiffBn
+ VSUBS VDD OnBn openDVS_pixel2x2_bot
XopenDVS_pixel2x2_bot_658 rowReadOFF<40> rowReadOFF<41> rowReadON<41> RefrBp PrBp
+ PrSFBp col_periphery_1x2_31/COL_LINE0 pixRst<14> pixRst<15> col_periphery_1x2_31/COL_LINE1
+ OffBn openDVS_pixel2x2_bot_658/vpd[2] openDVS_pixel2x2_bot_658/vpd[3] openDVS_pixel2x2_bot_658/vpd[1]
+ openDVS_pixel2x2_bot_658/vpd[0] rowReadON<40> openDVS_pixel2x2_bot_906/GndD DiffBn
+ VSUBS VDD OnBn openDVS_pixel2x2_bot
XopenDVS_pixel2x2_bot_56 rowReadOFF<24> rowReadOFF<25> rowReadON<25> RefrBp PrBp PrSFBp
+ col_periphery_1x2_12/COL_LINE0 pixRst<38> pixRst<39> col_periphery_1x2_12/COL_LINE1
+ OffBn openDVS_pixel2x2_bot_56/vpd[2] openDVS_pixel2x2_bot_56/vpd[3] openDVS_pixel2x2_bot_56/vpd[1]
+ openDVS_pixel2x2_bot_56/vpd[0] rowReadON<24> openDVS_pixel2x2_bot_99/GndD DiffBn
+ VSUBS VDD OnBn openDVS_pixel2x2_bot
XopenDVS_pixel2x2_bot_636 rowReadOFF<30> rowReadOFF<31> rowReadON<31> RefrBp PrBp
+ PrSFBp col_periphery_1x2_31/COL_LINE0 pixRst<14> pixRst<15> col_periphery_1x2_31/COL_LINE1
+ OffBn openDVS_pixel2x2_bot_636/vpd[2] openDVS_pixel2x2_bot_636/vpd[3] openDVS_pixel2x2_bot_636/vpd[1]
+ openDVS_pixel2x2_bot_636/vpd[0] rowReadON<30> openDVS_pixel2x2_bot_991/GndD DiffBn
+ VSUBS VDD OnBn openDVS_pixel2x2_bot
XopenDVS_pixel2x2_bot_89 rowReadOFF<16> rowReadOFF<17> rowReadON<17> RefrBp PrBp PrSFBp
+ col_periphery_1x2_4/COL_LINE0 pixRst<58> pixRst<59> col_periphery_1x2_4/COL_LINE1
+ OffBn openDVS_pixel2x2_bot_89/vpd[2] openDVS_pixel2x2_bot_89/vpd[3] openDVS_pixel2x2_bot_89/vpd[1]
+ openDVS_pixel2x2_bot_89/vpd[0] rowReadON<16> openDVS_pixel2x2_bot_91/GndD DiffBn
+ VSUBS VDD OnBn openDVS_pixel2x2_bot
XopenDVS_pixel2x2_bot_67 rowReadOFF<18> rowReadOFF<19> rowReadON<19> RefrBp PrBp PrSFBp
+ col_periphery_1x2_7/COL_LINE0 pixRst<40> pixRst<41> col_periphery_1x2_7/COL_LINE1
+ OffBn openDVS_pixel2x2_bot_67/vpd[2] openDVS_pixel2x2_bot_67/vpd[3] openDVS_pixel2x2_bot_67/vpd[1]
+ openDVS_pixel2x2_bot_67/vpd[0] rowReadON<18> openDVS_pixel2x2_bot_69/GndD DiffBn
+ VSUBS VDD OnBn openDVS_pixel2x2_bot
XopenDVS_pixel2x2_bot_78 rowReadOFF<14> rowReadOFF<15> rowReadON<15> RefrBp PrBp PrSFBp
+ col_periphery_1x2_12/COL_LINE0 pixRst<38> pixRst<39> col_periphery_1x2_12/COL_LINE1
+ OffBn openDVS_pixel2x2_bot_78/vpd[2] openDVS_pixel2x2_bot_78/vpd[3] openDVS_pixel2x2_bot_78/vpd[1]
+ openDVS_pixel2x2_bot_78/vpd[0] rowReadON<14> openDVS_pixel2x2_bot_78/GndD DiffBn
+ VSUBS VDD OnBn openDVS_pixel2x2_bot
XopenDVS_pixel2x2_bot_45 rowReadOFF<12> rowReadOFF<13> rowReadON<13> RefrBp PrBp PrSFBp
+ col_periphery_1x2_11/COL_LINE0 pixRst<36> pixRst<37> col_periphery_1x2_11/COL_LINE1
+ OffBn openDVS_pixel2x2_bot_45/vpd[2] openDVS_pixel2x2_bot_45/vpd[3] openDVS_pixel2x2_bot_45/vpd[1]
+ openDVS_pixel2x2_bot_45/vpd[0] rowReadON<12> openDVS_pixel2x2_bot_79/GndD DiffBn
+ VSUBS VDD OnBn openDVS_pixel2x2_bot
XopenDVS_pixel2x2_bot_23 rowReadOFF<0> rowReadOFF<1> rowReadON<1> RefrBp PrBp PrSFBp
+ col_periphery_1x2_7/COL_LINE0 pixRst<40> pixRst<41> col_periphery_1x2_7/COL_LINE1
+ OffBn openDVS_pixel2x2_bot_23/vpd[2] openDVS_pixel2x2_bot_23/vpd[3] openDVS_pixel2x2_bot_23/vpd[1]
+ openDVS_pixel2x2_bot_23/vpd[0] rowReadON<0> GND DiffBn VSUBS VDD OnBn openDVS_pixel2x2_bot
XopenDVS_pixel2x2_bot_12 rowReadOFF<0> rowReadOFF<1> rowReadON<1> RefrBp PrBp PrSFBp
+ col_periphery_1x2_4/COL_LINE0 pixRst<58> pixRst<59> col_periphery_1x2_4/COL_LINE1
+ OffBn openDVS_pixel2x2_bot_12/vpd[2] openDVS_pixel2x2_bot_12/vpd[3] openDVS_pixel2x2_bot_12/vpd[1]
+ openDVS_pixel2x2_bot_12/vpd[0] rowReadON<0> GND DiffBn VSUBS VDD OnBn openDVS_pixel2x2_bot
XopenDVS_pixel2x2_bot_34 rowReadOFF<2> rowReadOFF<3> rowReadON<3> RefrBp PrBp PrSFBp
+ col_periphery_1x2_11/COL_LINE0 pixRst<36> pixRst<37> col_periphery_1x2_11/COL_LINE1
+ OffBn openDVS_pixel2x2_bot_34/vpd[2] openDVS_pixel2x2_bot_34/vpd[3] openDVS_pixel2x2_bot_34/vpd[1]
+ openDVS_pixel2x2_bot_34/vpd[0] rowReadON<2> openDVS_pixel2x2_bot_7/GndD DiffBn VSUBS
+ VDD OnBn openDVS_pixel2x2_bot
XopenDVS_pixel2x2_bot_499 rowReadOFF<60> rowReadOFF<61> rowReadON<61> RefrBp PrBp
+ PrSFBp col_periphery_1x2_29/COL_LINE0 pixRst<10> pixRst<11> col_periphery_1x2_29/COL_LINE1
+ OffBn openDVS_pixel2x2_bot_499/vpd[2] openDVS_pixel2x2_bot_499/vpd[3] openDVS_pixel2x2_bot_499/vpd[1]
+ openDVS_pixel2x2_bot_499/vpd[0] rowReadON<60> openDVS_pixel2x2_bot_902/GndD DiffBn
+ VSUBS VDD OnBn openDVS_pixel2x2_bot
XopenDVS_pixel2x2_bot_1009 rowReadOFF<48> rowReadOFF<49> rowReadON<49> RefrBp PrBp
+ PrSFBp col_periphery_1x2_9/COL_LINE0 pixRst<32> pixRst<33> col_periphery_1x2_9/COL_LINE1
+ OffBn openDVS_pixel2x2_bot_1009/vpd[2] openDVS_pixel2x2_bot_1009/vpd[3] openDVS_pixel2x2_bot_1009/vpd[1]
+ openDVS_pixel2x2_bot_1009/vpd[0] rowReadON<48> openDVS_pixel2x2_bot_927/GndD DiffBn
+ VSUBS VDD OnBn openDVS_pixel2x2_bot
XopenDVS_pixel2x2_bot_422 rowReadOFF<34> rowReadOFF<35> rowReadON<35> RefrBp PrBp
+ PrSFBp col_periphery_1x2_18/COL_LINE0 pixRst<20> pixRst<21> col_periphery_1x2_18/COL_LINE1
+ OffBn openDVS_pixel2x2_bot_422/vpd[2] openDVS_pixel2x2_bot_422/vpd[3] openDVS_pixel2x2_bot_422/vpd[1]
+ openDVS_pixel2x2_bot_422/vpd[0] rowReadON<34> openDVS_pixel2x2_bot_995/GndD DiffBn
+ VSUBS VDD OnBn openDVS_pixel2x2_bot
XopenDVS_pixel2x2_bot_433 rowReadOFF<40> rowReadOFF<41> rowReadON<41> RefrBp PrBp
+ PrSFBp col_periphery_1x2_17/COL_LINE0 pixRst<18> pixRst<19> col_periphery_1x2_17/COL_LINE1
+ OffBn openDVS_pixel2x2_bot_433/vpd[2] openDVS_pixel2x2_bot_433/vpd[3] openDVS_pixel2x2_bot_433/vpd[1]
+ openDVS_pixel2x2_bot_433/vpd[0] rowReadON<40> openDVS_pixel2x2_bot_906/GndD DiffBn
+ VSUBS VDD OnBn openDVS_pixel2x2_bot
XopenDVS_pixel2x2_bot_411 rowReadOFF<42> rowReadOFF<43> rowReadON<43> RefrBp PrBp
+ PrSFBp col_periphery_1x2_17/COL_LINE0 pixRst<18> pixRst<19> col_periphery_1x2_17/COL_LINE1
+ OffBn openDVS_pixel2x2_bot_411/vpd[2] openDVS_pixel2x2_bot_411/vpd[3] openDVS_pixel2x2_bot_411/vpd[1]
+ openDVS_pixel2x2_bot_411/vpd[0] rowReadON<42> openDVS_pixel2x2_bot_908/GndD DiffBn
+ VSUBS VDD OnBn openDVS_pixel2x2_bot
XopenDVS_pixel2x2_bot_455 rowReadOFF<42> rowReadOFF<43> rowReadON<43> RefrBp PrBp
+ PrSFBp col_periphery_1x2_29/COL_LINE0 pixRst<10> pixRst<11> col_periphery_1x2_29/COL_LINE1
+ OffBn openDVS_pixel2x2_bot_455/vpd[2] openDVS_pixel2x2_bot_455/vpd[3] openDVS_pixel2x2_bot_455/vpd[1]
+ openDVS_pixel2x2_bot_455/vpd[0] rowReadON<42> openDVS_pixel2x2_bot_908/GndD DiffBn
+ VSUBS VDD OnBn openDVS_pixel2x2_bot
XopenDVS_pixel2x2_bot_477 rowReadOFF<38> rowReadOFF<39> rowReadON<39> RefrBp PrBp
+ PrSFBp col_periphery_1x2_28/COL_LINE0 pixRst<8> pixRst<9> col_periphery_1x2_28/COL_LINE1
+ OffBn openDVS_pixel2x2_bot_477/vpd[2] openDVS_pixel2x2_bot_477/vpd[3] openDVS_pixel2x2_bot_477/vpd[1]
+ openDVS_pixel2x2_bot_477/vpd[0] rowReadON<38> openDVS_pixel2x2_bot_999/GndD DiffBn
+ VSUBS VDD OnBn openDVS_pixel2x2_bot
XopenDVS_pixel2x2_bot_488 rowReadOFF<34> rowReadOFF<35> rowReadON<35> RefrBp PrBp
+ PrSFBp col_periphery_1x2_28/COL_LINE0 pixRst<8> pixRst<9> col_periphery_1x2_28/COL_LINE1
+ OffBn openDVS_pixel2x2_bot_488/vpd[2] openDVS_pixel2x2_bot_488/vpd[3] openDVS_pixel2x2_bot_488/vpd[1]
+ openDVS_pixel2x2_bot_488/vpd[0] rowReadON<34> openDVS_pixel2x2_bot_995/GndD DiffBn
+ VSUBS VDD OnBn openDVS_pixel2x2_bot
XopenDVS_pixel2x2_bot_466 rowReadOFF<38> rowReadOFF<39> rowReadON<39> RefrBp PrBp
+ PrSFBp col_periphery_1x2_24/COL_LINE0 pixRst<0> pixRst<1> col_periphery_1x2_24/COL_LINE1
+ OffBn openDVS_pixel2x2_bot_466/vpd[2] openDVS_pixel2x2_bot_466/vpd[3] openDVS_pixel2x2_bot_466/vpd[1]
+ openDVS_pixel2x2_bot_466/vpd[0] rowReadON<38> openDVS_pixel2x2_bot_999/GndD DiffBn
+ VSUBS VDD OnBn openDVS_pixel2x2_bot
XopenDVS_pixel2x2_bot_400 rowReadOFF<30> rowReadOFF<31> rowReadON<31> RefrBp PrBp
+ PrSFBp col_periphery_1x2_18/COL_LINE0 pixRst<20> pixRst<21> col_periphery_1x2_18/COL_LINE1
+ OffBn openDVS_pixel2x2_bot_400/vpd[2] openDVS_pixel2x2_bot_400/vpd[3] openDVS_pixel2x2_bot_400/vpd[1]
+ openDVS_pixel2x2_bot_400/vpd[0] rowReadON<30> openDVS_pixel2x2_bot_991/GndD DiffBn
+ VSUBS VDD OnBn openDVS_pixel2x2_bot
XopenDVS_pixel2x2_bot_444 rowReadOFF<32> rowReadOFF<33> rowReadON<33> RefrBp PrBp
+ PrSFBp col_periphery_1x2_24/COL_LINE0 pixRst<0> pixRst<1> col_periphery_1x2_24/COL_LINE1
+ OffBn openDVS_pixel2x2_bot_444/vpd[2] openDVS_pixel2x2_bot_444/vpd[3] openDVS_pixel2x2_bot_444/vpd[1]
+ openDVS_pixel2x2_bot_444/vpd[0] rowReadON<32> openDVS_pixel2x2_bot_993/GndD DiffBn
+ VSUBS VDD OnBn openDVS_pixel2x2_bot
Xcol_periphery_1x2_0 pixRst<51> col_periphery_1x2_0/COL_LINE0 col_periphery_1x2_0/COL_LINE1
+ nDETECT DETECT col_periphery_1x2_9/VDD VTHRESH pixRst<50> voutn<50> VSUBS voutn<51>
+ NCHARGE col_periphery_1x2
XopenDVS_pixel2x2_bot_296 rowReadOFF<24> rowReadOFF<25> rowReadON<25> RefrBp PrBp
+ PrSFBp col_periphery_1x2_17/COL_LINE0 pixRst<18> pixRst<19> col_periphery_1x2_17/COL_LINE1
+ OffBn openDVS_pixel2x2_bot_296/vpd[2] openDVS_pixel2x2_bot_296/vpd[3] openDVS_pixel2x2_bot_296/vpd[1]
+ openDVS_pixel2x2_bot_296/vpd[0] rowReadON<24> openDVS_pixel2x2_bot_99/GndD DiffBn
+ VSUBS VDD OnBn openDVS_pixel2x2_bot
XopenDVS_pixel2x2_bot_274 rowReadOFF<24> rowReadOFF<25> rowReadON<25> RefrBp PrBp
+ PrSFBp col_periphery_1x2_29/COL_LINE0 pixRst<10> pixRst<11> col_periphery_1x2_29/COL_LINE1
+ OffBn openDVS_pixel2x2_bot_274/vpd[2] openDVS_pixel2x2_bot_274/vpd[3] openDVS_pixel2x2_bot_274/vpd[1]
+ openDVS_pixel2x2_bot_274/vpd[0] rowReadON<24> openDVS_pixel2x2_bot_99/GndD DiffBn
+ VSUBS VDD OnBn openDVS_pixel2x2_bot
XopenDVS_pixel2x2_bot_241 rowReadOFF<24> rowReadOFF<25> rowReadON<25> RefrBp PrBp
+ PrSFBp col_periphery_1x2_26/COL_LINE0 pixRst<4> pixRst<5> col_periphery_1x2_26/COL_LINE1
+ OffBn openDVS_pixel2x2_bot_241/vpd[2] openDVS_pixel2x2_bot_241/vpd[3] openDVS_pixel2x2_bot_241/vpd[1]
+ openDVS_pixel2x2_bot_241/vpd[0] rowReadON<24> openDVS_pixel2x2_bot_99/GndD DiffBn
+ VSUBS VDD OnBn openDVS_pixel2x2_bot
XopenDVS_pixel2x2_bot_263 rowReadOFF<14> rowReadOFF<15> rowReadON<15> RefrBp PrBp
+ PrSFBp col_periphery_1x2_28/COL_LINE0 pixRst<8> pixRst<9> col_periphery_1x2_28/COL_LINE1
+ OffBn openDVS_pixel2x2_bot_263/vpd[2] openDVS_pixel2x2_bot_263/vpd[3] openDVS_pixel2x2_bot_263/vpd[1]
+ openDVS_pixel2x2_bot_263/vpd[0] rowReadON<14> openDVS_pixel2x2_bot_78/GndD DiffBn
+ VSUBS VDD OnBn openDVS_pixel2x2_bot
XopenDVS_pixel2x2_bot_252 rowReadOFF<20> rowReadOFF<21> rowReadON<21> RefrBp PrBp
+ PrSFBp col_periphery_1x2_26/COL_LINE0 pixRst<4> pixRst<5> col_periphery_1x2_26/COL_LINE1
+ OffBn openDVS_pixel2x2_bot_252/vpd[2] openDVS_pixel2x2_bot_252/vpd[3] openDVS_pixel2x2_bot_252/vpd[1]
+ openDVS_pixel2x2_bot_252/vpd[0] rowReadON<20> openDVS_pixel2x2_bot_95/GndD DiffBn
+ VSUBS VDD OnBn openDVS_pixel2x2_bot
XopenDVS_pixel2x2_bot_230 rowReadOFF<4> rowReadOFF<5> rowReadON<5> RefrBp PrBp PrSFBp
+ col_periphery_1x2_24/COL_LINE0 pixRst<0> pixRst<1> col_periphery_1x2_24/COL_LINE1
+ OffBn openDVS_pixel2x2_bot_230/vpd[2] openDVS_pixel2x2_bot_230/vpd[3] openDVS_pixel2x2_bot_230/vpd[1]
+ openDVS_pixel2x2_bot_230/vpd[0] rowReadON<4> openDVS_pixel2x2_bot_6/GndD DiffBn
+ VSUBS VDD OnBn openDVS_pixel2x2_bot
XopenDVS_pixel2x2_bot_285 rowReadOFF<10> rowReadOFF<11> rowReadON<11> RefrBp PrBp
+ PrSFBp col_periphery_1x2_28/COL_LINE0 pixRst<8> pixRst<9> col_periphery_1x2_28/COL_LINE1
+ OffBn openDVS_pixel2x2_bot_285/vpd[2] openDVS_pixel2x2_bot_285/vpd[3] openDVS_pixel2x2_bot_285/vpd[1]
+ openDVS_pixel2x2_bot_285/vpd[0] rowReadON<10> openDVS_pixel2x2_bot_82/GndD DiffBn
+ VSUBS VDD OnBn openDVS_pixel2x2_bot
XopenDVS_pixel2x2_bot_9 rowReadOFF<0> rowReadOFF<1> rowReadON<1> RefrBp PrBp PrSFBp
+ col_periphery_1x2_1/COL_LINE0 pixRst<52> pixRst<53> col_periphery_1x2_1/COL_LINE1
+ OffBn openDVS_pixel2x2_bot_9/vpd[2] openDVS_pixel2x2_bot_9/vpd[3] openDVS_pixel2x2_bot_9/vpd[1]
+ openDVS_pixel2x2_bot_9/vpd[0] rowReadON<0> GND DiffBn VSUBS VDD OnBn openDVS_pixel2x2_bot
XopenDVS_pixel2x2_bot_829 rowReadOFF<46> rowReadOFF<47> rowReadON<47> RefrBp PrBp
+ PrSFBp col_periphery_1x2_5/COL_LINE0 pixRst<60> pixRst<61> col_periphery_1x2_5/COL_LINE1
+ OffBn openDVS_pixel2x2_bot_829/vpd[2] openDVS_pixel2x2_bot_829/vpd[3] openDVS_pixel2x2_bot_829/vpd[1]
+ openDVS_pixel2x2_bot_829/vpd[0] rowReadON<46> openDVS_pixel2x2_bot_925/GndD DiffBn
+ VSUBS VDD OnBn openDVS_pixel2x2_bot
XopenDVS_pixel2x2_bot_818 rowReadOFF<46> rowReadOFF<47> rowReadON<47> RefrBp PrBp
+ PrSFBp col_periphery_1x2_3/COL_LINE0 pixRst<56> pixRst<57> col_periphery_1x2_3/COL_LINE1
+ OffBn openDVS_pixel2x2_bot_818/vpd[2] openDVS_pixel2x2_bot_818/vpd[3] openDVS_pixel2x2_bot_818/vpd[1]
+ openDVS_pixel2x2_bot_818/vpd[0] rowReadON<46> openDVS_pixel2x2_bot_925/GndD DiffBn
+ VSUBS VDD OnBn openDVS_pixel2x2_bot
XopenDVS_pixel2x2_bot_807 rowReadOFF<46> rowReadOFF<47> rowReadON<47> RefrBp PrBp
+ PrSFBp col_periphery_1x2_8/COL_LINE0 pixRst<42> pixRst<43> col_periphery_1x2_8/COL_LINE1
+ OffBn openDVS_pixel2x2_bot_807/vpd[2] openDVS_pixel2x2_bot_807/vpd[3] openDVS_pixel2x2_bot_807/vpd[1]
+ openDVS_pixel2x2_bot_807/vpd[0] rowReadON<46> openDVS_pixel2x2_bot_925/GndD DiffBn
+ VSUBS VDD OnBn openDVS_pixel2x2_bot
XopenDVS_pixel2x2_bot_604 rowReadOFF<62> rowReadOFF<63> rowReadON<63> RefrBp PrBp
+ PrSFBp col_periphery_1x2_17/COL_LINE0 pixRst<18> pixRst<19> col_periphery_1x2_17/COL_LINE1
+ OffBn openDVS_pixel2x2_bot_604/vpd[2] openDVS_pixel2x2_bot_604/vpd[3] openDVS_pixel2x2_bot_604/vpd[1]
+ openDVS_pixel2x2_bot_604/vpd[0] rowReadON<62> openDVS_pixel2x2_bot_886/GndD DiffBn
+ VSUBS VDD OnBn openDVS_pixel2x2_bot
XopenDVS_pixel2x2_bot_615 rowReadOFF<60> rowReadOFF<61> rowReadON<61> RefrBp PrBp
+ PrSFBp col_periphery_1x2_31/COL_LINE0 pixRst<14> pixRst<15> col_periphery_1x2_31/COL_LINE1
+ OffBn openDVS_pixel2x2_bot_615/vpd[2] openDVS_pixel2x2_bot_615/vpd[3] openDVS_pixel2x2_bot_615/vpd[1]
+ openDVS_pixel2x2_bot_615/vpd[0] rowReadON<60> openDVS_pixel2x2_bot_902/GndD DiffBn
+ VSUBS VDD OnBn openDVS_pixel2x2_bot
XopenDVS_pixel2x2_bot_626 rowReadOFF<44> rowReadOFF<45> rowReadON<45> RefrBp PrBp
+ PrSFBp col_periphery_1x2_17/COL_LINE0 pixRst<18> pixRst<19> col_periphery_1x2_17/COL_LINE1
+ OffBn openDVS_pixel2x2_bot_626/vpd[2] openDVS_pixel2x2_bot_626/vpd[3] openDVS_pixel2x2_bot_626/vpd[1]
+ openDVS_pixel2x2_bot_626/vpd[0] rowReadON<44> openDVS_pixel2x2_bot_923/GndD DiffBn
+ VSUBS VDD OnBn openDVS_pixel2x2_bot
XopenDVS_pixel2x2_bot_659 rowReadOFF<40> rowReadOFF<41> rowReadON<41> RefrBp PrBp
+ PrSFBp col_periphery_1x2_16/COL_LINE0 pixRst<16> pixRst<17> col_periphery_1x2_16/COL_LINE1
+ OffBn openDVS_pixel2x2_bot_659/vpd[2] openDVS_pixel2x2_bot_659/vpd[3] openDVS_pixel2x2_bot_659/vpd[1]
+ openDVS_pixel2x2_bot_659/vpd[0] rowReadON<40> openDVS_pixel2x2_bot_906/GndD DiffBn
+ VSUBS VDD OnBn openDVS_pixel2x2_bot
XopenDVS_pixel2x2_bot_648 rowReadOFF<36> rowReadOFF<37> rowReadON<37> RefrBp PrBp
+ PrSFBp col_periphery_1x2_31/COL_LINE0 pixRst<14> pixRst<15> col_periphery_1x2_31/COL_LINE1
+ OffBn openDVS_pixel2x2_bot_648/vpd[2] openDVS_pixel2x2_bot_648/vpd[3] openDVS_pixel2x2_bot_648/vpd[1]
+ openDVS_pixel2x2_bot_648/vpd[0] rowReadON<36> openDVS_pixel2x2_bot_997/GndD DiffBn
+ VSUBS VDD OnBn openDVS_pixel2x2_bot
XopenDVS_pixel2x2_bot_57 rowReadOFF<24> rowReadOFF<25> rowReadON<25> RefrBp PrBp PrSFBp
+ col_periphery_1x2_7/COL_LINE0 pixRst<40> pixRst<41> col_periphery_1x2_7/COL_LINE1
+ OffBn openDVS_pixel2x2_bot_57/vpd[2] openDVS_pixel2x2_bot_57/vpd[3] openDVS_pixel2x2_bot_57/vpd[1]
+ openDVS_pixel2x2_bot_57/vpd[0] rowReadON<24> openDVS_pixel2x2_bot_99/GndD DiffBn
+ VSUBS VDD OnBn openDVS_pixel2x2_bot
XopenDVS_pixel2x2_bot_637 rowReadOFF<30> rowReadOFF<31> rowReadON<31> RefrBp PrBp
+ PrSFBp col_periphery_1x2_16/COL_LINE0 pixRst<16> pixRst<17> col_periphery_1x2_16/COL_LINE1
+ OffBn openDVS_pixel2x2_bot_637/vpd[2] openDVS_pixel2x2_bot_637/vpd[3] openDVS_pixel2x2_bot_637/vpd[1]
+ openDVS_pixel2x2_bot_637/vpd[0] rowReadON<30> openDVS_pixel2x2_bot_991/GndD DiffBn
+ VSUBS VDD OnBn openDVS_pixel2x2_bot
XopenDVS_pixel2x2_bot_68 rowReadOFF<18> rowReadOFF<19> rowReadON<19> RefrBp PrBp PrSFBp
+ col_periphery_1x2_8/COL_LINE0 pixRst<42> pixRst<43> col_periphery_1x2_8/COL_LINE1
+ OffBn openDVS_pixel2x2_bot_68/vpd[2] openDVS_pixel2x2_bot_68/vpd[3] openDVS_pixel2x2_bot_68/vpd[1]
+ openDVS_pixel2x2_bot_68/vpd[0] rowReadON<18> openDVS_pixel2x2_bot_69/GndD DiffBn
+ VSUBS VDD OnBn openDVS_pixel2x2_bot
XopenDVS_pixel2x2_bot_46 rowReadOFF<12> rowReadOFF<13> rowReadON<13> RefrBp PrBp PrSFBp
+ col_periphery_1x2_12/COL_LINE0 pixRst<38> pixRst<39> col_periphery_1x2_12/COL_LINE1
+ OffBn openDVS_pixel2x2_bot_46/vpd[2] openDVS_pixel2x2_bot_46/vpd[3] openDVS_pixel2x2_bot_46/vpd[1]
+ openDVS_pixel2x2_bot_46/vpd[0] rowReadON<12> openDVS_pixel2x2_bot_79/GndD DiffBn
+ VSUBS VDD OnBn openDVS_pixel2x2_bot
XopenDVS_pixel2x2_bot_79 rowReadOFF<12> rowReadOFF<13> rowReadON<13> RefrBp PrBp PrSFBp
+ col_periphery_1x2_10/COL_LINE0 pixRst<34> pixRst<35> col_periphery_1x2_10/COL_LINE1
+ OffBn openDVS_pixel2x2_bot_79/vpd[2] openDVS_pixel2x2_bot_79/vpd[3] openDVS_pixel2x2_bot_79/vpd[1]
+ openDVS_pixel2x2_bot_79/vpd[0] rowReadON<12> openDVS_pixel2x2_bot_79/GndD DiffBn
+ VSUBS VDD OnBn openDVS_pixel2x2_bot
XopenDVS_pixel2x2_bot_24 rowReadOFF<0> rowReadOFF<1> rowReadON<1> RefrBp PrBp PrSFBp
+ col_periphery_1x2_8/COL_LINE0 pixRst<42> pixRst<43> col_periphery_1x2_8/COL_LINE1
+ OffBn openDVS_pixel2x2_bot_24/vpd[2] openDVS_pixel2x2_bot_24/vpd[3] openDVS_pixel2x2_bot_24/vpd[1]
+ openDVS_pixel2x2_bot_24/vpd[0] rowReadON<0> GND DiffBn VSUBS VDD OnBn openDVS_pixel2x2_bot
XopenDVS_pixel2x2_bot_13 rowReadOFF<0> rowReadOFF<1> rowReadON<1> RefrBp PrBp PrSFBp
+ col_periphery_1x2_5/COL_LINE0 pixRst<60> pixRst<61> col_periphery_1x2_5/COL_LINE1
+ OffBn openDVS_pixel2x2_bot_13/vpd[2] openDVS_pixel2x2_bot_13/vpd[3] openDVS_pixel2x2_bot_13/vpd[1]
+ openDVS_pixel2x2_bot_13/vpd[0] rowReadON<0> GND DiffBn VSUBS VDD OnBn openDVS_pixel2x2_bot
XopenDVS_pixel2x2_bot_35 rowReadOFF<2> rowReadOFF<3> rowReadON<3> RefrBp PrBp PrSFBp
+ col_periphery_1x2_12/COL_LINE0 pixRst<38> pixRst<39> col_periphery_1x2_12/COL_LINE1
+ OffBn openDVS_pixel2x2_bot_35/vpd[2] openDVS_pixel2x2_bot_35/vpd[3] openDVS_pixel2x2_bot_35/vpd[1]
+ openDVS_pixel2x2_bot_35/vpd[0] rowReadON<2> openDVS_pixel2x2_bot_7/GndD DiffBn VSUBS
+ VDD OnBn openDVS_pixel2x2_bot
XopenDVS_pixel2x2_bot_412 rowReadOFF<42> rowReadOFF<43> rowReadON<43> RefrBp PrBp
+ PrSFBp col_periphery_1x2_18/COL_LINE0 pixRst<20> pixRst<21> col_periphery_1x2_18/COL_LINE1
+ OffBn openDVS_pixel2x2_bot_412/vpd[2] openDVS_pixel2x2_bot_412/vpd[3] openDVS_pixel2x2_bot_412/vpd[1]
+ openDVS_pixel2x2_bot_412/vpd[0] rowReadON<42> openDVS_pixel2x2_bot_908/GndD DiffBn
+ VSUBS VDD OnBn openDVS_pixel2x2_bot
XopenDVS_pixel2x2_bot_401 rowReadOFF<30> rowReadOFF<31> rowReadON<31> RefrBp PrBp
+ PrSFBp col_periphery_1x2_19/COL_LINE0 pixRst<22> pixRst<23> col_periphery_1x2_19/COL_LINE1
+ OffBn openDVS_pixel2x2_bot_401/vpd[2] openDVS_pixel2x2_bot_401/vpd[3] openDVS_pixel2x2_bot_401/vpd[1]
+ openDVS_pixel2x2_bot_401/vpd[0] rowReadON<30> openDVS_pixel2x2_bot_991/GndD DiffBn
+ VSUBS VDD OnBn openDVS_pixel2x2_bot
XopenDVS_pixel2x2_bot_434 rowReadOFF<40> rowReadOFF<41> rowReadON<41> RefrBp PrBp
+ PrSFBp col_periphery_1x2_18/COL_LINE0 pixRst<20> pixRst<21> col_periphery_1x2_18/COL_LINE1
+ OffBn openDVS_pixel2x2_bot_434/vpd[2] openDVS_pixel2x2_bot_434/vpd[3] openDVS_pixel2x2_bot_434/vpd[1]
+ openDVS_pixel2x2_bot_434/vpd[0] rowReadON<40> openDVS_pixel2x2_bot_906/GndD DiffBn
+ VSUBS VDD OnBn openDVS_pixel2x2_bot
XopenDVS_pixel2x2_bot_423 rowReadOFF<34> rowReadOFF<35> rowReadON<35> RefrBp PrBp
+ PrSFBp col_periphery_1x2_19/COL_LINE0 pixRst<22> pixRst<23> col_periphery_1x2_19/COL_LINE1
+ OffBn openDVS_pixel2x2_bot_423/vpd[2] openDVS_pixel2x2_bot_423/vpd[3] openDVS_pixel2x2_bot_423/vpd[1]
+ openDVS_pixel2x2_bot_423/vpd[0] rowReadON<34> openDVS_pixel2x2_bot_995/GndD DiffBn
+ VSUBS VDD OnBn openDVS_pixel2x2_bot
XopenDVS_pixel2x2_bot_456 rowReadOFF<42> rowReadOFF<43> rowReadON<43> RefrBp PrBp
+ PrSFBp col_periphery_1x2_30/COL_LINE0 pixRst<12> pixRst<13> col_periphery_1x2_30/COL_LINE1
+ OffBn openDVS_pixel2x2_bot_456/vpd[2] openDVS_pixel2x2_bot_456/vpd[3] openDVS_pixel2x2_bot_456/vpd[1]
+ openDVS_pixel2x2_bot_456/vpd[0] rowReadON<42> openDVS_pixel2x2_bot_908/GndD DiffBn
+ VSUBS VDD OnBn openDVS_pixel2x2_bot
XopenDVS_pixel2x2_bot_478 rowReadOFF<38> rowReadOFF<39> rowReadON<39> RefrBp PrBp
+ PrSFBp col_periphery_1x2_29/COL_LINE0 pixRst<10> pixRst<11> col_periphery_1x2_29/COL_LINE1
+ OffBn openDVS_pixel2x2_bot_478/vpd[2] openDVS_pixel2x2_bot_478/vpd[3] openDVS_pixel2x2_bot_478/vpd[1]
+ openDVS_pixel2x2_bot_478/vpd[0] rowReadON<38> openDVS_pixel2x2_bot_999/GndD DiffBn
+ VSUBS VDD OnBn openDVS_pixel2x2_bot
XopenDVS_pixel2x2_bot_489 rowReadOFF<34> rowReadOFF<35> rowReadON<35> RefrBp PrBp
+ PrSFBp col_periphery_1x2_29/COL_LINE0 pixRst<10> pixRst<11> col_periphery_1x2_29/COL_LINE1
+ OffBn openDVS_pixel2x2_bot_489/vpd[2] openDVS_pixel2x2_bot_489/vpd[3] openDVS_pixel2x2_bot_489/vpd[1]
+ openDVS_pixel2x2_bot_489/vpd[0] rowReadON<34> openDVS_pixel2x2_bot_995/GndD DiffBn
+ VSUBS VDD OnBn openDVS_pixel2x2_bot
XopenDVS_pixel2x2_bot_445 rowReadOFF<32> rowReadOFF<33> rowReadON<33> RefrBp PrBp
+ PrSFBp col_periphery_1x2_25/COL_LINE0 pixRst<2> pixRst<3> col_periphery_1x2_25/COL_LINE1
+ OffBn openDVS_pixel2x2_bot_445/vpd[2] openDVS_pixel2x2_bot_445/vpd[3] openDVS_pixel2x2_bot_445/vpd[1]
+ openDVS_pixel2x2_bot_445/vpd[0] rowReadON<32> openDVS_pixel2x2_bot_993/GndD DiffBn
+ VSUBS VDD OnBn openDVS_pixel2x2_bot
XopenDVS_pixel2x2_bot_467 rowReadOFF<30> rowReadOFF<31> rowReadON<31> RefrBp PrBp
+ PrSFBp col_periphery_1x2_24/COL_LINE0 pixRst<0> pixRst<1> col_periphery_1x2_24/COL_LINE1
+ OffBn openDVS_pixel2x2_bot_467/vpd[2] openDVS_pixel2x2_bot_467/vpd[3] openDVS_pixel2x2_bot_467/vpd[1]
+ openDVS_pixel2x2_bot_467/vpd[0] rowReadON<30> openDVS_pixel2x2_bot_991/GndD DiffBn
+ VSUBS VDD OnBn openDVS_pixel2x2_bot
Xcol_periphery_1x2_1 pixRst<53> col_periphery_1x2_1/COL_LINE0 col_periphery_1x2_1/COL_LINE1
+ nDETECT DETECT col_periphery_1x2_9/VDD VTHRESH pixRst<52> voutn<52> VSUBS voutn<53>
+ NCHARGE col_periphery_1x2
XopenDVS_pixel2x2_bot_990 rowReadOFF<30> rowReadOFF<31> rowReadON<31> RefrBp PrBp
+ PrSFBp col_periphery_1x2_23/COL_LINE0 pixRst<30> pixRst<31> col_periphery_1x2_23/COL_LINE1
+ OffBn openDVS_pixel2x2_bot_990/vpd[2] openDVS_pixel2x2_bot_990/vpd[3] openDVS_pixel2x2_bot_990/vpd[1]
+ openDVS_pixel2x2_bot_990/vpd[0] rowReadON<30> openDVS_pixel2x2_bot_991/GndD DiffBn
+ VSUBS VDD OnBn openDVS_pixel2x2_bot
XopenDVS_pixel2x2_bot_297 rowReadOFF<24> rowReadOFF<25> rowReadON<25> RefrBp PrBp
+ PrSFBp col_periphery_1x2_18/COL_LINE0 pixRst<20> pixRst<21> col_periphery_1x2_18/COL_LINE1
+ OffBn openDVS_pixel2x2_bot_297/vpd[2] openDVS_pixel2x2_bot_297/vpd[3] openDVS_pixel2x2_bot_297/vpd[1]
+ openDVS_pixel2x2_bot_297/vpd[0] rowReadON<24> openDVS_pixel2x2_bot_99/GndD DiffBn
+ VSUBS VDD OnBn openDVS_pixel2x2_bot
XopenDVS_pixel2x2_bot_275 rowReadOFF<24> rowReadOFF<25> rowReadON<25> RefrBp PrBp
+ PrSFBp col_periphery_1x2_30/COL_LINE0 pixRst<12> pixRst<13> col_periphery_1x2_30/COL_LINE1
+ OffBn openDVS_pixel2x2_bot_275/vpd[2] openDVS_pixel2x2_bot_275/vpd[3] openDVS_pixel2x2_bot_275/vpd[1]
+ openDVS_pixel2x2_bot_275/vpd[0] rowReadON<24> openDVS_pixel2x2_bot_99/GndD DiffBn
+ VSUBS VDD OnBn openDVS_pixel2x2_bot
XopenDVS_pixel2x2_bot_264 rowReadOFF<14> rowReadOFF<15> rowReadON<15> RefrBp PrBp
+ PrSFBp col_periphery_1x2_29/COL_LINE0 pixRst<10> pixRst<11> col_periphery_1x2_29/COL_LINE1
+ OffBn openDVS_pixel2x2_bot_264/vpd[2] openDVS_pixel2x2_bot_264/vpd[3] openDVS_pixel2x2_bot_264/vpd[1]
+ openDVS_pixel2x2_bot_264/vpd[0] rowReadON<14> openDVS_pixel2x2_bot_78/GndD DiffBn
+ VSUBS VDD OnBn openDVS_pixel2x2_bot
XopenDVS_pixel2x2_bot_253 rowReadOFF<20> rowReadOFF<21> rowReadON<21> RefrBp PrBp
+ PrSFBp col_periphery_1x2_27/COL_LINE0 pixRst<6> pixRst<7> col_periphery_1x2_27/COL_LINE1
+ OffBn openDVS_pixel2x2_bot_253/vpd[2] openDVS_pixel2x2_bot_253/vpd[3] openDVS_pixel2x2_bot_253/vpd[1]
+ openDVS_pixel2x2_bot_253/vpd[0] rowReadON<20> openDVS_pixel2x2_bot_95/GndD DiffBn
+ VSUBS VDD OnBn openDVS_pixel2x2_bot
XopenDVS_pixel2x2_bot_242 rowReadOFF<12> rowReadOFF<13> rowReadON<13> RefrBp PrBp
+ PrSFBp col_periphery_1x2_24/COL_LINE0 pixRst<0> pixRst<1> col_periphery_1x2_24/COL_LINE1
+ OffBn openDVS_pixel2x2_bot_242/vpd[2] openDVS_pixel2x2_bot_242/vpd[3] openDVS_pixel2x2_bot_242/vpd[1]
+ openDVS_pixel2x2_bot_242/vpd[0] rowReadON<12> openDVS_pixel2x2_bot_79/GndD DiffBn
+ VSUBS VDD OnBn openDVS_pixel2x2_bot
XopenDVS_pixel2x2_bot_220 rowReadOFF<0> rowReadOFF<1> rowReadON<1> RefrBp PrBp PrSFBp
+ col_periphery_1x2_24/COL_LINE0 pixRst<0> pixRst<1> col_periphery_1x2_24/COL_LINE1
+ OffBn openDVS_pixel2x2_bot_220/vpd[2] openDVS_pixel2x2_bot_220/vpd[3] openDVS_pixel2x2_bot_220/vpd[1]
+ openDVS_pixel2x2_bot_220/vpd[0] rowReadON<0> GND DiffBn VSUBS VDD OnBn openDVS_pixel2x2_bot
XopenDVS_pixel2x2_bot_231 rowReadOFF<2> rowReadOFF<3> rowReadON<3> RefrBp PrBp PrSFBp
+ col_periphery_1x2_24/COL_LINE0 pixRst<0> pixRst<1> col_periphery_1x2_24/COL_LINE1
+ OffBn openDVS_pixel2x2_bot_231/vpd[2] openDVS_pixel2x2_bot_231/vpd[3] openDVS_pixel2x2_bot_231/vpd[1]
+ openDVS_pixel2x2_bot_231/vpd[0] rowReadON<2> openDVS_pixel2x2_bot_7/GndD DiffBn
+ VSUBS VDD OnBn openDVS_pixel2x2_bot
XopenDVS_pixel2x2_bot_286 rowReadOFF<10> rowReadOFF<11> rowReadON<11> RefrBp PrBp
+ PrSFBp col_periphery_1x2_29/COL_LINE0 pixRst<10> pixRst<11> col_periphery_1x2_29/COL_LINE1
+ OffBn openDVS_pixel2x2_bot_286/vpd[2] openDVS_pixel2x2_bot_286/vpd[3] openDVS_pixel2x2_bot_286/vpd[1]
+ openDVS_pixel2x2_bot_286/vpd[0] rowReadON<10> openDVS_pixel2x2_bot_82/GndD DiffBn
+ VSUBS VDD OnBn openDVS_pixel2x2_bot
XopenDVS_pixel2x2_bot_819 rowReadOFF<46> rowReadOFF<47> rowReadON<47> RefrBp PrBp
+ PrSFBp col_periphery_1x2_4/COL_LINE0 pixRst<58> pixRst<59> col_periphery_1x2_4/COL_LINE1
+ OffBn openDVS_pixel2x2_bot_819/vpd[2] openDVS_pixel2x2_bot_819/vpd[3] openDVS_pixel2x2_bot_819/vpd[1]
+ openDVS_pixel2x2_bot_819/vpd[0] rowReadON<46> openDVS_pixel2x2_bot_925/GndD DiffBn
+ VSUBS VDD OnBn openDVS_pixel2x2_bot
XopenDVS_pixel2x2_bot_808 rowReadOFF<46> rowReadOFF<47> rowReadON<47> RefrBp PrBp
+ PrSFBp col_periphery_1x2_13/COL_LINE0 pixRst<44> pixRst<45> col_periphery_1x2_13/COL_LINE1
+ OffBn openDVS_pixel2x2_bot_808/vpd[2] openDVS_pixel2x2_bot_808/vpd[3] openDVS_pixel2x2_bot_808/vpd[1]
+ openDVS_pixel2x2_bot_808/vpd[0] rowReadON<46> openDVS_pixel2x2_bot_925/GndD DiffBn
+ VSUBS VDD OnBn openDVS_pixel2x2_bot
XopenDVS_pixel2x2_bot_605 rowReadOFF<62> rowReadOFF<63> rowReadON<63> RefrBp PrBp
+ PrSFBp col_periphery_1x2_18/COL_LINE0 pixRst<20> pixRst<21> col_periphery_1x2_18/COL_LINE1
+ OffBn openDVS_pixel2x2_bot_605/vpd[2] openDVS_pixel2x2_bot_605/vpd[3] openDVS_pixel2x2_bot_605/vpd[1]
+ openDVS_pixel2x2_bot_605/vpd[0] rowReadON<62> openDVS_pixel2x2_bot_886/GndD DiffBn
+ VSUBS VDD OnBn openDVS_pixel2x2_bot
XopenDVS_pixel2x2_bot_616 rowReadOFF<60> rowReadOFF<61> rowReadON<61> RefrBp PrBp
+ PrSFBp col_periphery_1x2_16/COL_LINE0 pixRst<16> pixRst<17> col_periphery_1x2_16/COL_LINE1
+ OffBn openDVS_pixel2x2_bot_616/vpd[2] openDVS_pixel2x2_bot_616/vpd[3] openDVS_pixel2x2_bot_616/vpd[1]
+ openDVS_pixel2x2_bot_616/vpd[0] rowReadON<60> openDVS_pixel2x2_bot_902/GndD DiffBn
+ VSUBS VDD OnBn openDVS_pixel2x2_bot
XopenDVS_pixel2x2_bot_627 rowReadOFF<44> rowReadOFF<45> rowReadON<45> RefrBp PrBp
+ PrSFBp col_periphery_1x2_18/COL_LINE0 pixRst<20> pixRst<21> col_periphery_1x2_18/COL_LINE1
+ OffBn openDVS_pixel2x2_bot_627/vpd[2] openDVS_pixel2x2_bot_627/vpd[3] openDVS_pixel2x2_bot_627/vpd[1]
+ openDVS_pixel2x2_bot_627/vpd[0] rowReadON<44> openDVS_pixel2x2_bot_923/GndD DiffBn
+ VSUBS VDD OnBn openDVS_pixel2x2_bot
XopenDVS_pixel2x2_bot_638 rowReadOFF<46> rowReadOFF<47> rowReadON<47> RefrBp PrBp
+ PrSFBp col_periphery_1x2_31/COL_LINE0 pixRst<14> pixRst<15> col_periphery_1x2_31/COL_LINE1
+ OffBn openDVS_pixel2x2_bot_638/vpd[2] openDVS_pixel2x2_bot_638/vpd[3] openDVS_pixel2x2_bot_638/vpd[1]
+ openDVS_pixel2x2_bot_638/vpd[0] rowReadON<46> openDVS_pixel2x2_bot_925/GndD DiffBn
+ VSUBS VDD OnBn openDVS_pixel2x2_bot
XopenDVS_pixel2x2_bot_649 rowReadOFF<36> rowReadOFF<37> rowReadON<37> RefrBp PrBp
+ PrSFBp col_periphery_1x2_16/COL_LINE0 pixRst<16> pixRst<17> col_periphery_1x2_16/COL_LINE1
+ OffBn openDVS_pixel2x2_bot_649/vpd[2] openDVS_pixel2x2_bot_649/vpd[3] openDVS_pixel2x2_bot_649/vpd[1]
+ openDVS_pixel2x2_bot_649/vpd[0] rowReadON<36> openDVS_pixel2x2_bot_997/GndD DiffBn
+ VSUBS VDD OnBn openDVS_pixel2x2_bot
XopenDVS_pixel2x2_bot_58 rowReadOFF<22> rowReadOFF<23> rowReadON<23> RefrBp PrBp PrSFBp
+ col_periphery_1x2_7/COL_LINE0 pixRst<40> pixRst<41> col_periphery_1x2_7/COL_LINE1
+ OffBn openDVS_pixel2x2_bot_58/vpd[2] openDVS_pixel2x2_bot_58/vpd[3] openDVS_pixel2x2_bot_58/vpd[1]
+ openDVS_pixel2x2_bot_58/vpd[0] rowReadON<22> openDVS_pixel2x2_bot_97/GndD DiffBn
+ VSUBS VDD OnBn openDVS_pixel2x2_bot
XopenDVS_pixel2x2_bot_69 rowReadOFF<18> rowReadOFF<19> rowReadON<19> RefrBp PrBp PrSFBp
+ col_periphery_1x2_13/COL_LINE0 pixRst<44> pixRst<45> col_periphery_1x2_13/COL_LINE1
+ OffBn openDVS_pixel2x2_bot_69/vpd[2] openDVS_pixel2x2_bot_69/vpd[3] openDVS_pixel2x2_bot_69/vpd[1]
+ openDVS_pixel2x2_bot_69/vpd[0] rowReadON<18> openDVS_pixel2x2_bot_69/GndD DiffBn
+ VSUBS VDD OnBn openDVS_pixel2x2_bot
XopenDVS_pixel2x2_bot_47 rowReadOFF<14> rowReadOFF<15> rowReadON<15> RefrBp PrBp PrSFBp
+ col_periphery_1x2_7/COL_LINE0 pixRst<40> pixRst<41> col_periphery_1x2_7/COL_LINE1
+ OffBn openDVS_pixel2x2_bot_47/vpd[2] openDVS_pixel2x2_bot_47/vpd[3] openDVS_pixel2x2_bot_47/vpd[1]
+ openDVS_pixel2x2_bot_47/vpd[0] rowReadON<14> openDVS_pixel2x2_bot_78/GndD DiffBn
+ VSUBS VDD OnBn openDVS_pixel2x2_bot
XopenDVS_pixel2x2_bot_25 rowReadOFF<0> rowReadOFF<1> rowReadON<1> RefrBp PrBp PrSFBp
+ col_periphery_1x2_13/COL_LINE0 pixRst<44> pixRst<45> col_periphery_1x2_13/COL_LINE1
+ OffBn openDVS_pixel2x2_bot_25/vpd[2] openDVS_pixel2x2_bot_25/vpd[3] openDVS_pixel2x2_bot_25/vpd[1]
+ openDVS_pixel2x2_bot_25/vpd[0] rowReadON<0> GND DiffBn VSUBS VDD OnBn openDVS_pixel2x2_bot
XopenDVS_pixel2x2_bot_14 rowReadOFF<0> rowReadOFF<1> rowReadON<1> RefrBp PrBp PrSFBp
+ col_periphery_1x2_6/COL_LINE0 pixRst<62> pixRst<63> col_periphery_1x2_6/COL_LINE1
+ OffBn openDVS_pixel2x2_bot_14/vpd[2] openDVS_pixel2x2_bot_14/vpd[3] openDVS_pixel2x2_bot_14/vpd[1]
+ openDVS_pixel2x2_bot_14/vpd[0] rowReadON<0> GND DiffBn VSUBS VDD OnBn openDVS_pixel2x2_bot
XopenDVS_pixel2x2_bot_36 rowReadOFF<2> rowReadOFF<3> rowReadON<3> RefrBp PrBp PrSFBp
+ col_periphery_1x2_7/COL_LINE0 pixRst<40> pixRst<41> col_periphery_1x2_7/COL_LINE1
+ OffBn openDVS_pixel2x2_bot_36/vpd[2] openDVS_pixel2x2_bot_36/vpd[3] openDVS_pixel2x2_bot_36/vpd[1]
+ openDVS_pixel2x2_bot_36/vpd[0] rowReadON<2> openDVS_pixel2x2_bot_7/GndD DiffBn VSUBS
+ VDD OnBn openDVS_pixel2x2_bot
XopenDVS_pixel2x2_bot_424 rowReadOFF<34> rowReadOFF<35> rowReadON<35> RefrBp PrBp
+ PrSFBp col_periphery_1x2_20/COL_LINE0 pixRst<24> pixRst<25> col_periphery_1x2_20/COL_LINE1
+ OffBn openDVS_pixel2x2_bot_424/vpd[2] openDVS_pixel2x2_bot_424/vpd[3] openDVS_pixel2x2_bot_424/vpd[1]
+ openDVS_pixel2x2_bot_424/vpd[0] rowReadON<34> openDVS_pixel2x2_bot_995/GndD DiffBn
+ VSUBS VDD OnBn openDVS_pixel2x2_bot
XopenDVS_pixel2x2_bot_413 rowReadOFF<42> rowReadOFF<43> rowReadON<43> RefrBp PrBp
+ PrSFBp col_periphery_1x2_19/COL_LINE0 pixRst<22> pixRst<23> col_periphery_1x2_19/COL_LINE1
+ OffBn openDVS_pixel2x2_bot_413/vpd[2] openDVS_pixel2x2_bot_413/vpd[3] openDVS_pixel2x2_bot_413/vpd[1]
+ openDVS_pixel2x2_bot_413/vpd[0] rowReadON<42> openDVS_pixel2x2_bot_908/GndD DiffBn
+ VSUBS VDD OnBn openDVS_pixel2x2_bot
XopenDVS_pixel2x2_bot_435 rowReadOFF<36> rowReadOFF<37> rowReadON<37> RefrBp PrBp
+ PrSFBp col_periphery_1x2_17/COL_LINE0 pixRst<18> pixRst<19> col_periphery_1x2_17/COL_LINE1
+ OffBn openDVS_pixel2x2_bot_435/vpd[2] openDVS_pixel2x2_bot_435/vpd[3] openDVS_pixel2x2_bot_435/vpd[1]
+ openDVS_pixel2x2_bot_435/vpd[0] rowReadON<36> openDVS_pixel2x2_bot_997/GndD DiffBn
+ VSUBS VDD OnBn openDVS_pixel2x2_bot
XopenDVS_pixel2x2_bot_479 rowReadOFF<38> rowReadOFF<39> rowReadON<39> RefrBp PrBp
+ PrSFBp col_periphery_1x2_30/COL_LINE0 pixRst<12> pixRst<13> col_periphery_1x2_30/COL_LINE1
+ OffBn openDVS_pixel2x2_bot_479/vpd[2] openDVS_pixel2x2_bot_479/vpd[3] openDVS_pixel2x2_bot_479/vpd[1]
+ openDVS_pixel2x2_bot_479/vpd[0] rowReadON<38> openDVS_pixel2x2_bot_999/GndD DiffBn
+ VSUBS VDD OnBn openDVS_pixel2x2_bot
XopenDVS_pixel2x2_bot_402 rowReadOFF<30> rowReadOFF<31> rowReadON<31> RefrBp PrBp
+ PrSFBp col_periphery_1x2_20/COL_LINE0 pixRst<24> pixRst<25> col_periphery_1x2_20/COL_LINE1
+ OffBn openDVS_pixel2x2_bot_402/vpd[2] openDVS_pixel2x2_bot_402/vpd[3] openDVS_pixel2x2_bot_402/vpd[1]
+ openDVS_pixel2x2_bot_402/vpd[0] rowReadON<30> openDVS_pixel2x2_bot_991/GndD DiffBn
+ VSUBS VDD OnBn openDVS_pixel2x2_bot
XopenDVS_pixel2x2_bot_457 rowReadOFF<32> rowReadOFF<33> rowReadON<33> RefrBp PrBp
+ PrSFBp col_periphery_1x2_30/COL_LINE0 pixRst<12> pixRst<13> col_periphery_1x2_30/COL_LINE1
+ OffBn openDVS_pixel2x2_bot_457/vpd[2] openDVS_pixel2x2_bot_457/vpd[3] openDVS_pixel2x2_bot_457/vpd[1]
+ openDVS_pixel2x2_bot_457/vpd[0] rowReadON<32> openDVS_pixel2x2_bot_993/GndD DiffBn
+ VSUBS VDD OnBn openDVS_pixel2x2_bot
XopenDVS_pixel2x2_bot_446 rowReadOFF<32> rowReadOFF<33> rowReadON<33> RefrBp PrBp
+ PrSFBp col_periphery_1x2_26/COL_LINE0 pixRst<4> pixRst<5> col_periphery_1x2_26/COL_LINE1
+ OffBn openDVS_pixel2x2_bot_446/vpd[2] openDVS_pixel2x2_bot_446/vpd[3] openDVS_pixel2x2_bot_446/vpd[1]
+ openDVS_pixel2x2_bot_446/vpd[0] rowReadON<32> openDVS_pixel2x2_bot_993/GndD DiffBn
+ VSUBS VDD OnBn openDVS_pixel2x2_bot
XopenDVS_pixel2x2_bot_468 rowReadOFF<30> rowReadOFF<31> rowReadON<31> RefrBp PrBp
+ PrSFBp col_periphery_1x2_25/COL_LINE0 pixRst<2> pixRst<3> col_periphery_1x2_25/COL_LINE1
+ OffBn openDVS_pixel2x2_bot_468/vpd[2] openDVS_pixel2x2_bot_468/vpd[3] openDVS_pixel2x2_bot_468/vpd[1]
+ openDVS_pixel2x2_bot_468/vpd[0] rowReadON<30> openDVS_pixel2x2_bot_991/GndD DiffBn
+ VSUBS VDD OnBn openDVS_pixel2x2_bot
Xcol_periphery_1x2_2 pixRst<55> col_periphery_1x2_2/COL_LINE0 col_periphery_1x2_2/COL_LINE1
+ nDETECT DETECT col_periphery_1x2_9/VDD VTHRESH pixRst<54> voutn<54> VSUBS voutn<55>
+ NCHARGE col_periphery_1x2
XopenDVS_pixel2x2_bot_980 rowReadOFF<26> rowReadOFF<27> rowReadON<27> RefrBp PrBp
+ PrSFBp col_periphery_1x2_15/COL_LINE0 pixRst<48> pixRst<49> col_periphery_1x2_15/COL_LINE1
+ OffBn openDVS_pixel2x2_bot_980/vpd[2] openDVS_pixel2x2_bot_980/vpd[3] openDVS_pixel2x2_bot_980/vpd[1]
+ openDVS_pixel2x2_bot_980/vpd[0] rowReadON<26> openDVS_pixel2x2_bot_987/GndD DiffBn
+ VSUBS VDD OnBn openDVS_pixel2x2_bot
XopenDVS_pixel2x2_bot_991 rowReadOFF<30> rowReadOFF<31> rowReadON<31> RefrBp PrBp
+ PrSFBp col_periphery_1x2_9/COL_LINE0 pixRst<32> pixRst<33> col_periphery_1x2_9/COL_LINE1
+ OffBn openDVS_pixel2x2_bot_991/vpd[2] openDVS_pixel2x2_bot_991/vpd[3] openDVS_pixel2x2_bot_991/vpd[1]
+ openDVS_pixel2x2_bot_991/vpd[0] rowReadON<30> openDVS_pixel2x2_bot_991/GndD DiffBn
+ VSUBS VDD OnBn openDVS_pixel2x2_bot
XopenDVS_pixel2x2_bot_298 rowReadOFF<12> rowReadOFF<13> rowReadON<13> RefrBp PrBp
+ PrSFBp col_periphery_1x2_17/COL_LINE0 pixRst<18> pixRst<19> col_periphery_1x2_17/COL_LINE1
+ OffBn openDVS_pixel2x2_bot_298/vpd[2] openDVS_pixel2x2_bot_298/vpd[3] openDVS_pixel2x2_bot_298/vpd[1]
+ openDVS_pixel2x2_bot_298/vpd[0] rowReadON<12> openDVS_pixel2x2_bot_79/GndD DiffBn
+ VSUBS VDD OnBn openDVS_pixel2x2_bot
XopenDVS_pixel2x2_bot_265 rowReadOFF<14> rowReadOFF<15> rowReadON<15> RefrBp PrBp
+ PrSFBp col_periphery_1x2_30/COL_LINE0 pixRst<12> pixRst<13> col_periphery_1x2_30/COL_LINE1
+ OffBn openDVS_pixel2x2_bot_265/vpd[2] openDVS_pixel2x2_bot_265/vpd[3] openDVS_pixel2x2_bot_265/vpd[1]
+ openDVS_pixel2x2_bot_265/vpd[0] rowReadON<14> openDVS_pixel2x2_bot_78/GndD DiffBn
+ VSUBS VDD OnBn openDVS_pixel2x2_bot
XopenDVS_pixel2x2_bot_254 rowReadOFF<18> rowReadOFF<19> rowReadON<19> RefrBp PrBp
+ PrSFBp col_periphery_1x2_24/COL_LINE0 pixRst<0> pixRst<1> col_periphery_1x2_24/COL_LINE1
+ OffBn openDVS_pixel2x2_bot_254/vpd[2] openDVS_pixel2x2_bot_254/vpd[3] openDVS_pixel2x2_bot_254/vpd[1]
+ openDVS_pixel2x2_bot_254/vpd[0] rowReadON<18> openDVS_pixel2x2_bot_69/GndD DiffBn
+ VSUBS VDD OnBn openDVS_pixel2x2_bot
XopenDVS_pixel2x2_bot_276 rowReadOFF<16> rowReadOFF<17> rowReadON<17> RefrBp PrBp
+ PrSFBp col_periphery_1x2_24/COL_LINE0 pixRst<0> pixRst<1> col_periphery_1x2_24/COL_LINE1
+ OffBn openDVS_pixel2x2_bot_276/vpd[2] openDVS_pixel2x2_bot_276/vpd[3] openDVS_pixel2x2_bot_276/vpd[1]
+ openDVS_pixel2x2_bot_276/vpd[0] rowReadON<16> openDVS_pixel2x2_bot_91/GndD DiffBn
+ VSUBS VDD OnBn openDVS_pixel2x2_bot
XopenDVS_pixel2x2_bot_243 rowReadOFF<12> rowReadOFF<13> rowReadON<13> RefrBp PrBp
+ PrSFBp col_periphery_1x2_25/COL_LINE0 pixRst<2> pixRst<3> col_periphery_1x2_25/COL_LINE1
+ OffBn openDVS_pixel2x2_bot_243/vpd[2] openDVS_pixel2x2_bot_243/vpd[3] openDVS_pixel2x2_bot_243/vpd[1]
+ openDVS_pixel2x2_bot_243/vpd[0] rowReadON<12> openDVS_pixel2x2_bot_79/GndD DiffBn
+ VSUBS VDD OnBn openDVS_pixel2x2_bot
XopenDVS_pixel2x2_bot_221 rowReadOFF<0> rowReadOFF<1> rowReadON<1> RefrBp PrBp PrSFBp
+ col_periphery_1x2_25/COL_LINE0 pixRst<2> pixRst<3> col_periphery_1x2_25/COL_LINE1
+ OffBn openDVS_pixel2x2_bot_221/vpd[2] openDVS_pixel2x2_bot_221/vpd[3] openDVS_pixel2x2_bot_221/vpd[1]
+ openDVS_pixel2x2_bot_221/vpd[0] rowReadON<0> GND DiffBn VSUBS VDD OnBn openDVS_pixel2x2_bot
XopenDVS_pixel2x2_bot_210 rowReadOFF<0> rowReadOFF<1> rowReadON<1> RefrBp PrBp PrSFBp
+ col_periphery_1x2_21/COL_LINE0 pixRst<26> pixRst<27> col_periphery_1x2_21/COL_LINE1
+ OffBn openDVS_pixel2x2_bot_210/vpd[2] openDVS_pixel2x2_bot_210/vpd[3] openDVS_pixel2x2_bot_210/vpd[1]
+ openDVS_pixel2x2_bot_210/vpd[0] rowReadON<0> GND DiffBn VSUBS VDD OnBn openDVS_pixel2x2_bot
XopenDVS_pixel2x2_bot_232 rowReadOFF<2> rowReadOFF<3> rowReadON<3> RefrBp PrBp PrSFBp
+ col_periphery_1x2_25/COL_LINE0 pixRst<2> pixRst<3> col_periphery_1x2_25/COL_LINE1
+ OffBn openDVS_pixel2x2_bot_232/vpd[2] openDVS_pixel2x2_bot_232/vpd[3] openDVS_pixel2x2_bot_232/vpd[1]
+ openDVS_pixel2x2_bot_232/vpd[0] rowReadON<2> openDVS_pixel2x2_bot_7/GndD DiffBn
+ VSUBS VDD OnBn openDVS_pixel2x2_bot
XopenDVS_pixel2x2_bot_287 rowReadOFF<10> rowReadOFF<11> rowReadON<11> RefrBp PrBp
+ PrSFBp col_periphery_1x2_30/COL_LINE0 pixRst<12> pixRst<13> col_periphery_1x2_30/COL_LINE1
+ OffBn openDVS_pixel2x2_bot_287/vpd[2] openDVS_pixel2x2_bot_287/vpd[3] openDVS_pixel2x2_bot_287/vpd[1]
+ openDVS_pixel2x2_bot_287/vpd[0] rowReadON<10> openDVS_pixel2x2_bot_82/GndD DiffBn
+ VSUBS VDD OnBn openDVS_pixel2x2_bot
XopenDVS_pixel2x2_bot_809 rowReadOFF<58> rowReadOFF<59> rowReadON<59> RefrBp PrBp
+ PrSFBp col_periphery_1x2_10/COL_LINE0 pixRst<34> pixRst<35> col_periphery_1x2_10/COL_LINE1
+ OffBn openDVS_pixel2x2_bot_809/vpd[2] openDVS_pixel2x2_bot_809/vpd[3] openDVS_pixel2x2_bot_809/vpd[1]
+ openDVS_pixel2x2_bot_809/vpd[0] rowReadON<58> openDVS_pixel2x2_bot_890/GndD DiffBn
+ VSUBS VDD OnBn openDVS_pixel2x2_bot
XopenDVS_pixel2x2_bot_628 rowReadOFF<44> rowReadOFF<45> rowReadON<45> RefrBp PrBp
+ PrSFBp col_periphery_1x2_19/COL_LINE0 pixRst<22> pixRst<23> col_periphery_1x2_19/COL_LINE1
+ OffBn openDVS_pixel2x2_bot_628/vpd[2] openDVS_pixel2x2_bot_628/vpd[3] openDVS_pixel2x2_bot_628/vpd[1]
+ openDVS_pixel2x2_bot_628/vpd[0] rowReadON<44> openDVS_pixel2x2_bot_923/GndD DiffBn
+ VSUBS VDD OnBn openDVS_pixel2x2_bot
XopenDVS_pixel2x2_bot_606 rowReadOFF<50> rowReadOFF<51> rowReadON<51> RefrBp PrBp
+ PrSFBp col_periphery_1x2_17/COL_LINE0 pixRst<18> pixRst<19> col_periphery_1x2_17/COL_LINE1
+ OffBn openDVS_pixel2x2_bot_606/vpd[2] openDVS_pixel2x2_bot_606/vpd[3] openDVS_pixel2x2_bot_606/vpd[1]
+ openDVS_pixel2x2_bot_606/vpd[0] rowReadON<50> openDVS_pixel2x2_bot_929/GndD DiffBn
+ VSUBS VDD OnBn openDVS_pixel2x2_bot
XopenDVS_pixel2x2_bot_639 rowReadOFF<46> rowReadOFF<47> rowReadON<47> RefrBp PrBp
+ PrSFBp col_periphery_1x2_16/COL_LINE0 pixRst<16> pixRst<17> col_periphery_1x2_16/COL_LINE1
+ OffBn openDVS_pixel2x2_bot_639/vpd[2] openDVS_pixel2x2_bot_639/vpd[3] openDVS_pixel2x2_bot_639/vpd[1]
+ openDVS_pixel2x2_bot_639/vpd[0] rowReadON<46> openDVS_pixel2x2_bot_925/GndD DiffBn
+ VSUBS VDD OnBn openDVS_pixel2x2_bot
XopenDVS_pixel2x2_bot_617 rowReadOFF<44> rowReadOFF<45> rowReadON<45> RefrBp PrBp
+ PrSFBp col_periphery_1x2_24/COL_LINE0 pixRst<0> pixRst<1> col_periphery_1x2_24/COL_LINE1
+ OffBn openDVS_pixel2x2_bot_617/vpd[2] openDVS_pixel2x2_bot_617/vpd[3] openDVS_pixel2x2_bot_617/vpd[1]
+ openDVS_pixel2x2_bot_617/vpd[0] rowReadON<44> openDVS_pixel2x2_bot_923/GndD DiffBn
+ VSUBS VDD OnBn openDVS_pixel2x2_bot
XopenDVS_pixel2x2_bot_59 rowReadOFF<24> rowReadOFF<25> rowReadON<25> RefrBp PrBp PrSFBp
+ col_periphery_1x2_8/COL_LINE0 pixRst<42> pixRst<43> col_periphery_1x2_8/COL_LINE1
+ OffBn openDVS_pixel2x2_bot_59/vpd[2] openDVS_pixel2x2_bot_59/vpd[3] openDVS_pixel2x2_bot_59/vpd[1]
+ openDVS_pixel2x2_bot_59/vpd[0] rowReadON<24> openDVS_pixel2x2_bot_99/GndD DiffBn
+ VSUBS VDD OnBn openDVS_pixel2x2_bot
XopenDVS_pixel2x2_bot_48 rowReadOFF<22> rowReadOFF<23> rowReadON<23> RefrBp PrBp PrSFBp
+ col_periphery_1x2_10/COL_LINE0 pixRst<34> pixRst<35> col_periphery_1x2_10/COL_LINE1
+ OffBn openDVS_pixel2x2_bot_48/vpd[2] openDVS_pixel2x2_bot_48/vpd[3] openDVS_pixel2x2_bot_48/vpd[1]
+ openDVS_pixel2x2_bot_48/vpd[0] rowReadON<22> openDVS_pixel2x2_bot_97/GndD DiffBn
+ VSUBS VDD OnBn openDVS_pixel2x2_bot
XopenDVS_pixel2x2_bot_15 rowReadOFF<2> rowReadOFF<3> rowReadON<3> RefrBp PrBp PrSFBp
+ col_periphery_1x2_3/COL_LINE0 pixRst<56> pixRst<57> col_periphery_1x2_3/COL_LINE1
+ OffBn openDVS_pixel2x2_bot_15/vpd[2] openDVS_pixel2x2_bot_15/vpd[3] openDVS_pixel2x2_bot_15/vpd[1]
+ openDVS_pixel2x2_bot_15/vpd[0] rowReadON<2> openDVS_pixel2x2_bot_7/GndD DiffBn VSUBS
+ VDD OnBn openDVS_pixel2x2_bot
XopenDVS_pixel2x2_bot_37 rowReadOFF<2> rowReadOFF<3> rowReadON<3> RefrBp PrBp PrSFBp
+ col_periphery_1x2_8/COL_LINE0 pixRst<42> pixRst<43> col_periphery_1x2_8/COL_LINE1
+ OffBn openDVS_pixel2x2_bot_37/vpd[2] openDVS_pixel2x2_bot_37/vpd[3] openDVS_pixel2x2_bot_37/vpd[1]
+ openDVS_pixel2x2_bot_37/vpd[0] rowReadON<2> openDVS_pixel2x2_bot_7/GndD DiffBn VSUBS
+ VDD OnBn openDVS_pixel2x2_bot
XopenDVS_pixel2x2_bot_26 rowReadOFF<2> rowReadOFF<3> rowReadON<3> RefrBp PrBp PrSFBp
+ col_periphery_1x2_13/COL_LINE0 pixRst<44> pixRst<45> col_periphery_1x2_13/COL_LINE1
+ OffBn openDVS_pixel2x2_bot_26/vpd[2] openDVS_pixel2x2_bot_26/vpd[3] openDVS_pixel2x2_bot_26/vpd[1]
+ openDVS_pixel2x2_bot_26/vpd[0] rowReadON<2> openDVS_pixel2x2_bot_7/GndD DiffBn VSUBS
+ VDD OnBn openDVS_pixel2x2_bot
XopenDVS_pixel2x2_bot_425 rowReadOFF<34> rowReadOFF<35> rowReadON<35> RefrBp PrBp
+ PrSFBp col_periphery_1x2_21/COL_LINE0 pixRst<26> pixRst<27> col_periphery_1x2_21/COL_LINE1
+ OffBn openDVS_pixel2x2_bot_425/vpd[2] openDVS_pixel2x2_bot_425/vpd[3] openDVS_pixel2x2_bot_425/vpd[1]
+ openDVS_pixel2x2_bot_425/vpd[0] rowReadON<34> openDVS_pixel2x2_bot_995/GndD DiffBn
+ VSUBS VDD OnBn openDVS_pixel2x2_bot
XopenDVS_pixel2x2_bot_414 rowReadOFF<42> rowReadOFF<43> rowReadON<43> RefrBp PrBp
+ PrSFBp col_periphery_1x2_20/COL_LINE0 pixRst<24> pixRst<25> col_periphery_1x2_20/COL_LINE1
+ OffBn openDVS_pixel2x2_bot_414/vpd[2] openDVS_pixel2x2_bot_414/vpd[3] openDVS_pixel2x2_bot_414/vpd[1]
+ openDVS_pixel2x2_bot_414/vpd[0] rowReadON<42> openDVS_pixel2x2_bot_908/GndD DiffBn
+ VSUBS VDD OnBn openDVS_pixel2x2_bot
XopenDVS_pixel2x2_bot_436 rowReadOFF<36> rowReadOFF<37> rowReadON<37> RefrBp PrBp
+ PrSFBp col_periphery_1x2_18/COL_LINE0 pixRst<20> pixRst<21> col_periphery_1x2_18/COL_LINE1
+ OffBn openDVS_pixel2x2_bot_436/vpd[2] openDVS_pixel2x2_bot_436/vpd[3] openDVS_pixel2x2_bot_436/vpd[1]
+ openDVS_pixel2x2_bot_436/vpd[0] rowReadON<36> openDVS_pixel2x2_bot_997/GndD DiffBn
+ VSUBS VDD OnBn openDVS_pixel2x2_bot
XopenDVS_pixel2x2_bot_458 rowReadOFF<36> rowReadOFF<37> rowReadON<37> RefrBp PrBp
+ PrSFBp col_periphery_1x2_28/COL_LINE0 pixRst<8> pixRst<9> col_periphery_1x2_28/COL_LINE1
+ OffBn openDVS_pixel2x2_bot_458/vpd[2] openDVS_pixel2x2_bot_458/vpd[3] openDVS_pixel2x2_bot_458/vpd[1]
+ openDVS_pixel2x2_bot_458/vpd[0] rowReadON<36> openDVS_pixel2x2_bot_997/GndD DiffBn
+ VSUBS VDD OnBn openDVS_pixel2x2_bot
XopenDVS_pixel2x2_bot_403 rowReadOFF<30> rowReadOFF<31> rowReadON<31> RefrBp PrBp
+ PrSFBp col_periphery_1x2_21/COL_LINE0 pixRst<26> pixRst<27> col_periphery_1x2_21/COL_LINE1
+ OffBn openDVS_pixel2x2_bot_403/vpd[2] openDVS_pixel2x2_bot_403/vpd[3] openDVS_pixel2x2_bot_403/vpd[1]
+ openDVS_pixel2x2_bot_403/vpd[0] rowReadON<30> openDVS_pixel2x2_bot_991/GndD DiffBn
+ VSUBS VDD OnBn openDVS_pixel2x2_bot
XopenDVS_pixel2x2_bot_447 rowReadOFF<32> rowReadOFF<33> rowReadON<33> RefrBp PrBp
+ PrSFBp col_periphery_1x2_27/COL_LINE0 pixRst<6> pixRst<7> col_periphery_1x2_27/COL_LINE1
+ OffBn openDVS_pixel2x2_bot_447/vpd[2] openDVS_pixel2x2_bot_447/vpd[3] openDVS_pixel2x2_bot_447/vpd[1]
+ openDVS_pixel2x2_bot_447/vpd[0] rowReadON<32> openDVS_pixel2x2_bot_993/GndD DiffBn
+ VSUBS VDD OnBn openDVS_pixel2x2_bot
XopenDVS_pixel2x2_bot_469 rowReadOFF<30> rowReadOFF<31> rowReadON<31> RefrBp PrBp
+ PrSFBp col_periphery_1x2_26/COL_LINE0 pixRst<4> pixRst<5> col_periphery_1x2_26/COL_LINE1
+ OffBn openDVS_pixel2x2_bot_469/vpd[2] openDVS_pixel2x2_bot_469/vpd[3] openDVS_pixel2x2_bot_469/vpd[1]
+ openDVS_pixel2x2_bot_469/vpd[0] rowReadON<30> openDVS_pixel2x2_bot_991/GndD DiffBn
+ VSUBS VDD OnBn openDVS_pixel2x2_bot
Xcol_periphery_1x2_3 pixRst<57> col_periphery_1x2_3/COL_LINE0 col_periphery_1x2_3/COL_LINE1
+ nDETECT DETECT col_periphery_1x2_9/VDD VTHRESH pixRst<56> voutn<56> VSUBS voutn<57>
+ NCHARGE col_periphery_1x2
XopenDVS_pixel2x2_bot_981 rowReadOFF<26> rowReadOFF<27> rowReadON<27> RefrBp PrBp
+ PrSFBp col_periphery_1x2_0/COL_LINE0 pixRst<50> pixRst<51> col_periphery_1x2_0/COL_LINE1
+ OffBn openDVS_pixel2x2_bot_981/vpd[2] openDVS_pixel2x2_bot_981/vpd[3] openDVS_pixel2x2_bot_981/vpd[1]
+ openDVS_pixel2x2_bot_981/vpd[0] rowReadON<26> openDVS_pixel2x2_bot_987/GndD DiffBn
+ VSUBS VDD OnBn openDVS_pixel2x2_bot
XopenDVS_pixel2x2_bot_992 rowReadOFF<32> rowReadOFF<33> rowReadON<33> RefrBp PrBp
+ PrSFBp col_periphery_1x2_23/COL_LINE0 pixRst<30> pixRst<31> col_periphery_1x2_23/COL_LINE1
+ OffBn openDVS_pixel2x2_bot_992/vpd[2] openDVS_pixel2x2_bot_992/vpd[3] openDVS_pixel2x2_bot_992/vpd[1]
+ openDVS_pixel2x2_bot_992/vpd[0] rowReadON<32> openDVS_pixel2x2_bot_993/GndD DiffBn
+ VSUBS VDD OnBn openDVS_pixel2x2_bot
XopenDVS_pixel2x2_bot_970 rowReadOFF<26> rowReadOFF<27> rowReadON<27> RefrBp PrBp
+ PrSFBp col_periphery_1x2_22/COL_LINE0 pixRst<28> pixRst<29> col_periphery_1x2_22/COL_LINE1
+ OffBn openDVS_pixel2x2_bot_970/vpd[2] openDVS_pixel2x2_bot_970/vpd[3] openDVS_pixel2x2_bot_970/vpd[1]
+ openDVS_pixel2x2_bot_970/vpd[0] rowReadON<26> openDVS_pixel2x2_bot_987/GndD DiffBn
+ VSUBS VDD OnBn openDVS_pixel2x2_bot
XopenDVS_pixel2x2_bot_299 rowReadOFF<12> rowReadOFF<13> rowReadON<13> RefrBp PrBp
+ PrSFBp col_periphery_1x2_18/COL_LINE0 pixRst<20> pixRst<21> col_periphery_1x2_18/COL_LINE1
+ OffBn openDVS_pixel2x2_bot_299/vpd[2] openDVS_pixel2x2_bot_299/vpd[3] openDVS_pixel2x2_bot_299/vpd[1]
+ openDVS_pixel2x2_bot_299/vpd[0] rowReadON<12> openDVS_pixel2x2_bot_79/GndD DiffBn
+ VSUBS VDD OnBn openDVS_pixel2x2_bot
XopenDVS_pixel2x2_bot_288 rowReadOFF<16> rowReadOFF<17> rowReadON<17> RefrBp PrBp
+ PrSFBp col_periphery_1x2_28/COL_LINE0 pixRst<8> pixRst<9> col_periphery_1x2_28/COL_LINE1
+ OffBn openDVS_pixel2x2_bot_288/vpd[2] openDVS_pixel2x2_bot_288/vpd[3] openDVS_pixel2x2_bot_288/vpd[1]
+ openDVS_pixel2x2_bot_288/vpd[0] rowReadON<16> openDVS_pixel2x2_bot_91/GndD DiffBn
+ VSUBS VDD OnBn openDVS_pixel2x2_bot
XopenDVS_pixel2x2_bot_266 rowReadOFF<18> rowReadOFF<19> rowReadON<19> RefrBp PrBp
+ PrSFBp col_periphery_1x2_27/COL_LINE0 pixRst<6> pixRst<7> col_periphery_1x2_27/COL_LINE1
+ OffBn openDVS_pixel2x2_bot_266/vpd[2] openDVS_pixel2x2_bot_266/vpd[3] openDVS_pixel2x2_bot_266/vpd[1]
+ openDVS_pixel2x2_bot_266/vpd[0] rowReadON<18> openDVS_pixel2x2_bot_69/GndD DiffBn
+ VSUBS VDD OnBn openDVS_pixel2x2_bot
XopenDVS_pixel2x2_bot_244 rowReadOFF<12> rowReadOFF<13> rowReadON<13> RefrBp PrBp
+ PrSFBp col_periphery_1x2_26/COL_LINE0 pixRst<4> pixRst<5> col_periphery_1x2_26/COL_LINE1
+ OffBn openDVS_pixel2x2_bot_244/vpd[2] openDVS_pixel2x2_bot_244/vpd[3] openDVS_pixel2x2_bot_244/vpd[1]
+ openDVS_pixel2x2_bot_244/vpd[0] rowReadON<12> openDVS_pixel2x2_bot_79/GndD DiffBn
+ VSUBS VDD OnBn openDVS_pixel2x2_bot
XopenDVS_pixel2x2_bot_255 rowReadOFF<18> rowReadOFF<19> rowReadON<19> RefrBp PrBp
+ PrSFBp col_periphery_1x2_25/COL_LINE0 pixRst<2> pixRst<3> col_periphery_1x2_25/COL_LINE1
+ OffBn openDVS_pixel2x2_bot_255/vpd[2] openDVS_pixel2x2_bot_255/vpd[3] openDVS_pixel2x2_bot_255/vpd[1]
+ openDVS_pixel2x2_bot_255/vpd[0] rowReadON<18> openDVS_pixel2x2_bot_69/GndD DiffBn
+ VSUBS VDD OnBn openDVS_pixel2x2_bot
XopenDVS_pixel2x2_bot_277 rowReadOFF<16> rowReadOFF<17> rowReadON<17> RefrBp PrBp
+ PrSFBp col_periphery_1x2_25/COL_LINE0 pixRst<2> pixRst<3> col_periphery_1x2_25/COL_LINE1
+ OffBn openDVS_pixel2x2_bot_277/vpd[2] openDVS_pixel2x2_bot_277/vpd[3] openDVS_pixel2x2_bot_277/vpd[1]
+ openDVS_pixel2x2_bot_277/vpd[0] rowReadON<16> openDVS_pixel2x2_bot_91/GndD DiffBn
+ VSUBS VDD OnBn openDVS_pixel2x2_bot
XopenDVS_pixel2x2_bot_222 rowReadOFF<0> rowReadOFF<1> rowReadON<1> RefrBp PrBp PrSFBp
+ col_periphery_1x2_26/COL_LINE0 pixRst<4> pixRst<5> col_periphery_1x2_26/COL_LINE1
+ OffBn openDVS_pixel2x2_bot_222/vpd[2] openDVS_pixel2x2_bot_222/vpd[3] openDVS_pixel2x2_bot_222/vpd[1]
+ openDVS_pixel2x2_bot_222/vpd[0] rowReadON<0> GND DiffBn VSUBS VDD OnBn openDVS_pixel2x2_bot
XopenDVS_pixel2x2_bot_211 rowReadOFF<0> rowReadOFF<1> rowReadON<1> RefrBp PrBp PrSFBp
+ col_periphery_1x2_22/COL_LINE0 pixRst<28> pixRst<29> col_periphery_1x2_22/COL_LINE1
+ OffBn openDVS_pixel2x2_bot_211/vpd[2] openDVS_pixel2x2_bot_211/vpd[3] openDVS_pixel2x2_bot_211/vpd[1]
+ openDVS_pixel2x2_bot_211/vpd[0] rowReadON<0> GND DiffBn VSUBS VDD OnBn openDVS_pixel2x2_bot
XopenDVS_pixel2x2_bot_233 rowReadOFF<2> rowReadOFF<3> rowReadON<3> RefrBp PrBp PrSFBp
+ col_periphery_1x2_26/COL_LINE0 pixRst<4> pixRst<5> col_periphery_1x2_26/COL_LINE1
+ OffBn openDVS_pixel2x2_bot_233/vpd[2] openDVS_pixel2x2_bot_233/vpd[3] openDVS_pixel2x2_bot_233/vpd[1]
+ openDVS_pixel2x2_bot_233/vpd[0] rowReadON<2> openDVS_pixel2x2_bot_7/GndD DiffBn
+ VSUBS VDD OnBn openDVS_pixel2x2_bot
XopenDVS_pixel2x2_bot_200 rowReadOFF<2> rowReadOFF<3> rowReadON<3> RefrBp PrBp PrSFBp
+ col_periphery_1x2_18/COL_LINE0 pixRst<20> pixRst<21> col_periphery_1x2_18/COL_LINE1
+ OffBn openDVS_pixel2x2_bot_200/vpd[2] openDVS_pixel2x2_bot_200/vpd[3] openDVS_pixel2x2_bot_200/vpd[1]
+ openDVS_pixel2x2_bot_200/vpd[0] rowReadON<2> openDVS_pixel2x2_bot_7/GndD DiffBn
+ VSUBS VDD OnBn openDVS_pixel2x2_bot
XopenDVS_pixel2x2_bot_629 rowReadOFF<44> rowReadOFF<45> rowReadON<45> RefrBp PrBp
+ PrSFBp col_periphery_1x2_20/COL_LINE0 pixRst<24> pixRst<25> col_periphery_1x2_20/COL_LINE1
+ OffBn openDVS_pixel2x2_bot_629/vpd[2] openDVS_pixel2x2_bot_629/vpd[3] openDVS_pixel2x2_bot_629/vpd[1]
+ openDVS_pixel2x2_bot_629/vpd[0] rowReadON<44> openDVS_pixel2x2_bot_923/GndD DiffBn
+ VSUBS VDD OnBn openDVS_pixel2x2_bot
XopenDVS_pixel2x2_bot_607 rowReadOFF<50> rowReadOFF<51> rowReadON<51> RefrBp PrBp
+ PrSFBp col_periphery_1x2_18/COL_LINE0 pixRst<20> pixRst<21> col_periphery_1x2_18/COL_LINE1
+ OffBn openDVS_pixel2x2_bot_607/vpd[2] openDVS_pixel2x2_bot_607/vpd[3] openDVS_pixel2x2_bot_607/vpd[1]
+ openDVS_pixel2x2_bot_607/vpd[0] rowReadON<50> openDVS_pixel2x2_bot_929/GndD DiffBn
+ VSUBS VDD OnBn openDVS_pixel2x2_bot
XopenDVS_pixel2x2_bot_618 rowReadOFF<44> rowReadOFF<45> rowReadON<45> RefrBp PrBp
+ PrSFBp col_periphery_1x2_25/COL_LINE0 pixRst<2> pixRst<3> col_periphery_1x2_25/COL_LINE1
+ OffBn openDVS_pixel2x2_bot_618/vpd[2] openDVS_pixel2x2_bot_618/vpd[3] openDVS_pixel2x2_bot_618/vpd[1]
+ openDVS_pixel2x2_bot_618/vpd[0] rowReadON<44> openDVS_pixel2x2_bot_923/GndD DiffBn
+ VSUBS VDD OnBn openDVS_pixel2x2_bot
XopenDVS_pixel2x2_bot_49 rowReadOFF<12> rowReadOFF<13> rowReadON<13> RefrBp PrBp PrSFBp
+ col_periphery_1x2_7/COL_LINE0 pixRst<40> pixRst<41> col_periphery_1x2_7/COL_LINE1
+ OffBn openDVS_pixel2x2_bot_49/vpd[2] openDVS_pixel2x2_bot_49/vpd[3] openDVS_pixel2x2_bot_49/vpd[1]
+ openDVS_pixel2x2_bot_49/vpd[0] rowReadON<12> openDVS_pixel2x2_bot_79/GndD DiffBn
+ VSUBS VDD OnBn openDVS_pixel2x2_bot
XopenDVS_pixel2x2_bot_16 rowReadOFF<2> rowReadOFF<3> rowReadON<3> RefrBp PrBp PrSFBp
+ col_periphery_1x2_4/COL_LINE0 pixRst<58> pixRst<59> col_periphery_1x2_4/COL_LINE1
+ OffBn openDVS_pixel2x2_bot_16/vpd[2] openDVS_pixel2x2_bot_16/vpd[3] openDVS_pixel2x2_bot_16/vpd[1]
+ openDVS_pixel2x2_bot_16/vpd[0] rowReadON<2> openDVS_pixel2x2_bot_7/GndD DiffBn VSUBS
+ VDD OnBn openDVS_pixel2x2_bot
XopenDVS_pixel2x2_bot_38 rowReadOFF<0> rowReadOFF<1> rowReadON<1> RefrBp PrBp PrSFBp
+ col_periphery_1x2_10/COL_LINE0 pixRst<34> pixRst<35> col_periphery_1x2_10/COL_LINE1
+ OffBn openDVS_pixel2x2_bot_38/vpd[2] openDVS_pixel2x2_bot_38/vpd[3] openDVS_pixel2x2_bot_38/vpd[1]
+ openDVS_pixel2x2_bot_38/vpd[0] rowReadON<0> GND DiffBn VSUBS VDD OnBn openDVS_pixel2x2_bot
XopenDVS_pixel2x2_bot_27 rowReadOFF<4> rowReadOFF<5> rowReadON<5> RefrBp PrBp PrSFBp
+ col_periphery_1x2_11/COL_LINE0 pixRst<36> pixRst<37> col_periphery_1x2_11/COL_LINE1
+ OffBn openDVS_pixel2x2_bot_27/vpd[2] openDVS_pixel2x2_bot_27/vpd[3] openDVS_pixel2x2_bot_27/vpd[1]
+ openDVS_pixel2x2_bot_27/vpd[0] rowReadON<4> openDVS_pixel2x2_bot_6/GndD DiffBn VSUBS
+ VDD OnBn openDVS_pixel2x2_bot
XopenDVS_pixel2x2_bot_426 rowReadOFF<34> rowReadOFF<35> rowReadON<35> RefrBp PrBp
+ PrSFBp col_periphery_1x2_22/COL_LINE0 pixRst<28> pixRst<29> col_periphery_1x2_22/COL_LINE1
+ OffBn openDVS_pixel2x2_bot_426/vpd[2] openDVS_pixel2x2_bot_426/vpd[3] openDVS_pixel2x2_bot_426/vpd[1]
+ openDVS_pixel2x2_bot_426/vpd[0] rowReadON<34> openDVS_pixel2x2_bot_995/GndD DiffBn
+ VSUBS VDD OnBn openDVS_pixel2x2_bot
XopenDVS_pixel2x2_bot_415 rowReadOFF<42> rowReadOFF<43> rowReadON<43> RefrBp PrBp
+ PrSFBp col_periphery_1x2_21/COL_LINE0 pixRst<26> pixRst<27> col_periphery_1x2_21/COL_LINE1
+ OffBn openDVS_pixel2x2_bot_415/vpd[2] openDVS_pixel2x2_bot_415/vpd[3] openDVS_pixel2x2_bot_415/vpd[1]
+ openDVS_pixel2x2_bot_415/vpd[0] rowReadON<42> openDVS_pixel2x2_bot_908/GndD DiffBn
+ VSUBS VDD OnBn openDVS_pixel2x2_bot
XopenDVS_pixel2x2_bot_437 rowReadOFF<36> rowReadOFF<37> rowReadON<37> RefrBp PrBp
+ PrSFBp col_periphery_1x2_19/COL_LINE0 pixRst<22> pixRst<23> col_periphery_1x2_19/COL_LINE1
+ OffBn openDVS_pixel2x2_bot_437/vpd[2] openDVS_pixel2x2_bot_437/vpd[3] openDVS_pixel2x2_bot_437/vpd[1]
+ openDVS_pixel2x2_bot_437/vpd[0] rowReadON<36> openDVS_pixel2x2_bot_997/GndD DiffBn
+ VSUBS VDD OnBn openDVS_pixel2x2_bot
XopenDVS_pixel2x2_bot_459 rowReadOFF<36> rowReadOFF<37> rowReadON<37> RefrBp PrBp
+ PrSFBp col_periphery_1x2_29/COL_LINE0 pixRst<10> pixRst<11> col_periphery_1x2_29/COL_LINE1
+ OffBn openDVS_pixel2x2_bot_459/vpd[2] openDVS_pixel2x2_bot_459/vpd[3] openDVS_pixel2x2_bot_459/vpd[1]
+ openDVS_pixel2x2_bot_459/vpd[0] rowReadON<36> openDVS_pixel2x2_bot_997/GndD DiffBn
+ VSUBS VDD OnBn openDVS_pixel2x2_bot
XopenDVS_pixel2x2_bot_404 rowReadOFF<30> rowReadOFF<31> rowReadON<31> RefrBp PrBp
+ PrSFBp col_periphery_1x2_22/COL_LINE0 pixRst<28> pixRst<29> col_periphery_1x2_22/COL_LINE1
+ OffBn openDVS_pixel2x2_bot_404/vpd[2] openDVS_pixel2x2_bot_404/vpd[3] openDVS_pixel2x2_bot_404/vpd[1]
+ openDVS_pixel2x2_bot_404/vpd[0] rowReadON<30> openDVS_pixel2x2_bot_991/GndD DiffBn
+ VSUBS VDD OnBn openDVS_pixel2x2_bot
XopenDVS_pixel2x2_bot_448 rowReadOFF<32> rowReadOFF<33> rowReadON<33> RefrBp PrBp
+ PrSFBp col_periphery_1x2_28/COL_LINE0 pixRst<8> pixRst<9> col_periphery_1x2_28/COL_LINE1
+ OffBn openDVS_pixel2x2_bot_448/vpd[2] openDVS_pixel2x2_bot_448/vpd[3] openDVS_pixel2x2_bot_448/vpd[1]
+ openDVS_pixel2x2_bot_448/vpd[0] rowReadON<32> openDVS_pixel2x2_bot_993/GndD DiffBn
+ VSUBS VDD OnBn openDVS_pixel2x2_bot
Xcol_periphery_1x2_4 pixRst<59> col_periphery_1x2_4/COL_LINE0 col_periphery_1x2_4/COL_LINE1
+ nDETECT DETECT col_periphery_1x2_9/VDD VTHRESH pixRst<58> voutn<58> VSUBS voutn<59>
+ NCHARGE col_periphery_1x2
XopenDVS_pixel2x2_bot_982 rowReadOFF<26> rowReadOFF<27> rowReadON<27> RefrBp PrBp
+ PrSFBp col_periphery_1x2_1/COL_LINE0 pixRst<52> pixRst<53> col_periphery_1x2_1/COL_LINE1
+ OffBn openDVS_pixel2x2_bot_982/vpd[2] openDVS_pixel2x2_bot_982/vpd[3] openDVS_pixel2x2_bot_982/vpd[1]
+ openDVS_pixel2x2_bot_982/vpd[0] rowReadON<26> openDVS_pixel2x2_bot_987/GndD DiffBn
+ VSUBS VDD OnBn openDVS_pixel2x2_bot
XopenDVS_pixel2x2_bot_993 rowReadOFF<32> rowReadOFF<33> rowReadON<33> RefrBp PrBp
+ PrSFBp col_periphery_1x2_9/COL_LINE0 pixRst<32> pixRst<33> col_periphery_1x2_9/COL_LINE1
+ OffBn openDVS_pixel2x2_bot_993/vpd[2] openDVS_pixel2x2_bot_993/vpd[3] openDVS_pixel2x2_bot_993/vpd[1]
+ openDVS_pixel2x2_bot_993/vpd[0] rowReadON<32> openDVS_pixel2x2_bot_993/GndD DiffBn
+ VSUBS VDD OnBn openDVS_pixel2x2_bot
XopenDVS_pixel2x2_bot_971 rowReadOFF<26> rowReadOFF<27> rowReadON<27> RefrBp PrBp
+ PrSFBp col_periphery_1x2_23/COL_LINE0 pixRst<30> pixRst<31> col_periphery_1x2_23/COL_LINE1
+ OffBn openDVS_pixel2x2_bot_971/vpd[2] openDVS_pixel2x2_bot_971/vpd[3] openDVS_pixel2x2_bot_971/vpd[1]
+ openDVS_pixel2x2_bot_971/vpd[0] rowReadON<26> openDVS_pixel2x2_bot_987/GndD DiffBn
+ VSUBS VDD OnBn openDVS_pixel2x2_bot
XopenDVS_pixel2x2_bot_960 rowReadOFF<26> rowReadOFF<27> rowReadON<27> RefrBp PrBp
+ PrSFBp col_periphery_1x2_28/COL_LINE0 pixRst<8> pixRst<9> col_periphery_1x2_28/COL_LINE1
+ OffBn openDVS_pixel2x2_bot_960/vpd[2] openDVS_pixel2x2_bot_960/vpd[3] openDVS_pixel2x2_bot_960/vpd[1]
+ openDVS_pixel2x2_bot_960/vpd[0] rowReadON<26> openDVS_pixel2x2_bot_987/GndD DiffBn
+ VSUBS VDD OnBn openDVS_pixel2x2_bot
XopenDVS_pixel2x2_bot_234 rowReadOFF<16> rowReadOFF<17> rowReadON<17> RefrBp PrBp
+ PrSFBp col_periphery_1x2_30/COL_LINE0 pixRst<12> pixRst<13> col_periphery_1x2_30/COL_LINE1
+ OffBn openDVS_pixel2x2_bot_234/vpd[2] openDVS_pixel2x2_bot_234/vpd[3] openDVS_pixel2x2_bot_234/vpd[1]
+ openDVS_pixel2x2_bot_234/vpd[0] rowReadON<16> openDVS_pixel2x2_bot_91/GndD DiffBn
+ VSUBS VDD OnBn openDVS_pixel2x2_bot
XopenDVS_pixel2x2_bot_289 rowReadOFF<16> rowReadOFF<17> rowReadON<17> RefrBp PrBp
+ PrSFBp col_periphery_1x2_29/COL_LINE0 pixRst<10> pixRst<11> col_periphery_1x2_29/COL_LINE1
+ OffBn openDVS_pixel2x2_bot_289/vpd[2] openDVS_pixel2x2_bot_289/vpd[3] openDVS_pixel2x2_bot_289/vpd[1]
+ openDVS_pixel2x2_bot_289/vpd[0] rowReadON<16> openDVS_pixel2x2_bot_91/GndD DiffBn
+ VSUBS VDD OnBn openDVS_pixel2x2_bot
XopenDVS_pixel2x2_bot_267 rowReadOFF<18> rowReadOFF<19> rowReadON<19> RefrBp PrBp
+ PrSFBp col_periphery_1x2_28/COL_LINE0 pixRst<8> pixRst<9> col_periphery_1x2_28/COL_LINE1
+ OffBn openDVS_pixel2x2_bot_267/vpd[2] openDVS_pixel2x2_bot_267/vpd[3] openDVS_pixel2x2_bot_267/vpd[1]
+ openDVS_pixel2x2_bot_267/vpd[0] rowReadON<18> openDVS_pixel2x2_bot_69/GndD DiffBn
+ VSUBS VDD OnBn openDVS_pixel2x2_bot
XopenDVS_pixel2x2_bot_245 rowReadOFF<12> rowReadOFF<13> rowReadON<13> RefrBp PrBp
+ PrSFBp col_periphery_1x2_27/COL_LINE0 pixRst<6> pixRst<7> col_periphery_1x2_27/COL_LINE1
+ OffBn openDVS_pixel2x2_bot_245/vpd[2] openDVS_pixel2x2_bot_245/vpd[3] openDVS_pixel2x2_bot_245/vpd[1]
+ openDVS_pixel2x2_bot_245/vpd[0] rowReadON<12> openDVS_pixel2x2_bot_79/GndD DiffBn
+ VSUBS VDD OnBn openDVS_pixel2x2_bot
XopenDVS_pixel2x2_bot_256 rowReadOFF<18> rowReadOFF<19> rowReadON<19> RefrBp PrBp
+ PrSFBp col_periphery_1x2_26/COL_LINE0 pixRst<4> pixRst<5> col_periphery_1x2_26/COL_LINE1
+ OffBn openDVS_pixel2x2_bot_256/vpd[2] openDVS_pixel2x2_bot_256/vpd[3] openDVS_pixel2x2_bot_256/vpd[1]
+ openDVS_pixel2x2_bot_256/vpd[0] rowReadON<18> openDVS_pixel2x2_bot_69/GndD DiffBn
+ VSUBS VDD OnBn openDVS_pixel2x2_bot
XopenDVS_pixel2x2_bot_278 rowReadOFF<16> rowReadOFF<17> rowReadON<17> RefrBp PrBp
+ PrSFBp col_periphery_1x2_26/COL_LINE0 pixRst<4> pixRst<5> col_periphery_1x2_26/COL_LINE1
+ OffBn openDVS_pixel2x2_bot_278/vpd[2] openDVS_pixel2x2_bot_278/vpd[3] openDVS_pixel2x2_bot_278/vpd[1]
+ openDVS_pixel2x2_bot_278/vpd[0] rowReadON<16> openDVS_pixel2x2_bot_91/GndD DiffBn
+ VSUBS VDD OnBn openDVS_pixel2x2_bot
XopenDVS_pixel2x2_bot_223 rowReadOFF<0> rowReadOFF<1> rowReadON<1> RefrBp PrBp PrSFBp
+ col_periphery_1x2_27/COL_LINE0 pixRst<6> pixRst<7> col_periphery_1x2_27/COL_LINE1
+ OffBn openDVS_pixel2x2_bot_223/vpd[2] openDVS_pixel2x2_bot_223/vpd[3] openDVS_pixel2x2_bot_223/vpd[1]
+ openDVS_pixel2x2_bot_223/vpd[0] rowReadON<0> GND DiffBn VSUBS VDD OnBn openDVS_pixel2x2_bot
XopenDVS_pixel2x2_bot_201 rowReadOFF<2> rowReadOFF<3> rowReadON<3> RefrBp PrBp PrSFBp
+ col_periphery_1x2_19/COL_LINE0 pixRst<22> pixRst<23> col_periphery_1x2_19/COL_LINE1
+ OffBn openDVS_pixel2x2_bot_201/vpd[2] openDVS_pixel2x2_bot_201/vpd[3] openDVS_pixel2x2_bot_201/vpd[1]
+ openDVS_pixel2x2_bot_201/vpd[0] rowReadON<2> openDVS_pixel2x2_bot_7/GndD DiffBn
+ VSUBS VDD OnBn openDVS_pixel2x2_bot
XopenDVS_pixel2x2_bot_212 rowReadOFF<4> rowReadOFF<5> rowReadON<5> RefrBp PrBp PrSFBp
+ col_periphery_1x2_19/COL_LINE0 pixRst<22> pixRst<23> col_periphery_1x2_19/COL_LINE1
+ OffBn openDVS_pixel2x2_bot_212/vpd[2] openDVS_pixel2x2_bot_212/vpd[3] openDVS_pixel2x2_bot_212/vpd[1]
+ openDVS_pixel2x2_bot_212/vpd[0] rowReadON<4> openDVS_pixel2x2_bot_6/GndD DiffBn
+ VSUBS VDD OnBn openDVS_pixel2x2_bot
XopenDVS_pixel2x2_bot_790 rowReadOFF<52> rowReadOFF<53> rowReadON<53> RefrBp PrBp
+ PrSFBp col_periphery_1x2_13/COL_LINE0 pixRst<44> pixRst<45> col_periphery_1x2_13/COL_LINE1
+ OffBn openDVS_pixel2x2_bot_790/vpd[2] openDVS_pixel2x2_bot_790/vpd[3] openDVS_pixel2x2_bot_790/vpd[1]
+ openDVS_pixel2x2_bot_790/vpd[0] rowReadON<52> openDVS_pixel2x2_bot_882/GndD DiffBn
+ VSUBS VDD OnBn openDVS_pixel2x2_bot
XopenDVS_pixel2x2_bot_608 rowReadOFF<54> rowReadOFF<55> rowReadON<55> RefrBp PrBp
+ PrSFBp col_periphery_1x2_17/COL_LINE0 pixRst<18> pixRst<19> col_periphery_1x2_17/COL_LINE1
+ OffBn openDVS_pixel2x2_bot_608/vpd[2] openDVS_pixel2x2_bot_608/vpd[3] openDVS_pixel2x2_bot_608/vpd[1]
+ openDVS_pixel2x2_bot_608/vpd[0] rowReadON<54> openDVS_pixel2x2_bot_885/GndD DiffBn
+ VSUBS VDD OnBn openDVS_pixel2x2_bot
XopenDVS_pixel2x2_bot_619 rowReadOFF<44> rowReadOFF<45> rowReadON<45> RefrBp PrBp
+ PrSFBp col_periphery_1x2_26/COL_LINE0 pixRst<4> pixRst<5> col_periphery_1x2_26/COL_LINE1
+ OffBn openDVS_pixel2x2_bot_619/vpd[2] openDVS_pixel2x2_bot_619/vpd[3] openDVS_pixel2x2_bot_619/vpd[1]
+ openDVS_pixel2x2_bot_619/vpd[0] rowReadON<44> openDVS_pixel2x2_bot_923/GndD DiffBn
+ VSUBS VDD OnBn openDVS_pixel2x2_bot
XopenDVS_pixel2x2_bot_39 rowReadOFF<16> rowReadOFF<17> rowReadON<17> RefrBp PrBp PrSFBp
+ col_periphery_1x2_8/COL_LINE0 pixRst<42> pixRst<43> col_periphery_1x2_8/COL_LINE1
+ OffBn openDVS_pixel2x2_bot_39/vpd[2] openDVS_pixel2x2_bot_39/vpd[3] openDVS_pixel2x2_bot_39/vpd[1]
+ openDVS_pixel2x2_bot_39/vpd[0] rowReadON<16> openDVS_pixel2x2_bot_91/GndD DiffBn
+ VSUBS VDD OnBn openDVS_pixel2x2_bot
XopenDVS_pixel2x2_bot_17 rowReadOFF<2> rowReadOFF<3> rowReadON<3> RefrBp PrBp PrSFBp
+ col_periphery_1x2_5/COL_LINE0 pixRst<60> pixRst<61> col_periphery_1x2_5/COL_LINE1
+ OffBn openDVS_pixel2x2_bot_17/vpd[2] openDVS_pixel2x2_bot_17/vpd[3] openDVS_pixel2x2_bot_17/vpd[1]
+ openDVS_pixel2x2_bot_17/vpd[0] rowReadON<2> openDVS_pixel2x2_bot_7/GndD DiffBn VSUBS
+ VDD OnBn openDVS_pixel2x2_bot
XopenDVS_pixel2x2_bot_28 rowReadOFF<4> rowReadOFF<5> rowReadON<5> RefrBp PrBp PrSFBp
+ col_periphery_1x2_12/COL_LINE0 pixRst<38> pixRst<39> col_periphery_1x2_12/COL_LINE1
+ OffBn openDVS_pixel2x2_bot_28/vpd[2] openDVS_pixel2x2_bot_28/vpd[3] openDVS_pixel2x2_bot_28/vpd[1]
+ openDVS_pixel2x2_bot_28/vpd[0] rowReadON<4> openDVS_pixel2x2_bot_6/GndD DiffBn VSUBS
+ VDD OnBn openDVS_pixel2x2_bot
XopenDVS_pixel2x2_bot_416 rowReadOFF<42> rowReadOFF<43> rowReadON<43> RefrBp PrBp
+ PrSFBp col_periphery_1x2_22/COL_LINE0 pixRst<28> pixRst<29> col_periphery_1x2_22/COL_LINE1
+ OffBn openDVS_pixel2x2_bot_416/vpd[2] openDVS_pixel2x2_bot_416/vpd[3] openDVS_pixel2x2_bot_416/vpd[1]
+ openDVS_pixel2x2_bot_416/vpd[0] rowReadON<42> openDVS_pixel2x2_bot_908/GndD DiffBn
+ VSUBS VDD OnBn openDVS_pixel2x2_bot
XopenDVS_pixel2x2_bot_427 rowReadOFF<38> rowReadOFF<39> rowReadON<39> RefrBp PrBp
+ PrSFBp col_periphery_1x2_19/COL_LINE0 pixRst<22> pixRst<23> col_periphery_1x2_19/COL_LINE1
+ OffBn openDVS_pixel2x2_bot_427/vpd[2] openDVS_pixel2x2_bot_427/vpd[3] openDVS_pixel2x2_bot_427/vpd[1]
+ openDVS_pixel2x2_bot_427/vpd[0] rowReadON<38> openDVS_pixel2x2_bot_999/GndD DiffBn
+ VSUBS VDD OnBn openDVS_pixel2x2_bot
XopenDVS_pixel2x2_bot_405 rowReadOFF<32> rowReadOFF<33> rowReadON<33> RefrBp PrBp
+ PrSFBp col_periphery_1x2_21/COL_LINE0 pixRst<26> pixRst<27> col_periphery_1x2_21/COL_LINE1
+ OffBn openDVS_pixel2x2_bot_405/vpd[2] openDVS_pixel2x2_bot_405/vpd[3] openDVS_pixel2x2_bot_405/vpd[1]
+ openDVS_pixel2x2_bot_405/vpd[0] rowReadON<32> openDVS_pixel2x2_bot_993/GndD DiffBn
+ VSUBS VDD OnBn openDVS_pixel2x2_bot
XopenDVS_pixel2x2_bot_449 rowReadOFF<32> rowReadOFF<33> rowReadON<33> RefrBp PrBp
+ PrSFBp col_periphery_1x2_29/COL_LINE0 pixRst<10> pixRst<11> col_periphery_1x2_29/COL_LINE1
+ OffBn openDVS_pixel2x2_bot_449/vpd[2] openDVS_pixel2x2_bot_449/vpd[3] openDVS_pixel2x2_bot_449/vpd[1]
+ openDVS_pixel2x2_bot_449/vpd[0] rowReadON<32> openDVS_pixel2x2_bot_993/GndD DiffBn
+ VSUBS VDD OnBn openDVS_pixel2x2_bot
XopenDVS_pixel2x2_bot_438 rowReadOFF<28> rowReadOFF<29> rowReadON<29> RefrBp PrBp
+ PrSFBp col_periphery_1x2_28/COL_LINE0 pixRst<8> pixRst<9> col_periphery_1x2_28/COL_LINE1
+ OffBn openDVS_pixel2x2_bot_438/vpd[2] openDVS_pixel2x2_bot_438/vpd[3] openDVS_pixel2x2_bot_438/vpd[1]
+ openDVS_pixel2x2_bot_438/vpd[0] rowReadON<28> openDVS_pixel2x2_bot_989/GndD DiffBn
+ VSUBS VDD OnBn openDVS_pixel2x2_bot
XopenDVS_pixel2x2_bot_994 rowReadOFF<34> rowReadOFF<35> rowReadON<35> RefrBp PrBp
+ PrSFBp col_periphery_1x2_23/COL_LINE0 pixRst<30> pixRst<31> col_periphery_1x2_23/COL_LINE1
+ OffBn openDVS_pixel2x2_bot_994/vpd[2] openDVS_pixel2x2_bot_994/vpd[3] openDVS_pixel2x2_bot_994/vpd[1]
+ openDVS_pixel2x2_bot_994/vpd[0] rowReadON<34> openDVS_pixel2x2_bot_995/GndD DiffBn
+ VSUBS VDD OnBn openDVS_pixel2x2_bot
XopenDVS_pixel2x2_bot_983 rowReadOFF<26> rowReadOFF<27> rowReadON<27> RefrBp PrBp
+ PrSFBp col_periphery_1x2_2/COL_LINE0 pixRst<54> pixRst<55> col_periphery_1x2_2/COL_LINE1
+ OffBn openDVS_pixel2x2_bot_983/vpd[2] openDVS_pixel2x2_bot_983/vpd[3] openDVS_pixel2x2_bot_983/vpd[1]
+ openDVS_pixel2x2_bot_983/vpd[0] rowReadON<26> openDVS_pixel2x2_bot_987/GndD DiffBn
+ VSUBS VDD OnBn openDVS_pixel2x2_bot
XopenDVS_pixel2x2_bot_972 rowReadOFF<26> rowReadOFF<27> rowReadON<27> RefrBp PrBp
+ PrSFBp col_periphery_1x2_9/COL_LINE0 pixRst<32> pixRst<33> col_periphery_1x2_9/COL_LINE1
+ OffBn openDVS_pixel2x2_bot_972/vpd[2] openDVS_pixel2x2_bot_972/vpd[3] openDVS_pixel2x2_bot_972/vpd[1]
+ openDVS_pixel2x2_bot_972/vpd[0] rowReadON<26> openDVS_pixel2x2_bot_987/GndD DiffBn
+ VSUBS VDD OnBn openDVS_pixel2x2_bot
XopenDVS_pixel2x2_bot_961 rowReadOFF<26> rowReadOFF<27> rowReadON<27> RefrBp PrBp
+ PrSFBp col_periphery_1x2_29/COL_LINE0 pixRst<10> pixRst<11> col_periphery_1x2_29/COL_LINE1
+ OffBn openDVS_pixel2x2_bot_961/vpd[2] openDVS_pixel2x2_bot_961/vpd[3] openDVS_pixel2x2_bot_961/vpd[1]
+ openDVS_pixel2x2_bot_961/vpd[0] rowReadON<26> openDVS_pixel2x2_bot_987/GndD DiffBn
+ VSUBS VDD OnBn openDVS_pixel2x2_bot
XopenDVS_pixel2x2_bot_950 rowReadOFF<20> rowReadOFF<21> rowReadON<21> RefrBp PrBp
+ PrSFBp col_periphery_1x2_23/COL_LINE0 pixRst<30> pixRst<31> col_periphery_1x2_23/COL_LINE1
+ OffBn openDVS_pixel2x2_bot_950/vpd[2] openDVS_pixel2x2_bot_950/vpd[3] openDVS_pixel2x2_bot_950/vpd[1]
+ openDVS_pixel2x2_bot_950/vpd[0] rowReadON<20> openDVS_pixel2x2_bot_95/GndD DiffBn
+ VSUBS VDD OnBn openDVS_pixel2x2_bot
Xcol_periphery_1x2_5 pixRst<61> col_periphery_1x2_5/COL_LINE0 col_periphery_1x2_5/COL_LINE1
+ nDETECT DETECT col_periphery_1x2_9/VDD VTHRESH pixRst<60> voutn<60> VSUBS voutn<61>
+ NCHARGE col_periphery_1x2
XopenDVS_pixel2x2_bot_235 rowReadOFF<22> rowReadOFF<23> rowReadON<23> RefrBp PrBp
+ PrSFBp col_periphery_1x2_29/COL_LINE0 pixRst<10> pixRst<11> col_periphery_1x2_29/COL_LINE1
+ OffBn openDVS_pixel2x2_bot_235/vpd[2] openDVS_pixel2x2_bot_235/vpd[3] openDVS_pixel2x2_bot_235/vpd[1]
+ openDVS_pixel2x2_bot_235/vpd[0] rowReadON<22> openDVS_pixel2x2_bot_97/GndD DiffBn
+ VSUBS VDD OnBn openDVS_pixel2x2_bot
XopenDVS_pixel2x2_bot_257 rowReadOFF<24> rowReadOFF<25> rowReadON<25> RefrBp PrBp
+ PrSFBp col_periphery_1x2_27/COL_LINE0 pixRst<6> pixRst<7> col_periphery_1x2_27/COL_LINE1
+ OffBn openDVS_pixel2x2_bot_257/vpd[2] openDVS_pixel2x2_bot_257/vpd[3] openDVS_pixel2x2_bot_257/vpd[1]
+ openDVS_pixel2x2_bot_257/vpd[0] rowReadON<24> openDVS_pixel2x2_bot_99/GndD DiffBn
+ VSUBS VDD OnBn openDVS_pixel2x2_bot
XopenDVS_pixel2x2_bot_268 rowReadOFF<18> rowReadOFF<19> rowReadON<19> RefrBp PrBp
+ PrSFBp col_periphery_1x2_29/COL_LINE0 pixRst<10> pixRst<11> col_periphery_1x2_29/COL_LINE1
+ OffBn openDVS_pixel2x2_bot_268/vpd[2] openDVS_pixel2x2_bot_268/vpd[3] openDVS_pixel2x2_bot_268/vpd[1]
+ openDVS_pixel2x2_bot_268/vpd[0] rowReadON<18> openDVS_pixel2x2_bot_69/GndD DiffBn
+ VSUBS VDD OnBn openDVS_pixel2x2_bot
XopenDVS_pixel2x2_bot_246 rowReadOFF<12> rowReadOFF<13> rowReadON<13> RefrBp PrBp
+ PrSFBp col_periphery_1x2_28/COL_LINE0 pixRst<8> pixRst<9> col_periphery_1x2_28/COL_LINE1
+ OffBn openDVS_pixel2x2_bot_246/vpd[2] openDVS_pixel2x2_bot_246/vpd[3] openDVS_pixel2x2_bot_246/vpd[1]
+ openDVS_pixel2x2_bot_246/vpd[0] rowReadON<12> openDVS_pixel2x2_bot_79/GndD DiffBn
+ VSUBS VDD OnBn openDVS_pixel2x2_bot
XopenDVS_pixel2x2_bot_279 rowReadOFF<16> rowReadOFF<17> rowReadON<17> RefrBp PrBp
+ PrSFBp col_periphery_1x2_27/COL_LINE0 pixRst<6> pixRst<7> col_periphery_1x2_27/COL_LINE1
+ OffBn openDVS_pixel2x2_bot_279/vpd[2] openDVS_pixel2x2_bot_279/vpd[3] openDVS_pixel2x2_bot_279/vpd[1]
+ openDVS_pixel2x2_bot_279/vpd[0] rowReadON<16> openDVS_pixel2x2_bot_91/GndD DiffBn
+ VSUBS VDD OnBn openDVS_pixel2x2_bot
XopenDVS_pixel2x2_bot_224 rowReadOFF<0> rowReadOFF<1> rowReadON<1> RefrBp PrBp PrSFBp
+ col_periphery_1x2_28/COL_LINE0 pixRst<8> pixRst<9> col_periphery_1x2_28/COL_LINE1
+ OffBn openDVS_pixel2x2_bot_224/vpd[2] openDVS_pixel2x2_bot_224/vpd[3] openDVS_pixel2x2_bot_224/vpd[1]
+ openDVS_pixel2x2_bot_224/vpd[0] rowReadON<0> GND DiffBn VSUBS VDD OnBn openDVS_pixel2x2_bot
XopenDVS_pixel2x2_bot_213 rowReadOFF<2> rowReadOFF<3> rowReadON<3> RefrBp PrBp PrSFBp
+ col_periphery_1x2_27/COL_LINE0 pixRst<6> pixRst<7> col_periphery_1x2_27/COL_LINE1
+ OffBn openDVS_pixel2x2_bot_213/vpd[2] openDVS_pixel2x2_bot_213/vpd[3] openDVS_pixel2x2_bot_213/vpd[1]
+ openDVS_pixel2x2_bot_213/vpd[0] rowReadON<2> openDVS_pixel2x2_bot_7/GndD DiffBn
+ VSUBS VDD OnBn openDVS_pixel2x2_bot
XopenDVS_pixel2x2_bot_202 rowReadOFF<2> rowReadOFF<3> rowReadON<3> RefrBp PrBp PrSFBp
+ col_periphery_1x2_20/COL_LINE0 pixRst<24> pixRst<25> col_periphery_1x2_20/COL_LINE1
+ OffBn openDVS_pixel2x2_bot_202/vpd[2] openDVS_pixel2x2_bot_202/vpd[3] openDVS_pixel2x2_bot_202/vpd[1]
+ openDVS_pixel2x2_bot_202/vpd[0] rowReadON<2> openDVS_pixel2x2_bot_7/GndD DiffBn
+ VSUBS VDD OnBn openDVS_pixel2x2_bot
XopenDVS_pixel2x2_bot_791 rowReadOFF<60> rowReadOFF<61> rowReadON<61> RefrBp PrBp
+ PrSFBp col_periphery_1x2_8/COL_LINE0 pixRst<42> pixRst<43> col_periphery_1x2_8/COL_LINE1
+ OffBn openDVS_pixel2x2_bot_791/vpd[2] openDVS_pixel2x2_bot_791/vpd[3] openDVS_pixel2x2_bot_791/vpd[1]
+ openDVS_pixel2x2_bot_791/vpd[0] rowReadON<60> openDVS_pixel2x2_bot_902/GndD DiffBn
+ VSUBS VDD OnBn openDVS_pixel2x2_bot
XopenDVS_pixel2x2_bot_780 rowReadOFF<54> rowReadOFF<55> rowReadON<55> RefrBp PrBp
+ PrSFBp col_periphery_1x2_13/COL_LINE0 pixRst<44> pixRst<45> col_periphery_1x2_13/COL_LINE1
+ OffBn openDVS_pixel2x2_bot_780/vpd[2] openDVS_pixel2x2_bot_780/vpd[3] openDVS_pixel2x2_bot_780/vpd[1]
+ openDVS_pixel2x2_bot_780/vpd[0] rowReadON<54> openDVS_pixel2x2_bot_885/GndD DiffBn
+ VSUBS VDD OnBn openDVS_pixel2x2_bot
XopenDVS_pixel2x2_bot_609 rowReadOFF<54> rowReadOFF<55> rowReadON<55> RefrBp PrBp
+ PrSFBp col_periphery_1x2_18/COL_LINE0 pixRst<20> pixRst<21> col_periphery_1x2_18/COL_LINE1
+ OffBn openDVS_pixel2x2_bot_609/vpd[2] openDVS_pixel2x2_bot_609/vpd[3] openDVS_pixel2x2_bot_609/vpd[1]
+ openDVS_pixel2x2_bot_609/vpd[0] rowReadON<54> openDVS_pixel2x2_bot_885/GndD DiffBn
+ VSUBS VDD OnBn openDVS_pixel2x2_bot
XopenDVS_pixel2x2_bot_18 rowReadOFF<2> rowReadOFF<3> rowReadON<3> RefrBp PrBp PrSFBp
+ col_periphery_1x2_6/COL_LINE0 pixRst<62> pixRst<63> col_periphery_1x2_6/COL_LINE1
+ OffBn openDVS_pixel2x2_bot_18/vpd[2] openDVS_pixel2x2_bot_18/vpd[3] openDVS_pixel2x2_bot_18/vpd[1]
+ openDVS_pixel2x2_bot_18/vpd[0] rowReadON<2> openDVS_pixel2x2_bot_7/GndD DiffBn VSUBS
+ VDD OnBn openDVS_pixel2x2_bot
XopenDVS_pixel2x2_bot_29 rowReadOFF<4> rowReadOFF<5> rowReadON<5> RefrBp PrBp PrSFBp
+ col_periphery_1x2_7/COL_LINE0 pixRst<40> pixRst<41> col_periphery_1x2_7/COL_LINE1
+ OffBn openDVS_pixel2x2_bot_29/vpd[2] openDVS_pixel2x2_bot_29/vpd[3] openDVS_pixel2x2_bot_29/vpd[1]
+ openDVS_pixel2x2_bot_29/vpd[0] rowReadON<4> openDVS_pixel2x2_bot_6/GndD DiffBn VSUBS
+ VDD OnBn openDVS_pixel2x2_bot
XopenDVS_pixel2x2_bot_428 rowReadOFF<38> rowReadOFF<39> rowReadON<39> RefrBp PrBp
+ PrSFBp col_periphery_1x2_20/COL_LINE0 pixRst<24> pixRst<25> col_periphery_1x2_20/COL_LINE1
+ OffBn openDVS_pixel2x2_bot_428/vpd[2] openDVS_pixel2x2_bot_428/vpd[3] openDVS_pixel2x2_bot_428/vpd[1]
+ openDVS_pixel2x2_bot_428/vpd[0] rowReadON<38> openDVS_pixel2x2_bot_999/GndD DiffBn
+ VSUBS VDD OnBn openDVS_pixel2x2_bot
XopenDVS_pixel2x2_bot_406 rowReadOFF<32> rowReadOFF<33> rowReadON<33> RefrBp PrBp
+ PrSFBp col_periphery_1x2_22/COL_LINE0 pixRst<28> pixRst<29> col_periphery_1x2_22/COL_LINE1
+ OffBn openDVS_pixel2x2_bot_406/vpd[2] openDVS_pixel2x2_bot_406/vpd[3] openDVS_pixel2x2_bot_406/vpd[1]
+ openDVS_pixel2x2_bot_406/vpd[0] rowReadON<32> openDVS_pixel2x2_bot_993/GndD DiffBn
+ VSUBS VDD OnBn openDVS_pixel2x2_bot
XopenDVS_pixel2x2_bot_417 rowReadOFF<28> rowReadOFF<29> rowReadON<29> RefrBp PrBp
+ PrSFBp col_periphery_1x2_19/COL_LINE0 pixRst<22> pixRst<23> col_periphery_1x2_19/COL_LINE1
+ OffBn openDVS_pixel2x2_bot_417/vpd[2] openDVS_pixel2x2_bot_417/vpd[3] openDVS_pixel2x2_bot_417/vpd[1]
+ openDVS_pixel2x2_bot_417/vpd[0] rowReadON<28> openDVS_pixel2x2_bot_989/GndD DiffBn
+ VSUBS VDD OnBn openDVS_pixel2x2_bot
XopenDVS_pixel2x2_bot_984 rowReadOFF<26> rowReadOFF<27> rowReadON<27> RefrBp PrBp
+ PrSFBp col_periphery_1x2_3/COL_LINE0 pixRst<56> pixRst<57> col_periphery_1x2_3/COL_LINE1
+ OffBn openDVS_pixel2x2_bot_984/vpd[2] openDVS_pixel2x2_bot_984/vpd[3] openDVS_pixel2x2_bot_984/vpd[1]
+ openDVS_pixel2x2_bot_984/vpd[0] rowReadON<26> openDVS_pixel2x2_bot_987/GndD DiffBn
+ VSUBS VDD OnBn openDVS_pixel2x2_bot
XopenDVS_pixel2x2_bot_973 rowReadOFF<26> rowReadOFF<27> rowReadON<27> RefrBp PrBp
+ PrSFBp col_periphery_1x2_10/COL_LINE0 pixRst<34> pixRst<35> col_periphery_1x2_10/COL_LINE1
+ OffBn openDVS_pixel2x2_bot_973/vpd[2] openDVS_pixel2x2_bot_973/vpd[3] openDVS_pixel2x2_bot_973/vpd[1]
+ openDVS_pixel2x2_bot_973/vpd[0] rowReadON<26> openDVS_pixel2x2_bot_987/GndD DiffBn
+ VSUBS VDD OnBn openDVS_pixel2x2_bot
XopenDVS_pixel2x2_bot_439 rowReadOFF<28> rowReadOFF<29> rowReadON<29> RefrBp PrBp
+ PrSFBp col_periphery_1x2_29/COL_LINE0 pixRst<10> pixRst<11> col_periphery_1x2_29/COL_LINE1
+ OffBn openDVS_pixel2x2_bot_439/vpd[2] openDVS_pixel2x2_bot_439/vpd[3] openDVS_pixel2x2_bot_439/vpd[1]
+ openDVS_pixel2x2_bot_439/vpd[0] rowReadON<28> openDVS_pixel2x2_bot_989/GndD DiffBn
+ VSUBS VDD OnBn openDVS_pixel2x2_bot
XopenDVS_pixel2x2_bot_962 rowReadOFF<26> rowReadOFF<27> rowReadON<27> RefrBp PrBp
+ PrSFBp col_periphery_1x2_30/COL_LINE0 pixRst<12> pixRst<13> col_periphery_1x2_30/COL_LINE1
+ OffBn openDVS_pixel2x2_bot_962/vpd[2] openDVS_pixel2x2_bot_962/vpd[3] openDVS_pixel2x2_bot_962/vpd[1]
+ openDVS_pixel2x2_bot_962/vpd[0] rowReadON<26> openDVS_pixel2x2_bot_987/GndD DiffBn
+ VSUBS VDD OnBn openDVS_pixel2x2_bot
XopenDVS_pixel2x2_bot_951 rowReadOFF<20> rowReadOFF<21> rowReadON<21> RefrBp PrBp
+ PrSFBp col_periphery_1x2_9/COL_LINE0 pixRst<32> pixRst<33> col_periphery_1x2_9/COL_LINE1
+ OffBn openDVS_pixel2x2_bot_951/vpd[2] openDVS_pixel2x2_bot_951/vpd[3] openDVS_pixel2x2_bot_951/vpd[1]
+ openDVS_pixel2x2_bot_951/vpd[0] rowReadON<20> openDVS_pixel2x2_bot_95/GndD DiffBn
+ VSUBS VDD OnBn openDVS_pixel2x2_bot
Xcol_periphery_1x2_6 pixRst<63> col_periphery_1x2_6/COL_LINE0 col_periphery_1x2_6/COL_LINE1
+ nDETECT DETECT col_periphery_1x2_9/VDD VTHRESH pixRst<62> voutn<62> VSUBS voutn<63>
+ NCHARGE col_periphery_1x2
XopenDVS_pixel2x2_bot_940 rowReadOFF<10> rowReadOFF<11> rowReadON<11> RefrBp PrBp
+ PrSFBp col_periphery_1x2_23/COL_LINE0 pixRst<30> pixRst<31> col_periphery_1x2_23/COL_LINE1
+ OffBn openDVS_pixel2x2_bot_940/vpd[2] openDVS_pixel2x2_bot_940/vpd[3] openDVS_pixel2x2_bot_940/vpd[1]
+ openDVS_pixel2x2_bot_940/vpd[0] rowReadON<10> openDVS_pixel2x2_bot_82/GndD DiffBn
+ VSUBS VDD OnBn openDVS_pixel2x2_bot
XopenDVS_pixel2x2_bot_995 rowReadOFF<34> rowReadOFF<35> rowReadON<35> RefrBp PrBp
+ PrSFBp col_periphery_1x2_9/COL_LINE0 pixRst<32> pixRst<33> col_periphery_1x2_9/COL_LINE1
+ OffBn openDVS_pixel2x2_bot_995/vpd[2] openDVS_pixel2x2_bot_995/vpd[3] openDVS_pixel2x2_bot_995/vpd[1]
+ openDVS_pixel2x2_bot_995/vpd[0] rowReadON<34> openDVS_pixel2x2_bot_995/GndD DiffBn
+ VSUBS VDD OnBn openDVS_pixel2x2_bot
XopenDVS_pixel2x2_bot_236 rowReadOFF<22> rowReadOFF<23> rowReadON<23> RefrBp PrBp
+ PrSFBp col_periphery_1x2_30/COL_LINE0 pixRst<12> pixRst<13> col_periphery_1x2_30/COL_LINE1
+ OffBn openDVS_pixel2x2_bot_236/vpd[2] openDVS_pixel2x2_bot_236/vpd[3] openDVS_pixel2x2_bot_236/vpd[1]
+ openDVS_pixel2x2_bot_236/vpd[0] rowReadON<22> openDVS_pixel2x2_bot_97/GndD DiffBn
+ VSUBS VDD OnBn openDVS_pixel2x2_bot
XopenDVS_pixel2x2_bot_258 rowReadOFF<24> rowReadOFF<25> rowReadON<25> RefrBp PrBp
+ PrSFBp col_periphery_1x2_28/COL_LINE0 pixRst<8> pixRst<9> col_periphery_1x2_28/COL_LINE1
+ OffBn openDVS_pixel2x2_bot_258/vpd[2] openDVS_pixel2x2_bot_258/vpd[3] openDVS_pixel2x2_bot_258/vpd[1]
+ openDVS_pixel2x2_bot_258/vpd[0] rowReadON<24> openDVS_pixel2x2_bot_99/GndD DiffBn
+ VSUBS VDD OnBn openDVS_pixel2x2_bot
XopenDVS_pixel2x2_bot_269 rowReadOFF<18> rowReadOFF<19> rowReadON<19> RefrBp PrBp
+ PrSFBp col_periphery_1x2_30/COL_LINE0 pixRst<12> pixRst<13> col_periphery_1x2_30/COL_LINE1
+ OffBn openDVS_pixel2x2_bot_269/vpd[2] openDVS_pixel2x2_bot_269/vpd[3] openDVS_pixel2x2_bot_269/vpd[1]
+ openDVS_pixel2x2_bot_269/vpd[0] rowReadON<18> openDVS_pixel2x2_bot_69/GndD DiffBn
+ VSUBS VDD OnBn openDVS_pixel2x2_bot
XopenDVS_pixel2x2_bot_247 rowReadOFF<12> rowReadOFF<13> rowReadON<13> RefrBp PrBp
+ PrSFBp col_periphery_1x2_29/COL_LINE0 pixRst<10> pixRst<11> col_periphery_1x2_29/COL_LINE1
+ OffBn openDVS_pixel2x2_bot_247/vpd[2] openDVS_pixel2x2_bot_247/vpd[3] openDVS_pixel2x2_bot_247/vpd[1]
+ openDVS_pixel2x2_bot_247/vpd[0] rowReadON<12> openDVS_pixel2x2_bot_79/GndD DiffBn
+ VSUBS VDD OnBn openDVS_pixel2x2_bot
XopenDVS_pixel2x2_bot_225 rowReadOFF<0> rowReadOFF<1> rowReadON<1> RefrBp PrBp PrSFBp
+ col_periphery_1x2_29/COL_LINE0 pixRst<10> pixRst<11> col_periphery_1x2_29/COL_LINE1
+ OffBn openDVS_pixel2x2_bot_225/vpd[2] openDVS_pixel2x2_bot_225/vpd[3] openDVS_pixel2x2_bot_225/vpd[1]
+ openDVS_pixel2x2_bot_225/vpd[0] rowReadON<0> GND DiffBn VSUBS VDD OnBn openDVS_pixel2x2_bot
XopenDVS_pixel2x2_bot_214 rowReadOFF<2> rowReadOFF<3> rowReadON<3> RefrBp PrBp PrSFBp
+ col_periphery_1x2_28/COL_LINE0 pixRst<8> pixRst<9> col_periphery_1x2_28/COL_LINE1
+ OffBn openDVS_pixel2x2_bot_214/vpd[2] openDVS_pixel2x2_bot_214/vpd[3] openDVS_pixel2x2_bot_214/vpd[1]
+ openDVS_pixel2x2_bot_214/vpd[0] rowReadON<2> openDVS_pixel2x2_bot_7/GndD DiffBn
+ VSUBS VDD OnBn openDVS_pixel2x2_bot
XopenDVS_pixel2x2_bot_203 rowReadOFF<2> rowReadOFF<3> rowReadON<3> RefrBp PrBp PrSFBp
+ col_periphery_1x2_21/COL_LINE0 pixRst<26> pixRst<27> col_periphery_1x2_21/COL_LINE1
+ OffBn openDVS_pixel2x2_bot_203/vpd[2] openDVS_pixel2x2_bot_203/vpd[3] openDVS_pixel2x2_bot_203/vpd[1]
+ openDVS_pixel2x2_bot_203/vpd[0] rowReadON<2> openDVS_pixel2x2_bot_7/GndD DiffBn
+ VSUBS VDD OnBn openDVS_pixel2x2_bot
XopenDVS_pixel2x2_bot_792 rowReadOFF<56> rowReadOFF<57> rowReadON<57> RefrBp PrBp
+ PrSFBp col_periphery_1x2_10/COL_LINE0 pixRst<34> pixRst<35> col_periphery_1x2_10/COL_LINE1
+ OffBn openDVS_pixel2x2_bot_792/vpd[2] openDVS_pixel2x2_bot_792/vpd[3] openDVS_pixel2x2_bot_792/vpd[1]
+ openDVS_pixel2x2_bot_792/vpd[0] rowReadON<56> openDVS_pixel2x2_bot_888/GndD DiffBn
+ VSUBS VDD OnBn openDVS_pixel2x2_bot
XopenDVS_pixel2x2_bot_770 rowReadOFF<50> rowReadOFF<51> rowReadON<51> RefrBp PrBp
+ PrSFBp col_periphery_1x2_8/COL_LINE0 pixRst<42> pixRst<43> col_periphery_1x2_8/COL_LINE1
+ OffBn openDVS_pixel2x2_bot_770/vpd[2] openDVS_pixel2x2_bot_770/vpd[3] openDVS_pixel2x2_bot_770/vpd[1]
+ openDVS_pixel2x2_bot_770/vpd[0] rowReadON<50> openDVS_pixel2x2_bot_929/GndD DiffBn
+ VSUBS VDD OnBn openDVS_pixel2x2_bot
XopenDVS_pixel2x2_bot_781 rowReadOFF<48> rowReadOFF<49> rowReadON<49> RefrBp PrBp
+ PrSFBp col_periphery_1x2_12/COL_LINE0 pixRst<38> pixRst<39> col_periphery_1x2_12/COL_LINE1
+ OffBn openDVS_pixel2x2_bot_781/vpd[2] openDVS_pixel2x2_bot_781/vpd[3] openDVS_pixel2x2_bot_781/vpd[1]
+ openDVS_pixel2x2_bot_781/vpd[0] rowReadON<48> openDVS_pixel2x2_bot_927/GndD DiffBn
+ VSUBS VDD OnBn openDVS_pixel2x2_bot
XopenDVS_pixel2x2_bot_19 rowReadOFF<2> rowReadOFF<3> rowReadON<3> RefrBp PrBp PrSFBp
+ col_periphery_1x2_0/COL_LINE0 pixRst<50> pixRst<51> col_periphery_1x2_0/COL_LINE1
+ OffBn openDVS_pixel2x2_bot_19/vpd[2] openDVS_pixel2x2_bot_19/vpd[3] openDVS_pixel2x2_bot_19/vpd[1]
+ openDVS_pixel2x2_bot_19/vpd[0] rowReadON<2> openDVS_pixel2x2_bot_7/GndD DiffBn VSUBS
+ VDD OnBn openDVS_pixel2x2_bot
XopenDVS_pixel2x2_bot_429 rowReadOFF<38> rowReadOFF<39> rowReadON<39> RefrBp PrBp
+ PrSFBp col_periphery_1x2_21/COL_LINE0 pixRst<26> pixRst<27> col_periphery_1x2_21/COL_LINE1
+ OffBn openDVS_pixel2x2_bot_429/vpd[2] openDVS_pixel2x2_bot_429/vpd[3] openDVS_pixel2x2_bot_429/vpd[1]
+ openDVS_pixel2x2_bot_429/vpd[0] rowReadON<38> openDVS_pixel2x2_bot_999/GndD DiffBn
+ VSUBS VDD OnBn openDVS_pixel2x2_bot
XopenDVS_pixel2x2_bot_407 rowReadOFF<38> rowReadOFF<39> rowReadON<39> RefrBp PrBp
+ PrSFBp col_periphery_1x2_17/COL_LINE0 pixRst<18> pixRst<19> col_periphery_1x2_17/COL_LINE1
+ OffBn openDVS_pixel2x2_bot_407/vpd[2] openDVS_pixel2x2_bot_407/vpd[3] openDVS_pixel2x2_bot_407/vpd[1]
+ openDVS_pixel2x2_bot_407/vpd[0] rowReadON<38> openDVS_pixel2x2_bot_999/GndD DiffBn
+ VSUBS VDD OnBn openDVS_pixel2x2_bot
XopenDVS_pixel2x2_bot_418 rowReadOFF<28> rowReadOFF<29> rowReadON<29> RefrBp PrBp
+ PrSFBp col_periphery_1x2_20/COL_LINE0 pixRst<24> pixRst<25> col_periphery_1x2_20/COL_LINE1
+ OffBn openDVS_pixel2x2_bot_418/vpd[2] openDVS_pixel2x2_bot_418/vpd[3] openDVS_pixel2x2_bot_418/vpd[1]
+ openDVS_pixel2x2_bot_418/vpd[0] rowReadON<28> openDVS_pixel2x2_bot_989/GndD DiffBn
+ VSUBS VDD OnBn openDVS_pixel2x2_bot
Xcol_periphery_1x2_7 pixRst<41> col_periphery_1x2_7/COL_LINE0 col_periphery_1x2_7/COL_LINE1
+ nDETECT DETECT col_periphery_1x2_9/VDD VTHRESH pixRst<40> voutn<40> VSUBS voutn<41>
+ NCHARGE col_periphery_1x2
XopenDVS_pixel2x2_bot_996 rowReadOFF<36> rowReadOFF<37> rowReadON<37> RefrBp PrBp
+ PrSFBp col_periphery_1x2_23/COL_LINE0 pixRst<30> pixRst<31> col_periphery_1x2_23/COL_LINE1
+ OffBn openDVS_pixel2x2_bot_996/vpd[2] openDVS_pixel2x2_bot_996/vpd[3] openDVS_pixel2x2_bot_996/vpd[1]
+ openDVS_pixel2x2_bot_996/vpd[0] rowReadON<36> openDVS_pixel2x2_bot_997/GndD DiffBn
+ VSUBS VDD OnBn openDVS_pixel2x2_bot
XopenDVS_pixel2x2_bot_985 rowReadOFF<26> rowReadOFF<27> rowReadON<27> RefrBp PrBp
+ PrSFBp col_periphery_1x2_4/COL_LINE0 pixRst<58> pixRst<59> col_periphery_1x2_4/COL_LINE1
+ OffBn openDVS_pixel2x2_bot_985/vpd[2] openDVS_pixel2x2_bot_985/vpd[3] openDVS_pixel2x2_bot_985/vpd[1]
+ openDVS_pixel2x2_bot_985/vpd[0] rowReadON<26> openDVS_pixel2x2_bot_987/GndD DiffBn
+ VSUBS VDD OnBn openDVS_pixel2x2_bot
XopenDVS_pixel2x2_bot_974 rowReadOFF<26> rowReadOFF<27> rowReadON<27> RefrBp PrBp
+ PrSFBp col_periphery_1x2_11/COL_LINE0 pixRst<36> pixRst<37> col_periphery_1x2_11/COL_LINE1
+ OffBn openDVS_pixel2x2_bot_974/vpd[2] openDVS_pixel2x2_bot_974/vpd[3] openDVS_pixel2x2_bot_974/vpd[1]
+ openDVS_pixel2x2_bot_974/vpd[0] rowReadON<26> openDVS_pixel2x2_bot_987/GndD DiffBn
+ VSUBS VDD OnBn openDVS_pixel2x2_bot
XopenDVS_pixel2x2_bot_952 rowReadOFF<22> rowReadOFF<23> rowReadON<23> RefrBp PrBp
+ PrSFBp col_periphery_1x2_23/COL_LINE0 pixRst<30> pixRst<31> col_periphery_1x2_23/COL_LINE1
+ OffBn openDVS_pixel2x2_bot_952/vpd[2] openDVS_pixel2x2_bot_952/vpd[3] openDVS_pixel2x2_bot_952/vpd[1]
+ openDVS_pixel2x2_bot_952/vpd[0] rowReadON<22> openDVS_pixel2x2_bot_97/GndD DiffBn
+ VSUBS VDD OnBn openDVS_pixel2x2_bot
XopenDVS_pixel2x2_bot_963 rowReadOFF<26> rowReadOFF<27> rowReadON<27> RefrBp PrBp
+ PrSFBp col_periphery_1x2_31/COL_LINE0 pixRst<14> pixRst<15> col_periphery_1x2_31/COL_LINE1
+ OffBn openDVS_pixel2x2_bot_963/vpd[2] openDVS_pixel2x2_bot_963/vpd[3] openDVS_pixel2x2_bot_963/vpd[1]
+ openDVS_pixel2x2_bot_963/vpd[0] rowReadON<26> openDVS_pixel2x2_bot_987/GndD DiffBn
+ VSUBS VDD OnBn openDVS_pixel2x2_bot
XopenDVS_pixel2x2_bot_930 rowReadOFF<0> rowReadOFF<1> rowReadON<1> RefrBp PrBp PrSFBp
+ col_periphery_1x2_23/COL_LINE0 pixRst<30> pixRst<31> col_periphery_1x2_23/COL_LINE1
+ OffBn openDVS_pixel2x2_bot_930/vpd[2] openDVS_pixel2x2_bot_930/vpd[3] openDVS_pixel2x2_bot_930/vpd[1]
+ openDVS_pixel2x2_bot_930/vpd[0] rowReadON<0> GND DiffBn VSUBS VDD OnBn openDVS_pixel2x2_bot
XopenDVS_pixel2x2_bot_941 rowReadOFF<10> rowReadOFF<11> rowReadON<11> RefrBp PrBp
+ PrSFBp col_periphery_1x2_9/COL_LINE0 pixRst<32> pixRst<33> col_periphery_1x2_9/COL_LINE1
+ OffBn openDVS_pixel2x2_bot_941/vpd[2] openDVS_pixel2x2_bot_941/vpd[3] openDVS_pixel2x2_bot_941/vpd[1]
+ openDVS_pixel2x2_bot_941/vpd[0] rowReadON<10> openDVS_pixel2x2_bot_82/GndD DiffBn
+ VSUBS VDD OnBn openDVS_pixel2x2_bot
XopenDVS_pixel2x2_bot_237 rowReadOFF<22> rowReadOFF<23> rowReadON<23> RefrBp PrBp
+ PrSFBp col_periphery_1x2_24/COL_LINE0 pixRst<0> pixRst<1> col_periphery_1x2_24/COL_LINE1
+ OffBn openDVS_pixel2x2_bot_237/vpd[2] openDVS_pixel2x2_bot_237/vpd[3] openDVS_pixel2x2_bot_237/vpd[1]
+ openDVS_pixel2x2_bot_237/vpd[0] rowReadON<22> openDVS_pixel2x2_bot_97/GndD DiffBn
+ VSUBS VDD OnBn openDVS_pixel2x2_bot
XopenDVS_pixel2x2_bot_248 rowReadOFF<12> rowReadOFF<13> rowReadON<13> RefrBp PrBp
+ PrSFBp col_periphery_1x2_30/COL_LINE0 pixRst<12> pixRst<13> col_periphery_1x2_30/COL_LINE1
+ OffBn openDVS_pixel2x2_bot_248/vpd[2] openDVS_pixel2x2_bot_248/vpd[3] openDVS_pixel2x2_bot_248/vpd[1]
+ openDVS_pixel2x2_bot_248/vpd[0] rowReadON<12> openDVS_pixel2x2_bot_79/GndD DiffBn
+ VSUBS VDD OnBn openDVS_pixel2x2_bot
XopenDVS_pixel2x2_bot_259 rowReadOFF<14> rowReadOFF<15> rowReadON<15> RefrBp PrBp
+ PrSFBp col_periphery_1x2_24/COL_LINE0 pixRst<0> pixRst<1> col_periphery_1x2_24/COL_LINE1
+ OffBn openDVS_pixel2x2_bot_259/vpd[2] openDVS_pixel2x2_bot_259/vpd[3] openDVS_pixel2x2_bot_259/vpd[1]
+ openDVS_pixel2x2_bot_259/vpd[0] rowReadON<14> openDVS_pixel2x2_bot_78/GndD DiffBn
+ VSUBS VDD OnBn openDVS_pixel2x2_bot
XopenDVS_pixel2x2_bot_226 rowReadOFF<0> rowReadOFF<1> rowReadON<1> RefrBp PrBp PrSFBp
+ col_periphery_1x2_30/COL_LINE0 pixRst<12> pixRst<13> col_periphery_1x2_30/COL_LINE1
+ OffBn openDVS_pixel2x2_bot_226/vpd[2] openDVS_pixel2x2_bot_226/vpd[3] openDVS_pixel2x2_bot_226/vpd[1]
+ openDVS_pixel2x2_bot_226/vpd[0] rowReadON<0> GND DiffBn VSUBS VDD OnBn openDVS_pixel2x2_bot
XopenDVS_pixel2x2_bot_215 rowReadOFF<2> rowReadOFF<3> rowReadON<3> RefrBp PrBp PrSFBp
+ col_periphery_1x2_29/COL_LINE0 pixRst<10> pixRst<11> col_periphery_1x2_29/COL_LINE1
+ OffBn openDVS_pixel2x2_bot_215/vpd[2] openDVS_pixel2x2_bot_215/vpd[3] openDVS_pixel2x2_bot_215/vpd[1]
+ openDVS_pixel2x2_bot_215/vpd[0] rowReadON<2> openDVS_pixel2x2_bot_7/GndD DiffBn
+ VSUBS VDD OnBn openDVS_pixel2x2_bot
XopenDVS_pixel2x2_bot_204 rowReadOFF<2> rowReadOFF<3> rowReadON<3> RefrBp PrBp PrSFBp
+ col_periphery_1x2_22/COL_LINE0 pixRst<28> pixRst<29> col_periphery_1x2_22/COL_LINE1
+ OffBn openDVS_pixel2x2_bot_204/vpd[2] openDVS_pixel2x2_bot_204/vpd[3] openDVS_pixel2x2_bot_204/vpd[1]
+ openDVS_pixel2x2_bot_204/vpd[0] rowReadON<2> openDVS_pixel2x2_bot_7/GndD DiffBn
+ VSUBS VDD OnBn openDVS_pixel2x2_bot
XopenDVS_pixel2x2_bot_793 rowReadOFF<56> rowReadOFF<57> rowReadON<57> RefrBp PrBp
+ PrSFBp col_periphery_1x2_11/COL_LINE0 pixRst<36> pixRst<37> col_periphery_1x2_11/COL_LINE1
+ OffBn openDVS_pixel2x2_bot_793/vpd[2] openDVS_pixel2x2_bot_793/vpd[3] openDVS_pixel2x2_bot_793/vpd[1]
+ openDVS_pixel2x2_bot_793/vpd[0] rowReadON<56> openDVS_pixel2x2_bot_888/GndD DiffBn
+ VSUBS VDD OnBn openDVS_pixel2x2_bot
XopenDVS_pixel2x2_bot_771 rowReadOFF<62> rowReadOFF<63> rowReadON<63> RefrBp PrBp
+ PrSFBp col_periphery_1x2_10/COL_LINE0 pixRst<34> pixRst<35> col_periphery_1x2_10/COL_LINE1
+ OffBn openDVS_pixel2x2_bot_771/vpd[2] openDVS_pixel2x2_bot_771/vpd[3] openDVS_pixel2x2_bot_771/vpd[1]
+ openDVS_pixel2x2_bot_771/vpd[0] rowReadON<62> openDVS_pixel2x2_bot_886/GndD DiffBn
+ VSUBS VDD OnBn openDVS_pixel2x2_bot
XopenDVS_pixel2x2_bot_782 rowReadOFF<48> rowReadOFF<49> rowReadON<49> RefrBp PrBp
+ PrSFBp col_periphery_1x2_7/COL_LINE0 pixRst<40> pixRst<41> col_periphery_1x2_7/COL_LINE1
+ OffBn openDVS_pixel2x2_bot_782/vpd[2] openDVS_pixel2x2_bot_782/vpd[3] openDVS_pixel2x2_bot_782/vpd[1]
+ openDVS_pixel2x2_bot_782/vpd[0] rowReadON<48> openDVS_pixel2x2_bot_927/GndD DiffBn
+ VSUBS VDD OnBn openDVS_pixel2x2_bot
XopenDVS_pixel2x2_bot_760 rowReadOFF<34> rowReadOFF<35> rowReadON<35> RefrBp PrBp
+ PrSFBp col_periphery_1x2_12/COL_LINE0 pixRst<38> pixRst<39> col_periphery_1x2_12/COL_LINE1
+ OffBn openDVS_pixel2x2_bot_760/vpd[2] openDVS_pixel2x2_bot_760/vpd[3] openDVS_pixel2x2_bot_760/vpd[1]
+ openDVS_pixel2x2_bot_760/vpd[0] rowReadON<34> openDVS_pixel2x2_bot_995/GndD DiffBn
+ VSUBS VDD OnBn openDVS_pixel2x2_bot
XopenDVS_pixel2x2_bot_590 rowReadOFF<56> rowReadOFF<57> rowReadON<57> RefrBp PrBp
+ PrSFBp col_periphery_1x2_19/COL_LINE0 pixRst<22> pixRst<23> col_periphery_1x2_19/COL_LINE1
+ OffBn openDVS_pixel2x2_bot_590/vpd[2] openDVS_pixel2x2_bot_590/vpd[3] openDVS_pixel2x2_bot_590/vpd[1]
+ openDVS_pixel2x2_bot_590/vpd[0] rowReadON<56> openDVS_pixel2x2_bot_888/GndD DiffBn
+ VSUBS VDD OnBn openDVS_pixel2x2_bot
XopenDVS_pixel2x2_bot_408 rowReadOFF<38> rowReadOFF<39> rowReadON<39> RefrBp PrBp
+ PrSFBp col_periphery_1x2_18/COL_LINE0 pixRst<20> pixRst<21> col_periphery_1x2_18/COL_LINE1
+ OffBn openDVS_pixel2x2_bot_408/vpd[2] openDVS_pixel2x2_bot_408/vpd[3] openDVS_pixel2x2_bot_408/vpd[1]
+ openDVS_pixel2x2_bot_408/vpd[0] rowReadON<38> openDVS_pixel2x2_bot_999/GndD DiffBn
+ VSUBS VDD OnBn openDVS_pixel2x2_bot
XopenDVS_pixel2x2_bot_419 rowReadOFF<28> rowReadOFF<29> rowReadON<29> RefrBp PrBp
+ PrSFBp col_periphery_1x2_21/COL_LINE0 pixRst<26> pixRst<27> col_periphery_1x2_21/COL_LINE1
+ OffBn openDVS_pixel2x2_bot_419/vpd[2] openDVS_pixel2x2_bot_419/vpd[3] openDVS_pixel2x2_bot_419/vpd[1]
+ openDVS_pixel2x2_bot_419/vpd[0] rowReadON<28> openDVS_pixel2x2_bot_989/GndD DiffBn
+ VSUBS VDD OnBn openDVS_pixel2x2_bot
Xcol_periphery_1x2_8 pixRst<43> col_periphery_1x2_8/COL_LINE0 col_periphery_1x2_8/COL_LINE1
+ nDETECT DETECT col_periphery_1x2_9/VDD VTHRESH pixRst<42> voutn<42> VSUBS voutn<43>
+ NCHARGE col_periphery_1x2
XopenDVS_pixel2x2_bot_920 rowReadOFF<44> rowReadOFF<45> rowReadON<45> RefrBp PrBp
+ PrSFBp col_periphery_1x2_3/COL_LINE0 pixRst<56> pixRst<57> col_periphery_1x2_3/COL_LINE1
+ OffBn openDVS_pixel2x2_bot_920/vpd[2] openDVS_pixel2x2_bot_920/vpd[3] openDVS_pixel2x2_bot_920/vpd[1]
+ openDVS_pixel2x2_bot_920/vpd[0] rowReadON<44> openDVS_pixel2x2_bot_923/GndD DiffBn
+ VSUBS VDD OnBn openDVS_pixel2x2_bot
XopenDVS_pixel2x2_bot_997 rowReadOFF<36> rowReadOFF<37> rowReadON<37> RefrBp PrBp
+ PrSFBp col_periphery_1x2_9/COL_LINE0 pixRst<32> pixRst<33> col_periphery_1x2_9/COL_LINE1
+ OffBn openDVS_pixel2x2_bot_997/vpd[2] openDVS_pixel2x2_bot_997/vpd[3] openDVS_pixel2x2_bot_997/vpd[1]
+ openDVS_pixel2x2_bot_997/vpd[0] rowReadON<36> openDVS_pixel2x2_bot_997/GndD DiffBn
+ VSUBS VDD OnBn openDVS_pixel2x2_bot
XopenDVS_pixel2x2_bot_986 rowReadOFF<26> rowReadOFF<27> rowReadON<27> RefrBp PrBp
+ PrSFBp col_periphery_1x2_5/COL_LINE0 pixRst<60> pixRst<61> col_periphery_1x2_5/COL_LINE1
+ OffBn openDVS_pixel2x2_bot_986/vpd[2] openDVS_pixel2x2_bot_986/vpd[3] openDVS_pixel2x2_bot_986/vpd[1]
+ openDVS_pixel2x2_bot_986/vpd[0] rowReadON<26> openDVS_pixel2x2_bot_987/GndD DiffBn
+ VSUBS VDD OnBn openDVS_pixel2x2_bot
XopenDVS_pixel2x2_bot_975 rowReadOFF<26> rowReadOFF<27> rowReadON<27> RefrBp PrBp
+ PrSFBp col_periphery_1x2_12/COL_LINE0 pixRst<38> pixRst<39> col_periphery_1x2_12/COL_LINE1
+ OffBn openDVS_pixel2x2_bot_975/vpd[2] openDVS_pixel2x2_bot_975/vpd[3] openDVS_pixel2x2_bot_975/vpd[1]
+ openDVS_pixel2x2_bot_975/vpd[0] rowReadON<26> openDVS_pixel2x2_bot_987/GndD DiffBn
+ VSUBS VDD OnBn openDVS_pixel2x2_bot
XopenDVS_pixel2x2_bot_953 rowReadOFF<22> rowReadOFF<23> rowReadON<23> RefrBp PrBp
+ PrSFBp col_periphery_1x2_9/COL_LINE0 pixRst<32> pixRst<33> col_periphery_1x2_9/COL_LINE1
+ OffBn openDVS_pixel2x2_bot_953/vpd[2] openDVS_pixel2x2_bot_953/vpd[3] openDVS_pixel2x2_bot_953/vpd[1]
+ openDVS_pixel2x2_bot_953/vpd[0] rowReadON<22> openDVS_pixel2x2_bot_97/GndD DiffBn
+ VSUBS VDD OnBn openDVS_pixel2x2_bot
XopenDVS_pixel2x2_bot_964 rowReadOFF<26> rowReadOFF<27> rowReadON<27> RefrBp PrBp
+ PrSFBp col_periphery_1x2_16/COL_LINE0 pixRst<16> pixRst<17> col_periphery_1x2_16/COL_LINE1
+ OffBn openDVS_pixel2x2_bot_964/vpd[2] openDVS_pixel2x2_bot_964/vpd[3] openDVS_pixel2x2_bot_964/vpd[1]
+ openDVS_pixel2x2_bot_964/vpd[0] rowReadON<26> openDVS_pixel2x2_bot_987/GndD DiffBn
+ VSUBS VDD OnBn openDVS_pixel2x2_bot
XopenDVS_pixel2x2_bot_942 rowReadOFF<12> rowReadOFF<13> rowReadON<13> RefrBp PrBp
+ PrSFBp col_periphery_1x2_23/COL_LINE0 pixRst<30> pixRst<31> col_periphery_1x2_23/COL_LINE1
+ OffBn openDVS_pixel2x2_bot_942/vpd[2] openDVS_pixel2x2_bot_942/vpd[3] openDVS_pixel2x2_bot_942/vpd[1]
+ openDVS_pixel2x2_bot_942/vpd[0] rowReadON<12> openDVS_pixel2x2_bot_79/GndD DiffBn
+ VSUBS VDD OnBn openDVS_pixel2x2_bot
XopenDVS_pixel2x2_bot_931 rowReadOFF<0> rowReadOFF<1> rowReadON<1> RefrBp PrBp PrSFBp
+ col_periphery_1x2_9/COL_LINE0 pixRst<32> pixRst<33> col_periphery_1x2_9/COL_LINE1
+ OffBn openDVS_pixel2x2_bot_931/vpd[2] openDVS_pixel2x2_bot_931/vpd[3] openDVS_pixel2x2_bot_931/vpd[1]
+ openDVS_pixel2x2_bot_931/vpd[0] rowReadON<0> GND DiffBn VSUBS VDD OnBn openDVS_pixel2x2_bot
XopenDVS_pixel2x2_bot_750 rowReadOFF<32> rowReadOFF<33> rowReadON<33> RefrBp PrBp
+ PrSFBp col_periphery_1x2_12/COL_LINE0 pixRst<38> pixRst<39> col_periphery_1x2_12/COL_LINE1
+ OffBn openDVS_pixel2x2_bot_750/vpd[2] openDVS_pixel2x2_bot_750/vpd[3] openDVS_pixel2x2_bot_750/vpd[1]
+ openDVS_pixel2x2_bot_750/vpd[0] rowReadON<32> openDVS_pixel2x2_bot_993/GndD DiffBn
+ VSUBS VDD OnBn openDVS_pixel2x2_bot
XopenDVS_pixel2x2_bot_249 rowReadOFF<22> rowReadOFF<23> rowReadON<23> RefrBp PrBp
+ PrSFBp col_periphery_1x2_27/COL_LINE0 pixRst<6> pixRst<7> col_periphery_1x2_27/COL_LINE1
+ OffBn openDVS_pixel2x2_bot_249/vpd[2] openDVS_pixel2x2_bot_249/vpd[3] openDVS_pixel2x2_bot_249/vpd[1]
+ openDVS_pixel2x2_bot_249/vpd[0] rowReadON<22> openDVS_pixel2x2_bot_97/GndD DiffBn
+ VSUBS VDD OnBn openDVS_pixel2x2_bot
XopenDVS_pixel2x2_bot_238 rowReadOFF<22> rowReadOFF<23> rowReadON<23> RefrBp PrBp
+ PrSFBp col_periphery_1x2_25/COL_LINE0 pixRst<2> pixRst<3> col_periphery_1x2_25/COL_LINE1
+ OffBn openDVS_pixel2x2_bot_238/vpd[2] openDVS_pixel2x2_bot_238/vpd[3] openDVS_pixel2x2_bot_238/vpd[1]
+ openDVS_pixel2x2_bot_238/vpd[0] rowReadON<22> openDVS_pixel2x2_bot_97/GndD DiffBn
+ VSUBS VDD OnBn openDVS_pixel2x2_bot
XopenDVS_pixel2x2_bot_216 rowReadOFF<2> rowReadOFF<3> rowReadON<3> RefrBp PrBp PrSFBp
+ col_periphery_1x2_30/COL_LINE0 pixRst<12> pixRst<13> col_periphery_1x2_30/COL_LINE1
+ OffBn openDVS_pixel2x2_bot_216/vpd[2] openDVS_pixel2x2_bot_216/vpd[3] openDVS_pixel2x2_bot_216/vpd[1]
+ openDVS_pixel2x2_bot_216/vpd[0] rowReadON<2> openDVS_pixel2x2_bot_7/GndD DiffBn
+ VSUBS VDD OnBn openDVS_pixel2x2_bot
XopenDVS_pixel2x2_bot_227 rowReadOFF<4> rowReadOFF<5> rowReadON<5> RefrBp PrBp PrSFBp
+ col_periphery_1x2_30/COL_LINE0 pixRst<12> pixRst<13> col_periphery_1x2_30/COL_LINE1
+ OffBn openDVS_pixel2x2_bot_227/vpd[2] openDVS_pixel2x2_bot_227/vpd[3] openDVS_pixel2x2_bot_227/vpd[1]
+ openDVS_pixel2x2_bot_227/vpd[0] rowReadON<4> openDVS_pixel2x2_bot_6/GndD DiffBn
+ VSUBS VDD OnBn openDVS_pixel2x2_bot
XopenDVS_pixel2x2_bot_205 rowReadOFF<4> rowReadOFF<5> rowReadON<5> RefrBp PrBp PrSFBp
+ col_periphery_1x2_18/COL_LINE0 pixRst<20> pixRst<21> col_periphery_1x2_18/COL_LINE1
+ OffBn openDVS_pixel2x2_bot_205/vpd[2] openDVS_pixel2x2_bot_205/vpd[3] openDVS_pixel2x2_bot_205/vpd[1]
+ openDVS_pixel2x2_bot_205/vpd[0] rowReadON<4> openDVS_pixel2x2_bot_6/GndD DiffBn
+ VSUBS VDD OnBn openDVS_pixel2x2_bot
XopenDVS_pixel2x2_bot_794 rowReadOFF<56> rowReadOFF<57> rowReadON<57> RefrBp PrBp
+ PrSFBp col_periphery_1x2_12/COL_LINE0 pixRst<38> pixRst<39> col_periphery_1x2_12/COL_LINE1
+ OffBn openDVS_pixel2x2_bot_794/vpd[2] openDVS_pixel2x2_bot_794/vpd[3] openDVS_pixel2x2_bot_794/vpd[1]
+ openDVS_pixel2x2_bot_794/vpd[0] rowReadON<56> openDVS_pixel2x2_bot_888/GndD DiffBn
+ VSUBS VDD OnBn openDVS_pixel2x2_bot
XopenDVS_pixel2x2_bot_783 rowReadOFF<60> rowReadOFF<61> rowReadON<61> RefrBp PrBp
+ PrSFBp col_periphery_1x2_10/COL_LINE0 pixRst<34> pixRst<35> col_periphery_1x2_10/COL_LINE1
+ OffBn openDVS_pixel2x2_bot_783/vpd[2] openDVS_pixel2x2_bot_783/vpd[3] openDVS_pixel2x2_bot_783/vpd[1]
+ openDVS_pixel2x2_bot_783/vpd[0] rowReadON<60> openDVS_pixel2x2_bot_902/GndD DiffBn
+ VSUBS VDD OnBn openDVS_pixel2x2_bot
XopenDVS_pixel2x2_bot_772 rowReadOFF<48> rowReadOFF<49> rowReadON<49> RefrBp PrBp
+ PrSFBp col_periphery_1x2_10/COL_LINE0 pixRst<34> pixRst<35> col_periphery_1x2_10/COL_LINE1
+ OffBn openDVS_pixel2x2_bot_772/vpd[2] openDVS_pixel2x2_bot_772/vpd[3] openDVS_pixel2x2_bot_772/vpd[1]
+ openDVS_pixel2x2_bot_772/vpd[0] rowReadON<48> openDVS_pixel2x2_bot_927/GndD DiffBn
+ VSUBS VDD OnBn openDVS_pixel2x2_bot
XopenDVS_pixel2x2_bot_761 rowReadOFF<34> rowReadOFF<35> rowReadON<35> RefrBp PrBp
+ PrSFBp col_periphery_1x2_7/COL_LINE0 pixRst<40> pixRst<41> col_periphery_1x2_7/COL_LINE1
+ OffBn openDVS_pixel2x2_bot_761/vpd[2] openDVS_pixel2x2_bot_761/vpd[3] openDVS_pixel2x2_bot_761/vpd[1]
+ openDVS_pixel2x2_bot_761/vpd[0] rowReadON<34> openDVS_pixel2x2_bot_995/GndD DiffBn
+ VSUBS VDD OnBn openDVS_pixel2x2_bot
XopenDVS_pixel2x2_bot_591 rowReadOFF<56> rowReadOFF<57> rowReadON<57> RefrBp PrBp
+ PrSFBp col_periphery_1x2_20/COL_LINE0 pixRst<24> pixRst<25> col_periphery_1x2_20/COL_LINE1
+ OffBn openDVS_pixel2x2_bot_591/vpd[2] openDVS_pixel2x2_bot_591/vpd[3] openDVS_pixel2x2_bot_591/vpd[1]
+ openDVS_pixel2x2_bot_591/vpd[0] rowReadON<56> openDVS_pixel2x2_bot_888/GndD DiffBn
+ VSUBS VDD OnBn openDVS_pixel2x2_bot
XopenDVS_pixel2x2_bot_580 rowReadOFF<50> rowReadOFF<51> rowReadON<51> RefrBp PrBp
+ PrSFBp col_periphery_1x2_21/COL_LINE0 pixRst<26> pixRst<27> col_periphery_1x2_21/COL_LINE1
+ OffBn openDVS_pixel2x2_bot_580/vpd[2] openDVS_pixel2x2_bot_580/vpd[3] openDVS_pixel2x2_bot_580/vpd[1]
+ openDVS_pixel2x2_bot_580/vpd[0] rowReadON<50> openDVS_pixel2x2_bot_929/GndD DiffBn
+ VSUBS VDD OnBn openDVS_pixel2x2_bot
XopenDVS_pixel2x2_bot_409 rowReadOFF<28> rowReadOFF<29> rowReadON<29> RefrBp PrBp
+ PrSFBp col_periphery_1x2_17/COL_LINE0 pixRst<18> pixRst<19> col_periphery_1x2_17/COL_LINE1
+ OffBn openDVS_pixel2x2_bot_409/vpd[2] openDVS_pixel2x2_bot_409/vpd[3] openDVS_pixel2x2_bot_409/vpd[1]
+ openDVS_pixel2x2_bot_409/vpd[0] rowReadON<28> openDVS_pixel2x2_bot_989/GndD DiffBn
+ VSUBS VDD OnBn openDVS_pixel2x2_bot
Xcol_periphery_1x2_9 pixRst<33> col_periphery_1x2_9/COL_LINE0 col_periphery_1x2_9/COL_LINE1
+ nDETECT DETECT col_periphery_1x2_9/VDD VTHRESH pixRst<32> voutn<32> VSUBS voutn<33>
+ NCHARGE col_periphery_1x2
XopenDVS_pixel2x2_bot_921 rowReadOFF<44> rowReadOFF<45> rowReadON<45> RefrBp PrBp
+ PrSFBp col_periphery_1x2_4/COL_LINE0 pixRst<58> pixRst<59> col_periphery_1x2_4/COL_LINE1
+ OffBn openDVS_pixel2x2_bot_921/vpd[2] openDVS_pixel2x2_bot_921/vpd[3] openDVS_pixel2x2_bot_921/vpd[1]
+ openDVS_pixel2x2_bot_921/vpd[0] rowReadON<44> openDVS_pixel2x2_bot_923/GndD DiffBn
+ VSUBS VDD OnBn openDVS_pixel2x2_bot
XopenDVS_pixel2x2_bot_910 rowReadOFF<44> rowReadOFF<45> rowReadON<45> RefrBp PrBp
+ PrSFBp col_periphery_1x2_11/COL_LINE0 pixRst<36> pixRst<37> col_periphery_1x2_11/COL_LINE1
+ OffBn openDVS_pixel2x2_bot_910/vpd[2] openDVS_pixel2x2_bot_910/vpd[3] openDVS_pixel2x2_bot_910/vpd[1]
+ openDVS_pixel2x2_bot_910/vpd[0] rowReadON<44> openDVS_pixel2x2_bot_923/GndD DiffBn
+ VSUBS VDD OnBn openDVS_pixel2x2_bot
XopenDVS_pixel2x2_bot_998 rowReadOFF<38> rowReadOFF<39> rowReadON<39> RefrBp PrBp
+ PrSFBp col_periphery_1x2_23/COL_LINE0 pixRst<30> pixRst<31> col_periphery_1x2_23/COL_LINE1
+ OffBn openDVS_pixel2x2_bot_998/vpd[2] openDVS_pixel2x2_bot_998/vpd[3] openDVS_pixel2x2_bot_998/vpd[1]
+ openDVS_pixel2x2_bot_998/vpd[0] rowReadON<38> openDVS_pixel2x2_bot_999/GndD DiffBn
+ VSUBS VDD OnBn openDVS_pixel2x2_bot
XopenDVS_pixel2x2_bot_987 rowReadOFF<26> rowReadOFF<27> rowReadON<27> RefrBp PrBp
+ PrSFBp col_periphery_1x2_6/COL_LINE0 pixRst<62> pixRst<63> col_periphery_1x2_6/COL_LINE1
+ OffBn openDVS_pixel2x2_bot_987/vpd[2] openDVS_pixel2x2_bot_987/vpd[3] openDVS_pixel2x2_bot_987/vpd[1]
+ openDVS_pixel2x2_bot_987/vpd[0] rowReadON<26> openDVS_pixel2x2_bot_987/GndD DiffBn
+ VSUBS VDD OnBn openDVS_pixel2x2_bot
XopenDVS_pixel2x2_bot_976 rowReadOFF<26> rowReadOFF<27> rowReadON<27> RefrBp PrBp
+ PrSFBp col_periphery_1x2_7/COL_LINE0 pixRst<40> pixRst<41> col_periphery_1x2_7/COL_LINE1
+ OffBn openDVS_pixel2x2_bot_976/vpd[2] openDVS_pixel2x2_bot_976/vpd[3] openDVS_pixel2x2_bot_976/vpd[1]
+ openDVS_pixel2x2_bot_976/vpd[0] rowReadON<26> openDVS_pixel2x2_bot_987/GndD DiffBn
+ VSUBS VDD OnBn openDVS_pixel2x2_bot
XopenDVS_pixel2x2_bot_954 rowReadOFF<24> rowReadOFF<25> rowReadON<25> RefrBp PrBp
+ PrSFBp col_periphery_1x2_23/COL_LINE0 pixRst<30> pixRst<31> col_periphery_1x2_23/COL_LINE1
+ OffBn openDVS_pixel2x2_bot_954/vpd[2] openDVS_pixel2x2_bot_954/vpd[3] openDVS_pixel2x2_bot_954/vpd[1]
+ openDVS_pixel2x2_bot_954/vpd[0] rowReadON<24> openDVS_pixel2x2_bot_99/GndD DiffBn
+ VSUBS VDD OnBn openDVS_pixel2x2_bot
XopenDVS_pixel2x2_bot_965 rowReadOFF<26> rowReadOFF<27> rowReadON<27> RefrBp PrBp
+ PrSFBp col_periphery_1x2_17/COL_LINE0 pixRst<18> pixRst<19> col_periphery_1x2_17/COL_LINE1
+ OffBn openDVS_pixel2x2_bot_965/vpd[2] openDVS_pixel2x2_bot_965/vpd[3] openDVS_pixel2x2_bot_965/vpd[1]
+ openDVS_pixel2x2_bot_965/vpd[0] rowReadON<26> openDVS_pixel2x2_bot_987/GndD DiffBn
+ VSUBS VDD OnBn openDVS_pixel2x2_bot
XopenDVS_pixel2x2_bot_943 rowReadOFF<12> rowReadOFF<13> rowReadON<13> RefrBp PrBp
+ PrSFBp col_periphery_1x2_9/COL_LINE0 pixRst<32> pixRst<33> col_periphery_1x2_9/COL_LINE1
+ OffBn openDVS_pixel2x2_bot_943/vpd[2] openDVS_pixel2x2_bot_943/vpd[3] openDVS_pixel2x2_bot_943/vpd[1]
+ openDVS_pixel2x2_bot_943/vpd[0] rowReadON<12> openDVS_pixel2x2_bot_79/GndD DiffBn
+ VSUBS VDD OnBn openDVS_pixel2x2_bot
XopenDVS_pixel2x2_bot_932 rowReadOFF<2> rowReadOFF<3> rowReadON<3> RefrBp PrBp PrSFBp
+ col_periphery_1x2_23/COL_LINE0 pixRst<30> pixRst<31> col_periphery_1x2_23/COL_LINE1
+ OffBn openDVS_pixel2x2_bot_932/vpd[2] openDVS_pixel2x2_bot_932/vpd[3] openDVS_pixel2x2_bot_932/vpd[1]
+ openDVS_pixel2x2_bot_932/vpd[0] rowReadON<2> openDVS_pixel2x2_bot_7/GndD DiffBn
+ VSUBS VDD OnBn openDVS_pixel2x2_bot
XopenDVS_pixel2x2_bot_239 rowReadOFF<22> rowReadOFF<23> rowReadON<23> RefrBp PrBp
+ PrSFBp col_periphery_1x2_26/COL_LINE0 pixRst<4> pixRst<5> col_periphery_1x2_26/COL_LINE1
+ OffBn openDVS_pixel2x2_bot_239/vpd[2] openDVS_pixel2x2_bot_239/vpd[3] openDVS_pixel2x2_bot_239/vpd[1]
+ openDVS_pixel2x2_bot_239/vpd[0] rowReadON<22> openDVS_pixel2x2_bot_97/GndD DiffBn
+ VSUBS VDD OnBn openDVS_pixel2x2_bot
XopenDVS_pixel2x2_bot_206 rowReadOFF<0> rowReadOFF<1> rowReadON<1> RefrBp PrBp PrSFBp
+ col_periphery_1x2_17/COL_LINE0 pixRst<18> pixRst<19> col_periphery_1x2_17/COL_LINE1
+ OffBn openDVS_pixel2x2_bot_206/vpd[2] openDVS_pixel2x2_bot_206/vpd[3] openDVS_pixel2x2_bot_206/vpd[1]
+ openDVS_pixel2x2_bot_206/vpd[0] rowReadON<0> GND DiffBn VSUBS VDD OnBn openDVS_pixel2x2_bot
XopenDVS_pixel2x2_bot_217 rowReadOFF<4> rowReadOFF<5> rowReadON<5> RefrBp PrBp PrSFBp
+ col_periphery_1x2_25/COL_LINE0 pixRst<2> pixRst<3> col_periphery_1x2_25/COL_LINE1
+ OffBn openDVS_pixel2x2_bot_217/vpd[2] openDVS_pixel2x2_bot_217/vpd[3] openDVS_pixel2x2_bot_217/vpd[1]
+ openDVS_pixel2x2_bot_217/vpd[0] rowReadON<4> openDVS_pixel2x2_bot_6/GndD DiffBn
+ VSUBS VDD OnBn openDVS_pixel2x2_bot
XopenDVS_pixel2x2_bot_228 rowReadOFF<4> rowReadOFF<5> rowReadON<5> RefrBp PrBp PrSFBp
+ col_periphery_1x2_27/COL_LINE0 pixRst<6> pixRst<7> col_periphery_1x2_27/COL_LINE1
+ OffBn openDVS_pixel2x2_bot_228/vpd[2] openDVS_pixel2x2_bot_228/vpd[3] openDVS_pixel2x2_bot_228/vpd[1]
+ openDVS_pixel2x2_bot_228/vpd[0] rowReadON<4> openDVS_pixel2x2_bot_6/GndD DiffBn
+ VSUBS VDD OnBn openDVS_pixel2x2_bot
XopenDVS_pixel2x2_bot_773 rowReadOFF<62> rowReadOFF<63> rowReadON<63> RefrBp PrBp
+ PrSFBp col_periphery_1x2_13/COL_LINE0 pixRst<44> pixRst<45> col_periphery_1x2_13/COL_LINE1
+ OffBn openDVS_pixel2x2_bot_773/vpd[2] openDVS_pixel2x2_bot_773/vpd[3] openDVS_pixel2x2_bot_773/vpd[1]
+ openDVS_pixel2x2_bot_773/vpd[0] rowReadON<62> openDVS_pixel2x2_bot_886/GndD DiffBn
+ VSUBS VDD OnBn openDVS_pixel2x2_bot
XopenDVS_pixel2x2_bot_795 rowReadOFF<56> rowReadOFF<57> rowReadON<57> RefrBp PrBp
+ PrSFBp col_periphery_1x2_7/COL_LINE0 pixRst<40> pixRst<41> col_periphery_1x2_7/COL_LINE1
+ OffBn openDVS_pixel2x2_bot_795/vpd[2] openDVS_pixel2x2_bot_795/vpd[3] openDVS_pixel2x2_bot_795/vpd[1]
+ openDVS_pixel2x2_bot_795/vpd[0] rowReadON<56> openDVS_pixel2x2_bot_888/GndD DiffBn
+ VSUBS VDD OnBn openDVS_pixel2x2_bot
XopenDVS_pixel2x2_bot_784 rowReadOFF<60> rowReadOFF<61> rowReadON<61> RefrBp PrBp
+ PrSFBp col_periphery_1x2_11/COL_LINE0 pixRst<36> pixRst<37> col_periphery_1x2_11/COL_LINE1
+ OffBn openDVS_pixel2x2_bot_784/vpd[2] openDVS_pixel2x2_bot_784/vpd[3] openDVS_pixel2x2_bot_784/vpd[1]
+ openDVS_pixel2x2_bot_784/vpd[0] rowReadON<60> openDVS_pixel2x2_bot_902/GndD DiffBn
+ VSUBS VDD OnBn openDVS_pixel2x2_bot
XopenDVS_pixel2x2_bot_762 rowReadOFF<34> rowReadOFF<35> rowReadON<35> RefrBp PrBp
+ PrSFBp col_periphery_1x2_8/COL_LINE0 pixRst<42> pixRst<43> col_periphery_1x2_8/COL_LINE1
+ OffBn openDVS_pixel2x2_bot_762/vpd[2] openDVS_pixel2x2_bot_762/vpd[3] openDVS_pixel2x2_bot_762/vpd[1]
+ openDVS_pixel2x2_bot_762/vpd[0] rowReadON<34> openDVS_pixel2x2_bot_995/GndD DiffBn
+ VSUBS VDD OnBn openDVS_pixel2x2_bot
XopenDVS_pixel2x2_bot_751 rowReadOFF<32> rowReadOFF<33> rowReadON<33> RefrBp PrBp
+ PrSFBp col_periphery_1x2_7/COL_LINE0 pixRst<40> pixRst<41> col_periphery_1x2_7/COL_LINE1
+ OffBn openDVS_pixel2x2_bot_751/vpd[2] openDVS_pixel2x2_bot_751/vpd[3] openDVS_pixel2x2_bot_751/vpd[1]
+ openDVS_pixel2x2_bot_751/vpd[0] rowReadON<32> openDVS_pixel2x2_bot_993/GndD DiffBn
+ VSUBS VDD OnBn openDVS_pixel2x2_bot
XopenDVS_pixel2x2_bot_740 rowReadOFF<30> rowReadOFF<31> rowReadON<31> RefrBp PrBp
+ PrSFBp col_periphery_1x2_12/COL_LINE0 pixRst<38> pixRst<39> col_periphery_1x2_12/COL_LINE1
+ OffBn openDVS_pixel2x2_bot_740/vpd[2] openDVS_pixel2x2_bot_740/vpd[3] openDVS_pixel2x2_bot_740/vpd[1]
+ openDVS_pixel2x2_bot_740/vpd[0] rowReadON<30> openDVS_pixel2x2_bot_991/GndD DiffBn
+ VSUBS VDD OnBn openDVS_pixel2x2_bot
XopenDVS_pixel2x2_bot_570 rowReadOFF<60> rowReadOFF<61> rowReadON<61> RefrBp PrBp
+ PrSFBp col_periphery_1x2_18/COL_LINE0 pixRst<20> pixRst<21> col_periphery_1x2_18/COL_LINE1
+ OffBn openDVS_pixel2x2_bot_570/vpd[2] openDVS_pixel2x2_bot_570/vpd[3] openDVS_pixel2x2_bot_570/vpd[1]
+ openDVS_pixel2x2_bot_570/vpd[0] rowReadON<60> openDVS_pixel2x2_bot_902/GndD DiffBn
+ VSUBS VDD OnBn openDVS_pixel2x2_bot
XopenDVS_pixel2x2_bot_592 rowReadOFF<58> rowReadOFF<59> rowReadON<59> RefrBp PrBp
+ PrSFBp col_periphery_1x2_17/COL_LINE0 pixRst<18> pixRst<19> col_periphery_1x2_17/COL_LINE1
+ OffBn openDVS_pixel2x2_bot_592/vpd[2] openDVS_pixel2x2_bot_592/vpd[3] openDVS_pixel2x2_bot_592/vpd[1]
+ openDVS_pixel2x2_bot_592/vpd[0] rowReadON<58> openDVS_pixel2x2_bot_890/GndD DiffBn
+ VSUBS VDD OnBn openDVS_pixel2x2_bot
XopenDVS_pixel2x2_bot_581 rowReadOFF<50> rowReadOFF<51> rowReadON<51> RefrBp PrBp
+ PrSFBp col_periphery_1x2_22/COL_LINE0 pixRst<28> pixRst<29> col_periphery_1x2_22/COL_LINE1
+ OffBn openDVS_pixel2x2_bot_581/vpd[2] openDVS_pixel2x2_bot_581/vpd[3] openDVS_pixel2x2_bot_581/vpd[1]
+ openDVS_pixel2x2_bot_581/vpd[0] rowReadON<50> openDVS_pixel2x2_bot_929/GndD DiffBn
+ VSUBS VDD OnBn openDVS_pixel2x2_bot
XopenDVS_pixel2x2_bot_922 rowReadOFF<44> rowReadOFF<45> rowReadON<45> RefrBp PrBp
+ PrSFBp col_periphery_1x2_5/COL_LINE0 pixRst<60> pixRst<61> col_periphery_1x2_5/COL_LINE1
+ OffBn openDVS_pixel2x2_bot_922/vpd[2] openDVS_pixel2x2_bot_922/vpd[3] openDVS_pixel2x2_bot_922/vpd[1]
+ openDVS_pixel2x2_bot_922/vpd[0] rowReadON<44> openDVS_pixel2x2_bot_923/GndD DiffBn
+ VSUBS VDD OnBn openDVS_pixel2x2_bot
XopenDVS_pixel2x2_bot_911 rowReadOFF<44> rowReadOFF<45> rowReadON<45> RefrBp PrBp
+ PrSFBp col_periphery_1x2_12/COL_LINE0 pixRst<38> pixRst<39> col_periphery_1x2_12/COL_LINE1
+ OffBn openDVS_pixel2x2_bot_911/vpd[2] openDVS_pixel2x2_bot_911/vpd[3] openDVS_pixel2x2_bot_911/vpd[1]
+ openDVS_pixel2x2_bot_911/vpd[0] rowReadON<44> openDVS_pixel2x2_bot_923/GndD DiffBn
+ VSUBS VDD OnBn openDVS_pixel2x2_bot
XopenDVS_pixel2x2_bot_900 rowReadOFF<36> rowReadOFF<37> rowReadON<37> RefrBp PrBp
+ PrSFBp col_periphery_1x2_15/COL_LINE0 pixRst<48> pixRst<49> col_periphery_1x2_15/COL_LINE1
+ OffBn openDVS_pixel2x2_bot_900/vpd[2] openDVS_pixel2x2_bot_900/vpd[3] openDVS_pixel2x2_bot_900/vpd[1]
+ openDVS_pixel2x2_bot_900/vpd[0] rowReadON<36> openDVS_pixel2x2_bot_997/GndD DiffBn
+ VSUBS VDD OnBn openDVS_pixel2x2_bot
XopenDVS_pixel2x2_bot_999 rowReadOFF<38> rowReadOFF<39> rowReadON<39> RefrBp PrBp
+ PrSFBp col_periphery_1x2_9/COL_LINE0 pixRst<32> pixRst<33> col_periphery_1x2_9/COL_LINE1
+ OffBn openDVS_pixel2x2_bot_999/vpd[2] openDVS_pixel2x2_bot_999/vpd[3] openDVS_pixel2x2_bot_999/vpd[1]
+ openDVS_pixel2x2_bot_999/vpd[0] rowReadON<38> openDVS_pixel2x2_bot_999/GndD DiffBn
+ VSUBS VDD OnBn openDVS_pixel2x2_bot
XopenDVS_pixel2x2_bot_977 rowReadOFF<26> rowReadOFF<27> rowReadON<27> RefrBp PrBp
+ PrSFBp col_periphery_1x2_8/COL_LINE0 pixRst<42> pixRst<43> col_periphery_1x2_8/COL_LINE1
+ OffBn openDVS_pixel2x2_bot_977/vpd[2] openDVS_pixel2x2_bot_977/vpd[3] openDVS_pixel2x2_bot_977/vpd[1]
+ openDVS_pixel2x2_bot_977/vpd[0] rowReadON<26> openDVS_pixel2x2_bot_987/GndD DiffBn
+ VSUBS VDD OnBn openDVS_pixel2x2_bot
XopenDVS_pixel2x2_bot_955 rowReadOFF<24> rowReadOFF<25> rowReadON<25> RefrBp PrBp
+ PrSFBp col_periphery_1x2_9/COL_LINE0 pixRst<32> pixRst<33> col_periphery_1x2_9/COL_LINE1
+ OffBn openDVS_pixel2x2_bot_955/vpd[2] openDVS_pixel2x2_bot_955/vpd[3] openDVS_pixel2x2_bot_955/vpd[1]
+ openDVS_pixel2x2_bot_955/vpd[0] rowReadON<24> openDVS_pixel2x2_bot_99/GndD DiffBn
+ VSUBS VDD OnBn openDVS_pixel2x2_bot
XopenDVS_pixel2x2_bot_988 rowReadOFF<28> rowReadOFF<29> rowReadON<29> RefrBp PrBp
+ PrSFBp col_periphery_1x2_23/COL_LINE0 pixRst<30> pixRst<31> col_periphery_1x2_23/COL_LINE1
+ OffBn openDVS_pixel2x2_bot_988/vpd[2] openDVS_pixel2x2_bot_988/vpd[3] openDVS_pixel2x2_bot_988/vpd[1]
+ openDVS_pixel2x2_bot_988/vpd[0] rowReadON<28> openDVS_pixel2x2_bot_989/GndD DiffBn
+ VSUBS VDD OnBn openDVS_pixel2x2_bot
XopenDVS_pixel2x2_bot_966 rowReadOFF<26> rowReadOFF<27> rowReadON<27> RefrBp PrBp
+ PrSFBp col_periphery_1x2_18/COL_LINE0 pixRst<20> pixRst<21> col_periphery_1x2_18/COL_LINE1
+ OffBn openDVS_pixel2x2_bot_966/vpd[2] openDVS_pixel2x2_bot_966/vpd[3] openDVS_pixel2x2_bot_966/vpd[1]
+ openDVS_pixel2x2_bot_966/vpd[0] rowReadON<26> openDVS_pixel2x2_bot_987/GndD DiffBn
+ VSUBS VDD OnBn openDVS_pixel2x2_bot
XopenDVS_pixel2x2_bot_944 rowReadOFF<14> rowReadOFF<15> rowReadON<15> RefrBp PrBp
+ PrSFBp col_periphery_1x2_23/COL_LINE0 pixRst<30> pixRst<31> col_periphery_1x2_23/COL_LINE1
+ OffBn openDVS_pixel2x2_bot_944/vpd[2] openDVS_pixel2x2_bot_944/vpd[3] openDVS_pixel2x2_bot_944/vpd[1]
+ openDVS_pixel2x2_bot_944/vpd[0] rowReadON<14> openDVS_pixel2x2_bot_78/GndD DiffBn
+ VSUBS VDD OnBn openDVS_pixel2x2_bot
XopenDVS_pixel2x2_bot_933 rowReadOFF<2> rowReadOFF<3> rowReadON<3> RefrBp PrBp PrSFBp
+ col_periphery_1x2_9/COL_LINE0 pixRst<32> pixRst<33> col_periphery_1x2_9/COL_LINE1
+ OffBn openDVS_pixel2x2_bot_933/vpd[2] openDVS_pixel2x2_bot_933/vpd[3] openDVS_pixel2x2_bot_933/vpd[1]
+ openDVS_pixel2x2_bot_933/vpd[0] rowReadON<2> openDVS_pixel2x2_bot_7/GndD DiffBn
+ VSUBS VDD OnBn openDVS_pixel2x2_bot
XopenDVS_pixel2x2_bot_207 rowReadOFF<0> rowReadOFF<1> rowReadON<1> RefrBp PrBp PrSFBp
+ col_periphery_1x2_18/COL_LINE0 pixRst<20> pixRst<21> col_periphery_1x2_18/COL_LINE1
+ OffBn openDVS_pixel2x2_bot_207/vpd[2] openDVS_pixel2x2_bot_207/vpd[3] openDVS_pixel2x2_bot_207/vpd[1]
+ openDVS_pixel2x2_bot_207/vpd[0] rowReadON<0> GND DiffBn VSUBS VDD OnBn openDVS_pixel2x2_bot
XopenDVS_pixel2x2_bot_218 rowReadOFF<4> rowReadOFF<5> rowReadON<5> RefrBp PrBp PrSFBp
+ col_periphery_1x2_26/COL_LINE0 pixRst<4> pixRst<5> col_periphery_1x2_26/COL_LINE1
+ OffBn openDVS_pixel2x2_bot_218/vpd[2] openDVS_pixel2x2_bot_218/vpd[3] openDVS_pixel2x2_bot_218/vpd[1]
+ openDVS_pixel2x2_bot_218/vpd[0] rowReadON<4> openDVS_pixel2x2_bot_6/GndD DiffBn
+ VSUBS VDD OnBn openDVS_pixel2x2_bot
XopenDVS_pixel2x2_bot_229 rowReadOFF<4> rowReadOFF<5> rowReadON<5> RefrBp PrBp PrSFBp
+ col_periphery_1x2_28/COL_LINE0 pixRst<8> pixRst<9> col_periphery_1x2_28/COL_LINE1
+ OffBn openDVS_pixel2x2_bot_229/vpd[2] openDVS_pixel2x2_bot_229/vpd[3] openDVS_pixel2x2_bot_229/vpd[1]
+ openDVS_pixel2x2_bot_229/vpd[0] rowReadON<4> openDVS_pixel2x2_bot_6/GndD DiffBn
+ VSUBS VDD OnBn openDVS_pixel2x2_bot
XopenDVS_pixel2x2_bot_796 rowReadOFF<56> rowReadOFF<57> rowReadON<57> RefrBp PrBp
+ PrSFBp col_periphery_1x2_8/COL_LINE0 pixRst<42> pixRst<43> col_periphery_1x2_8/COL_LINE1
+ OffBn openDVS_pixel2x2_bot_796/vpd[2] openDVS_pixel2x2_bot_796/vpd[3] openDVS_pixel2x2_bot_796/vpd[1]
+ openDVS_pixel2x2_bot_796/vpd[0] rowReadON<56> openDVS_pixel2x2_bot_888/GndD DiffBn
+ VSUBS VDD OnBn openDVS_pixel2x2_bot
XopenDVS_pixel2x2_bot_785 rowReadOFF<48> rowReadOFF<49> rowReadON<49> RefrBp PrBp
+ PrSFBp col_periphery_1x2_8/COL_LINE0 pixRst<42> pixRst<43> col_periphery_1x2_8/COL_LINE1
+ OffBn openDVS_pixel2x2_bot_785/vpd[2] openDVS_pixel2x2_bot_785/vpd[3] openDVS_pixel2x2_bot_785/vpd[1]
+ openDVS_pixel2x2_bot_785/vpd[0] rowReadON<48> openDVS_pixel2x2_bot_927/GndD DiffBn
+ VSUBS VDD OnBn openDVS_pixel2x2_bot
XopenDVS_pixel2x2_bot_774 rowReadOFF<48> rowReadOFF<49> rowReadON<49> RefrBp PrBp
+ PrSFBp col_periphery_1x2_11/COL_LINE0 pixRst<36> pixRst<37> col_periphery_1x2_11/COL_LINE1
+ OffBn openDVS_pixel2x2_bot_774/vpd[2] openDVS_pixel2x2_bot_774/vpd[3] openDVS_pixel2x2_bot_774/vpd[1]
+ openDVS_pixel2x2_bot_774/vpd[0] rowReadON<48> openDVS_pixel2x2_bot_927/GndD DiffBn
+ VSUBS VDD OnBn openDVS_pixel2x2_bot
XopenDVS_pixel2x2_bot_763 rowReadOFF<34> rowReadOFF<35> rowReadON<35> RefrBp PrBp
+ PrSFBp col_periphery_1x2_13/COL_LINE0 pixRst<44> pixRst<45> col_periphery_1x2_13/COL_LINE1
+ OffBn openDVS_pixel2x2_bot_763/vpd[2] openDVS_pixel2x2_bot_763/vpd[3] openDVS_pixel2x2_bot_763/vpd[1]
+ openDVS_pixel2x2_bot_763/vpd[0] rowReadON<34> openDVS_pixel2x2_bot_995/GndD DiffBn
+ VSUBS VDD OnBn openDVS_pixel2x2_bot
XopenDVS_pixel2x2_bot_752 rowReadOFF<32> rowReadOFF<33> rowReadON<33> RefrBp PrBp
+ PrSFBp col_periphery_1x2_8/COL_LINE0 pixRst<42> pixRst<43> col_periphery_1x2_8/COL_LINE1
+ OffBn openDVS_pixel2x2_bot_752/vpd[2] openDVS_pixel2x2_bot_752/vpd[3] openDVS_pixel2x2_bot_752/vpd[1]
+ openDVS_pixel2x2_bot_752/vpd[0] rowReadON<32> openDVS_pixel2x2_bot_993/GndD DiffBn
+ VSUBS VDD OnBn openDVS_pixel2x2_bot
XopenDVS_pixel2x2_bot_741 rowReadOFF<30> rowReadOFF<31> rowReadON<31> RefrBp PrBp
+ PrSFBp col_periphery_1x2_7/COL_LINE0 pixRst<40> pixRst<41> col_periphery_1x2_7/COL_LINE1
+ OffBn openDVS_pixel2x2_bot_741/vpd[2] openDVS_pixel2x2_bot_741/vpd[3] openDVS_pixel2x2_bot_741/vpd[1]
+ openDVS_pixel2x2_bot_741/vpd[0] rowReadON<30> openDVS_pixel2x2_bot_991/GndD DiffBn
+ VSUBS VDD OnBn openDVS_pixel2x2_bot
XopenDVS_pixel2x2_bot_730 rowReadOFF<28> rowReadOFF<29> rowReadON<29> RefrBp PrBp
+ PrSFBp col_periphery_1x2_12/COL_LINE0 pixRst<38> pixRst<39> col_periphery_1x2_12/COL_LINE1
+ OffBn openDVS_pixel2x2_bot_730/vpd[2] openDVS_pixel2x2_bot_730/vpd[3] openDVS_pixel2x2_bot_730/vpd[1]
+ openDVS_pixel2x2_bot_730/vpd[0] rowReadON<28> openDVS_pixel2x2_bot_989/GndD DiffBn
+ VSUBS VDD OnBn openDVS_pixel2x2_bot
XopenDVS_pixel2x2_bot_571 rowReadOFF<60> rowReadOFF<61> rowReadON<61> RefrBp PrBp
+ PrSFBp col_periphery_1x2_19/COL_LINE0 pixRst<22> pixRst<23> col_periphery_1x2_19/COL_LINE1
+ OffBn openDVS_pixel2x2_bot_571/vpd[2] openDVS_pixel2x2_bot_571/vpd[3] openDVS_pixel2x2_bot_571/vpd[1]
+ openDVS_pixel2x2_bot_571/vpd[0] rowReadON<60> openDVS_pixel2x2_bot_902/GndD DiffBn
+ VSUBS VDD OnBn openDVS_pixel2x2_bot
XopenDVS_pixel2x2_bot_560 rowReadOFF<58> rowReadOFF<59> rowReadON<59> RefrBp PrBp
+ PrSFBp col_periphery_1x2_19/COL_LINE0 pixRst<22> pixRst<23> col_periphery_1x2_19/COL_LINE1
+ OffBn openDVS_pixel2x2_bot_560/vpd[2] openDVS_pixel2x2_bot_560/vpd[3] openDVS_pixel2x2_bot_560/vpd[1]
+ openDVS_pixel2x2_bot_560/vpd[0] rowReadON<58> openDVS_pixel2x2_bot_890/GndD DiffBn
+ VSUBS VDD OnBn openDVS_pixel2x2_bot
XopenDVS_pixel2x2_bot_593 rowReadOFF<58> rowReadOFF<59> rowReadON<59> RefrBp PrBp
+ PrSFBp col_periphery_1x2_18/COL_LINE0 pixRst<20> pixRst<21> col_periphery_1x2_18/COL_LINE1
+ OffBn openDVS_pixel2x2_bot_593/vpd[2] openDVS_pixel2x2_bot_593/vpd[3] openDVS_pixel2x2_bot_593/vpd[1]
+ openDVS_pixel2x2_bot_593/vpd[0] rowReadON<58> openDVS_pixel2x2_bot_890/GndD DiffBn
+ VSUBS VDD OnBn openDVS_pixel2x2_bot
XopenDVS_pixel2x2_bot_582 rowReadOFF<48> rowReadOFF<49> rowReadON<49> RefrBp PrBp
+ PrSFBp col_periphery_1x2_17/COL_LINE0 pixRst<18> pixRst<19> col_periphery_1x2_17/COL_LINE1
+ OffBn openDVS_pixel2x2_bot_582/vpd[2] openDVS_pixel2x2_bot_582/vpd[3] openDVS_pixel2x2_bot_582/vpd[1]
+ openDVS_pixel2x2_bot_582/vpd[0] rowReadON<48> openDVS_pixel2x2_bot_927/GndD DiffBn
+ VSUBS VDD OnBn openDVS_pixel2x2_bot
XopenDVS_pixel2x2_bot_390 rowReadOFF<36> rowReadOFF<37> rowReadON<37> RefrBp PrBp
+ PrSFBp col_periphery_1x2_20/COL_LINE0 pixRst<24> pixRst<25> col_periphery_1x2_20/COL_LINE1
+ OffBn openDVS_pixel2x2_bot_390/vpd[2] openDVS_pixel2x2_bot_390/vpd[3] openDVS_pixel2x2_bot_390/vpd[1]
+ openDVS_pixel2x2_bot_390/vpd[0] rowReadON<36> openDVS_pixel2x2_bot_997/GndD DiffBn
+ VSUBS VDD OnBn openDVS_pixel2x2_bot
XopenDVS_pixel2x2_bot_901 rowReadOFF<60> rowReadOFF<61> rowReadON<61> RefrBp PrBp
+ PrSFBp col_periphery_1x2_14/COL_LINE0 pixRst<46> pixRst<47> col_periphery_1x2_14/COL_LINE1
+ OffBn openDVS_pixel2x2_bot_901/vpd[2] openDVS_pixel2x2_bot_901/vpd[3] openDVS_pixel2x2_bot_901/vpd[1]
+ openDVS_pixel2x2_bot_901/vpd[0] rowReadON<60> openDVS_pixel2x2_bot_902/GndD DiffBn
+ VSUBS VDD OnBn openDVS_pixel2x2_bot
XopenDVS_pixel2x2_bot_923 rowReadOFF<44> rowReadOFF<45> rowReadON<45> RefrBp PrBp
+ PrSFBp col_periphery_1x2_6/COL_LINE0 pixRst<62> pixRst<63> col_periphery_1x2_6/COL_LINE1
+ OffBn openDVS_pixel2x2_bot_923/vpd[2] openDVS_pixel2x2_bot_923/vpd[3] openDVS_pixel2x2_bot_923/vpd[1]
+ openDVS_pixel2x2_bot_923/vpd[0] rowReadON<44> openDVS_pixel2x2_bot_923/GndD DiffBn
+ VSUBS VDD OnBn openDVS_pixel2x2_bot
XopenDVS_pixel2x2_bot_912 rowReadOFF<44> rowReadOFF<45> rowReadON<45> RefrBp PrBp
+ PrSFBp col_periphery_1x2_7/COL_LINE0 pixRst<40> pixRst<41> col_periphery_1x2_7/COL_LINE1
+ OffBn openDVS_pixel2x2_bot_912/vpd[2] openDVS_pixel2x2_bot_912/vpd[3] openDVS_pixel2x2_bot_912/vpd[1]
+ openDVS_pixel2x2_bot_912/vpd[0] rowReadON<44> openDVS_pixel2x2_bot_923/GndD DiffBn
+ VSUBS VDD OnBn openDVS_pixel2x2_bot
XopenDVS_pixel2x2_bot_978 rowReadOFF<26> rowReadOFF<27> rowReadON<27> RefrBp PrBp
+ PrSFBp col_periphery_1x2_13/COL_LINE0 pixRst<44> pixRst<45> col_periphery_1x2_13/COL_LINE1
+ OffBn openDVS_pixel2x2_bot_978/vpd[2] openDVS_pixel2x2_bot_978/vpd[3] openDVS_pixel2x2_bot_978/vpd[1]
+ openDVS_pixel2x2_bot_978/vpd[0] rowReadON<26> openDVS_pixel2x2_bot_987/GndD DiffBn
+ VSUBS VDD OnBn openDVS_pixel2x2_bot
XopenDVS_pixel2x2_bot_989 rowReadOFF<28> rowReadOFF<29> rowReadON<29> RefrBp PrBp
+ PrSFBp col_periphery_1x2_9/COL_LINE0 pixRst<32> pixRst<33> col_periphery_1x2_9/COL_LINE1
+ OffBn openDVS_pixel2x2_bot_989/vpd[2] openDVS_pixel2x2_bot_989/vpd[3] openDVS_pixel2x2_bot_989/vpd[1]
+ openDVS_pixel2x2_bot_989/vpd[0] rowReadON<28> openDVS_pixel2x2_bot_989/GndD DiffBn
+ VSUBS VDD OnBn openDVS_pixel2x2_bot
XopenDVS_pixel2x2_bot_967 rowReadOFF<26> rowReadOFF<27> rowReadON<27> RefrBp PrBp
+ PrSFBp col_periphery_1x2_19/COL_LINE0 pixRst<22> pixRst<23> col_periphery_1x2_19/COL_LINE1
+ OffBn openDVS_pixel2x2_bot_967/vpd[2] openDVS_pixel2x2_bot_967/vpd[3] openDVS_pixel2x2_bot_967/vpd[1]
+ openDVS_pixel2x2_bot_967/vpd[0] rowReadON<26> openDVS_pixel2x2_bot_987/GndD DiffBn
+ VSUBS VDD OnBn openDVS_pixel2x2_bot
XopenDVS_pixel2x2_bot_956 rowReadOFF<26> rowReadOFF<27> rowReadON<27> RefrBp PrBp
+ PrSFBp col_periphery_1x2_24/COL_LINE0 pixRst<0> pixRst<1> col_periphery_1x2_24/COL_LINE1
+ OffBn openDVS_pixel2x2_bot_956/vpd[2] openDVS_pixel2x2_bot_956/vpd[3] openDVS_pixel2x2_bot_956/vpd[1]
+ openDVS_pixel2x2_bot_956/vpd[0] rowReadON<26> openDVS_pixel2x2_bot_987/GndD DiffBn
+ VSUBS VDD OnBn openDVS_pixel2x2_bot
XopenDVS_pixel2x2_bot_945 rowReadOFF<14> rowReadOFF<15> rowReadON<15> RefrBp PrBp
+ PrSFBp col_periphery_1x2_9/COL_LINE0 pixRst<32> pixRst<33> col_periphery_1x2_9/COL_LINE1
+ OffBn openDVS_pixel2x2_bot_945/vpd[2] openDVS_pixel2x2_bot_945/vpd[3] openDVS_pixel2x2_bot_945/vpd[1]
+ openDVS_pixel2x2_bot_945/vpd[0] rowReadON<14> openDVS_pixel2x2_bot_78/GndD DiffBn
+ VSUBS VDD OnBn openDVS_pixel2x2_bot
XopenDVS_pixel2x2_bot_934 rowReadOFF<4> rowReadOFF<5> rowReadON<5> RefrBp PrBp PrSFBp
+ col_periphery_1x2_23/COL_LINE0 pixRst<30> pixRst<31> col_periphery_1x2_23/COL_LINE1
+ OffBn openDVS_pixel2x2_bot_934/vpd[2] openDVS_pixel2x2_bot_934/vpd[3] openDVS_pixel2x2_bot_934/vpd[1]
+ openDVS_pixel2x2_bot_934/vpd[0] rowReadON<4> openDVS_pixel2x2_bot_6/GndD DiffBn
+ VSUBS VDD OnBn openDVS_pixel2x2_bot
XopenDVS_pixel2x2_bot_208 rowReadOFF<0> rowReadOFF<1> rowReadON<1> RefrBp PrBp PrSFBp
+ col_periphery_1x2_19/COL_LINE0 pixRst<22> pixRst<23> col_periphery_1x2_19/COL_LINE1
+ OffBn openDVS_pixel2x2_bot_208/vpd[2] openDVS_pixel2x2_bot_208/vpd[3] openDVS_pixel2x2_bot_208/vpd[1]
+ openDVS_pixel2x2_bot_208/vpd[0] rowReadON<0> GND DiffBn VSUBS VDD OnBn openDVS_pixel2x2_bot
XopenDVS_pixel2x2_bot_219 rowReadOFF<4> rowReadOFF<5> rowReadON<5> RefrBp PrBp PrSFBp
+ col_periphery_1x2_29/COL_LINE0 pixRst<10> pixRst<11> col_periphery_1x2_29/COL_LINE1
+ OffBn openDVS_pixel2x2_bot_219/vpd[2] openDVS_pixel2x2_bot_219/vpd[3] openDVS_pixel2x2_bot_219/vpd[1]
+ openDVS_pixel2x2_bot_219/vpd[0] rowReadON<4> openDVS_pixel2x2_bot_6/GndD DiffBn
+ VSUBS VDD OnBn openDVS_pixel2x2_bot
XopenDVS_pixel2x2_bot_797 rowReadOFF<56> rowReadOFF<57> rowReadON<57> RefrBp PrBp
+ PrSFBp col_periphery_1x2_13/COL_LINE0 pixRst<44> pixRst<45> col_periphery_1x2_13/COL_LINE1
+ OffBn openDVS_pixel2x2_bot_797/vpd[2] openDVS_pixel2x2_bot_797/vpd[3] openDVS_pixel2x2_bot_797/vpd[1]
+ openDVS_pixel2x2_bot_797/vpd[0] rowReadON<56> openDVS_pixel2x2_bot_888/GndD DiffBn
+ VSUBS VDD OnBn openDVS_pixel2x2_bot
XopenDVS_pixel2x2_bot_764 rowReadOFF<62> rowReadOFF<63> rowReadON<63> RefrBp PrBp
+ PrSFBp col_periphery_1x2_11/COL_LINE0 pixRst<36> pixRst<37> col_periphery_1x2_11/COL_LINE1
+ OffBn openDVS_pixel2x2_bot_764/vpd[2] openDVS_pixel2x2_bot_764/vpd[3] openDVS_pixel2x2_bot_764/vpd[1]
+ openDVS_pixel2x2_bot_764/vpd[0] rowReadON<62> openDVS_pixel2x2_bot_886/GndD DiffBn
+ VSUBS VDD OnBn openDVS_pixel2x2_bot
XopenDVS_pixel2x2_bot_775 rowReadOFF<54> rowReadOFF<55> rowReadON<55> RefrBp PrBp
+ PrSFBp col_periphery_1x2_10/COL_LINE0 pixRst<34> pixRst<35> col_periphery_1x2_10/COL_LINE1
+ OffBn openDVS_pixel2x2_bot_775/vpd[2] openDVS_pixel2x2_bot_775/vpd[3] openDVS_pixel2x2_bot_775/vpd[1]
+ openDVS_pixel2x2_bot_775/vpd[0] rowReadON<54> openDVS_pixel2x2_bot_885/GndD DiffBn
+ VSUBS VDD OnBn openDVS_pixel2x2_bot
XopenDVS_pixel2x2_bot_786 rowReadOFF<48> rowReadOFF<49> rowReadON<49> RefrBp PrBp
+ PrSFBp col_periphery_1x2_13/COL_LINE0 pixRst<44> pixRst<45> col_periphery_1x2_13/COL_LINE1
+ OffBn openDVS_pixel2x2_bot_786/vpd[2] openDVS_pixel2x2_bot_786/vpd[3] openDVS_pixel2x2_bot_786/vpd[1]
+ openDVS_pixel2x2_bot_786/vpd[0] rowReadON<48> openDVS_pixel2x2_bot_927/GndD DiffBn
+ VSUBS VDD OnBn openDVS_pixel2x2_bot
XopenDVS_pixel2x2_bot_720 rowReadOFF<36> rowReadOFF<37> rowReadON<37> RefrBp PrBp
+ PrSFBp col_periphery_1x2_10/COL_LINE0 pixRst<34> pixRst<35> col_periphery_1x2_10/COL_LINE1
+ OffBn openDVS_pixel2x2_bot_720/vpd[2] openDVS_pixel2x2_bot_720/vpd[3] openDVS_pixel2x2_bot_720/vpd[1]
+ openDVS_pixel2x2_bot_720/vpd[0] rowReadON<36> openDVS_pixel2x2_bot_997/GndD DiffBn
+ VSUBS VDD OnBn openDVS_pixel2x2_bot
XopenDVS_pixel2x2_bot_753 rowReadOFF<32> rowReadOFF<33> rowReadON<33> RefrBp PrBp
+ PrSFBp col_periphery_1x2_13/COL_LINE0 pixRst<44> pixRst<45> col_periphery_1x2_13/COL_LINE1
+ OffBn openDVS_pixel2x2_bot_753/vpd[2] openDVS_pixel2x2_bot_753/vpd[3] openDVS_pixel2x2_bot_753/vpd[1]
+ openDVS_pixel2x2_bot_753/vpd[0] rowReadON<32> openDVS_pixel2x2_bot_993/GndD DiffBn
+ VSUBS VDD OnBn openDVS_pixel2x2_bot
XopenDVS_pixel2x2_bot_742 rowReadOFF<30> rowReadOFF<31> rowReadON<31> RefrBp PrBp
+ PrSFBp col_periphery_1x2_8/COL_LINE0 pixRst<42> pixRst<43> col_periphery_1x2_8/COL_LINE1
+ OffBn openDVS_pixel2x2_bot_742/vpd[2] openDVS_pixel2x2_bot_742/vpd[3] openDVS_pixel2x2_bot_742/vpd[1]
+ openDVS_pixel2x2_bot_742/vpd[0] rowReadON<30> openDVS_pixel2x2_bot_991/GndD DiffBn
+ VSUBS VDD OnBn openDVS_pixel2x2_bot
XopenDVS_pixel2x2_bot_731 rowReadOFF<28> rowReadOFF<29> rowReadON<29> RefrBp PrBp
+ PrSFBp col_periphery_1x2_7/COL_LINE0 pixRst<40> pixRst<41> col_periphery_1x2_7/COL_LINE1
+ OffBn openDVS_pixel2x2_bot_731/vpd[2] openDVS_pixel2x2_bot_731/vpd[3] openDVS_pixel2x2_bot_731/vpd[1]
+ openDVS_pixel2x2_bot_731/vpd[0] rowReadON<28> openDVS_pixel2x2_bot_989/GndD DiffBn
+ VSUBS VDD OnBn openDVS_pixel2x2_bot
XopenDVS_pixel2x2_bot_594 rowReadOFF<56> rowReadOFF<57> rowReadON<57> RefrBp PrBp
+ PrSFBp col_periphery_1x2_21/COL_LINE0 pixRst<26> pixRst<27> col_periphery_1x2_21/COL_LINE1
+ OffBn openDVS_pixel2x2_bot_594/vpd[2] openDVS_pixel2x2_bot_594/vpd[3] openDVS_pixel2x2_bot_594/vpd[1]
+ openDVS_pixel2x2_bot_594/vpd[0] rowReadON<56> openDVS_pixel2x2_bot_888/GndD DiffBn
+ VSUBS VDD OnBn openDVS_pixel2x2_bot
XopenDVS_pixel2x2_bot_572 rowReadOFF<60> rowReadOFF<61> rowReadON<61> RefrBp PrBp
+ PrSFBp col_periphery_1x2_20/COL_LINE0 pixRst<24> pixRst<25> col_periphery_1x2_20/COL_LINE1
+ OffBn openDVS_pixel2x2_bot_572/vpd[2] openDVS_pixel2x2_bot_572/vpd[3] openDVS_pixel2x2_bot_572/vpd[1]
+ openDVS_pixel2x2_bot_572/vpd[0] rowReadON<60> openDVS_pixel2x2_bot_902/GndD DiffBn
+ VSUBS VDD OnBn openDVS_pixel2x2_bot
XopenDVS_pixel2x2_bot_583 rowReadOFF<48> rowReadOFF<49> rowReadON<49> RefrBp PrBp
+ PrSFBp col_periphery_1x2_18/COL_LINE0 pixRst<20> pixRst<21> col_periphery_1x2_18/COL_LINE1
+ OffBn openDVS_pixel2x2_bot_583/vpd[2] openDVS_pixel2x2_bot_583/vpd[3] openDVS_pixel2x2_bot_583/vpd[1]
+ openDVS_pixel2x2_bot_583/vpd[0] rowReadON<48> openDVS_pixel2x2_bot_927/GndD DiffBn
+ VSUBS VDD OnBn openDVS_pixel2x2_bot
XopenDVS_pixel2x2_bot_561 rowReadOFF<52> rowReadOFF<53> rowReadON<53> RefrBp PrBp
+ PrSFBp col_periphery_1x2_17/COL_LINE0 pixRst<18> pixRst<19> col_periphery_1x2_17/COL_LINE1
+ OffBn openDVS_pixel2x2_bot_561/vpd[2] openDVS_pixel2x2_bot_561/vpd[3] openDVS_pixel2x2_bot_561/vpd[1]
+ openDVS_pixel2x2_bot_561/vpd[0] rowReadON<52> openDVS_pixel2x2_bot_882/GndD DiffBn
+ VSUBS VDD OnBn openDVS_pixel2x2_bot
XopenDVS_pixel2x2_bot_550 rowReadOFF<50> rowReadOFF<51> rowReadON<51> RefrBp PrBp
+ PrSFBp col_periphery_1x2_29/COL_LINE0 pixRst<10> pixRst<11> col_periphery_1x2_29/COL_LINE1
+ OffBn openDVS_pixel2x2_bot_550/vpd[2] openDVS_pixel2x2_bot_550/vpd[3] openDVS_pixel2x2_bot_550/vpd[1]
+ openDVS_pixel2x2_bot_550/vpd[0] rowReadON<50> openDVS_pixel2x2_bot_929/GndD DiffBn
+ VSUBS VDD OnBn openDVS_pixel2x2_bot
XopenDVS_pixel2x2_bot_391 rowReadOFF<36> rowReadOFF<37> rowReadON<37> RefrBp PrBp
+ PrSFBp col_periphery_1x2_21/COL_LINE0 pixRst<26> pixRst<27> col_periphery_1x2_21/COL_LINE1
+ OffBn openDVS_pixel2x2_bot_391/vpd[2] openDVS_pixel2x2_bot_391/vpd[3] openDVS_pixel2x2_bot_391/vpd[1]
+ openDVS_pixel2x2_bot_391/vpd[0] rowReadON<36> openDVS_pixel2x2_bot_997/GndD DiffBn
+ VSUBS VDD OnBn openDVS_pixel2x2_bot
XopenDVS_pixel2x2_bot_380 rowReadOFF<14> rowReadOFF<15> rowReadON<15> RefrBp PrBp
+ PrSFBp col_periphery_1x2_16/COL_LINE0 pixRst<16> pixRst<17> col_periphery_1x2_16/COL_LINE1
+ OffBn openDVS_pixel2x2_bot_380/vpd[2] openDVS_pixel2x2_bot_380/vpd[3] openDVS_pixel2x2_bot_380/vpd[1]
+ openDVS_pixel2x2_bot_380/vpd[0] rowReadON<14> openDVS_pixel2x2_bot_78/GndD DiffBn
+ VSUBS VDD OnBn openDVS_pixel2x2_bot
XopenDVS_pixel2x2_bot_902 rowReadOFF<60> rowReadOFF<61> rowReadON<61> RefrBp PrBp
+ PrSFBp col_periphery_1x2_15/COL_LINE0 pixRst<48> pixRst<49> col_periphery_1x2_15/COL_LINE1
+ OffBn openDVS_pixel2x2_bot_902/vpd[2] openDVS_pixel2x2_bot_902/vpd[3] openDVS_pixel2x2_bot_902/vpd[1]
+ openDVS_pixel2x2_bot_902/vpd[0] rowReadON<60> openDVS_pixel2x2_bot_902/GndD DiffBn
+ VSUBS VDD OnBn openDVS_pixel2x2_bot
XopenDVS_pixel2x2_bot_924 rowReadOFF<46> rowReadOFF<47> rowReadON<47> RefrBp PrBp
+ PrSFBp col_periphery_1x2_14/COL_LINE0 pixRst<46> pixRst<47> col_periphery_1x2_14/COL_LINE1
+ OffBn openDVS_pixel2x2_bot_924/vpd[2] openDVS_pixel2x2_bot_924/vpd[3] openDVS_pixel2x2_bot_924/vpd[1]
+ openDVS_pixel2x2_bot_924/vpd[0] rowReadON<46> openDVS_pixel2x2_bot_925/GndD DiffBn
+ VSUBS VDD OnBn openDVS_pixel2x2_bot
XopenDVS_pixel2x2_bot_913 rowReadOFF<44> rowReadOFF<45> rowReadON<45> RefrBp PrBp
+ PrSFBp col_periphery_1x2_8/COL_LINE0 pixRst<42> pixRst<43> col_periphery_1x2_8/COL_LINE1
+ OffBn openDVS_pixel2x2_bot_913/vpd[2] openDVS_pixel2x2_bot_913/vpd[3] openDVS_pixel2x2_bot_913/vpd[1]
+ openDVS_pixel2x2_bot_913/vpd[0] rowReadON<44> openDVS_pixel2x2_bot_923/GndD DiffBn
+ VSUBS VDD OnBn openDVS_pixel2x2_bot
XopenDVS_pixel2x2_bot_979 rowReadOFF<26> rowReadOFF<27> rowReadON<27> RefrBp PrBp
+ PrSFBp col_periphery_1x2_14/COL_LINE0 pixRst<46> pixRst<47> col_periphery_1x2_14/COL_LINE1
+ OffBn openDVS_pixel2x2_bot_979/vpd[2] openDVS_pixel2x2_bot_979/vpd[3] openDVS_pixel2x2_bot_979/vpd[1]
+ openDVS_pixel2x2_bot_979/vpd[0] rowReadON<26> openDVS_pixel2x2_bot_987/GndD DiffBn
+ VSUBS VDD OnBn openDVS_pixel2x2_bot
XopenDVS_pixel2x2_bot_968 rowReadOFF<26> rowReadOFF<27> rowReadON<27> RefrBp PrBp
+ PrSFBp col_periphery_1x2_20/COL_LINE0 pixRst<24> pixRst<25> col_periphery_1x2_20/COL_LINE1
+ OffBn openDVS_pixel2x2_bot_968/vpd[2] openDVS_pixel2x2_bot_968/vpd[3] openDVS_pixel2x2_bot_968/vpd[1]
+ openDVS_pixel2x2_bot_968/vpd[0] rowReadON<26> openDVS_pixel2x2_bot_987/GndD DiffBn
+ VSUBS VDD OnBn openDVS_pixel2x2_bot
XopenDVS_pixel2x2_bot_957 rowReadOFF<26> rowReadOFF<27> rowReadON<27> RefrBp PrBp
+ PrSFBp col_periphery_1x2_25/COL_LINE0 pixRst<2> pixRst<3> col_periphery_1x2_25/COL_LINE1
+ OffBn openDVS_pixel2x2_bot_957/vpd[2] openDVS_pixel2x2_bot_957/vpd[3] openDVS_pixel2x2_bot_957/vpd[1]
+ openDVS_pixel2x2_bot_957/vpd[0] rowReadON<26> openDVS_pixel2x2_bot_987/GndD DiffBn
+ VSUBS VDD OnBn openDVS_pixel2x2_bot
XopenDVS_pixel2x2_bot_946 rowReadOFF<16> rowReadOFF<17> rowReadON<17> RefrBp PrBp
+ PrSFBp col_periphery_1x2_23/COL_LINE0 pixRst<30> pixRst<31> col_periphery_1x2_23/COL_LINE1
+ OffBn openDVS_pixel2x2_bot_946/vpd[2] openDVS_pixel2x2_bot_946/vpd[3] openDVS_pixel2x2_bot_946/vpd[1]
+ openDVS_pixel2x2_bot_946/vpd[0] rowReadON<16> openDVS_pixel2x2_bot_91/GndD DiffBn
+ VSUBS VDD OnBn openDVS_pixel2x2_bot
XopenDVS_pixel2x2_bot_935 rowReadOFF<4> rowReadOFF<5> rowReadON<5> RefrBp PrBp PrSFBp
+ col_periphery_1x2_9/COL_LINE0 pixRst<32> pixRst<33> col_periphery_1x2_9/COL_LINE1
+ OffBn openDVS_pixel2x2_bot_935/vpd[2] openDVS_pixel2x2_bot_935/vpd[3] openDVS_pixel2x2_bot_935/vpd[1]
+ openDVS_pixel2x2_bot_935/vpd[0] rowReadON<4> openDVS_pixel2x2_bot_6/GndD DiffBn
+ VSUBS VDD OnBn openDVS_pixel2x2_bot
XopenDVS_pixel2x2_bot_209 rowReadOFF<0> rowReadOFF<1> rowReadON<1> RefrBp PrBp PrSFBp
+ col_periphery_1x2_20/COL_LINE0 pixRst<24> pixRst<25> col_periphery_1x2_20/COL_LINE1
+ OffBn openDVS_pixel2x2_bot_209/vpd[2] openDVS_pixel2x2_bot_209/vpd[3] openDVS_pixel2x2_bot_209/vpd[1]
+ openDVS_pixel2x2_bot_209/vpd[0] rowReadON<0> GND DiffBn VSUBS VDD OnBn openDVS_pixel2x2_bot
XopenDVS_pixel2x2_bot_798 rowReadOFF<60> rowReadOFF<61> rowReadON<61> RefrBp PrBp
+ PrSFBp col_periphery_1x2_13/COL_LINE0 pixRst<44> pixRst<45> col_periphery_1x2_13/COL_LINE1
+ OffBn openDVS_pixel2x2_bot_798/vpd[2] openDVS_pixel2x2_bot_798/vpd[3] openDVS_pixel2x2_bot_798/vpd[1]
+ openDVS_pixel2x2_bot_798/vpd[0] rowReadON<60> openDVS_pixel2x2_bot_902/GndD DiffBn
+ VSUBS VDD OnBn openDVS_pixel2x2_bot
XopenDVS_pixel2x2_bot_765 rowReadOFF<62> rowReadOFF<63> rowReadON<63> RefrBp PrBp
+ PrSFBp col_periphery_1x2_12/COL_LINE0 pixRst<38> pixRst<39> col_periphery_1x2_12/COL_LINE1
+ OffBn openDVS_pixel2x2_bot_765/vpd[2] openDVS_pixel2x2_bot_765/vpd[3] openDVS_pixel2x2_bot_765/vpd[1]
+ openDVS_pixel2x2_bot_765/vpd[0] rowReadON<62> openDVS_pixel2x2_bot_886/GndD DiffBn
+ VSUBS VDD OnBn openDVS_pixel2x2_bot
XopenDVS_pixel2x2_bot_787 rowReadOFF<60> rowReadOFF<61> rowReadON<61> RefrBp PrBp
+ PrSFBp col_periphery_1x2_12/COL_LINE0 pixRst<38> pixRst<39> col_periphery_1x2_12/COL_LINE1
+ OffBn openDVS_pixel2x2_bot_787/vpd[2] openDVS_pixel2x2_bot_787/vpd[3] openDVS_pixel2x2_bot_787/vpd[1]
+ openDVS_pixel2x2_bot_787/vpd[0] rowReadON<60> openDVS_pixel2x2_bot_902/GndD DiffBn
+ VSUBS VDD OnBn openDVS_pixel2x2_bot
XopenDVS_pixel2x2_bot_776 rowReadOFF<54> rowReadOFF<55> rowReadON<55> RefrBp PrBp
+ PrSFBp col_periphery_1x2_11/COL_LINE0 pixRst<36> pixRst<37> col_periphery_1x2_11/COL_LINE1
+ OffBn openDVS_pixel2x2_bot_776/vpd[2] openDVS_pixel2x2_bot_776/vpd[3] openDVS_pixel2x2_bot_776/vpd[1]
+ openDVS_pixel2x2_bot_776/vpd[0] rowReadON<54> openDVS_pixel2x2_bot_885/GndD DiffBn
+ VSUBS VDD OnBn openDVS_pixel2x2_bot
XopenDVS_pixel2x2_bot_754 rowReadOFF<42> rowReadOFF<43> rowReadON<43> RefrBp PrBp
+ PrSFBp col_periphery_1x2_8/COL_LINE0 pixRst<42> pixRst<43> col_periphery_1x2_8/COL_LINE1
+ OffBn openDVS_pixel2x2_bot_754/vpd[2] openDVS_pixel2x2_bot_754/vpd[3] openDVS_pixel2x2_bot_754/vpd[1]
+ openDVS_pixel2x2_bot_754/vpd[0] rowReadON<42> openDVS_pixel2x2_bot_908/GndD DiffBn
+ VSUBS VDD OnBn openDVS_pixel2x2_bot
XopenDVS_pixel2x2_bot_721 rowReadOFF<36> rowReadOFF<37> rowReadON<37> RefrBp PrBp
+ PrSFBp col_periphery_1x2_11/COL_LINE0 pixRst<36> pixRst<37> col_periphery_1x2_11/COL_LINE1
+ OffBn openDVS_pixel2x2_bot_721/vpd[2] openDVS_pixel2x2_bot_721/vpd[3] openDVS_pixel2x2_bot_721/vpd[1]
+ openDVS_pixel2x2_bot_721/vpd[0] rowReadON<36> openDVS_pixel2x2_bot_997/GndD DiffBn
+ VSUBS VDD OnBn openDVS_pixel2x2_bot
XopenDVS_pixel2x2_bot_710 rowReadOFF<32> rowReadOFF<33> rowReadON<33> RefrBp PrBp
+ PrSFBp col_periphery_1x2_4/COL_LINE0 pixRst<58> pixRst<59> col_periphery_1x2_4/COL_LINE1
+ OffBn openDVS_pixel2x2_bot_710/vpd[2] openDVS_pixel2x2_bot_710/vpd[3] openDVS_pixel2x2_bot_710/vpd[1]
+ openDVS_pixel2x2_bot_710/vpd[0] rowReadON<32> openDVS_pixel2x2_bot_993/GndD DiffBn
+ VSUBS VDD OnBn openDVS_pixel2x2_bot
XopenDVS_pixel2x2_bot_743 rowReadOFF<30> rowReadOFF<31> rowReadON<31> RefrBp PrBp
+ PrSFBp col_periphery_1x2_13/COL_LINE0 pixRst<44> pixRst<45> col_periphery_1x2_13/COL_LINE1
+ OffBn openDVS_pixel2x2_bot_743/vpd[2] openDVS_pixel2x2_bot_743/vpd[3] openDVS_pixel2x2_bot_743/vpd[1]
+ openDVS_pixel2x2_bot_743/vpd[0] rowReadON<30> openDVS_pixel2x2_bot_991/GndD DiffBn
+ VSUBS VDD OnBn openDVS_pixel2x2_bot
XopenDVS_pixel2x2_bot_732 rowReadOFF<28> rowReadOFF<29> rowReadON<29> RefrBp PrBp
+ PrSFBp col_periphery_1x2_8/COL_LINE0 pixRst<42> pixRst<43> col_periphery_1x2_8/COL_LINE1
+ OffBn openDVS_pixel2x2_bot_732/vpd[2] openDVS_pixel2x2_bot_732/vpd[3] openDVS_pixel2x2_bot_732/vpd[1]
+ openDVS_pixel2x2_bot_732/vpd[0] rowReadON<28> openDVS_pixel2x2_bot_989/GndD DiffBn
+ VSUBS VDD OnBn openDVS_pixel2x2_bot
XopenDVS_pixel2x2_bot_573 rowReadOFF<58> rowReadOFF<59> rowReadON<59> RefrBp PrBp
+ PrSFBp col_periphery_1x2_22/COL_LINE0 pixRst<28> pixRst<29> col_periphery_1x2_22/COL_LINE1
+ OffBn openDVS_pixel2x2_bot_573/vpd[2] openDVS_pixel2x2_bot_573/vpd[3] openDVS_pixel2x2_bot_573/vpd[1]
+ openDVS_pixel2x2_bot_573/vpd[0] rowReadON<58> openDVS_pixel2x2_bot_890/GndD DiffBn
+ VSUBS VDD OnBn openDVS_pixel2x2_bot
XopenDVS_pixel2x2_bot_595 rowReadOFF<62> rowReadOFF<63> rowReadON<63> RefrBp PrBp
+ PrSFBp col_periphery_1x2_19/COL_LINE0 pixRst<22> pixRst<23> col_periphery_1x2_19/COL_LINE1
+ OffBn openDVS_pixel2x2_bot_595/vpd[2] openDVS_pixel2x2_bot_595/vpd[3] openDVS_pixel2x2_bot_595/vpd[1]
+ openDVS_pixel2x2_bot_595/vpd[0] rowReadON<62> openDVS_pixel2x2_bot_886/GndD DiffBn
+ VSUBS VDD OnBn openDVS_pixel2x2_bot
XopenDVS_pixel2x2_bot_562 rowReadOFF<52> rowReadOFF<53> rowReadON<53> RefrBp PrBp
+ PrSFBp col_periphery_1x2_18/COL_LINE0 pixRst<20> pixRst<21> col_periphery_1x2_18/COL_LINE1
+ OffBn openDVS_pixel2x2_bot_562/vpd[2] openDVS_pixel2x2_bot_562/vpd[3] openDVS_pixel2x2_bot_562/vpd[1]
+ openDVS_pixel2x2_bot_562/vpd[0] rowReadON<52> openDVS_pixel2x2_bot_882/GndD DiffBn
+ VSUBS VDD OnBn openDVS_pixel2x2_bot
XopenDVS_pixel2x2_bot_584 rowReadOFF<48> rowReadOFF<49> rowReadON<49> RefrBp PrBp
+ PrSFBp col_periphery_1x2_19/COL_LINE0 pixRst<22> pixRst<23> col_periphery_1x2_19/COL_LINE1
+ OffBn openDVS_pixel2x2_bot_584/vpd[2] openDVS_pixel2x2_bot_584/vpd[3] openDVS_pixel2x2_bot_584/vpd[1]
+ openDVS_pixel2x2_bot_584/vpd[0] rowReadON<48> openDVS_pixel2x2_bot_927/GndD DiffBn
+ VSUBS VDD OnBn openDVS_pixel2x2_bot
XopenDVS_pixel2x2_bot_551 rowReadOFF<50> rowReadOFF<51> rowReadON<51> RefrBp PrBp
+ PrSFBp col_periphery_1x2_30/COL_LINE0 pixRst<12> pixRst<13> col_periphery_1x2_30/COL_LINE1
+ OffBn openDVS_pixel2x2_bot_551/vpd[2] openDVS_pixel2x2_bot_551/vpd[3] openDVS_pixel2x2_bot_551/vpd[1]
+ openDVS_pixel2x2_bot_551/vpd[0] rowReadON<50> openDVS_pixel2x2_bot_929/GndD DiffBn
+ VSUBS VDD OnBn openDVS_pixel2x2_bot
XopenDVS_pixel2x2_bot_540 rowReadOFF<50> rowReadOFF<51> rowReadON<51> RefrBp PrBp
+ PrSFBp col_periphery_1x2_26/COL_LINE0 pixRst<4> pixRst<5> col_periphery_1x2_26/COL_LINE1
+ OffBn openDVS_pixel2x2_bot_540/vpd[2] openDVS_pixel2x2_bot_540/vpd[3] openDVS_pixel2x2_bot_540/vpd[1]
+ openDVS_pixel2x2_bot_540/vpd[0] rowReadON<50> openDVS_pixel2x2_bot_929/GndD DiffBn
+ VSUBS VDD OnBn openDVS_pixel2x2_bot
XopenDVS_pixel2x2_bot_392 rowReadOFF<36> rowReadOFF<37> rowReadON<37> RefrBp PrBp
+ PrSFBp col_periphery_1x2_22/COL_LINE0 pixRst<28> pixRst<29> col_periphery_1x2_22/COL_LINE1
+ OffBn openDVS_pixel2x2_bot_392/vpd[2] openDVS_pixel2x2_bot_392/vpd[3] openDVS_pixel2x2_bot_392/vpd[1]
+ openDVS_pixel2x2_bot_392/vpd[0] rowReadON<36> openDVS_pixel2x2_bot_997/GndD DiffBn
+ VSUBS VDD OnBn openDVS_pixel2x2_bot
XopenDVS_pixel2x2_bot_381 rowReadOFF<16> rowReadOFF<17> rowReadON<17> RefrBp PrBp
+ PrSFBp col_periphery_1x2_31/COL_LINE0 pixRst<14> pixRst<15> col_periphery_1x2_31/COL_LINE1
+ OffBn openDVS_pixel2x2_bot_381/vpd[2] openDVS_pixel2x2_bot_381/vpd[3] openDVS_pixel2x2_bot_381/vpd[1]
+ openDVS_pixel2x2_bot_381/vpd[0] rowReadON<16> openDVS_pixel2x2_bot_91/GndD DiffBn
+ VSUBS VDD OnBn openDVS_pixel2x2_bot
XopenDVS_pixel2x2_bot_370 rowReadOFF<8> rowReadOFF<9> rowReadON<9> RefrBp PrBp PrSFBp
+ col_periphery_1x2_18/COL_LINE0 pixRst<20> pixRst<21> col_periphery_1x2_18/COL_LINE1
+ OffBn openDVS_pixel2x2_bot_370/vpd[2] openDVS_pixel2x2_bot_370/vpd[3] openDVS_pixel2x2_bot_370/vpd[1]
+ openDVS_pixel2x2_bot_370/vpd[0] rowReadON<8> openDVS_pixel2x2_bot_939/GndD DiffBn
+ VSUBS VDD OnBn openDVS_pixel2x2_bot
XopenDVS_pixel2x2_bot_925 rowReadOFF<46> rowReadOFF<47> rowReadON<47> RefrBp PrBp
+ PrSFBp col_periphery_1x2_15/COL_LINE0 pixRst<48> pixRst<49> col_periphery_1x2_15/COL_LINE1
+ OffBn openDVS_pixel2x2_bot_925/vpd[2] openDVS_pixel2x2_bot_925/vpd[3] openDVS_pixel2x2_bot_925/vpd[1]
+ openDVS_pixel2x2_bot_925/vpd[0] rowReadON<46> openDVS_pixel2x2_bot_925/GndD DiffBn
+ VSUBS VDD OnBn openDVS_pixel2x2_bot
XopenDVS_pixel2x2_bot_914 rowReadOFF<44> rowReadOFF<45> rowReadON<45> RefrBp PrBp
+ PrSFBp col_periphery_1x2_13/COL_LINE0 pixRst<44> pixRst<45> col_periphery_1x2_13/COL_LINE1
+ OffBn openDVS_pixel2x2_bot_914/vpd[2] openDVS_pixel2x2_bot_914/vpd[3] openDVS_pixel2x2_bot_914/vpd[1]
+ openDVS_pixel2x2_bot_914/vpd[0] rowReadON<44> openDVS_pixel2x2_bot_923/GndD DiffBn
+ VSUBS VDD OnBn openDVS_pixel2x2_bot
XopenDVS_pixel2x2_bot_903 rowReadOFF<38> rowReadOFF<39> rowReadON<39> RefrBp PrBp
+ PrSFBp col_periphery_1x2_14/COL_LINE0 pixRst<46> pixRst<47> col_periphery_1x2_14/COL_LINE1
+ OffBn openDVS_pixel2x2_bot_903/vpd[2] openDVS_pixel2x2_bot_903/vpd[3] openDVS_pixel2x2_bot_903/vpd[1]
+ openDVS_pixel2x2_bot_903/vpd[0] rowReadON<38> openDVS_pixel2x2_bot_999/GndD DiffBn
+ VSUBS VDD OnBn openDVS_pixel2x2_bot
XopenDVS_pixel2x2_bot_969 rowReadOFF<26> rowReadOFF<27> rowReadON<27> RefrBp PrBp
+ PrSFBp col_periphery_1x2_21/COL_LINE0 pixRst<26> pixRst<27> col_periphery_1x2_21/COL_LINE1
+ OffBn openDVS_pixel2x2_bot_969/vpd[2] openDVS_pixel2x2_bot_969/vpd[3] openDVS_pixel2x2_bot_969/vpd[1]
+ openDVS_pixel2x2_bot_969/vpd[0] rowReadON<26> openDVS_pixel2x2_bot_987/GndD DiffBn
+ VSUBS VDD OnBn openDVS_pixel2x2_bot
XopenDVS_pixel2x2_bot_958 rowReadOFF<26> rowReadOFF<27> rowReadON<27> RefrBp PrBp
+ PrSFBp col_periphery_1x2_26/COL_LINE0 pixRst<4> pixRst<5> col_periphery_1x2_26/COL_LINE1
+ OffBn openDVS_pixel2x2_bot_958/vpd[2] openDVS_pixel2x2_bot_958/vpd[3] openDVS_pixel2x2_bot_958/vpd[1]
+ openDVS_pixel2x2_bot_958/vpd[0] rowReadON<26> openDVS_pixel2x2_bot_987/GndD DiffBn
+ VSUBS VDD OnBn openDVS_pixel2x2_bot
XopenDVS_pixel2x2_bot_947 rowReadOFF<16> rowReadOFF<17> rowReadON<17> RefrBp PrBp
+ PrSFBp col_periphery_1x2_9/COL_LINE0 pixRst<32> pixRst<33> col_periphery_1x2_9/COL_LINE1
+ OffBn openDVS_pixel2x2_bot_947/vpd[2] openDVS_pixel2x2_bot_947/vpd[3] openDVS_pixel2x2_bot_947/vpd[1]
+ openDVS_pixel2x2_bot_947/vpd[0] rowReadON<16> openDVS_pixel2x2_bot_91/GndD DiffBn
+ VSUBS VDD OnBn openDVS_pixel2x2_bot
XopenDVS_pixel2x2_bot_936 rowReadOFF<6> rowReadOFF<7> rowReadON<7> RefrBp PrBp PrSFBp
+ col_periphery_1x2_23/COL_LINE0 pixRst<30> pixRst<31> col_periphery_1x2_23/COL_LINE1
+ OffBn openDVS_pixel2x2_bot_936/vpd[2] openDVS_pixel2x2_bot_936/vpd[3] openDVS_pixel2x2_bot_936/vpd[1]
+ openDVS_pixel2x2_bot_936/vpd[0] rowReadON<6> openDVS_pixel2x2_bot_937/GndD DiffBn
+ VSUBS VDD OnBn openDVS_pixel2x2_bot
XopenDVS_pixel2x2_bot_766 rowReadOFF<50> rowReadOFF<51> rowReadON<51> RefrBp PrBp
+ PrSFBp col_periphery_1x2_10/COL_LINE0 pixRst<34> pixRst<35> col_periphery_1x2_10/COL_LINE1
+ OffBn openDVS_pixel2x2_bot_766/vpd[2] openDVS_pixel2x2_bot_766/vpd[3] openDVS_pixel2x2_bot_766/vpd[1]
+ openDVS_pixel2x2_bot_766/vpd[0] rowReadON<50> openDVS_pixel2x2_bot_929/GndD DiffBn
+ VSUBS VDD OnBn openDVS_pixel2x2_bot
XopenDVS_pixel2x2_bot_700 rowReadOFF<36> rowReadOFF<37> rowReadON<37> RefrBp PrBp
+ PrSFBp col_periphery_1x2_2/COL_LINE0 pixRst<54> pixRst<55> col_periphery_1x2_2/COL_LINE1
+ OffBn openDVS_pixel2x2_bot_700/vpd[2] openDVS_pixel2x2_bot_700/vpd[3] openDVS_pixel2x2_bot_700/vpd[1]
+ openDVS_pixel2x2_bot_700/vpd[0] rowReadON<36> openDVS_pixel2x2_bot_997/GndD DiffBn
+ VSUBS VDD OnBn openDVS_pixel2x2_bot
XopenDVS_pixel2x2_bot_755 rowReadOFF<42> rowReadOFF<43> rowReadON<43> RefrBp PrBp
+ PrSFBp col_periphery_1x2_13/COL_LINE0 pixRst<44> pixRst<45> col_periphery_1x2_13/COL_LINE1
+ OffBn openDVS_pixel2x2_bot_755/vpd[2] openDVS_pixel2x2_bot_755/vpd[3] openDVS_pixel2x2_bot_755/vpd[1]
+ openDVS_pixel2x2_bot_755/vpd[0] rowReadON<42> openDVS_pixel2x2_bot_908/GndD DiffBn
+ VSUBS VDD OnBn openDVS_pixel2x2_bot
XopenDVS_pixel2x2_bot_722 rowReadOFF<36> rowReadOFF<37> rowReadON<37> RefrBp PrBp
+ PrSFBp col_periphery_1x2_12/COL_LINE0 pixRst<38> pixRst<39> col_periphery_1x2_12/COL_LINE1
+ OffBn openDVS_pixel2x2_bot_722/vpd[2] openDVS_pixel2x2_bot_722/vpd[3] openDVS_pixel2x2_bot_722/vpd[1]
+ openDVS_pixel2x2_bot_722/vpd[0] rowReadON<36> openDVS_pixel2x2_bot_997/GndD DiffBn
+ VSUBS VDD OnBn openDVS_pixel2x2_bot
XopenDVS_pixel2x2_bot_744 rowReadOFF<38> rowReadOFF<39> rowReadON<39> RefrBp PrBp
+ PrSFBp col_periphery_1x2_12/COL_LINE0 pixRst<38> pixRst<39> col_periphery_1x2_12/COL_LINE1
+ OffBn openDVS_pixel2x2_bot_744/vpd[2] openDVS_pixel2x2_bot_744/vpd[3] openDVS_pixel2x2_bot_744/vpd[1]
+ openDVS_pixel2x2_bot_744/vpd[0] rowReadON<38> openDVS_pixel2x2_bot_999/GndD DiffBn
+ VSUBS VDD OnBn openDVS_pixel2x2_bot
XopenDVS_pixel2x2_bot_711 rowReadOFF<32> rowReadOFF<33> rowReadON<33> RefrBp PrBp
+ PrSFBp col_periphery_1x2_5/COL_LINE0 pixRst<60> pixRst<61> col_periphery_1x2_5/COL_LINE1
+ OffBn openDVS_pixel2x2_bot_711/vpd[2] openDVS_pixel2x2_bot_711/vpd[3] openDVS_pixel2x2_bot_711/vpd[1]
+ openDVS_pixel2x2_bot_711/vpd[0] rowReadON<32> openDVS_pixel2x2_bot_993/GndD DiffBn
+ VSUBS VDD OnBn openDVS_pixel2x2_bot
XopenDVS_pixel2x2_bot_733 rowReadOFF<28> rowReadOFF<29> rowReadON<29> RefrBp PrBp
+ PrSFBp col_periphery_1x2_13/COL_LINE0 pixRst<44> pixRst<45> col_periphery_1x2_13/COL_LINE1
+ OffBn openDVS_pixel2x2_bot_733/vpd[2] openDVS_pixel2x2_bot_733/vpd[3] openDVS_pixel2x2_bot_733/vpd[1]
+ openDVS_pixel2x2_bot_733/vpd[0] rowReadON<28> openDVS_pixel2x2_bot_989/GndD DiffBn
+ VSUBS VDD OnBn openDVS_pixel2x2_bot
XopenDVS_pixel2x2_bot_788 rowReadOFF<60> rowReadOFF<61> rowReadON<61> RefrBp PrBp
+ PrSFBp col_periphery_1x2_7/COL_LINE0 pixRst<40> pixRst<41> col_periphery_1x2_7/COL_LINE1
+ OffBn openDVS_pixel2x2_bot_788/vpd[2] openDVS_pixel2x2_bot_788/vpd[3] openDVS_pixel2x2_bot_788/vpd[1]
+ openDVS_pixel2x2_bot_788/vpd[0] rowReadON<60> openDVS_pixel2x2_bot_902/GndD DiffBn
+ VSUBS VDD OnBn openDVS_pixel2x2_bot
XopenDVS_pixel2x2_bot_799 rowReadOFF<62> rowReadOFF<63> rowReadON<63> RefrBp PrBp
+ PrSFBp col_periphery_1x2_7/COL_LINE0 pixRst<40> pixRst<41> col_periphery_1x2_7/COL_LINE1
+ OffBn openDVS_pixel2x2_bot_799/vpd[2] openDVS_pixel2x2_bot_799/vpd[3] openDVS_pixel2x2_bot_799/vpd[1]
+ openDVS_pixel2x2_bot_799/vpd[0] rowReadON<62> openDVS_pixel2x2_bot_886/GndD DiffBn
+ VSUBS VDD OnBn openDVS_pixel2x2_bot
XopenDVS_pixel2x2_bot_777 rowReadOFF<54> rowReadOFF<55> rowReadON<55> RefrBp PrBp
+ PrSFBp col_periphery_1x2_12/COL_LINE0 pixRst<38> pixRst<39> col_periphery_1x2_12/COL_LINE1
+ OffBn openDVS_pixel2x2_bot_777/vpd[2] openDVS_pixel2x2_bot_777/vpd[3] openDVS_pixel2x2_bot_777/vpd[1]
+ openDVS_pixel2x2_bot_777/vpd[0] rowReadON<54> openDVS_pixel2x2_bot_885/GndD DiffBn
+ VSUBS VDD OnBn openDVS_pixel2x2_bot
.ends

.subckt openDVS_pixel2x2_top rowReadOFF[1] rowReadON[0] RefrBp PrBp PrSFBp readLine[0]
+ pixRst[0] pixRst[1] readLine[1] OffBn vpd[2] vpd[3] vpd[1] vpd[0] rowReadON[1] rowReadOFF[0]
+ GndD DiffBn GndA OnBn VddA18
XopenDVS_pixel_1 DiffBn rowReadOFF[1] OnBn RefrBp OffBn PrSFBp GndA GndA rowReadON[1]
+ VddA18 RefrBp PrSFBp GndA readLine[1] VddA18 OnBn vpd[3] pixRst[1] PrBp DiffBn GndD
+ PrBp GndA OnBn DiffBn OffBn OffBn openDVS_pixel
XopenDVS_pixel_2 DiffBn rowReadOFF[1] OnBn OffBn OffBn PrSFBp GndA GndA rowReadON[1]
+ VddA18 RefrBp PrBp GndA readLine[0] VddA18 DiffBn vpd[1] pixRst[0] PrBp OnBn GndD
+ PrSFBp GndA OnBn DiffBn OffBn RefrBp openDVS_pixel
XopenDVS_pixel_3 DiffBn rowReadOFF[0] OnBn RefrBp OffBn PrSFBp GndA VddA18 rowReadON[0]
+ GndA RefrBp PrSFBp GndA readLine[1] VddA18 OnBn vpd[2] pixRst[1] PrBp DiffBn GndD
+ PrBp GndA OnBn DiffBn OffBn OffBn openDVS_pixel
XopenDVS_pixel_0 DiffBn rowReadOFF[0] OnBn OffBn OffBn PrSFBp GndA VddA18 rowReadON[0]
+ GndA RefrBp PrBp GndA readLine[0] VddA18 DiffBn vpd[0] pixRst[0] PrBp OnBn GndD
+ PrSFBp GndA OnBn DiffBn OffBn RefrBp openDVS_pixel
.ends

.subckt pixel_layout_tile voutn<47> voutn<46> voutn<45> voutn<44> pixRst<36> pixRst<43>
+ pixRst<44> pixRst<45> pixRst<46> pixRst<47> voutn<63> voutn<62> voutn<61> voutn<60>
+ voutn<59> voutn<58> voutn<57> voutn<56> voutn<49> voutn<48> pixRst<49> pixRst<58>
+ pixRst<59> pixRst<60> pixRst<62> voutn<29> voutn<28> voutn<27> voutn<26> voutn<25>
+ voutn<24> voutn<23> voutn<22> pixRst<25> pixRst<26> pixRst<27> pixRst<28> pixRst<30>
+ pixRst<31> pixRst<18> pixRst<17> rowReadOFF<2> rowReadOFF<3> nDETECT DETECT rowReadOFF<5>
+ rowReadON<4> rowReadON<5> rowReadON<8> rowReadON<9> rowReadOFF<0> rowReadOFF<1>
+ voutn<0> voutn<1> voutn<6> voutn<7> voutn<8> voutn<9> pixRst<9> pixRst<8> pixRst<7>
+ pixRst<6> pixRst<5> voutn<10> pixRst<2> pixRst<1> pixRst<14> pixRst<13> pixRst<12>
+ pixRst<11> pixRst<10> pixRst<0> rowReadOFF<18> rowReadOFF<26> rowReadON<12> rowReadOFF<27>
+ rowReadOFF<19> rowReadON<16> rowReadON<17> rowReadON<20> rowReadON<21> rowReadOFF<28>
+ rowReadOFF<29> rowReadOFF<60> rowReadOFF<61> rowReadOFF<62> rowReadOFF<63> rowReadOFF<36>
+ rowReadOFF<37> rowReadOFF<40> rowReadOFF<41> rowReadOFF<42> rowReadOFF<43> rowReadOFF<44>
+ rowReadOFF<45> rowReadOFF<46> rowReadOFF<47> rowReadOFF<48> rowReadOFF<49> rowReadON<30>
+ rowReadON<31> rowReadON<32> rowReadON<33> rowReadON<38> rowReadON<39> rowReadON<48>
+ rowReadON<49> rowReadON<52> rowReadON<53> rowReadON<56> rowReadON<57> rowReadON<58>
+ rowReadON<59> pixRst<50> pixRst<35> voutn<11> voutn<14> voutn<15> pixRst<57> pixRst<16>
+ rowReadOFF<34> voutn<12> rowReadOFF<35> voutn<13> pixRst<34> voutn<32> pixRst<33>
+ rowReadOFF<14> openDVS_pixel2x2_top_937/GndD voutn<33> rowReadOFF<15> rowReadOFF<32>
+ rowReadON<24> rowReadOFF<33> rowReadON<25> rowReadOFF<16> voutn<16> rowReadON<0>
+ pixRst<56> voutn<50> pixRst<55> openDVS_pixel2x2_top_949/GndD rowReadON<22> rowReadOFF<17>
+ rowReadON<26> rowReadON<1> voutn<17> openDVS_pixel2x2_top_535/GndD rowReadON<2>
+ rowReadON<23> voutn<51> rowReadON<62> openDVS_pixel2x2_top_933/GndD rowReadOFF<12>
+ rowReadOFF<56> rowReadON<3> rowReadON<28> voutn<34> rowReadON<63> rowReadOFF<13>
+ rowReadOFF<57> rowReadON<13> pixRst<32> pixRst<15> rowReadON<29> rowReadON<10> voutn<35>
+ rowReadON<11> pixRst<24> openDVS_pixel2x2_top_945/GndD pixRst<23> rowReadOFF<38>
+ rowReadON<6> rowReadOFF<39> openDVS_pixel2x2_top_943/GndD pixRst<21> voutn<18> openDVS_pixel2x2_top_539/GndD
+ rowReadON<7> voutn<52> openDVS_pixel2x2_top_96/GndD rowReadOFF<52> rowReadON<42>
+ rowReadON<50> pixRst<54> pixRst<53> voutn<19> voutn<2> rowReadOFF<53> openDVS_pixel2x2_top_931/GndD
+ voutn<53> rowReadON<43> voutn<40> rowReadON<51> openDVS_pixel2x2_top_78/GndD NCHARGE
+ VTHRESH pixRst<39> openDVS_pixel2x2_top_67/GndD voutn<3> voutn<36> rowReadOFF<10>
+ pixRst<42> rowReadON<40> rowReadON<54> pixRst<41> voutn<41> rowReadON<27> rowReadON<18>
+ rowReadOFF<11> openDVS_pixel2x2_top_993/GndD voutn<37> rowReadON<55> rowReadOFF<22>
+ rowReadOFF<20> rowReadON<19> rowReadOFF<54> openDVS_pixel2x2_top_955/GndD openDVS_pixel2x2_top_995/GndD
+ rowReadOFF<23> rowReadOFF<21> rowReadON<14> rowReadON<36> rowReadON<46> rowReadOFF<55>
+ pixRst<22> openDVS_pixel2x2_top_987/GndD openDVS_pixel2x2_top_991/GndD openDVS_pixel2x2_top_74/GndD
+ rowReadOFF<58> rowReadON<15> rowReadON<37> rowReadON<47> rowReadON<34> voutn<20>
+ pixRst<61> pixRst<20> openDVS_pixel2x2_top_6/GndD pixRst<19> voutn<54> rowReadOFF<59>
+ rowReadOFF<8> pixRst<48> rowReadON<35> pixRst<63> voutn<21> openDVS_pixel2x2_top_989/GndD
+ voutn<4> rowReadOFF<9> pixRst<52> voutn<55> voutn<42> pixRst<51> openDVS_pixel2x2_top_941/GndD
+ openDVS_pixel2x2_top_947/GndD pixRst<4> rowReadOFF<6> pixRst<3> openDVS_pixel2x2_top_82/GndD
+ voutn<5> rowReadON<60> openDVS_pixel2x2_top_99/GndD voutn<38> pixRst<38> pixRst<37>
+ rowReadON<44> openDVS_pixel2x2_top_3/GndD openDVS_pixel2x2_top_999/GndD voutn<43>
+ rowReadOFF<30> rowReadOFF<50> rowReadOFF<7> rowReadON<41> rowReadOFF<24> pixRst<40>
+ rowReadON<61> openDVS_pixel2x2_top_939/GndD voutn<39> rowReadON<45> voutn<30> openDVS_pixel2x2_top_537/GndD
+ rowReadOFF<31> rowReadOFF<51> rowReadOFF<25> openDVS_pixel2x2_top_997/GndD pixRst<29>
+ openDVS_pixel2x2_top_9/GndD voutn<31> openDVS_pixel2x2_top_935/GndD rowReadOFF<4>
+ openDVS_pixel2x2_top_951/GndD col_periphery_1x2_9/VDD PrSFBp PrBp OnBn DiffBn OffBn
+ RefrBp GndA openDVS_pixel2x2_top_953/GndD VddA18
XopenDVS_pixel2x2_top_309 rowReadOFF<57> rowReadON<56> RefrBp PrBp PrSFBp col_periphery_1x2_10/COL_LINE0
+ pixRst<22> pixRst<23> col_periphery_1x2_10/COL_LINE1 OffBn openDVS_pixel2x2_top_309/vpd[2]
+ openDVS_pixel2x2_top_309/vpd[3] openDVS_pixel2x2_top_309/vpd[1] openDVS_pixel2x2_top_309/vpd[0]
+ rowReadON<57> rowReadOFF<56> openDVS_pixel2x2_top_9/GndD DiffBn GndA OnBn VddA18
+ openDVS_pixel2x2_top
XopenDVS_pixel2x2_top_865 rowReadOFF<5> rowReadON<4> RefrBp PrBp PrSFBp col_periphery_1x2_27/COL_LINE0
+ pixRst<56> pixRst<57> col_periphery_1x2_27/COL_LINE1 OffBn openDVS_pixel2x2_top_865/vpd[2]
+ openDVS_pixel2x2_top_865/vpd[3] openDVS_pixel2x2_top_865/vpd[1] openDVS_pixel2x2_top_865/vpd[0]
+ rowReadON<5> rowReadOFF<4> openDVS_pixel2x2_top_935/GndD DiffBn GndA OnBn VddA18
+ openDVS_pixel2x2_top
XopenDVS_pixel2x2_top_876 rowReadOFF<5> rowReadON<4> RefrBp PrBp PrSFBp col_periphery_1x2_26/COL_LINE0
+ pixRst<54> pixRst<55> col_periphery_1x2_26/COL_LINE1 OffBn openDVS_pixel2x2_top_876/vpd[2]
+ openDVS_pixel2x2_top_876/vpd[3] openDVS_pixel2x2_top_876/vpd[1] openDVS_pixel2x2_top_876/vpd[0]
+ rowReadON<5> rowReadOFF<4> openDVS_pixel2x2_top_935/GndD DiffBn GndA OnBn VddA18
+ openDVS_pixel2x2_top
XopenDVS_pixel2x2_top_887 rowReadOFF<7> rowReadON<6> RefrBp PrBp PrSFBp col_periphery_1x2_25/COL_LINE0
+ pixRst<52> pixRst<53> col_periphery_1x2_25/COL_LINE1 OffBn openDVS_pixel2x2_top_887/vpd[2]
+ openDVS_pixel2x2_top_887/vpd[3] openDVS_pixel2x2_top_887/vpd[1] openDVS_pixel2x2_top_887/vpd[0]
+ rowReadON<7> rowReadOFF<6> openDVS_pixel2x2_top_937/GndD DiffBn GndA OnBn VddA18
+ openDVS_pixel2x2_top
XopenDVS_pixel2x2_top_898 rowReadOFF<5> rowReadON<4> RefrBp PrBp PrSFBp col_periphery_1x2_31/COL_LINE0
+ pixRst<48> pixRst<49> col_periphery_1x2_31/COL_LINE1 OffBn openDVS_pixel2x2_top_898/vpd[2]
+ openDVS_pixel2x2_top_898/vpd[3] openDVS_pixel2x2_top_898/vpd[1] openDVS_pixel2x2_top_898/vpd[0]
+ rowReadON<5> rowReadOFF<4> openDVS_pixel2x2_top_935/GndD DiffBn GndA OnBn VddA18
+ openDVS_pixel2x2_top
XopenDVS_pixel2x2_top_843 rowReadOFF<1> rowReadON<0> RefrBp PrBp PrSFBp col_periphery_1x2_19/COL_LINE0
+ pixRst<38> pixRst<39> col_periphery_1x2_19/COL_LINE1 OffBn openDVS_pixel2x2_top_843/vpd[2]
+ openDVS_pixel2x2_top_843/vpd[3] openDVS_pixel2x2_top_843/vpd[1] openDVS_pixel2x2_top_843/vpd[0]
+ rowReadON<1> rowReadOFF<0> openDVS_pixel2x2_top_931/GndD DiffBn GndA OnBn VddA18
+ openDVS_pixel2x2_top
XopenDVS_pixel2x2_top_854 rowReadOFF<5> rowReadON<4> RefrBp PrBp PrSFBp col_periphery_1x2_18/COL_LINE0
+ pixRst<36> pixRst<37> col_periphery_1x2_18/COL_LINE1 OffBn openDVS_pixel2x2_top_854/vpd[2]
+ openDVS_pixel2x2_top_854/vpd[3] openDVS_pixel2x2_top_854/vpd[1] openDVS_pixel2x2_top_854/vpd[0]
+ rowReadON<5> rowReadOFF<4> openDVS_pixel2x2_top_935/GndD DiffBn GndA OnBn VddA18
+ openDVS_pixel2x2_top
XopenDVS_pixel2x2_top_832 rowReadOFF<19> rowReadON<18> RefrBp PrBp PrSFBp col_periphery_1x2_21/COL_LINE0
+ pixRst<42> pixRst<43> col_periphery_1x2_21/COL_LINE1 OffBn openDVS_pixel2x2_top_832/vpd[2]
+ openDVS_pixel2x2_top_832/vpd[3] openDVS_pixel2x2_top_832/vpd[1] openDVS_pixel2x2_top_832/vpd[0]
+ rowReadON<19> rowReadOFF<18> openDVS_pixel2x2_top_949/GndD DiffBn GndA OnBn VddA18
+ openDVS_pixel2x2_top
XopenDVS_pixel2x2_top_821 rowReadOFF<17> rowReadON<16> RefrBp PrBp PrSFBp col_periphery_1x2_19/COL_LINE0
+ pixRst<38> pixRst<39> col_periphery_1x2_19/COL_LINE1 OffBn openDVS_pixel2x2_top_821/vpd[2]
+ openDVS_pixel2x2_top_821/vpd[3] openDVS_pixel2x2_top_821/vpd[1] openDVS_pixel2x2_top_821/vpd[0]
+ rowReadON<17> rowReadOFF<16> openDVS_pixel2x2_top_947/GndD DiffBn GndA OnBn VddA18
+ openDVS_pixel2x2_top
XopenDVS_pixel2x2_top_810 rowReadOFF<15> rowReadON<14> RefrBp PrBp PrSFBp col_periphery_1x2_18/COL_LINE0
+ pixRst<36> pixRst<37> col_periphery_1x2_18/COL_LINE1 OffBn openDVS_pixel2x2_top_810/vpd[2]
+ openDVS_pixel2x2_top_810/vpd[3] openDVS_pixel2x2_top_810/vpd[1] openDVS_pixel2x2_top_810/vpd[0]
+ rowReadON<15> rowReadOFF<14> openDVS_pixel2x2_top_945/GndD DiffBn GndA OnBn VddA18
+ openDVS_pixel2x2_top
XopenDVS_pixel2x2_top_139 rowReadOFF<39> rowReadON<38> RefrBp PrBp PrSFBp col_periphery_1x2_20/COL_LINE0
+ pixRst<40> pixRst<41> col_periphery_1x2_20/COL_LINE1 OffBn openDVS_pixel2x2_top_139/vpd[2]
+ openDVS_pixel2x2_top_139/vpd[3] openDVS_pixel2x2_top_139/vpd[1] openDVS_pixel2x2_top_139/vpd[0]
+ rowReadON<39> rowReadOFF<38> openDVS_pixel2x2_top_999/GndD DiffBn GndA OnBn VddA18
+ openDVS_pixel2x2_top
XopenDVS_pixel2x2_top_117 rowReadOFF<37> rowReadON<36> RefrBp PrBp PrSFBp col_periphery_1x2_17/COL_LINE0
+ pixRst<34> pixRst<35> col_periphery_1x2_17/COL_LINE1 OffBn openDVS_pixel2x2_top_117/vpd[2]
+ openDVS_pixel2x2_top_117/vpd[3] openDVS_pixel2x2_top_117/vpd[1] openDVS_pixel2x2_top_117/vpd[0]
+ rowReadON<37> rowReadOFF<36> openDVS_pixel2x2_top_997/GndD DiffBn GndA OnBn VddA18
+ openDVS_pixel2x2_top
XopenDVS_pixel2x2_top_106 rowReadOFF<59> rowReadON<58> RefrBp PrBp PrSFBp col_periphery_1x2_21/COL_LINE0
+ pixRst<42> pixRst<43> col_periphery_1x2_21/COL_LINE1 OffBn openDVS_pixel2x2_top_106/vpd[2]
+ openDVS_pixel2x2_top_106/vpd[3] openDVS_pixel2x2_top_106/vpd[1] openDVS_pixel2x2_top_106/vpd[0]
+ rowReadON<59> rowReadOFF<58> openDVS_pixel2x2_top_74/GndD DiffBn GndA OnBn VddA18
+ openDVS_pixel2x2_top
XopenDVS_pixel2x2_top_128 rowReadOFF<43> rowReadON<42> RefrBp PrBp PrSFBp col_periphery_1x2_18/COL_LINE0
+ pixRst<36> pixRst<37> col_periphery_1x2_18/COL_LINE1 OffBn openDVS_pixel2x2_top_128/vpd[2]
+ openDVS_pixel2x2_top_128/vpd[3] openDVS_pixel2x2_top_128/vpd[1] openDVS_pixel2x2_top_128/vpd[0]
+ rowReadON<43> rowReadOFF<42> openDVS_pixel2x2_top_537/GndD DiffBn GndA OnBn VddA18
+ openDVS_pixel2x2_top
XopenDVS_pixel2x2_top_695 rowReadOFF<7> rowReadON<6> RefrBp PrBp PrSFBp col_periphery_1x2_13/COL_LINE0
+ pixRst<28> pixRst<29> col_periphery_1x2_13/COL_LINE1 OffBn openDVS_pixel2x2_top_695/vpd[2]
+ openDVS_pixel2x2_top_695/vpd[3] openDVS_pixel2x2_top_695/vpd[1] openDVS_pixel2x2_top_695/vpd[0]
+ rowReadON<7> rowReadOFF<6> openDVS_pixel2x2_top_937/GndD DiffBn GndA OnBn VddA18
+ openDVS_pixel2x2_top
XopenDVS_pixel2x2_top_673 rowReadOFF<5> rowReadON<4> RefrBp PrBp PrSFBp col_periphery_1x2_9/COL_LINE0
+ pixRst<20> pixRst<21> col_periphery_1x2_9/COL_LINE1 OffBn openDVS_pixel2x2_top_673/vpd[2]
+ openDVS_pixel2x2_top_673/vpd[3] openDVS_pixel2x2_top_673/vpd[1] openDVS_pixel2x2_top_673/vpd[0]
+ rowReadON<5> rowReadOFF<4> openDVS_pixel2x2_top_935/GndD DiffBn GndA OnBn VddA18
+ openDVS_pixel2x2_top
XopenDVS_pixel2x2_top_651 rowReadOFF<3> rowReadON<2> RefrBp PrBp PrSFBp col_periphery_1x2_5/COL_LINE0
+ pixRst<6> pixRst<7> col_periphery_1x2_5/COL_LINE1 OffBn openDVS_pixel2x2_top_651/vpd[2]
+ openDVS_pixel2x2_top_651/vpd[3] openDVS_pixel2x2_top_651/vpd[1] openDVS_pixel2x2_top_651/vpd[0]
+ rowReadON<3> rowReadOFF<2> openDVS_pixel2x2_top_933/GndD DiffBn GndA OnBn VddA18
+ openDVS_pixel2x2_top
XopenDVS_pixel2x2_top_684 rowReadOFF<7> rowReadON<6> RefrBp PrBp PrSFBp col_periphery_1x2_3/COL_LINE0
+ pixRst<2> pixRst<3> col_periphery_1x2_3/COL_LINE1 OffBn openDVS_pixel2x2_top_684/vpd[2]
+ openDVS_pixel2x2_top_684/vpd[3] openDVS_pixel2x2_top_684/vpd[1] openDVS_pixel2x2_top_684/vpd[0]
+ rowReadON<7> rowReadOFF<6> openDVS_pixel2x2_top_937/GndD DiffBn GndA OnBn VddA18
+ openDVS_pixel2x2_top
XopenDVS_pixel2x2_top_662 rowReadOFF<5> rowReadON<4> RefrBp PrBp PrSFBp col_periphery_1x2_2/COL_LINE0
+ pixRst<0> pixRst<1> col_periphery_1x2_2/COL_LINE1 OffBn openDVS_pixel2x2_top_662/vpd[2]
+ openDVS_pixel2x2_top_662/vpd[3] openDVS_pixel2x2_top_662/vpd[1] openDVS_pixel2x2_top_662/vpd[0]
+ rowReadON<5> rowReadOFF<4> openDVS_pixel2x2_top_935/GndD DiffBn GndA OnBn VddA18
+ openDVS_pixel2x2_top
XopenDVS_pixel2x2_top_640 rowReadOFF<15> rowReadON<14> RefrBp PrBp PrSFBp col_periphery_1x2_6/COL_LINE0
+ pixRst<8> pixRst<9> col_periphery_1x2_6/COL_LINE1 OffBn openDVS_pixel2x2_top_640/vpd[2]
+ openDVS_pixel2x2_top_640/vpd[3] openDVS_pixel2x2_top_640/vpd[1] openDVS_pixel2x2_top_640/vpd[0]
+ rowReadON<15> rowReadOFF<14> openDVS_pixel2x2_top_945/GndD DiffBn GndA OnBn VddA18
+ openDVS_pixel2x2_top
XopenDVS_pixel2x2_top_1018 rowReadOFF<59> rowReadON<58> RefrBp PrBp PrSFBp col_periphery_1x2_14/COL_LINE0
+ pixRst<30> pixRst<31> col_periphery_1x2_14/COL_LINE1 OffBn openDVS_pixel2x2_top_1018/vpd[2]
+ openDVS_pixel2x2_top_1018/vpd[3] openDVS_pixel2x2_top_1018/vpd[1] openDVS_pixel2x2_top_1018/vpd[0]
+ rowReadON<59> rowReadOFF<58> openDVS_pixel2x2_top_74/GndD DiffBn GndA OnBn VddA18
+ openDVS_pixel2x2_top
XopenDVS_pixel2x2_top_1007 rowReadOFF<47> rowReadON<46> RefrBp PrBp PrSFBp col_periphery_1x2_16/COL_LINE0
+ pixRst<32> pixRst<33> col_periphery_1x2_16/COL_LINE1 OffBn openDVS_pixel2x2_top_1007/vpd[2]
+ openDVS_pixel2x2_top_1007/vpd[3] openDVS_pixel2x2_top_1007/vpd[1] openDVS_pixel2x2_top_1007/vpd[0]
+ rowReadON<47> rowReadOFF<46> openDVS_pixel2x2_top_78/GndD DiffBn GndA OnBn VddA18
+ openDVS_pixel2x2_top
XopenDVS_pixel2x2_top_470 rowReadOFF<39> rowReadON<38> RefrBp PrBp PrSFBp col_periphery_1x2_11/COL_LINE0
+ pixRst<24> pixRst<25> col_periphery_1x2_11/COL_LINE1 OffBn openDVS_pixel2x2_top_470/vpd[2]
+ openDVS_pixel2x2_top_470/vpd[3] openDVS_pixel2x2_top_470/vpd[1] openDVS_pixel2x2_top_470/vpd[0]
+ rowReadON<39> rowReadOFF<38> openDVS_pixel2x2_top_999/GndD DiffBn GndA OnBn VddA18
+ openDVS_pixel2x2_top
XopenDVS_pixel2x2_top_492 rowReadOFF<45> rowReadON<44> RefrBp PrBp PrSFBp col_periphery_1x2_5/COL_LINE0
+ pixRst<6> pixRst<7> col_periphery_1x2_5/COL_LINE1 OffBn openDVS_pixel2x2_top_492/vpd[2]
+ openDVS_pixel2x2_top_492/vpd[3] openDVS_pixel2x2_top_492/vpd[1] openDVS_pixel2x2_top_492/vpd[0]
+ rowReadON<45> rowReadOFF<44> openDVS_pixel2x2_top_539/GndD DiffBn GndA OnBn VddA18
+ openDVS_pixel2x2_top
XopenDVS_pixel2x2_top_481 rowReadOFF<43> rowReadON<42> RefrBp PrBp PrSFBp col_periphery_1x2_11/COL_LINE0
+ pixRst<24> pixRst<25> col_periphery_1x2_11/COL_LINE1 OffBn openDVS_pixel2x2_top_481/vpd[2]
+ openDVS_pixel2x2_top_481/vpd[3] openDVS_pixel2x2_top_481/vpd[1] openDVS_pixel2x2_top_481/vpd[0]
+ rowReadON<43> rowReadOFF<42> openDVS_pixel2x2_top_537/GndD DiffBn GndA OnBn VddA18
+ openDVS_pixel2x2_top
XopenDVS_pixel2x2_top_866 rowReadOFF<5> rowReadON<4> RefrBp PrBp PrSFBp col_periphery_1x2_28/COL_LINE0
+ pixRst<58> pixRst<59> col_periphery_1x2_28/COL_LINE1 OffBn openDVS_pixel2x2_top_866/vpd[2]
+ openDVS_pixel2x2_top_866/vpd[3] openDVS_pixel2x2_top_866/vpd[1] openDVS_pixel2x2_top_866/vpd[0]
+ rowReadON<5> rowReadOFF<4> openDVS_pixel2x2_top_935/GndD DiffBn GndA OnBn VddA18
+ openDVS_pixel2x2_top
XopenDVS_pixel2x2_top_888 rowReadOFF<7> rowReadON<6> RefrBp PrBp PrSFBp col_periphery_1x2_26/COL_LINE0
+ pixRst<54> pixRst<55> col_periphery_1x2_26/COL_LINE1 OffBn openDVS_pixel2x2_top_888/vpd[2]
+ openDVS_pixel2x2_top_888/vpd[3] openDVS_pixel2x2_top_888/vpd[1] openDVS_pixel2x2_top_888/vpd[0]
+ rowReadON<7> rowReadOFF<6> openDVS_pixel2x2_top_937/GndD DiffBn GndA OnBn VddA18
+ openDVS_pixel2x2_top
XopenDVS_pixel2x2_top_877 rowReadOFF<3> rowReadON<2> RefrBp PrBp PrSFBp col_periphery_1x2_24/COL_LINE0
+ pixRst<50> pixRst<51> col_periphery_1x2_24/COL_LINE1 OffBn openDVS_pixel2x2_top_877/vpd[2]
+ openDVS_pixel2x2_top_877/vpd[3] openDVS_pixel2x2_top_877/vpd[1] openDVS_pixel2x2_top_877/vpd[0]
+ rowReadON<3> rowReadOFF<2> openDVS_pixel2x2_top_933/GndD DiffBn GndA OnBn VddA18
+ openDVS_pixel2x2_top
XopenDVS_pixel2x2_top_899 rowReadOFF<7> rowReadON<6> RefrBp PrBp PrSFBp col_periphery_1x2_23/COL_LINE0
+ pixRst<46> pixRst<47> col_periphery_1x2_23/COL_LINE1 OffBn openDVS_pixel2x2_top_899/vpd[2]
+ openDVS_pixel2x2_top_899/vpd[3] openDVS_pixel2x2_top_899/vpd[1] openDVS_pixel2x2_top_899/vpd[0]
+ rowReadON<7> rowReadOFF<6> openDVS_pixel2x2_top_937/GndD DiffBn GndA OnBn VddA18
+ openDVS_pixel2x2_top
XopenDVS_pixel2x2_top_844 rowReadOFF<1> rowReadON<0> RefrBp PrBp PrSFBp col_periphery_1x2_20/COL_LINE0
+ pixRst<40> pixRst<41> col_periphery_1x2_20/COL_LINE1 OffBn openDVS_pixel2x2_top_844/vpd[2]
+ openDVS_pixel2x2_top_844/vpd[3] openDVS_pixel2x2_top_844/vpd[1] openDVS_pixel2x2_top_844/vpd[0]
+ rowReadON<1> rowReadOFF<0> openDVS_pixel2x2_top_931/GndD DiffBn GndA OnBn VddA18
+ openDVS_pixel2x2_top
XopenDVS_pixel2x2_top_855 rowReadOFF<5> rowReadON<4> RefrBp PrBp PrSFBp col_periphery_1x2_19/COL_LINE0
+ pixRst<38> pixRst<39> col_periphery_1x2_19/COL_LINE1 OffBn openDVS_pixel2x2_top_855/vpd[2]
+ openDVS_pixel2x2_top_855/vpd[3] openDVS_pixel2x2_top_855/vpd[1] openDVS_pixel2x2_top_855/vpd[0]
+ rowReadON<5> rowReadOFF<4> openDVS_pixel2x2_top_935/GndD DiffBn GndA OnBn VddA18
+ openDVS_pixel2x2_top
XopenDVS_pixel2x2_top_833 rowReadOFF<19> rowReadON<18> RefrBp PrBp PrSFBp col_periphery_1x2_22/COL_LINE0
+ pixRst<44> pixRst<45> col_periphery_1x2_22/COL_LINE1 OffBn openDVS_pixel2x2_top_833/vpd[2]
+ openDVS_pixel2x2_top_833/vpd[3] openDVS_pixel2x2_top_833/vpd[1] openDVS_pixel2x2_top_833/vpd[0]
+ rowReadON<19> rowReadOFF<18> openDVS_pixel2x2_top_949/GndD DiffBn GndA OnBn VddA18
+ openDVS_pixel2x2_top
XopenDVS_pixel2x2_top_822 rowReadOFF<17> rowReadON<16> RefrBp PrBp PrSFBp col_periphery_1x2_20/COL_LINE0
+ pixRst<40> pixRst<41> col_periphery_1x2_20/COL_LINE1 OffBn openDVS_pixel2x2_top_822/vpd[2]
+ openDVS_pixel2x2_top_822/vpd[3] openDVS_pixel2x2_top_822/vpd[1] openDVS_pixel2x2_top_822/vpd[0]
+ rowReadON<17> rowReadOFF<16> openDVS_pixel2x2_top_947/GndD DiffBn GndA OnBn VddA18
+ openDVS_pixel2x2_top
XopenDVS_pixel2x2_top_811 rowReadOFF<15> rowReadON<14> RefrBp PrBp PrSFBp col_periphery_1x2_19/COL_LINE0
+ pixRst<38> pixRst<39> col_periphery_1x2_19/COL_LINE1 OffBn openDVS_pixel2x2_top_811/vpd[2]
+ openDVS_pixel2x2_top_811/vpd[3] openDVS_pixel2x2_top_811/vpd[1] openDVS_pixel2x2_top_811/vpd[0]
+ rowReadON<15> rowReadOFF<14> openDVS_pixel2x2_top_945/GndD DiffBn GndA OnBn VddA18
+ openDVS_pixel2x2_top
XopenDVS_pixel2x2_top_800 rowReadOFF<13> rowReadON<12> RefrBp PrBp PrSFBp col_periphery_1x2_18/COL_LINE0
+ pixRst<36> pixRst<37> col_periphery_1x2_18/COL_LINE1 OffBn openDVS_pixel2x2_top_800/vpd[2]
+ openDVS_pixel2x2_top_800/vpd[3] openDVS_pixel2x2_top_800/vpd[1] openDVS_pixel2x2_top_800/vpd[0]
+ rowReadON<13> rowReadOFF<12> openDVS_pixel2x2_top_943/GndD DiffBn GndA OnBn VddA18
+ openDVS_pixel2x2_top
XopenDVS_pixel2x2_top_118 rowReadOFF<37> rowReadON<36> RefrBp PrBp PrSFBp col_periphery_1x2_18/COL_LINE0
+ pixRst<36> pixRst<37> col_periphery_1x2_18/COL_LINE1 OffBn openDVS_pixel2x2_top_118/vpd[2]
+ openDVS_pixel2x2_top_118/vpd[3] openDVS_pixel2x2_top_118/vpd[1] openDVS_pixel2x2_top_118/vpd[0]
+ rowReadON<37> rowReadOFF<36> openDVS_pixel2x2_top_997/GndD DiffBn GndA OnBn VddA18
+ openDVS_pixel2x2_top
XopenDVS_pixel2x2_top_107 rowReadOFF<59> rowReadON<58> RefrBp PrBp PrSFBp col_periphery_1x2_22/COL_LINE0
+ pixRst<44> pixRst<45> col_periphery_1x2_22/COL_LINE1 OffBn openDVS_pixel2x2_top_107/vpd[2]
+ openDVS_pixel2x2_top_107/vpd[3] openDVS_pixel2x2_top_107/vpd[1] openDVS_pixel2x2_top_107/vpd[0]
+ rowReadON<59> rowReadOFF<58> openDVS_pixel2x2_top_74/GndD DiffBn GndA OnBn VddA18
+ openDVS_pixel2x2_top
XopenDVS_pixel2x2_top_129 rowReadOFF<43> rowReadON<42> RefrBp PrBp PrSFBp col_periphery_1x2_19/COL_LINE0
+ pixRst<38> pixRst<39> col_periphery_1x2_19/COL_LINE1 OffBn openDVS_pixel2x2_top_129/vpd[2]
+ openDVS_pixel2x2_top_129/vpd[3] openDVS_pixel2x2_top_129/vpd[1] openDVS_pixel2x2_top_129/vpd[0]
+ rowReadON<43> rowReadOFF<42> openDVS_pixel2x2_top_537/GndD DiffBn GndA OnBn VddA18
+ openDVS_pixel2x2_top
XopenDVS_pixel2x2_top_674 rowReadOFF<5> rowReadON<4> RefrBp PrBp PrSFBp col_periphery_1x2_10/COL_LINE0
+ pixRst<22> pixRst<23> col_periphery_1x2_10/COL_LINE1 OffBn openDVS_pixel2x2_top_674/vpd[2]
+ openDVS_pixel2x2_top_674/vpd[3] openDVS_pixel2x2_top_674/vpd[1] openDVS_pixel2x2_top_674/vpd[0]
+ rowReadON<5> rowReadOFF<4> openDVS_pixel2x2_top_935/GndD DiffBn GndA OnBn VddA18
+ openDVS_pixel2x2_top
XopenDVS_pixel2x2_top_685 rowReadOFF<7> rowReadON<6> RefrBp PrBp PrSFBp col_periphery_1x2_4/COL_LINE0
+ pixRst<4> pixRst<5> col_periphery_1x2_4/COL_LINE1 OffBn openDVS_pixel2x2_top_685/vpd[2]
+ openDVS_pixel2x2_top_685/vpd[3] openDVS_pixel2x2_top_685/vpd[1] openDVS_pixel2x2_top_685/vpd[0]
+ rowReadON<7> rowReadOFF<6> openDVS_pixel2x2_top_937/GndD DiffBn GndA OnBn VddA18
+ openDVS_pixel2x2_top
XopenDVS_pixel2x2_top_652 rowReadOFF<1> rowReadON<0> RefrBp PrBp PrSFBp col_periphery_1x2_2/COL_LINE0
+ pixRst<0> pixRst<1> col_periphery_1x2_2/COL_LINE1 OffBn openDVS_pixel2x2_top_652/vpd[2]
+ openDVS_pixel2x2_top_652/vpd[3] openDVS_pixel2x2_top_652/vpd[1] openDVS_pixel2x2_top_652/vpd[0]
+ rowReadON<1> rowReadOFF<0> openDVS_pixel2x2_top_931/GndD DiffBn GndA OnBn VddA18
+ openDVS_pixel2x2_top
XopenDVS_pixel2x2_top_663 rowReadOFF<5> rowReadON<4> RefrBp PrBp PrSFBp col_periphery_1x2_3/COL_LINE0
+ pixRst<2> pixRst<3> col_periphery_1x2_3/COL_LINE1 OffBn openDVS_pixel2x2_top_663/vpd[2]
+ openDVS_pixel2x2_top_663/vpd[3] openDVS_pixel2x2_top_663/vpd[1] openDVS_pixel2x2_top_663/vpd[0]
+ rowReadON<5> rowReadOFF<4> openDVS_pixel2x2_top_935/GndD DiffBn GndA OnBn VddA18
+ openDVS_pixel2x2_top
XopenDVS_pixel2x2_top_641 rowReadOFF<15> rowReadON<14> RefrBp PrBp PrSFBp col_periphery_1x2_1/COL_LINE0
+ pixRst<12> pixRst<13> col_periphery_1x2_1/COL_LINE1 OffBn openDVS_pixel2x2_top_641/vpd[2]
+ openDVS_pixel2x2_top_641/vpd[3] openDVS_pixel2x2_top_641/vpd[1] openDVS_pixel2x2_top_641/vpd[0]
+ rowReadON<15> rowReadOFF<14> openDVS_pixel2x2_top_945/GndD DiffBn GndA OnBn VddA18
+ openDVS_pixel2x2_top
XopenDVS_pixel2x2_top_696 rowReadOFF<23> rowReadON<22> RefrBp PrBp PrSFBp col_periphery_1x2_15/COL_LINE0
+ pixRst<14> pixRst<15> col_periphery_1x2_15/COL_LINE1 OffBn openDVS_pixel2x2_top_696/vpd[2]
+ openDVS_pixel2x2_top_696/vpd[3] openDVS_pixel2x2_top_696/vpd[1] openDVS_pixel2x2_top_696/vpd[0]
+ rowReadON<23> rowReadOFF<22> openDVS_pixel2x2_top_953/GndD DiffBn GndA OnBn VddA18
+ openDVS_pixel2x2_top
XopenDVS_pixel2x2_top_630 rowReadOFF<21> rowReadON<20> RefrBp PrBp PrSFBp col_periphery_1x2_2/COL_LINE0
+ pixRst<0> pixRst<1> col_periphery_1x2_2/COL_LINE1 OffBn openDVS_pixel2x2_top_630/vpd[2]
+ openDVS_pixel2x2_top_630/vpd[3] openDVS_pixel2x2_top_630/vpd[1] openDVS_pixel2x2_top_630/vpd[0]
+ rowReadON<21> rowReadOFF<20> openDVS_pixel2x2_top_951/GndD DiffBn GndA OnBn VddA18
+ openDVS_pixel2x2_top
XopenDVS_pixel2x2_top_1019 rowReadOFF<59> rowReadON<58> RefrBp PrBp PrSFBp col_periphery_1x2_16/COL_LINE0
+ pixRst<32> pixRst<33> col_periphery_1x2_16/COL_LINE1 OffBn openDVS_pixel2x2_top_1019/vpd[2]
+ openDVS_pixel2x2_top_1019/vpd[3] openDVS_pixel2x2_top_1019/vpd[1] openDVS_pixel2x2_top_1019/vpd[0]
+ rowReadON<59> rowReadOFF<58> openDVS_pixel2x2_top_74/GndD DiffBn GndA OnBn VddA18
+ openDVS_pixel2x2_top
XopenDVS_pixel2x2_top_1008 rowReadOFF<49> rowReadON<48> RefrBp PrBp PrSFBp col_periphery_1x2_14/COL_LINE0
+ pixRst<30> pixRst<31> col_periphery_1x2_14/COL_LINE1 OffBn openDVS_pixel2x2_top_1008/vpd[2]
+ openDVS_pixel2x2_top_1008/vpd[3] openDVS_pixel2x2_top_1008/vpd[1] openDVS_pixel2x2_top_1008/vpd[0]
+ rowReadON<49> rowReadOFF<48> openDVS_pixel2x2_top_3/GndD DiffBn GndA OnBn VddA18
+ openDVS_pixel2x2_top
XopenDVS_pixel2x2_top_0 rowReadOFF<49> rowReadON<48> RefrBp PrBp PrSFBp col_periphery_1x2_27/COL_LINE0
+ pixRst<56> pixRst<57> col_periphery_1x2_27/COL_LINE1 OffBn openDVS_pixel2x2_top_0/vpd[2]
+ openDVS_pixel2x2_top_0/vpd[3] openDVS_pixel2x2_top_0/vpd[1] openDVS_pixel2x2_top_0/vpd[0]
+ rowReadON<49> rowReadOFF<48> openDVS_pixel2x2_top_3/GndD DiffBn GndA OnBn VddA18
+ openDVS_pixel2x2_top
XopenDVS_pixel2x2_top_482 rowReadOFF<31> rowReadON<30> RefrBp PrBp PrSFBp col_periphery_1x2_8/COL_LINE0
+ pixRst<18> pixRst<19> col_periphery_1x2_8/COL_LINE1 OffBn openDVS_pixel2x2_top_482/vpd[2]
+ openDVS_pixel2x2_top_482/vpd[3] openDVS_pixel2x2_top_482/vpd[1] openDVS_pixel2x2_top_482/vpd[0]
+ rowReadON<31> rowReadOFF<30> openDVS_pixel2x2_top_991/GndD DiffBn GndA OnBn VddA18
+ openDVS_pixel2x2_top
XopenDVS_pixel2x2_top_471 rowReadOFF<39> rowReadON<38> RefrBp PrBp PrSFBp col_periphery_1x2_12/COL_LINE0
+ pixRst<26> pixRst<27> col_periphery_1x2_12/COL_LINE1 OffBn openDVS_pixel2x2_top_471/vpd[2]
+ openDVS_pixel2x2_top_471/vpd[3] openDVS_pixel2x2_top_471/vpd[1] openDVS_pixel2x2_top_471/vpd[0]
+ rowReadON<39> rowReadOFF<38> openDVS_pixel2x2_top_999/GndD DiffBn GndA OnBn VddA18
+ openDVS_pixel2x2_top
XopenDVS_pixel2x2_top_460 rowReadOFF<37> rowReadON<36> RefrBp PrBp PrSFBp col_periphery_1x2_10/COL_LINE0
+ pixRst<22> pixRst<23> col_periphery_1x2_10/COL_LINE1 OffBn openDVS_pixel2x2_top_460/vpd[2]
+ openDVS_pixel2x2_top_460/vpd[3] openDVS_pixel2x2_top_460/vpd[1] openDVS_pixel2x2_top_460/vpd[0]
+ rowReadON<37> rowReadOFF<36> openDVS_pixel2x2_top_997/GndD DiffBn GndA OnBn VddA18
+ openDVS_pixel2x2_top
XopenDVS_pixel2x2_top_493 rowReadOFF<45> rowReadON<44> RefrBp PrBp PrSFBp col_periphery_1x2_6/COL_LINE0
+ pixRst<8> pixRst<9> col_periphery_1x2_6/COL_LINE1 OffBn openDVS_pixel2x2_top_493/vpd[2]
+ openDVS_pixel2x2_top_493/vpd[3] openDVS_pixel2x2_top_493/vpd[1] openDVS_pixel2x2_top_493/vpd[0]
+ rowReadON<45> rowReadOFF<44> openDVS_pixel2x2_top_539/GndD DiffBn GndA OnBn VddA18
+ openDVS_pixel2x2_top
XopenDVS_pixel2x2_top_290 rowReadOFF<59> rowReadON<58> RefrBp PrBp PrSFBp col_periphery_1x2_8/COL_LINE0
+ pixRst<18> pixRst<19> col_periphery_1x2_8/COL_LINE1 OffBn openDVS_pixel2x2_top_290/vpd[2]
+ openDVS_pixel2x2_top_290/vpd[3] openDVS_pixel2x2_top_290/vpd[1] openDVS_pixel2x2_top_290/vpd[0]
+ rowReadON<59> rowReadOFF<58> openDVS_pixel2x2_top_74/GndD DiffBn GndA OnBn VddA18
+ openDVS_pixel2x2_top
XopenDVS_pixel2x2_top_889 rowReadOFF<7> rowReadON<6> RefrBp PrBp PrSFBp col_periphery_1x2_27/COL_LINE0
+ pixRst<56> pixRst<57> col_periphery_1x2_27/COL_LINE1 OffBn openDVS_pixel2x2_top_889/vpd[2]
+ openDVS_pixel2x2_top_889/vpd[3] openDVS_pixel2x2_top_889/vpd[1] openDVS_pixel2x2_top_889/vpd[0]
+ rowReadON<7> rowReadOFF<6> openDVS_pixel2x2_top_937/GndD DiffBn GndA OnBn VddA18
+ openDVS_pixel2x2_top
XopenDVS_pixel2x2_top_867 rowReadOFF<5> rowReadON<4> RefrBp PrBp PrSFBp col_periphery_1x2_24/COL_LINE0
+ pixRst<50> pixRst<51> col_periphery_1x2_24/COL_LINE1 OffBn openDVS_pixel2x2_top_867/vpd[2]
+ openDVS_pixel2x2_top_867/vpd[3] openDVS_pixel2x2_top_867/vpd[1] openDVS_pixel2x2_top_867/vpd[0]
+ rowReadON<5> rowReadOFF<4> openDVS_pixel2x2_top_935/GndD DiffBn GndA OnBn VddA18
+ openDVS_pixel2x2_top
XopenDVS_pixel2x2_top_845 rowReadOFF<1> rowReadON<0> RefrBp PrBp PrSFBp col_periphery_1x2_21/COL_LINE0
+ pixRst<42> pixRst<43> col_periphery_1x2_21/COL_LINE1 OffBn openDVS_pixel2x2_top_845/vpd[2]
+ openDVS_pixel2x2_top_845/vpd[3] openDVS_pixel2x2_top_845/vpd[1] openDVS_pixel2x2_top_845/vpd[0]
+ rowReadON<1> rowReadOFF<0> openDVS_pixel2x2_top_931/GndD DiffBn GndA OnBn VddA18
+ openDVS_pixel2x2_top
XopenDVS_pixel2x2_top_878 rowReadOFF<7> rowReadON<6> RefrBp PrBp PrSFBp col_periphery_1x2_20/COL_LINE0
+ pixRst<40> pixRst<41> col_periphery_1x2_20/COL_LINE1 OffBn openDVS_pixel2x2_top_878/vpd[2]
+ openDVS_pixel2x2_top_878/vpd[3] openDVS_pixel2x2_top_878/vpd[1] openDVS_pixel2x2_top_878/vpd[0]
+ rowReadON<7> rowReadOFF<6> openDVS_pixel2x2_top_937/GndD DiffBn GndA OnBn VddA18
+ openDVS_pixel2x2_top
XopenDVS_pixel2x2_top_856 rowReadOFF<3> rowReadON<2> RefrBp PrBp PrSFBp col_periphery_1x2_17/COL_LINE0
+ pixRst<34> pixRst<35> col_periphery_1x2_17/COL_LINE1 OffBn openDVS_pixel2x2_top_856/vpd[2]
+ openDVS_pixel2x2_top_856/vpd[3] openDVS_pixel2x2_top_856/vpd[1] openDVS_pixel2x2_top_856/vpd[0]
+ rowReadON<3> rowReadOFF<2> openDVS_pixel2x2_top_933/GndD DiffBn GndA OnBn VddA18
+ openDVS_pixel2x2_top
XopenDVS_pixel2x2_top_823 rowReadOFF<17> rowReadON<16> RefrBp PrBp PrSFBp col_periphery_1x2_21/COL_LINE0
+ pixRst<42> pixRst<43> col_periphery_1x2_21/COL_LINE1 OffBn openDVS_pixel2x2_top_823/vpd[2]
+ openDVS_pixel2x2_top_823/vpd[3] openDVS_pixel2x2_top_823/vpd[1] openDVS_pixel2x2_top_823/vpd[0]
+ rowReadON<17> rowReadOFF<16> openDVS_pixel2x2_top_947/GndD DiffBn GndA OnBn VddA18
+ openDVS_pixel2x2_top
XopenDVS_pixel2x2_top_812 rowReadOFF<15> rowReadON<14> RefrBp PrBp PrSFBp col_periphery_1x2_20/COL_LINE0
+ pixRst<40> pixRst<41> col_periphery_1x2_20/COL_LINE1 OffBn openDVS_pixel2x2_top_812/vpd[2]
+ openDVS_pixel2x2_top_812/vpd[3] openDVS_pixel2x2_top_812/vpd[1] openDVS_pixel2x2_top_812/vpd[0]
+ rowReadON<15> rowReadOFF<14> openDVS_pixel2x2_top_945/GndD DiffBn GndA OnBn VddA18
+ openDVS_pixel2x2_top
XopenDVS_pixel2x2_top_801 rowReadOFF<13> rowReadON<12> RefrBp PrBp PrSFBp col_periphery_1x2_19/COL_LINE0
+ pixRst<38> pixRst<39> col_periphery_1x2_19/COL_LINE1 OffBn openDVS_pixel2x2_top_801/vpd[2]
+ openDVS_pixel2x2_top_801/vpd[3] openDVS_pixel2x2_top_801/vpd[1] openDVS_pixel2x2_top_801/vpd[0]
+ rowReadON<13> rowReadOFF<12> openDVS_pixel2x2_top_943/GndD DiffBn GndA OnBn VddA18
+ openDVS_pixel2x2_top
XopenDVS_pixel2x2_top_834 rowReadOFF<23> rowReadON<22> RefrBp PrBp PrSFBp col_periphery_1x2_19/COL_LINE0
+ pixRst<38> pixRst<39> col_periphery_1x2_19/COL_LINE1 OffBn openDVS_pixel2x2_top_834/vpd[2]
+ openDVS_pixel2x2_top_834/vpd[3] openDVS_pixel2x2_top_834/vpd[1] openDVS_pixel2x2_top_834/vpd[0]
+ rowReadON<23> rowReadOFF<22> openDVS_pixel2x2_top_953/GndD DiffBn GndA OnBn VddA18
+ openDVS_pixel2x2_top
XopenDVS_pixel2x2_top_119 rowReadOFF<37> rowReadON<36> RefrBp PrBp PrSFBp col_periphery_1x2_19/COL_LINE0
+ pixRst<38> pixRst<39> col_periphery_1x2_19/COL_LINE1 OffBn openDVS_pixel2x2_top_119/vpd[2]
+ openDVS_pixel2x2_top_119/vpd[3] openDVS_pixel2x2_top_119/vpd[1] openDVS_pixel2x2_top_119/vpd[0]
+ rowReadON<37> rowReadOFF<36> openDVS_pixel2x2_top_997/GndD DiffBn GndA OnBn VddA18
+ openDVS_pixel2x2_top
XopenDVS_pixel2x2_top_108 rowReadOFF<49> rowReadON<48> RefrBp PrBp PrSFBp col_periphery_1x2_21/COL_LINE0
+ pixRst<42> pixRst<43> col_periphery_1x2_21/COL_LINE1 OffBn openDVS_pixel2x2_top_108/vpd[2]
+ openDVS_pixel2x2_top_108/vpd[3] openDVS_pixel2x2_top_108/vpd[1] openDVS_pixel2x2_top_108/vpd[0]
+ rowReadON<49> rowReadOFF<48> openDVS_pixel2x2_top_3/GndD DiffBn GndA OnBn VddA18
+ openDVS_pixel2x2_top
XopenDVS_pixel2x2_top_675 rowReadOFF<5> rowReadON<4> RefrBp PrBp PrSFBp col_periphery_1x2_11/COL_LINE0
+ pixRst<24> pixRst<25> col_periphery_1x2_11/COL_LINE1 OffBn openDVS_pixel2x2_top_675/vpd[2]
+ openDVS_pixel2x2_top_675/vpd[3] openDVS_pixel2x2_top_675/vpd[1] openDVS_pixel2x2_top_675/vpd[0]
+ rowReadON<5> rowReadOFF<4> openDVS_pixel2x2_top_935/GndD DiffBn GndA OnBn VddA18
+ openDVS_pixel2x2_top
XopenDVS_pixel2x2_top_664 rowReadOFF<3> rowReadON<2> RefrBp PrBp PrSFBp col_periphery_1x2_6/COL_LINE0
+ pixRst<8> pixRst<9> col_periphery_1x2_6/COL_LINE1 OffBn openDVS_pixel2x2_top_664/vpd[2]
+ openDVS_pixel2x2_top_664/vpd[3] openDVS_pixel2x2_top_664/vpd[1] openDVS_pixel2x2_top_664/vpd[0]
+ rowReadON<3> rowReadOFF<2> openDVS_pixel2x2_top_933/GndD DiffBn GndA OnBn VddA18
+ openDVS_pixel2x2_top
XopenDVS_pixel2x2_top_686 rowReadOFF<7> rowReadON<6> RefrBp PrBp PrSFBp col_periphery_1x2_5/COL_LINE0
+ pixRst<6> pixRst<7> col_periphery_1x2_5/COL_LINE1 OffBn openDVS_pixel2x2_top_686/vpd[2]
+ openDVS_pixel2x2_top_686/vpd[3] openDVS_pixel2x2_top_686/vpd[1] openDVS_pixel2x2_top_686/vpd[0]
+ rowReadON<7> rowReadOFF<6> openDVS_pixel2x2_top_937/GndD DiffBn GndA OnBn VddA18
+ openDVS_pixel2x2_top
XopenDVS_pixel2x2_top_653 rowReadOFF<1> rowReadON<0> RefrBp PrBp PrSFBp col_periphery_1x2_3/COL_LINE0
+ pixRst<2> pixRst<3> col_periphery_1x2_3/COL_LINE1 OffBn openDVS_pixel2x2_top_653/vpd[2]
+ openDVS_pixel2x2_top_653/vpd[3] openDVS_pixel2x2_top_653/vpd[1] openDVS_pixel2x2_top_653/vpd[0]
+ rowReadON<1> rowReadOFF<0> openDVS_pixel2x2_top_931/GndD DiffBn GndA OnBn VddA18
+ openDVS_pixel2x2_top
XopenDVS_pixel2x2_top_631 rowReadOFF<13> rowReadON<12> RefrBp PrBp PrSFBp col_periphery_1x2_0/COL_LINE0
+ pixRst<10> pixRst<11> col_periphery_1x2_0/COL_LINE1 OffBn openDVS_pixel2x2_top_631/vpd[2]
+ openDVS_pixel2x2_top_631/vpd[3] openDVS_pixel2x2_top_631/vpd[1] openDVS_pixel2x2_top_631/vpd[0]
+ rowReadON<13> rowReadOFF<12> openDVS_pixel2x2_top_943/GndD DiffBn GndA OnBn VddA18
+ openDVS_pixel2x2_top
XopenDVS_pixel2x2_top_642 rowReadOFF<15> rowReadON<14> RefrBp PrBp PrSFBp col_periphery_1x2_0/COL_LINE0
+ pixRst<10> pixRst<11> col_periphery_1x2_0/COL_LINE1 OffBn openDVS_pixel2x2_top_642/vpd[2]
+ openDVS_pixel2x2_top_642/vpd[3] openDVS_pixel2x2_top_642/vpd[1] openDVS_pixel2x2_top_642/vpd[0]
+ rowReadON<15> rowReadOFF<14> openDVS_pixel2x2_top_945/GndD DiffBn GndA OnBn VddA18
+ openDVS_pixel2x2_top
XopenDVS_pixel2x2_top_620 rowReadOFF<19> rowReadON<18> RefrBp PrBp PrSFBp col_periphery_1x2_1/COL_LINE0
+ pixRst<12> pixRst<13> col_periphery_1x2_1/COL_LINE1 OffBn openDVS_pixel2x2_top_620/vpd[2]
+ openDVS_pixel2x2_top_620/vpd[3] openDVS_pixel2x2_top_620/vpd[1] openDVS_pixel2x2_top_620/vpd[0]
+ rowReadON<19> rowReadOFF<18> openDVS_pixel2x2_top_949/GndD DiffBn GndA OnBn VddA18
+ openDVS_pixel2x2_top
XopenDVS_pixel2x2_top_697 rowReadOFF<23> rowReadON<22> RefrBp PrBp PrSFBp col_periphery_1x2_7/COL_LINE0
+ pixRst<16> pixRst<17> col_periphery_1x2_7/COL_LINE1 OffBn openDVS_pixel2x2_top_697/vpd[2]
+ openDVS_pixel2x2_top_697/vpd[3] openDVS_pixel2x2_top_697/vpd[1] openDVS_pixel2x2_top_697/vpd[0]
+ rowReadON<23> rowReadOFF<22> openDVS_pixel2x2_top_953/GndD DiffBn GndA OnBn VddA18
+ openDVS_pixel2x2_top
XopenDVS_pixel2x2_top_1009 rowReadOFF<49> rowReadON<48> RefrBp PrBp PrSFBp col_periphery_1x2_16/COL_LINE0
+ pixRst<32> pixRst<33> col_periphery_1x2_16/COL_LINE1 OffBn openDVS_pixel2x2_top_1009/vpd[2]
+ openDVS_pixel2x2_top_1009/vpd[3] openDVS_pixel2x2_top_1009/vpd[1] openDVS_pixel2x2_top_1009/vpd[0]
+ rowReadON<49> rowReadOFF<48> openDVS_pixel2x2_top_3/GndD DiffBn GndA OnBn VddA18
+ openDVS_pixel2x2_top
XopenDVS_pixel2x2_top_1 rowReadOFF<49> rowReadON<48> RefrBp PrBp PrSFBp col_periphery_1x2_28/COL_LINE0
+ pixRst<58> pixRst<59> col_periphery_1x2_28/COL_LINE1 OffBn openDVS_pixel2x2_top_1/vpd[2]
+ openDVS_pixel2x2_top_1/vpd[3] openDVS_pixel2x2_top_1/vpd[1] openDVS_pixel2x2_top_1/vpd[0]
+ rowReadON<49> rowReadOFF<48> openDVS_pixel2x2_top_3/GndD DiffBn GndA OnBn VddA18
+ openDVS_pixel2x2_top
XopenDVS_pixel2x2_top_483 rowReadOFF<31> rowReadON<30> RefrBp PrBp PrSFBp col_periphery_1x2_9/COL_LINE0
+ pixRst<20> pixRst<21> col_periphery_1x2_9/COL_LINE1 OffBn openDVS_pixel2x2_top_483/vpd[2]
+ openDVS_pixel2x2_top_483/vpd[3] openDVS_pixel2x2_top_483/vpd[1] openDVS_pixel2x2_top_483/vpd[0]
+ rowReadON<31> rowReadOFF<30> openDVS_pixel2x2_top_991/GndD DiffBn GndA OnBn VddA18
+ openDVS_pixel2x2_top
XopenDVS_pixel2x2_top_472 rowReadOFF<39> rowReadON<38> RefrBp PrBp PrSFBp col_periphery_1x2_13/COL_LINE0
+ pixRst<28> pixRst<29> col_periphery_1x2_13/COL_LINE1 OffBn openDVS_pixel2x2_top_472/vpd[2]
+ openDVS_pixel2x2_top_472/vpd[3] openDVS_pixel2x2_top_472/vpd[1] openDVS_pixel2x2_top_472/vpd[0]
+ rowReadON<39> rowReadOFF<38> openDVS_pixel2x2_top_999/GndD DiffBn GndA OnBn VddA18
+ openDVS_pixel2x2_top
XopenDVS_pixel2x2_top_461 rowReadOFF<37> rowReadON<36> RefrBp PrBp PrSFBp col_periphery_1x2_11/COL_LINE0
+ pixRst<24> pixRst<25> col_periphery_1x2_11/COL_LINE1 OffBn openDVS_pixel2x2_top_461/vpd[2]
+ openDVS_pixel2x2_top_461/vpd[3] openDVS_pixel2x2_top_461/vpd[1] openDVS_pixel2x2_top_461/vpd[0]
+ rowReadON<37> rowReadOFF<36> openDVS_pixel2x2_top_997/GndD DiffBn GndA OnBn VddA18
+ openDVS_pixel2x2_top
XopenDVS_pixel2x2_top_450 rowReadOFF<35> rowReadON<34> RefrBp PrBp PrSFBp col_periphery_1x2_8/COL_LINE0
+ pixRst<18> pixRst<19> col_periphery_1x2_8/COL_LINE1 OffBn openDVS_pixel2x2_top_450/vpd[2]
+ openDVS_pixel2x2_top_450/vpd[3] openDVS_pixel2x2_top_450/vpd[1] openDVS_pixel2x2_top_450/vpd[0]
+ rowReadON<35> rowReadOFF<34> openDVS_pixel2x2_top_995/GndD DiffBn GndA OnBn VddA18
+ openDVS_pixel2x2_top
XopenDVS_pixel2x2_top_494 rowReadOFF<45> rowReadON<44> RefrBp PrBp PrSFBp col_periphery_1x2_0/COL_LINE0
+ pixRst<10> pixRst<11> col_periphery_1x2_0/COL_LINE1 OffBn openDVS_pixel2x2_top_494/vpd[2]
+ openDVS_pixel2x2_top_494/vpd[3] openDVS_pixel2x2_top_494/vpd[1] openDVS_pixel2x2_top_494/vpd[0]
+ rowReadON<45> rowReadOFF<44> openDVS_pixel2x2_top_539/GndD DiffBn GndA OnBn VddA18
+ openDVS_pixel2x2_top
XopenDVS_pixel2x2_top_280 rowReadOFF<55> rowReadON<54> RefrBp PrBp PrSFBp col_periphery_1x2_13/COL_LINE0
+ pixRst<28> pixRst<29> col_periphery_1x2_13/COL_LINE1 OffBn openDVS_pixel2x2_top_280/vpd[2]
+ openDVS_pixel2x2_top_280/vpd[3] openDVS_pixel2x2_top_280/vpd[1] openDVS_pixel2x2_top_280/vpd[0]
+ rowReadON<55> rowReadOFF<54> openDVS_pixel2x2_top_67/GndD DiffBn GndA OnBn VddA18
+ openDVS_pixel2x2_top
XopenDVS_pixel2x2_top_291 rowReadOFF<59> rowReadON<58> RefrBp PrBp PrSFBp col_periphery_1x2_9/COL_LINE0
+ pixRst<20> pixRst<21> col_periphery_1x2_9/COL_LINE1 OffBn openDVS_pixel2x2_top_291/vpd[2]
+ openDVS_pixel2x2_top_291/vpd[3] openDVS_pixel2x2_top_291/vpd[1] openDVS_pixel2x2_top_291/vpd[0]
+ rowReadON<59> rowReadOFF<58> openDVS_pixel2x2_top_74/GndD DiffBn GndA OnBn VddA18
+ openDVS_pixel2x2_top
XopenDVS_pixel2x2_top_857 rowReadOFF<3> rowReadON<2> RefrBp PrBp PrSFBp col_periphery_1x2_25/COL_LINE0
+ pixRst<52> pixRst<53> col_periphery_1x2_25/COL_LINE1 OffBn openDVS_pixel2x2_top_857/vpd[2]
+ openDVS_pixel2x2_top_857/vpd[3] openDVS_pixel2x2_top_857/vpd[1] openDVS_pixel2x2_top_857/vpd[0]
+ rowReadON<3> rowReadOFF<2> openDVS_pixel2x2_top_933/GndD DiffBn GndA OnBn VddA18
+ openDVS_pixel2x2_top
XopenDVS_pixel2x2_top_868 rowReadOFF<1> rowReadON<0> RefrBp PrBp PrSFBp col_periphery_1x2_24/COL_LINE0
+ pixRst<50> pixRst<51> col_periphery_1x2_24/COL_LINE1 OffBn openDVS_pixel2x2_top_868/vpd[2]
+ openDVS_pixel2x2_top_868/vpd[3] openDVS_pixel2x2_top_868/vpd[1] openDVS_pixel2x2_top_868/vpd[0]
+ rowReadON<1> rowReadOFF<0> openDVS_pixel2x2_top_931/GndD DiffBn GndA OnBn VddA18
+ openDVS_pixel2x2_top
XopenDVS_pixel2x2_top_846 rowReadOFF<1> rowReadON<0> RefrBp PrBp PrSFBp col_periphery_1x2_22/COL_LINE0
+ pixRst<44> pixRst<45> col_periphery_1x2_22/COL_LINE1 OffBn openDVS_pixel2x2_top_846/vpd[2]
+ openDVS_pixel2x2_top_846/vpd[3] openDVS_pixel2x2_top_846/vpd[1] openDVS_pixel2x2_top_846/vpd[0]
+ rowReadON<1> rowReadOFF<0> openDVS_pixel2x2_top_931/GndD DiffBn GndA OnBn VddA18
+ openDVS_pixel2x2_top
XopenDVS_pixel2x2_top_879 rowReadOFF<7> rowReadON<6> RefrBp PrBp PrSFBp col_periphery_1x2_21/COL_LINE0
+ pixRst<42> pixRst<43> col_periphery_1x2_21/COL_LINE1 OffBn openDVS_pixel2x2_top_879/vpd[2]
+ openDVS_pixel2x2_top_879/vpd[3] openDVS_pixel2x2_top_879/vpd[1] openDVS_pixel2x2_top_879/vpd[0]
+ rowReadON<7> rowReadOFF<6> openDVS_pixel2x2_top_937/GndD DiffBn GndA OnBn VddA18
+ openDVS_pixel2x2_top
XopenDVS_pixel2x2_top_813 rowReadOFF<15> rowReadON<14> RefrBp PrBp PrSFBp col_periphery_1x2_21/COL_LINE0
+ pixRst<42> pixRst<43> col_periphery_1x2_21/COL_LINE1 OffBn openDVS_pixel2x2_top_813/vpd[2]
+ openDVS_pixel2x2_top_813/vpd[3] openDVS_pixel2x2_top_813/vpd[1] openDVS_pixel2x2_top_813/vpd[0]
+ rowReadON<15> rowReadOFF<14> openDVS_pixel2x2_top_945/GndD DiffBn GndA OnBn VddA18
+ openDVS_pixel2x2_top
XopenDVS_pixel2x2_top_824 rowReadOFF<17> rowReadON<16> RefrBp PrBp PrSFBp col_periphery_1x2_22/COL_LINE0
+ pixRst<44> pixRst<45> col_periphery_1x2_22/COL_LINE1 OffBn openDVS_pixel2x2_top_824/vpd[2]
+ openDVS_pixel2x2_top_824/vpd[3] openDVS_pixel2x2_top_824/vpd[1] openDVS_pixel2x2_top_824/vpd[0]
+ rowReadON<17> rowReadOFF<16> openDVS_pixel2x2_top_947/GndD DiffBn GndA OnBn VddA18
+ openDVS_pixel2x2_top
XopenDVS_pixel2x2_top_802 rowReadOFF<13> rowReadON<12> RefrBp PrBp PrSFBp col_periphery_1x2_20/COL_LINE0
+ pixRst<40> pixRst<41> col_periphery_1x2_20/COL_LINE1 OffBn openDVS_pixel2x2_top_802/vpd[2]
+ openDVS_pixel2x2_top_802/vpd[3] openDVS_pixel2x2_top_802/vpd[1] openDVS_pixel2x2_top_802/vpd[0]
+ rowReadON<13> rowReadOFF<12> openDVS_pixel2x2_top_943/GndD DiffBn GndA OnBn VddA18
+ openDVS_pixel2x2_top
XopenDVS_pixel2x2_top_835 rowReadOFF<23> rowReadON<22> RefrBp PrBp PrSFBp col_periphery_1x2_20/COL_LINE0
+ pixRst<40> pixRst<41> col_periphery_1x2_20/COL_LINE1 OffBn openDVS_pixel2x2_top_835/vpd[2]
+ openDVS_pixel2x2_top_835/vpd[3] openDVS_pixel2x2_top_835/vpd[1] openDVS_pixel2x2_top_835/vpd[0]
+ rowReadON<23> rowReadOFF<22> openDVS_pixel2x2_top_953/GndD DiffBn GndA OnBn VddA18
+ openDVS_pixel2x2_top
XopenDVS_pixel2x2_top_109 rowReadOFF<49> rowReadON<48> RefrBp PrBp PrSFBp col_periphery_1x2_22/COL_LINE0
+ pixRst<44> pixRst<45> col_periphery_1x2_22/COL_LINE1 OffBn openDVS_pixel2x2_top_109/vpd[2]
+ openDVS_pixel2x2_top_109/vpd[3] openDVS_pixel2x2_top_109/vpd[1] openDVS_pixel2x2_top_109/vpd[0]
+ rowReadON<49> rowReadOFF<48> openDVS_pixel2x2_top_3/GndD DiffBn GndA OnBn VddA18
+ openDVS_pixel2x2_top
XopenDVS_pixel2x2_top_665 rowReadOFF<5> rowReadON<4> RefrBp PrBp PrSFBp col_periphery_1x2_13/COL_LINE0
+ pixRst<28> pixRst<29> col_periphery_1x2_13/COL_LINE1 OffBn openDVS_pixel2x2_top_665/vpd[2]
+ openDVS_pixel2x2_top_665/vpd[3] openDVS_pixel2x2_top_665/vpd[1] openDVS_pixel2x2_top_665/vpd[0]
+ rowReadON<5> rowReadOFF<4> openDVS_pixel2x2_top_935/GndD DiffBn GndA OnBn VddA18
+ openDVS_pixel2x2_top
XopenDVS_pixel2x2_top_676 rowReadOFF<3> rowReadON<2> RefrBp PrBp PrSFBp col_periphery_1x2_8/COL_LINE0
+ pixRst<18> pixRst<19> col_periphery_1x2_8/COL_LINE1 OffBn openDVS_pixel2x2_top_676/vpd[2]
+ openDVS_pixel2x2_top_676/vpd[3] openDVS_pixel2x2_top_676/vpd[1] openDVS_pixel2x2_top_676/vpd[0]
+ rowReadON<3> rowReadOFF<2> openDVS_pixel2x2_top_933/GndD DiffBn GndA OnBn VddA18
+ openDVS_pixel2x2_top
XopenDVS_pixel2x2_top_698 rowReadOFF<7> rowReadON<6> RefrBp PrBp PrSFBp col_periphery_1x2_15/COL_LINE0
+ pixRst<14> pixRst<15> col_periphery_1x2_15/COL_LINE1 OffBn openDVS_pixel2x2_top_698/vpd[2]
+ openDVS_pixel2x2_top_698/vpd[3] openDVS_pixel2x2_top_698/vpd[1] openDVS_pixel2x2_top_698/vpd[0]
+ rowReadON<7> rowReadOFF<6> openDVS_pixel2x2_top_937/GndD DiffBn GndA OnBn VddA18
+ openDVS_pixel2x2_top
XopenDVS_pixel2x2_top_687 rowReadOFF<7> rowReadON<6> RefrBp PrBp PrSFBp col_periphery_1x2_6/COL_LINE0
+ pixRst<8> pixRst<9> col_periphery_1x2_6/COL_LINE1 OffBn openDVS_pixel2x2_top_687/vpd[2]
+ openDVS_pixel2x2_top_687/vpd[3] openDVS_pixel2x2_top_687/vpd[1] openDVS_pixel2x2_top_687/vpd[0]
+ rowReadON<7> rowReadOFF<6> openDVS_pixel2x2_top_937/GndD DiffBn GndA OnBn VddA18
+ openDVS_pixel2x2_top
XopenDVS_pixel2x2_top_654 rowReadOFF<1> rowReadON<0> RefrBp PrBp PrSFBp col_periphery_1x2_4/COL_LINE0
+ pixRst<4> pixRst<5> col_periphery_1x2_4/COL_LINE1 OffBn openDVS_pixel2x2_top_654/vpd[2]
+ openDVS_pixel2x2_top_654/vpd[3] openDVS_pixel2x2_top_654/vpd[1] openDVS_pixel2x2_top_654/vpd[0]
+ rowReadON<1> rowReadOFF<0> openDVS_pixel2x2_top_931/GndD DiffBn GndA OnBn VddA18
+ openDVS_pixel2x2_top
XopenDVS_pixel2x2_top_621 rowReadOFF<13> rowReadON<12> RefrBp PrBp PrSFBp col_periphery_1x2_6/COL_LINE0
+ pixRst<8> pixRst<9> col_periphery_1x2_6/COL_LINE1 OffBn openDVS_pixel2x2_top_621/vpd[2]
+ openDVS_pixel2x2_top_621/vpd[3] openDVS_pixel2x2_top_621/vpd[1] openDVS_pixel2x2_top_621/vpd[0]
+ rowReadON<13> rowReadOFF<12> openDVS_pixel2x2_top_943/GndD DiffBn GndA OnBn VddA18
+ openDVS_pixel2x2_top
XopenDVS_pixel2x2_top_632 rowReadOFF<13> rowReadON<12> RefrBp PrBp PrSFBp col_periphery_1x2_2/COL_LINE0
+ pixRst<0> pixRst<1> col_periphery_1x2_2/COL_LINE1 OffBn openDVS_pixel2x2_top_632/vpd[2]
+ openDVS_pixel2x2_top_632/vpd[3] openDVS_pixel2x2_top_632/vpd[1] openDVS_pixel2x2_top_632/vpd[0]
+ rowReadON<13> rowReadOFF<12> openDVS_pixel2x2_top_943/GndD DiffBn GndA OnBn VddA18
+ openDVS_pixel2x2_top
XopenDVS_pixel2x2_top_610 rowReadOFF<25> rowReadON<24> RefrBp PrBp PrSFBp col_periphery_1x2_0/COL_LINE0
+ pixRst<10> pixRst<11> col_periphery_1x2_0/COL_LINE1 OffBn openDVS_pixel2x2_top_610/vpd[2]
+ openDVS_pixel2x2_top_610/vpd[3] openDVS_pixel2x2_top_610/vpd[1] openDVS_pixel2x2_top_610/vpd[0]
+ rowReadON<25> rowReadOFF<24> openDVS_pixel2x2_top_955/GndD DiffBn GndA OnBn VddA18
+ openDVS_pixel2x2_top
XopenDVS_pixel2x2_top_643 rowReadOFF<23> rowReadON<22> RefrBp PrBp PrSFBp col_periphery_1x2_2/COL_LINE0
+ pixRst<0> pixRst<1> col_periphery_1x2_2/COL_LINE1 OffBn openDVS_pixel2x2_top_643/vpd[2]
+ openDVS_pixel2x2_top_643/vpd[3] openDVS_pixel2x2_top_643/vpd[1] openDVS_pixel2x2_top_643/vpd[0]
+ rowReadON<23> rowReadOFF<22> openDVS_pixel2x2_top_953/GndD DiffBn GndA OnBn VddA18
+ openDVS_pixel2x2_top
XopenDVS_pixel2x2_top_2 rowReadOFF<49> rowReadON<48> RefrBp PrBp PrSFBp col_periphery_1x2_29/COL_LINE0
+ pixRst<60> pixRst<61> col_periphery_1x2_29/COL_LINE1 OffBn openDVS_pixel2x2_top_2/vpd[2]
+ openDVS_pixel2x2_top_2/vpd[3] openDVS_pixel2x2_top_2/vpd[1] openDVS_pixel2x2_top_2/vpd[0]
+ rowReadON<49> rowReadOFF<48> openDVS_pixel2x2_top_3/GndD DiffBn GndA OnBn VddA18
+ openDVS_pixel2x2_top
XopenDVS_pixel2x2_top_484 rowReadOFF<31> rowReadON<30> RefrBp PrBp PrSFBp col_periphery_1x2_10/COL_LINE0
+ pixRst<22> pixRst<23> col_periphery_1x2_10/COL_LINE1 OffBn openDVS_pixel2x2_top_484/vpd[2]
+ openDVS_pixel2x2_top_484/vpd[3] openDVS_pixel2x2_top_484/vpd[1] openDVS_pixel2x2_top_484/vpd[0]
+ rowReadON<31> rowReadOFF<30> openDVS_pixel2x2_top_991/GndD DiffBn GndA OnBn VddA18
+ openDVS_pixel2x2_top
XopenDVS_pixel2x2_top_462 rowReadOFF<37> rowReadON<36> RefrBp PrBp PrSFBp col_periphery_1x2_12/COL_LINE0
+ pixRst<26> pixRst<27> col_periphery_1x2_12/COL_LINE1 OffBn openDVS_pixel2x2_top_462/vpd[2]
+ openDVS_pixel2x2_top_462/vpd[3] openDVS_pixel2x2_top_462/vpd[1] openDVS_pixel2x2_top_462/vpd[0]
+ rowReadON<37> rowReadOFF<36> openDVS_pixel2x2_top_997/GndD DiffBn GndA OnBn VddA18
+ openDVS_pixel2x2_top
XopenDVS_pixel2x2_top_451 rowReadOFF<35> rowReadON<34> RefrBp PrBp PrSFBp col_periphery_1x2_9/COL_LINE0
+ pixRst<20> pixRst<21> col_periphery_1x2_9/COL_LINE1 OffBn openDVS_pixel2x2_top_451/vpd[2]
+ openDVS_pixel2x2_top_451/vpd[3] openDVS_pixel2x2_top_451/vpd[1] openDVS_pixel2x2_top_451/vpd[0]
+ rowReadON<35> rowReadOFF<34> openDVS_pixel2x2_top_995/GndD DiffBn GndA OnBn VddA18
+ openDVS_pixel2x2_top
XopenDVS_pixel2x2_top_495 rowReadOFF<45> rowReadON<44> RefrBp PrBp PrSFBp col_periphery_1x2_1/COL_LINE0
+ pixRst<12> pixRst<13> col_periphery_1x2_1/COL_LINE1 OffBn openDVS_pixel2x2_top_495/vpd[2]
+ openDVS_pixel2x2_top_495/vpd[3] openDVS_pixel2x2_top_495/vpd[1] openDVS_pixel2x2_top_495/vpd[0]
+ rowReadON<45> rowReadOFF<44> openDVS_pixel2x2_top_539/GndD DiffBn GndA OnBn VddA18
+ openDVS_pixel2x2_top
XopenDVS_pixel2x2_top_473 rowReadOFF<43> rowReadON<42> RefrBp PrBp PrSFBp col_periphery_1x2_9/COL_LINE0
+ pixRst<20> pixRst<21> col_periphery_1x2_9/COL_LINE1 OffBn openDVS_pixel2x2_top_473/vpd[2]
+ openDVS_pixel2x2_top_473/vpd[3] openDVS_pixel2x2_top_473/vpd[1] openDVS_pixel2x2_top_473/vpd[0]
+ rowReadON<43> rowReadOFF<42> openDVS_pixel2x2_top_537/GndD DiffBn GndA OnBn VddA18
+ openDVS_pixel2x2_top
XopenDVS_pixel2x2_top_440 rowReadOFF<37> rowReadON<36> RefrBp PrBp PrSFBp col_periphery_1x2_1/COL_LINE0
+ pixRst<12> pixRst<13> col_periphery_1x2_1/COL_LINE1 OffBn openDVS_pixel2x2_top_440/vpd[2]
+ openDVS_pixel2x2_top_440/vpd[3] openDVS_pixel2x2_top_440/vpd[1] openDVS_pixel2x2_top_440/vpd[0]
+ rowReadON<37> rowReadOFF<36> openDVS_pixel2x2_top_997/GndD DiffBn GndA OnBn VddA18
+ openDVS_pixel2x2_top
XopenDVS_pixel2x2_top_270 rowReadOFF<55> rowReadON<54> RefrBp PrBp PrSFBp col_periphery_1x2_9/COL_LINE0
+ pixRst<20> pixRst<21> col_periphery_1x2_9/COL_LINE1 OffBn openDVS_pixel2x2_top_270/vpd[2]
+ openDVS_pixel2x2_top_270/vpd[3] openDVS_pixel2x2_top_270/vpd[1] openDVS_pixel2x2_top_270/vpd[0]
+ rowReadON<55> rowReadOFF<54> openDVS_pixel2x2_top_67/GndD DiffBn GndA OnBn VddA18
+ openDVS_pixel2x2_top
XopenDVS_pixel2x2_top_292 rowReadOFF<59> rowReadON<58> RefrBp PrBp PrSFBp col_periphery_1x2_10/COL_LINE0
+ pixRst<22> pixRst<23> col_periphery_1x2_10/COL_LINE1 OffBn openDVS_pixel2x2_top_292/vpd[2]
+ openDVS_pixel2x2_top_292/vpd[3] openDVS_pixel2x2_top_292/vpd[1] openDVS_pixel2x2_top_292/vpd[0]
+ rowReadON<59> rowReadOFF<58> openDVS_pixel2x2_top_74/GndD DiffBn GndA OnBn VddA18
+ openDVS_pixel2x2_top
XopenDVS_pixel2x2_top_281 rowReadOFF<61> rowReadON<60> RefrBp PrBp PrSFBp col_periphery_1x2_8/COL_LINE0
+ pixRst<18> pixRst<19> col_periphery_1x2_8/COL_LINE1 OffBn openDVS_pixel2x2_top_281/vpd[2]
+ openDVS_pixel2x2_top_281/vpd[3] openDVS_pixel2x2_top_281/vpd[1] openDVS_pixel2x2_top_281/vpd[0]
+ rowReadON<61> rowReadOFF<60> openDVS_pixel2x2_top_96/GndD DiffBn GndA OnBn VddA18
+ openDVS_pixel2x2_top
XopenDVS_pixel2x2_top_858 rowReadOFF<3> rowReadON<2> RefrBp PrBp PrSFBp col_periphery_1x2_26/COL_LINE0
+ pixRst<54> pixRst<55> col_periphery_1x2_26/COL_LINE1 OffBn openDVS_pixel2x2_top_858/vpd[2]
+ openDVS_pixel2x2_top_858/vpd[3] openDVS_pixel2x2_top_858/vpd[1] openDVS_pixel2x2_top_858/vpd[0]
+ rowReadON<3> rowReadOFF<2> openDVS_pixel2x2_top_933/GndD DiffBn GndA OnBn VddA18
+ openDVS_pixel2x2_top
XopenDVS_pixel2x2_top_869 rowReadOFF<1> rowReadON<0> RefrBp PrBp PrSFBp col_periphery_1x2_25/COL_LINE0
+ pixRst<52> pixRst<53> col_periphery_1x2_25/COL_LINE1 OffBn openDVS_pixel2x2_top_869/vpd[2]
+ openDVS_pixel2x2_top_869/vpd[3] openDVS_pixel2x2_top_869/vpd[1] openDVS_pixel2x2_top_869/vpd[0]
+ rowReadON<1> rowReadOFF<0> openDVS_pixel2x2_top_931/GndD DiffBn GndA OnBn VddA18
+ openDVS_pixel2x2_top
XopenDVS_pixel2x2_top_847 rowReadOFF<3> rowReadON<2> RefrBp PrBp PrSFBp col_periphery_1x2_18/COL_LINE0
+ pixRst<36> pixRst<37> col_periphery_1x2_18/COL_LINE1 OffBn openDVS_pixel2x2_top_847/vpd[2]
+ openDVS_pixel2x2_top_847/vpd[3] openDVS_pixel2x2_top_847/vpd[1] openDVS_pixel2x2_top_847/vpd[0]
+ rowReadON<3> rowReadOFF<2> openDVS_pixel2x2_top_933/GndD DiffBn GndA OnBn VddA18
+ openDVS_pixel2x2_top
XopenDVS_pixel2x2_top_803 rowReadOFF<13> rowReadON<12> RefrBp PrBp PrSFBp col_periphery_1x2_21/COL_LINE0
+ pixRst<42> pixRst<43> col_periphery_1x2_21/COL_LINE1 OffBn openDVS_pixel2x2_top_803/vpd[2]
+ openDVS_pixel2x2_top_803/vpd[3] openDVS_pixel2x2_top_803/vpd[1] openDVS_pixel2x2_top_803/vpd[0]
+ rowReadON<13> rowReadOFF<12> openDVS_pixel2x2_top_943/GndD DiffBn GndA OnBn VddA18
+ openDVS_pixel2x2_top
XopenDVS_pixel2x2_top_814 rowReadOFF<15> rowReadON<14> RefrBp PrBp PrSFBp col_periphery_1x2_22/COL_LINE0
+ pixRst<44> pixRst<45> col_periphery_1x2_22/COL_LINE1 OffBn openDVS_pixel2x2_top_814/vpd[2]
+ openDVS_pixel2x2_top_814/vpd[3] openDVS_pixel2x2_top_814/vpd[1] openDVS_pixel2x2_top_814/vpd[0]
+ rowReadON<15> rowReadOFF<14> openDVS_pixel2x2_top_945/GndD DiffBn GndA OnBn VddA18
+ openDVS_pixel2x2_top
XopenDVS_pixel2x2_top_825 rowReadOFF<23> rowReadON<22> RefrBp PrBp PrSFBp col_periphery_1x2_22/COL_LINE0
+ pixRst<44> pixRst<45> col_periphery_1x2_22/COL_LINE1 OffBn openDVS_pixel2x2_top_825/vpd[2]
+ openDVS_pixel2x2_top_825/vpd[3] openDVS_pixel2x2_top_825/vpd[1] openDVS_pixel2x2_top_825/vpd[0]
+ rowReadON<23> rowReadOFF<22> openDVS_pixel2x2_top_953/GndD DiffBn GndA OnBn VddA18
+ openDVS_pixel2x2_top
XopenDVS_pixel2x2_top_836 rowReadOFF<25> rowReadON<24> RefrBp PrBp PrSFBp col_periphery_1x2_17/COL_LINE0
+ pixRst<34> pixRst<35> col_periphery_1x2_17/COL_LINE1 OffBn openDVS_pixel2x2_top_836/vpd[2]
+ openDVS_pixel2x2_top_836/vpd[3] openDVS_pixel2x2_top_836/vpd[1] openDVS_pixel2x2_top_836/vpd[0]
+ rowReadON<25> rowReadOFF<24> openDVS_pixel2x2_top_955/GndD DiffBn GndA OnBn VddA18
+ openDVS_pixel2x2_top
XopenDVS_pixel2x2_top_655 rowReadOFF<1> rowReadON<0> RefrBp PrBp PrSFBp col_periphery_1x2_5/COL_LINE0
+ pixRst<6> pixRst<7> col_periphery_1x2_5/COL_LINE1 OffBn openDVS_pixel2x2_top_655/vpd[2]
+ openDVS_pixel2x2_top_655/vpd[3] openDVS_pixel2x2_top_655/vpd[1] openDVS_pixel2x2_top_655/vpd[0]
+ rowReadON<1> rowReadOFF<0> openDVS_pixel2x2_top_931/GndD DiffBn GndA OnBn VddA18
+ openDVS_pixel2x2_top
XopenDVS_pixel2x2_top_644 rowReadOFF<5> rowReadON<4> RefrBp PrBp PrSFBp col_periphery_1x2_4/COL_LINE0
+ pixRst<4> pixRst<5> col_periphery_1x2_4/COL_LINE1 OffBn openDVS_pixel2x2_top_644/vpd[2]
+ openDVS_pixel2x2_top_644/vpd[3] openDVS_pixel2x2_top_644/vpd[1] openDVS_pixel2x2_top_644/vpd[0]
+ rowReadON<5> rowReadOFF<4> openDVS_pixel2x2_top_935/GndD DiffBn GndA OnBn VddA18
+ openDVS_pixel2x2_top
XopenDVS_pixel2x2_top_600 rowReadOFF<17> rowReadON<16> RefrBp PrBp PrSFBp col_periphery_1x2_4/COL_LINE0
+ pixRst<4> pixRst<5> col_periphery_1x2_4/COL_LINE1 OffBn openDVS_pixel2x2_top_600/vpd[2]
+ openDVS_pixel2x2_top_600/vpd[3] openDVS_pixel2x2_top_600/vpd[1] openDVS_pixel2x2_top_600/vpd[0]
+ rowReadON<17> rowReadOFF<16> openDVS_pixel2x2_top_947/GndD DiffBn GndA OnBn VddA18
+ openDVS_pixel2x2_top
XopenDVS_pixel2x2_top_611 rowReadOFF<25> rowReadON<24> RefrBp PrBp PrSFBp col_periphery_1x2_1/COL_LINE0
+ pixRst<12> pixRst<13> col_periphery_1x2_1/COL_LINE1 OffBn openDVS_pixel2x2_top_611/vpd[2]
+ openDVS_pixel2x2_top_611/vpd[3] openDVS_pixel2x2_top_611/vpd[1] openDVS_pixel2x2_top_611/vpd[0]
+ rowReadON<25> rowReadOFF<24> openDVS_pixel2x2_top_955/GndD DiffBn GndA OnBn VddA18
+ openDVS_pixel2x2_top
XopenDVS_pixel2x2_top_633 rowReadOFF<25> rowReadON<24> RefrBp PrBp PrSFBp col_periphery_1x2_3/COL_LINE0
+ pixRst<2> pixRst<3> col_periphery_1x2_3/COL_LINE1 OffBn openDVS_pixel2x2_top_633/vpd[2]
+ openDVS_pixel2x2_top_633/vpd[3] openDVS_pixel2x2_top_633/vpd[1] openDVS_pixel2x2_top_633/vpd[0]
+ rowReadON<25> rowReadOFF<24> openDVS_pixel2x2_top_955/GndD DiffBn GndA OnBn VddA18
+ openDVS_pixel2x2_top
XopenDVS_pixel2x2_top_622 rowReadOFF<25> rowReadON<24> RefrBp PrBp PrSFBp col_periphery_1x2_2/COL_LINE0
+ pixRst<0> pixRst<1> col_periphery_1x2_2/COL_LINE1 OffBn openDVS_pixel2x2_top_622/vpd[2]
+ openDVS_pixel2x2_top_622/vpd[3] openDVS_pixel2x2_top_622/vpd[1] openDVS_pixel2x2_top_622/vpd[0]
+ rowReadON<25> rowReadOFF<24> openDVS_pixel2x2_top_955/GndD DiffBn GndA OnBn VddA18
+ openDVS_pixel2x2_top
XopenDVS_pixel2x2_top_677 rowReadOFF<3> rowReadON<2> RefrBp PrBp PrSFBp col_periphery_1x2_9/COL_LINE0
+ pixRst<20> pixRst<21> col_periphery_1x2_9/COL_LINE1 OffBn openDVS_pixel2x2_top_677/vpd[2]
+ openDVS_pixel2x2_top_677/vpd[3] openDVS_pixel2x2_top_677/vpd[1] openDVS_pixel2x2_top_677/vpd[0]
+ rowReadON<3> rowReadOFF<2> openDVS_pixel2x2_top_933/GndD DiffBn GndA OnBn VddA18
+ openDVS_pixel2x2_top
XopenDVS_pixel2x2_top_666 rowReadOFF<1> rowReadON<0> RefrBp PrBp PrSFBp col_periphery_1x2_8/COL_LINE0
+ pixRst<18> pixRst<19> col_periphery_1x2_8/COL_LINE1 OffBn openDVS_pixel2x2_top_666/vpd[2]
+ openDVS_pixel2x2_top_666/vpd[3] openDVS_pixel2x2_top_666/vpd[1] openDVS_pixel2x2_top_666/vpd[0]
+ rowReadON<1> rowReadOFF<0> openDVS_pixel2x2_top_931/GndD DiffBn GndA OnBn VddA18
+ openDVS_pixel2x2_top
XopenDVS_pixel2x2_top_699 rowReadOFF<7> rowReadON<6> RefrBp PrBp PrSFBp col_periphery_1x2_7/COL_LINE0
+ pixRst<16> pixRst<17> col_periphery_1x2_7/COL_LINE1 OffBn openDVS_pixel2x2_top_699/vpd[2]
+ openDVS_pixel2x2_top_699/vpd[3] openDVS_pixel2x2_top_699/vpd[1] openDVS_pixel2x2_top_699/vpd[0]
+ rowReadON<7> rowReadOFF<6> openDVS_pixel2x2_top_937/GndD DiffBn GndA OnBn VddA18
+ openDVS_pixel2x2_top
XopenDVS_pixel2x2_top_688 rowReadOFF<7> rowReadON<6> RefrBp PrBp PrSFBp col_periphery_1x2_0/COL_LINE0
+ pixRst<10> pixRst<11> col_periphery_1x2_0/COL_LINE1 OffBn openDVS_pixel2x2_top_688/vpd[2]
+ openDVS_pixel2x2_top_688/vpd[3] openDVS_pixel2x2_top_688/vpd[1] openDVS_pixel2x2_top_688/vpd[0]
+ rowReadON<7> rowReadOFF<6> openDVS_pixel2x2_top_937/GndD DiffBn GndA OnBn VddA18
+ openDVS_pixel2x2_top
XopenDVS_pixel2x2_top_3 rowReadOFF<49> rowReadON<48> RefrBp PrBp PrSFBp col_periphery_1x2_30/COL_LINE0
+ pixRst<62> pixRst<63> col_periphery_1x2_30/COL_LINE1 OffBn openDVS_pixel2x2_top_3/vpd[2]
+ openDVS_pixel2x2_top_3/vpd[3] openDVS_pixel2x2_top_3/vpd[1] openDVS_pixel2x2_top_3/vpd[0]
+ rowReadON<49> rowReadOFF<48> openDVS_pixel2x2_top_3/GndD DiffBn GndA OnBn VddA18
+ openDVS_pixel2x2_top
XopenDVS_pixel2x2_top_485 rowReadOFF<31> rowReadON<30> RefrBp PrBp PrSFBp col_periphery_1x2_11/COL_LINE0
+ pixRst<24> pixRst<25> col_periphery_1x2_11/COL_LINE1 OffBn openDVS_pixel2x2_top_485/vpd[2]
+ openDVS_pixel2x2_top_485/vpd[3] openDVS_pixel2x2_top_485/vpd[1] openDVS_pixel2x2_top_485/vpd[0]
+ rowReadON<31> rowReadOFF<30> openDVS_pixel2x2_top_991/GndD DiffBn GndA OnBn VddA18
+ openDVS_pixel2x2_top
XopenDVS_pixel2x2_top_474 rowReadOFF<29> rowReadON<28> RefrBp PrBp PrSFBp col_periphery_1x2_8/COL_LINE0
+ pixRst<18> pixRst<19> col_periphery_1x2_8/COL_LINE1 OffBn openDVS_pixel2x2_top_474/vpd[2]
+ openDVS_pixel2x2_top_474/vpd[3] openDVS_pixel2x2_top_474/vpd[1] openDVS_pixel2x2_top_474/vpd[0]
+ rowReadON<29> rowReadOFF<28> openDVS_pixel2x2_top_989/GndD DiffBn GndA OnBn VddA18
+ openDVS_pixel2x2_top
XopenDVS_pixel2x2_top_463 rowReadOFF<37> rowReadON<36> RefrBp PrBp PrSFBp col_periphery_1x2_13/COL_LINE0
+ pixRst<28> pixRst<29> col_periphery_1x2_13/COL_LINE1 OffBn openDVS_pixel2x2_top_463/vpd[2]
+ openDVS_pixel2x2_top_463/vpd[3] openDVS_pixel2x2_top_463/vpd[1] openDVS_pixel2x2_top_463/vpd[0]
+ rowReadON<37> rowReadOFF<36> openDVS_pixel2x2_top_997/GndD DiffBn GndA OnBn VddA18
+ openDVS_pixel2x2_top
XopenDVS_pixel2x2_top_452 rowReadOFF<35> rowReadON<34> RefrBp PrBp PrSFBp col_periphery_1x2_10/COL_LINE0
+ pixRst<22> pixRst<23> col_periphery_1x2_10/COL_LINE1 OffBn openDVS_pixel2x2_top_452/vpd[2]
+ openDVS_pixel2x2_top_452/vpd[3] openDVS_pixel2x2_top_452/vpd[1] openDVS_pixel2x2_top_452/vpd[0]
+ rowReadON<35> rowReadOFF<34> openDVS_pixel2x2_top_995/GndD DiffBn GndA OnBn VddA18
+ openDVS_pixel2x2_top
XopenDVS_pixel2x2_top_441 rowReadOFF<43> rowReadON<42> RefrBp PrBp PrSFBp col_periphery_1x2_4/COL_LINE0
+ pixRst<4> pixRst<5> col_periphery_1x2_4/COL_LINE1 OffBn openDVS_pixel2x2_top_441/vpd[2]
+ openDVS_pixel2x2_top_441/vpd[3] openDVS_pixel2x2_top_441/vpd[1] openDVS_pixel2x2_top_441/vpd[0]
+ rowReadON<43> rowReadOFF<42> openDVS_pixel2x2_top_537/GndD DiffBn GndA OnBn VddA18
+ openDVS_pixel2x2_top
XopenDVS_pixel2x2_top_496 rowReadOFF<45> rowReadON<44> RefrBp PrBp PrSFBp col_periphery_1x2_15/COL_LINE0
+ pixRst<14> pixRst<15> col_periphery_1x2_15/COL_LINE1 OffBn openDVS_pixel2x2_top_496/vpd[2]
+ openDVS_pixel2x2_top_496/vpd[3] openDVS_pixel2x2_top_496/vpd[1] openDVS_pixel2x2_top_496/vpd[0]
+ rowReadON<45> rowReadOFF<44> openDVS_pixel2x2_top_539/GndD DiffBn GndA OnBn VddA18
+ openDVS_pixel2x2_top
XopenDVS_pixel2x2_top_430 rowReadOFF<37> rowReadON<36> RefrBp PrBp PrSFBp col_periphery_1x2_5/COL_LINE0
+ pixRst<6> pixRst<7> col_periphery_1x2_5/COL_LINE1 OffBn openDVS_pixel2x2_top_430/vpd[2]
+ openDVS_pixel2x2_top_430/vpd[3] openDVS_pixel2x2_top_430/vpd[1] openDVS_pixel2x2_top_430/vpd[0]
+ rowReadON<37> rowReadOFF<36> openDVS_pixel2x2_top_997/GndD DiffBn GndA OnBn VddA18
+ openDVS_pixel2x2_top
XopenDVS_pixel2x2_top_271 rowReadOFF<55> rowReadON<54> RefrBp PrBp PrSFBp col_periphery_1x2_10/COL_LINE0
+ pixRst<22> pixRst<23> col_periphery_1x2_10/COL_LINE1 OffBn openDVS_pixel2x2_top_271/vpd[2]
+ openDVS_pixel2x2_top_271/vpd[3] openDVS_pixel2x2_top_271/vpd[1] openDVS_pixel2x2_top_271/vpd[0]
+ rowReadON<55> rowReadOFF<54> openDVS_pixel2x2_top_67/GndD DiffBn GndA OnBn VddA18
+ openDVS_pixel2x2_top
XopenDVS_pixel2x2_top_282 rowReadOFF<63> rowReadON<62> RefrBp PrBp PrSFBp col_periphery_1x2_10/COL_LINE0
+ pixRst<22> pixRst<23> col_periphery_1x2_10/COL_LINE1 OffBn openDVS_pixel2x2_top_282/vpd[2]
+ openDVS_pixel2x2_top_282/vpd[3] openDVS_pixel2x2_top_282/vpd[1] openDVS_pixel2x2_top_282/vpd[0]
+ rowReadON<63> rowReadOFF<62> openDVS_pixel2x2_top_82/GndD DiffBn GndA OnBn VddA18
+ openDVS_pixel2x2_top
XopenDVS_pixel2x2_top_293 rowReadOFF<53> rowReadON<52> RefrBp PrBp PrSFBp col_periphery_1x2_8/COL_LINE0
+ pixRst<18> pixRst<19> col_periphery_1x2_8/COL_LINE1 OffBn openDVS_pixel2x2_top_293/vpd[2]
+ openDVS_pixel2x2_top_293/vpd[3] openDVS_pixel2x2_top_293/vpd[1] openDVS_pixel2x2_top_293/vpd[0]
+ rowReadON<53> rowReadOFF<52> openDVS_pixel2x2_top_99/GndD DiffBn GndA OnBn VddA18
+ openDVS_pixel2x2_top
XopenDVS_pixel2x2_top_260 rowReadOFF<55> rowReadON<54> RefrBp PrBp PrSFBp col_periphery_1x2_23/COL_LINE0
+ pixRst<46> pixRst<47> col_periphery_1x2_23/COL_LINE1 OffBn openDVS_pixel2x2_top_260/vpd[2]
+ openDVS_pixel2x2_top_260/vpd[3] openDVS_pixel2x2_top_260/vpd[1] openDVS_pixel2x2_top_260/vpd[0]
+ rowReadON<55> rowReadOFF<54> openDVS_pixel2x2_top_67/GndD DiffBn GndA OnBn VddA18
+ openDVS_pixel2x2_top
XopenDVS_pixel2x2_top_859 rowReadOFF<3> rowReadON<2> RefrBp PrBp PrSFBp col_periphery_1x2_27/COL_LINE0
+ pixRst<56> pixRst<57> col_periphery_1x2_27/COL_LINE1 OffBn openDVS_pixel2x2_top_859/vpd[2]
+ openDVS_pixel2x2_top_859/vpd[3] openDVS_pixel2x2_top_859/vpd[1] openDVS_pixel2x2_top_859/vpd[0]
+ rowReadON<3> rowReadOFF<2> openDVS_pixel2x2_top_933/GndD DiffBn GndA OnBn VddA18
+ openDVS_pixel2x2_top
XopenDVS_pixel2x2_top_848 rowReadOFF<3> rowReadON<2> RefrBp PrBp PrSFBp col_periphery_1x2_19/COL_LINE0
+ pixRst<38> pixRst<39> col_periphery_1x2_19/COL_LINE1 OffBn openDVS_pixel2x2_top_848/vpd[2]
+ openDVS_pixel2x2_top_848/vpd[3] openDVS_pixel2x2_top_848/vpd[1] openDVS_pixel2x2_top_848/vpd[0]
+ rowReadON<3> rowReadOFF<2> openDVS_pixel2x2_top_933/GndD DiffBn GndA OnBn VddA18
+ openDVS_pixel2x2_top
XopenDVS_pixel2x2_top_804 rowReadOFF<13> rowReadON<12> RefrBp PrBp PrSFBp col_periphery_1x2_22/COL_LINE0
+ pixRst<44> pixRst<45> col_periphery_1x2_22/COL_LINE1 OffBn openDVS_pixel2x2_top_804/vpd[2]
+ openDVS_pixel2x2_top_804/vpd[3] openDVS_pixel2x2_top_804/vpd[1] openDVS_pixel2x2_top_804/vpd[0]
+ rowReadON<13> rowReadOFF<12> openDVS_pixel2x2_top_943/GndD DiffBn GndA OnBn VddA18
+ openDVS_pixel2x2_top
XopenDVS_pixel2x2_top_837 rowReadOFF<11> rowReadON<10> RefrBp PrBp PrSFBp col_periphery_1x2_17/COL_LINE0
+ pixRst<34> pixRst<35> col_periphery_1x2_17/COL_LINE1 OffBn openDVS_pixel2x2_top_837/vpd[2]
+ openDVS_pixel2x2_top_837/vpd[3] openDVS_pixel2x2_top_837/vpd[1] openDVS_pixel2x2_top_837/vpd[0]
+ rowReadON<11> rowReadOFF<10> openDVS_pixel2x2_top_941/GndD DiffBn GndA OnBn VddA18
+ openDVS_pixel2x2_top
XopenDVS_pixel2x2_top_815 rowReadOFF<21> rowReadON<20> RefrBp PrBp PrSFBp col_periphery_1x2_21/COL_LINE0
+ pixRst<42> pixRst<43> col_periphery_1x2_21/COL_LINE1 OffBn openDVS_pixel2x2_top_815/vpd[2]
+ openDVS_pixel2x2_top_815/vpd[3] openDVS_pixel2x2_top_815/vpd[1] openDVS_pixel2x2_top_815/vpd[0]
+ rowReadON<21> rowReadOFF<20> openDVS_pixel2x2_top_951/GndD DiffBn GndA OnBn VddA18
+ openDVS_pixel2x2_top
XopenDVS_pixel2x2_top_826 rowReadOFF<23> rowReadON<22> RefrBp PrBp PrSFBp col_periphery_1x2_17/COL_LINE0
+ pixRst<34> pixRst<35> col_periphery_1x2_17/COL_LINE1 OffBn openDVS_pixel2x2_top_826/vpd[2]
+ openDVS_pixel2x2_top_826/vpd[3] openDVS_pixel2x2_top_826/vpd[1] openDVS_pixel2x2_top_826/vpd[0]
+ rowReadON<23> rowReadOFF<22> openDVS_pixel2x2_top_953/GndD DiffBn GndA OnBn VddA18
+ openDVS_pixel2x2_top
XopenDVS_pixel2x2_top_667 rowReadOFF<1> rowReadON<0> RefrBp PrBp PrSFBp col_periphery_1x2_9/COL_LINE0
+ pixRst<20> pixRst<21> col_periphery_1x2_9/COL_LINE1 OffBn openDVS_pixel2x2_top_667/vpd[2]
+ openDVS_pixel2x2_top_667/vpd[3] openDVS_pixel2x2_top_667/vpd[1] openDVS_pixel2x2_top_667/vpd[0]
+ rowReadON<1> rowReadOFF<0> openDVS_pixel2x2_top_931/GndD DiffBn GndA OnBn VddA18
+ openDVS_pixel2x2_top
XopenDVS_pixel2x2_top_678 rowReadOFF<3> rowReadON<2> RefrBp PrBp PrSFBp col_periphery_1x2_10/COL_LINE0
+ pixRst<22> pixRst<23> col_periphery_1x2_10/COL_LINE1 OffBn openDVS_pixel2x2_top_678/vpd[2]
+ openDVS_pixel2x2_top_678/vpd[3] openDVS_pixel2x2_top_678/vpd[1] openDVS_pixel2x2_top_678/vpd[0]
+ rowReadON<3> rowReadOFF<2> openDVS_pixel2x2_top_933/GndD DiffBn GndA OnBn VddA18
+ openDVS_pixel2x2_top
XopenDVS_pixel2x2_top_689 rowReadOFF<7> rowReadON<6> RefrBp PrBp PrSFBp col_periphery_1x2_1/COL_LINE0
+ pixRst<12> pixRst<13> col_periphery_1x2_1/COL_LINE1 OffBn openDVS_pixel2x2_top_689/vpd[2]
+ openDVS_pixel2x2_top_689/vpd[3] openDVS_pixel2x2_top_689/vpd[1] openDVS_pixel2x2_top_689/vpd[0]
+ rowReadON<7> rowReadOFF<6> openDVS_pixel2x2_top_937/GndD DiffBn GndA OnBn VddA18
+ openDVS_pixel2x2_top
XopenDVS_pixel2x2_top_656 rowReadOFF<1> rowReadON<0> RefrBp PrBp PrSFBp col_periphery_1x2_6/COL_LINE0
+ pixRst<8> pixRst<9> col_periphery_1x2_6/COL_LINE1 OffBn openDVS_pixel2x2_top_656/vpd[2]
+ openDVS_pixel2x2_top_656/vpd[3] openDVS_pixel2x2_top_656/vpd[1] openDVS_pixel2x2_top_656/vpd[0]
+ rowReadON<1> rowReadOFF<0> openDVS_pixel2x2_top_931/GndD DiffBn GndA OnBn VddA18
+ openDVS_pixel2x2_top
XopenDVS_pixel2x2_top_645 rowReadOFF<5> rowReadON<4> RefrBp PrBp PrSFBp col_periphery_1x2_5/COL_LINE0
+ pixRst<6> pixRst<7> col_periphery_1x2_5/COL_LINE1 OffBn openDVS_pixel2x2_top_645/vpd[2]
+ openDVS_pixel2x2_top_645/vpd[3] openDVS_pixel2x2_top_645/vpd[1] openDVS_pixel2x2_top_645/vpd[0]
+ rowReadON<5> rowReadOFF<4> openDVS_pixel2x2_top_935/GndD DiffBn GndA OnBn VddA18
+ openDVS_pixel2x2_top
XopenDVS_pixel2x2_top_601 rowReadOFF<17> rowReadON<16> RefrBp PrBp PrSFBp col_periphery_1x2_5/COL_LINE0
+ pixRst<6> pixRst<7> col_periphery_1x2_5/COL_LINE1 OffBn openDVS_pixel2x2_top_601/vpd[2]
+ openDVS_pixel2x2_top_601/vpd[3] openDVS_pixel2x2_top_601/vpd[1] openDVS_pixel2x2_top_601/vpd[0]
+ rowReadON<17> rowReadOFF<16> openDVS_pixel2x2_top_947/GndD DiffBn GndA OnBn VddA18
+ openDVS_pixel2x2_top
XopenDVS_pixel2x2_top_612 rowReadOFF<15> rowReadON<14> RefrBp PrBp PrSFBp col_periphery_1x2_5/COL_LINE0
+ pixRst<6> pixRst<7> col_periphery_1x2_5/COL_LINE1 OffBn openDVS_pixel2x2_top_612/vpd[2]
+ openDVS_pixel2x2_top_612/vpd[3] openDVS_pixel2x2_top_612/vpd[1] openDVS_pixel2x2_top_612/vpd[0]
+ rowReadON<15> rowReadOFF<14> openDVS_pixel2x2_top_945/GndD DiffBn GndA OnBn VddA18
+ openDVS_pixel2x2_top
XopenDVS_pixel2x2_top_623 rowReadOFF<11> rowReadON<10> RefrBp PrBp PrSFBp col_periphery_1x2_2/COL_LINE0
+ pixRst<0> pixRst<1> col_periphery_1x2_2/COL_LINE1 OffBn openDVS_pixel2x2_top_623/vpd[2]
+ openDVS_pixel2x2_top_623/vpd[3] openDVS_pixel2x2_top_623/vpd[1] openDVS_pixel2x2_top_623/vpd[0]
+ rowReadON<11> rowReadOFF<10> openDVS_pixel2x2_top_941/GndD DiffBn GndA OnBn VddA18
+ openDVS_pixel2x2_top
XopenDVS_pixel2x2_top_634 rowReadOFF<25> rowReadON<24> RefrBp PrBp PrSFBp col_periphery_1x2_4/COL_LINE0
+ pixRst<4> pixRst<5> col_periphery_1x2_4/COL_LINE1 OffBn openDVS_pixel2x2_top_634/vpd[2]
+ openDVS_pixel2x2_top_634/vpd[3] openDVS_pixel2x2_top_634/vpd[1] openDVS_pixel2x2_top_634/vpd[0]
+ rowReadON<25> rowReadOFF<24> openDVS_pixel2x2_top_955/GndD DiffBn GndA OnBn VddA18
+ openDVS_pixel2x2_top
XopenDVS_pixel2x2_top_4 rowReadOFF<51> rowReadON<50> RefrBp PrBp PrSFBp col_periphery_1x2_28/COL_LINE0
+ pixRst<58> pixRst<59> col_periphery_1x2_28/COL_LINE1 OffBn openDVS_pixel2x2_top_4/vpd[2]
+ openDVS_pixel2x2_top_4/vpd[3] openDVS_pixel2x2_top_4/vpd[1] openDVS_pixel2x2_top_4/vpd[0]
+ rowReadON<51> rowReadOFF<50> openDVS_pixel2x2_top_6/GndD DiffBn GndA OnBn VddA18
+ openDVS_pixel2x2_top
XopenDVS_pixel2x2_top_486 rowReadOFF<31> rowReadON<30> RefrBp PrBp PrSFBp col_periphery_1x2_12/COL_LINE0
+ pixRst<26> pixRst<27> col_periphery_1x2_12/COL_LINE1 OffBn openDVS_pixel2x2_top_486/vpd[2]
+ openDVS_pixel2x2_top_486/vpd[3] openDVS_pixel2x2_top_486/vpd[1] openDVS_pixel2x2_top_486/vpd[0]
+ rowReadON<31> rowReadOFF<30> openDVS_pixel2x2_top_991/GndD DiffBn GndA OnBn VddA18
+ openDVS_pixel2x2_top
XopenDVS_pixel2x2_top_475 rowReadOFF<29> rowReadON<28> RefrBp PrBp PrSFBp col_periphery_1x2_9/COL_LINE0
+ pixRst<20> pixRst<21> col_periphery_1x2_9/COL_LINE1 OffBn openDVS_pixel2x2_top_475/vpd[2]
+ openDVS_pixel2x2_top_475/vpd[3] openDVS_pixel2x2_top_475/vpd[1] openDVS_pixel2x2_top_475/vpd[0]
+ rowReadON<29> rowReadOFF<28> openDVS_pixel2x2_top_989/GndD DiffBn GndA OnBn VddA18
+ openDVS_pixel2x2_top
XopenDVS_pixel2x2_top_420 rowReadOFF<29> rowReadON<28> RefrBp PrBp PrSFBp col_periphery_1x2_6/COL_LINE0
+ pixRst<8> pixRst<9> col_periphery_1x2_6/COL_LINE1 OffBn openDVS_pixel2x2_top_420/vpd[2]
+ openDVS_pixel2x2_top_420/vpd[3] openDVS_pixel2x2_top_420/vpd[1] openDVS_pixel2x2_top_420/vpd[0]
+ rowReadON<29> rowReadOFF<28> openDVS_pixel2x2_top_989/GndD DiffBn GndA OnBn VddA18
+ openDVS_pixel2x2_top
XopenDVS_pixel2x2_top_431 rowReadOFF<31> rowReadON<30> RefrBp PrBp PrSFBp col_periphery_1x2_2/COL_LINE0
+ pixRst<0> pixRst<1> col_periphery_1x2_2/COL_LINE1 OffBn openDVS_pixel2x2_top_431/vpd[2]
+ openDVS_pixel2x2_top_431/vpd[3] openDVS_pixel2x2_top_431/vpd[1] openDVS_pixel2x2_top_431/vpd[0]
+ rowReadON<31> rowReadOFF<30> openDVS_pixel2x2_top_991/GndD DiffBn GndA OnBn VddA18
+ openDVS_pixel2x2_top
XopenDVS_pixel2x2_top_453 rowReadOFF<35> rowReadON<34> RefrBp PrBp PrSFBp col_periphery_1x2_11/COL_LINE0
+ pixRst<24> pixRst<25> col_periphery_1x2_11/COL_LINE1 OffBn openDVS_pixel2x2_top_453/vpd[2]
+ openDVS_pixel2x2_top_453/vpd[3] openDVS_pixel2x2_top_453/vpd[1] openDVS_pixel2x2_top_453/vpd[0]
+ rowReadON<35> rowReadOFF<34> openDVS_pixel2x2_top_995/GndD DiffBn GndA OnBn VddA18
+ openDVS_pixel2x2_top
XopenDVS_pixel2x2_top_442 rowReadOFF<43> rowReadON<42> RefrBp PrBp PrSFBp col_periphery_1x2_5/COL_LINE0
+ pixRst<6> pixRst<7> col_periphery_1x2_5/COL_LINE1 OffBn openDVS_pixel2x2_top_442/vpd[2]
+ openDVS_pixel2x2_top_442/vpd[3] openDVS_pixel2x2_top_442/vpd[1] openDVS_pixel2x2_top_442/vpd[0]
+ rowReadON<43> rowReadOFF<42> openDVS_pixel2x2_top_537/GndD DiffBn GndA OnBn VddA18
+ openDVS_pixel2x2_top
XopenDVS_pixel2x2_top_497 rowReadOFF<45> rowReadON<44> RefrBp PrBp PrSFBp col_periphery_1x2_7/COL_LINE0
+ pixRst<16> pixRst<17> col_periphery_1x2_7/COL_LINE1 OffBn openDVS_pixel2x2_top_497/vpd[2]
+ openDVS_pixel2x2_top_497/vpd[3] openDVS_pixel2x2_top_497/vpd[1] openDVS_pixel2x2_top_497/vpd[0]
+ rowReadON<45> rowReadOFF<44> openDVS_pixel2x2_top_539/GndD DiffBn GndA OnBn VddA18
+ openDVS_pixel2x2_top
XopenDVS_pixel2x2_top_464 rowReadOFF<43> rowReadON<42> RefrBp PrBp PrSFBp col_periphery_1x2_12/COL_LINE0
+ pixRst<26> pixRst<27> col_periphery_1x2_12/COL_LINE1 OffBn openDVS_pixel2x2_top_464/vpd[2]
+ openDVS_pixel2x2_top_464/vpd[3] openDVS_pixel2x2_top_464/vpd[1] openDVS_pixel2x2_top_464/vpd[0]
+ rowReadON<43> rowReadOFF<42> openDVS_pixel2x2_top_537/GndD DiffBn GndA OnBn VddA18
+ openDVS_pixel2x2_top
XopenDVS_pixel2x2_top_283 rowReadOFF<61> rowReadON<60> RefrBp PrBp PrSFBp col_periphery_1x2_13/COL_LINE0
+ pixRst<28> pixRst<29> col_periphery_1x2_13/COL_LINE1 OffBn openDVS_pixel2x2_top_283/vpd[2]
+ openDVS_pixel2x2_top_283/vpd[3] openDVS_pixel2x2_top_283/vpd[1] openDVS_pixel2x2_top_283/vpd[0]
+ rowReadON<61> rowReadOFF<60> openDVS_pixel2x2_top_96/GndD DiffBn GndA OnBn VddA18
+ openDVS_pixel2x2_top
XopenDVS_pixel2x2_top_272 rowReadOFF<55> rowReadON<54> RefrBp PrBp PrSFBp col_periphery_1x2_11/COL_LINE0
+ pixRst<24> pixRst<25> col_periphery_1x2_11/COL_LINE1 OffBn openDVS_pixel2x2_top_272/vpd[2]
+ openDVS_pixel2x2_top_272/vpd[3] openDVS_pixel2x2_top_272/vpd[1] openDVS_pixel2x2_top_272/vpd[0]
+ rowReadON<55> rowReadOFF<54> openDVS_pixel2x2_top_67/GndD DiffBn GndA OnBn VddA18
+ openDVS_pixel2x2_top
XopenDVS_pixel2x2_top_294 rowReadOFF<47> rowReadON<46> RefrBp PrBp PrSFBp col_periphery_1x2_8/COL_LINE0
+ pixRst<18> pixRst<19> col_periphery_1x2_8/COL_LINE1 OffBn openDVS_pixel2x2_top_294/vpd[2]
+ openDVS_pixel2x2_top_294/vpd[3] openDVS_pixel2x2_top_294/vpd[1] openDVS_pixel2x2_top_294/vpd[0]
+ rowReadON<47> rowReadOFF<46> openDVS_pixel2x2_top_78/GndD DiffBn GndA OnBn VddA18
+ openDVS_pixel2x2_top
XopenDVS_pixel2x2_top_261 rowReadOFF<47> rowReadON<46> RefrBp PrBp PrSFBp col_periphery_1x2_23/COL_LINE0
+ pixRst<46> pixRst<47> col_periphery_1x2_23/COL_LINE1 OffBn openDVS_pixel2x2_top_261/vpd[2]
+ openDVS_pixel2x2_top_261/vpd[3] openDVS_pixel2x2_top_261/vpd[1] openDVS_pixel2x2_top_261/vpd[0]
+ rowReadON<47> rowReadOFF<46> openDVS_pixel2x2_top_78/GndD DiffBn GndA OnBn VddA18
+ openDVS_pixel2x2_top
XopenDVS_pixel2x2_top_250 rowReadOFF<45> rowReadON<44> RefrBp PrBp PrSFBp col_periphery_1x2_27/COL_LINE0
+ pixRst<56> pixRst<57> col_periphery_1x2_27/COL_LINE1 OffBn openDVS_pixel2x2_top_250/vpd[2]
+ openDVS_pixel2x2_top_250/vpd[3] openDVS_pixel2x2_top_250/vpd[1] openDVS_pixel2x2_top_250/vpd[0]
+ rowReadON<45> rowReadOFF<44> openDVS_pixel2x2_top_539/GndD DiffBn GndA OnBn VddA18
+ openDVS_pixel2x2_top
XopenDVS_pixel2x2_top_849 rowReadOFF<3> rowReadON<2> RefrBp PrBp PrSFBp col_periphery_1x2_20/COL_LINE0
+ pixRst<40> pixRst<41> col_periphery_1x2_20/COL_LINE1 OffBn openDVS_pixel2x2_top_849/vpd[2]
+ openDVS_pixel2x2_top_849/vpd[3] openDVS_pixel2x2_top_849/vpd[1] openDVS_pixel2x2_top_849/vpd[0]
+ rowReadON<3> rowReadOFF<2> openDVS_pixel2x2_top_933/GndD DiffBn GndA OnBn VddA18
+ openDVS_pixel2x2_top
XopenDVS_pixel2x2_top_838 rowReadOFF<11> rowReadON<10> RefrBp PrBp PrSFBp col_periphery_1x2_18/COL_LINE0
+ pixRst<36> pixRst<37> col_periphery_1x2_18/COL_LINE1 OffBn openDVS_pixel2x2_top_838/vpd[2]
+ openDVS_pixel2x2_top_838/vpd[3] openDVS_pixel2x2_top_838/vpd[1] openDVS_pixel2x2_top_838/vpd[0]
+ rowReadON<11> rowReadOFF<10> openDVS_pixel2x2_top_941/GndD DiffBn GndA OnBn VddA18
+ openDVS_pixel2x2_top
XopenDVS_pixel2x2_top_816 rowReadOFF<21> rowReadON<20> RefrBp PrBp PrSFBp col_periphery_1x2_22/COL_LINE0
+ pixRst<44> pixRst<45> col_periphery_1x2_22/COL_LINE1 OffBn openDVS_pixel2x2_top_816/vpd[2]
+ openDVS_pixel2x2_top_816/vpd[3] openDVS_pixel2x2_top_816/vpd[1] openDVS_pixel2x2_top_816/vpd[0]
+ rowReadON<21> rowReadOFF<20> openDVS_pixel2x2_top_951/GndD DiffBn GndA OnBn VddA18
+ openDVS_pixel2x2_top
XopenDVS_pixel2x2_top_805 rowReadOFF<21> rowReadON<20> RefrBp PrBp PrSFBp col_periphery_1x2_19/COL_LINE0
+ pixRst<38> pixRst<39> col_periphery_1x2_19/COL_LINE1 OffBn openDVS_pixel2x2_top_805/vpd[2]
+ openDVS_pixel2x2_top_805/vpd[3] openDVS_pixel2x2_top_805/vpd[1] openDVS_pixel2x2_top_805/vpd[0]
+ rowReadON<21> rowReadOFF<20> openDVS_pixel2x2_top_951/GndD DiffBn GndA OnBn VddA18
+ openDVS_pixel2x2_top
XopenDVS_pixel2x2_top_827 rowReadOFF<23> rowReadON<22> RefrBp PrBp PrSFBp col_periphery_1x2_18/COL_LINE0
+ pixRst<36> pixRst<37> col_periphery_1x2_18/COL_LINE1 OffBn openDVS_pixel2x2_top_827/vpd[2]
+ openDVS_pixel2x2_top_827/vpd[3] openDVS_pixel2x2_top_827/vpd[1] openDVS_pixel2x2_top_827/vpd[0]
+ rowReadON<23> rowReadOFF<22> openDVS_pixel2x2_top_953/GndD DiffBn GndA OnBn VddA18
+ openDVS_pixel2x2_top
XopenDVS_pixel2x2_top_679 rowReadOFF<3> rowReadON<2> RefrBp PrBp PrSFBp col_periphery_1x2_11/COL_LINE0
+ pixRst<24> pixRst<25> col_periphery_1x2_11/COL_LINE1 OffBn openDVS_pixel2x2_top_679/vpd[2]
+ openDVS_pixel2x2_top_679/vpd[3] openDVS_pixel2x2_top_679/vpd[1] openDVS_pixel2x2_top_679/vpd[0]
+ rowReadON<3> rowReadOFF<2> openDVS_pixel2x2_top_933/GndD DiffBn GndA OnBn VddA18
+ openDVS_pixel2x2_top
XopenDVS_pixel2x2_top_668 rowReadOFF<1> rowReadON<0> RefrBp PrBp PrSFBp col_periphery_1x2_10/COL_LINE0
+ pixRst<22> pixRst<23> col_periphery_1x2_10/COL_LINE1 OffBn openDVS_pixel2x2_top_668/vpd[2]
+ openDVS_pixel2x2_top_668/vpd[3] openDVS_pixel2x2_top_668/vpd[1] openDVS_pixel2x2_top_668/vpd[0]
+ rowReadON<1> rowReadOFF<0> openDVS_pixel2x2_top_931/GndD DiffBn GndA OnBn VddA18
+ openDVS_pixel2x2_top
XopenDVS_pixel2x2_top_657 rowReadOFF<1> rowReadON<0> RefrBp PrBp PrSFBp col_periphery_1x2_0/COL_LINE0
+ pixRst<10> pixRst<11> col_periphery_1x2_0/COL_LINE1 OffBn openDVS_pixel2x2_top_657/vpd[2]
+ openDVS_pixel2x2_top_657/vpd[3] openDVS_pixel2x2_top_657/vpd[1] openDVS_pixel2x2_top_657/vpd[0]
+ rowReadON<1> rowReadOFF<0> openDVS_pixel2x2_top_931/GndD DiffBn GndA OnBn VddA18
+ openDVS_pixel2x2_top
XopenDVS_pixel2x2_top_646 rowReadOFF<5> rowReadON<4> RefrBp PrBp PrSFBp col_periphery_1x2_6/COL_LINE0
+ pixRst<8> pixRst<9> col_periphery_1x2_6/COL_LINE1 OffBn openDVS_pixel2x2_top_646/vpd[2]
+ openDVS_pixel2x2_top_646/vpd[3] openDVS_pixel2x2_top_646/vpd[1] openDVS_pixel2x2_top_646/vpd[0]
+ rowReadON<5> rowReadOFF<4> openDVS_pixel2x2_top_935/GndD DiffBn GndA OnBn VddA18
+ openDVS_pixel2x2_top
XopenDVS_pixel2x2_top_602 rowReadOFF<17> rowReadON<16> RefrBp PrBp PrSFBp col_periphery_1x2_6/COL_LINE0
+ pixRst<8> pixRst<9> col_periphery_1x2_6/COL_LINE1 OffBn openDVS_pixel2x2_top_602/vpd[2]
+ openDVS_pixel2x2_top_602/vpd[3] openDVS_pixel2x2_top_602/vpd[1] openDVS_pixel2x2_top_602/vpd[0]
+ rowReadON<17> rowReadOFF<16> openDVS_pixel2x2_top_947/GndD DiffBn GndA OnBn VddA18
+ openDVS_pixel2x2_top
XopenDVS_pixel2x2_top_613 rowReadOFF<13> rowReadON<12> RefrBp PrBp PrSFBp col_periphery_1x2_5/COL_LINE0
+ pixRst<6> pixRst<7> col_periphery_1x2_5/COL_LINE1 OffBn openDVS_pixel2x2_top_613/vpd[2]
+ openDVS_pixel2x2_top_613/vpd[3] openDVS_pixel2x2_top_613/vpd[1] openDVS_pixel2x2_top_613/vpd[0]
+ rowReadON<13> rowReadOFF<12> openDVS_pixel2x2_top_943/GndD DiffBn GndA OnBn VddA18
+ openDVS_pixel2x2_top
XopenDVS_pixel2x2_top_624 rowReadOFF<11> rowReadON<10> RefrBp PrBp PrSFBp col_periphery_1x2_3/COL_LINE0
+ pixRst<2> pixRst<3> col_periphery_1x2_3/COL_LINE1 OffBn openDVS_pixel2x2_top_624/vpd[2]
+ openDVS_pixel2x2_top_624/vpd[3] openDVS_pixel2x2_top_624/vpd[1] openDVS_pixel2x2_top_624/vpd[0]
+ rowReadON<11> rowReadOFF<10> openDVS_pixel2x2_top_941/GndD DiffBn GndA OnBn VddA18
+ openDVS_pixel2x2_top
XopenDVS_pixel2x2_top_635 rowReadOFF<25> rowReadON<24> RefrBp PrBp PrSFBp col_periphery_1x2_5/COL_LINE0
+ pixRst<6> pixRst<7> col_periphery_1x2_5/COL_LINE1 OffBn openDVS_pixel2x2_top_635/vpd[2]
+ openDVS_pixel2x2_top_635/vpd[3] openDVS_pixel2x2_top_635/vpd[1] openDVS_pixel2x2_top_635/vpd[0]
+ rowReadON<25> rowReadOFF<24> openDVS_pixel2x2_top_955/GndD DiffBn GndA OnBn VddA18
+ openDVS_pixel2x2_top
XopenDVS_pixel2x2_top_5 rowReadOFF<51> rowReadON<50> RefrBp PrBp PrSFBp col_periphery_1x2_29/COL_LINE0
+ pixRst<60> pixRst<61> col_periphery_1x2_29/COL_LINE1 OffBn openDVS_pixel2x2_top_5/vpd[2]
+ openDVS_pixel2x2_top_5/vpd[3] openDVS_pixel2x2_top_5/vpd[1] openDVS_pixel2x2_top_5/vpd[0]
+ rowReadON<51> rowReadOFF<50> openDVS_pixel2x2_top_6/GndD DiffBn GndA OnBn VddA18
+ openDVS_pixel2x2_top
XopenDVS_pixel2x2_top_421 rowReadOFF<29> rowReadON<28> RefrBp PrBp PrSFBp col_periphery_1x2_0/COL_LINE0
+ pixRst<10> pixRst<11> col_periphery_1x2_0/COL_LINE1 OffBn openDVS_pixel2x2_top_421/vpd[2]
+ openDVS_pixel2x2_top_421/vpd[3] openDVS_pixel2x2_top_421/vpd[1] openDVS_pixel2x2_top_421/vpd[0]
+ rowReadON<29> rowReadOFF<28> openDVS_pixel2x2_top_989/GndD DiffBn GndA OnBn VddA18
+ openDVS_pixel2x2_top
XopenDVS_pixel2x2_top_410 rowReadOFF<35> rowReadON<34> RefrBp PrBp PrSFBp col_periphery_1x2_0/COL_LINE0
+ pixRst<10> pixRst<11> col_periphery_1x2_0/COL_LINE1 OffBn openDVS_pixel2x2_top_410/vpd[2]
+ openDVS_pixel2x2_top_410/vpd[3] openDVS_pixel2x2_top_410/vpd[1] openDVS_pixel2x2_top_410/vpd[0]
+ rowReadON<35> rowReadOFF<34> openDVS_pixel2x2_top_995/GndD DiffBn GndA OnBn VddA18
+ openDVS_pixel2x2_top
XopenDVS_pixel2x2_top_487 rowReadOFF<31> rowReadON<30> RefrBp PrBp PrSFBp col_periphery_1x2_13/COL_LINE0
+ pixRst<28> pixRst<29> col_periphery_1x2_13/COL_LINE1 OffBn openDVS_pixel2x2_top_487/vpd[2]
+ openDVS_pixel2x2_top_487/vpd[3] openDVS_pixel2x2_top_487/vpd[1] openDVS_pixel2x2_top_487/vpd[0]
+ rowReadON<31> rowReadOFF<30> openDVS_pixel2x2_top_991/GndD DiffBn GndA OnBn VddA18
+ openDVS_pixel2x2_top
XopenDVS_pixel2x2_top_476 rowReadOFF<29> rowReadON<28> RefrBp PrBp PrSFBp col_periphery_1x2_10/COL_LINE0
+ pixRst<22> pixRst<23> col_periphery_1x2_10/COL_LINE1 OffBn openDVS_pixel2x2_top_476/vpd[2]
+ openDVS_pixel2x2_top_476/vpd[3] openDVS_pixel2x2_top_476/vpd[1] openDVS_pixel2x2_top_476/vpd[0]
+ rowReadON<29> rowReadOFF<28> openDVS_pixel2x2_top_989/GndD DiffBn GndA OnBn VddA18
+ openDVS_pixel2x2_top
XopenDVS_pixel2x2_top_432 rowReadOFF<31> rowReadON<30> RefrBp PrBp PrSFBp col_periphery_1x2_3/COL_LINE0
+ pixRst<2> pixRst<3> col_periphery_1x2_3/COL_LINE1 OffBn openDVS_pixel2x2_top_432/vpd[2]
+ openDVS_pixel2x2_top_432/vpd[3] openDVS_pixel2x2_top_432/vpd[1] openDVS_pixel2x2_top_432/vpd[0]
+ rowReadON<31> rowReadOFF<30> openDVS_pixel2x2_top_991/GndD DiffBn GndA OnBn VddA18
+ openDVS_pixel2x2_top
XopenDVS_pixel2x2_top_454 rowReadOFF<35> rowReadON<34> RefrBp PrBp PrSFBp col_periphery_1x2_12/COL_LINE0
+ pixRst<26> pixRst<27> col_periphery_1x2_12/COL_LINE1 OffBn openDVS_pixel2x2_top_454/vpd[2]
+ openDVS_pixel2x2_top_454/vpd[3] openDVS_pixel2x2_top_454/vpd[1] openDVS_pixel2x2_top_454/vpd[0]
+ rowReadON<35> rowReadOFF<34> openDVS_pixel2x2_top_995/GndD DiffBn GndA OnBn VddA18
+ openDVS_pixel2x2_top
XopenDVS_pixel2x2_top_443 rowReadOFF<33> rowReadON<32> RefrBp PrBp PrSFBp col_periphery_1x2_9/COL_LINE0
+ pixRst<20> pixRst<21> col_periphery_1x2_9/COL_LINE1 OffBn openDVS_pixel2x2_top_443/vpd[2]
+ openDVS_pixel2x2_top_443/vpd[3] openDVS_pixel2x2_top_443/vpd[1] openDVS_pixel2x2_top_443/vpd[0]
+ rowReadON<33> rowReadOFF<32> openDVS_pixel2x2_top_993/GndD DiffBn GndA OnBn VddA18
+ openDVS_pixel2x2_top
XopenDVS_pixel2x2_top_498 rowReadOFF<45> rowReadON<44> RefrBp PrBp PrSFBp col_periphery_1x2_8/COL_LINE0
+ pixRst<18> pixRst<19> col_periphery_1x2_8/COL_LINE1 OffBn openDVS_pixel2x2_top_498/vpd[2]
+ openDVS_pixel2x2_top_498/vpd[3] openDVS_pixel2x2_top_498/vpd[1] openDVS_pixel2x2_top_498/vpd[0]
+ rowReadON<45> rowReadOFF<44> openDVS_pixel2x2_top_539/GndD DiffBn GndA OnBn VddA18
+ openDVS_pixel2x2_top
XopenDVS_pixel2x2_top_465 rowReadOFF<43> rowReadON<42> RefrBp PrBp PrSFBp col_periphery_1x2_13/COL_LINE0
+ pixRst<28> pixRst<29> col_periphery_1x2_13/COL_LINE1 OffBn openDVS_pixel2x2_top_465/vpd[2]
+ openDVS_pixel2x2_top_465/vpd[3] openDVS_pixel2x2_top_465/vpd[1] openDVS_pixel2x2_top_465/vpd[0]
+ rowReadON<43> rowReadOFF<42> openDVS_pixel2x2_top_537/GndD DiffBn GndA OnBn VddA18
+ openDVS_pixel2x2_top
XopenDVS_pixel2x2_top_273 rowReadOFF<55> rowReadON<54> RefrBp PrBp PrSFBp col_periphery_1x2_12/COL_LINE0
+ pixRst<26> pixRst<27> col_periphery_1x2_12/COL_LINE1 OffBn openDVS_pixel2x2_top_273/vpd[2]
+ openDVS_pixel2x2_top_273/vpd[3] openDVS_pixel2x2_top_273/vpd[1] openDVS_pixel2x2_top_273/vpd[0]
+ rowReadON<55> rowReadOFF<54> openDVS_pixel2x2_top_67/GndD DiffBn GndA OnBn VddA18
+ openDVS_pixel2x2_top
XopenDVS_pixel2x2_top_284 rowReadOFF<63> rowReadON<62> RefrBp PrBp PrSFBp col_periphery_1x2_12/COL_LINE0
+ pixRst<26> pixRst<27> col_periphery_1x2_12/COL_LINE1 OffBn openDVS_pixel2x2_top_284/vpd[2]
+ openDVS_pixel2x2_top_284/vpd[3] openDVS_pixel2x2_top_284/vpd[1] openDVS_pixel2x2_top_284/vpd[0]
+ rowReadON<63> rowReadOFF<62> openDVS_pixel2x2_top_82/GndD DiffBn GndA OnBn VddA18
+ openDVS_pixel2x2_top
XopenDVS_pixel2x2_top_295 rowReadOFF<47> rowReadON<46> RefrBp PrBp PrSFBp col_periphery_1x2_9/COL_LINE0
+ pixRst<20> pixRst<21> col_periphery_1x2_9/COL_LINE1 OffBn openDVS_pixel2x2_top_295/vpd[2]
+ openDVS_pixel2x2_top_295/vpd[3] openDVS_pixel2x2_top_295/vpd[1] openDVS_pixel2x2_top_295/vpd[0]
+ rowReadON<47> rowReadOFF<46> openDVS_pixel2x2_top_78/GndD DiffBn GndA OnBn VddA18
+ openDVS_pixel2x2_top
XopenDVS_pixel2x2_top_240 rowReadOFF<45> rowReadON<44> RefrBp PrBp PrSFBp col_periphery_1x2_18/COL_LINE0
+ pixRst<36> pixRst<37> col_periphery_1x2_18/COL_LINE1 OffBn openDVS_pixel2x2_top_240/vpd[2]
+ openDVS_pixel2x2_top_240/vpd[3] openDVS_pixel2x2_top_240/vpd[1] openDVS_pixel2x2_top_240/vpd[0]
+ rowReadON<45> rowReadOFF<44> openDVS_pixel2x2_top_539/GndD DiffBn GndA OnBn VddA18
+ openDVS_pixel2x2_top
XopenDVS_pixel2x2_top_262 rowReadOFF<47> rowReadON<46> RefrBp PrBp PrSFBp col_periphery_1x2_31/COL_LINE0
+ pixRst<48> pixRst<49> col_periphery_1x2_31/COL_LINE1 OffBn openDVS_pixel2x2_top_262/vpd[2]
+ openDVS_pixel2x2_top_262/vpd[3] openDVS_pixel2x2_top_262/vpd[1] openDVS_pixel2x2_top_262/vpd[0]
+ rowReadON<47> rowReadOFF<46> openDVS_pixel2x2_top_78/GndD DiffBn GndA OnBn VddA18
+ openDVS_pixel2x2_top
XopenDVS_pixel2x2_top_251 rowReadOFF<45> rowReadON<44> RefrBp PrBp PrSFBp col_periphery_1x2_28/COL_LINE0
+ pixRst<58> pixRst<59> col_periphery_1x2_28/COL_LINE1 OffBn openDVS_pixel2x2_top_251/vpd[2]
+ openDVS_pixel2x2_top_251/vpd[3] openDVS_pixel2x2_top_251/vpd[1] openDVS_pixel2x2_top_251/vpd[0]
+ rowReadON<45> rowReadOFF<44> openDVS_pixel2x2_top_539/GndD DiffBn GndA OnBn VddA18
+ openDVS_pixel2x2_top
XopenDVS_pixel2x2_top_839 rowReadOFF<5> rowReadON<4> RefrBp PrBp PrSFBp col_periphery_1x2_21/COL_LINE0
+ pixRst<42> pixRst<43> col_periphery_1x2_21/COL_LINE1 OffBn openDVS_pixel2x2_top_839/vpd[2]
+ openDVS_pixel2x2_top_839/vpd[3] openDVS_pixel2x2_top_839/vpd[1] openDVS_pixel2x2_top_839/vpd[0]
+ rowReadON<5> rowReadOFF<4> openDVS_pixel2x2_top_935/GndD DiffBn GndA OnBn VddA18
+ openDVS_pixel2x2_top
XopenDVS_pixel2x2_top_828 rowReadOFF<19> rowReadON<18> RefrBp PrBp PrSFBp col_periphery_1x2_17/COL_LINE0
+ pixRst<34> pixRst<35> col_periphery_1x2_17/COL_LINE1 OffBn openDVS_pixel2x2_top_828/vpd[2]
+ openDVS_pixel2x2_top_828/vpd[3] openDVS_pixel2x2_top_828/vpd[1] openDVS_pixel2x2_top_828/vpd[0]
+ rowReadON<19> rowReadOFF<18> openDVS_pixel2x2_top_949/GndD DiffBn GndA OnBn VddA18
+ openDVS_pixel2x2_top
XopenDVS_pixel2x2_top_817 rowReadOFF<25> rowReadON<24> RefrBp PrBp PrSFBp col_periphery_1x2_22/COL_LINE0
+ pixRst<44> pixRst<45> col_periphery_1x2_22/COL_LINE1 OffBn openDVS_pixel2x2_top_817/vpd[2]
+ openDVS_pixel2x2_top_817/vpd[3] openDVS_pixel2x2_top_817/vpd[1] openDVS_pixel2x2_top_817/vpd[0]
+ rowReadON<25> rowReadOFF<24> openDVS_pixel2x2_top_955/GndD DiffBn GndA OnBn VddA18
+ openDVS_pixel2x2_top
XopenDVS_pixel2x2_top_806 rowReadOFF<21> rowReadON<20> RefrBp PrBp PrSFBp col_periphery_1x2_20/COL_LINE0
+ pixRst<40> pixRst<41> col_periphery_1x2_20/COL_LINE1 OffBn openDVS_pixel2x2_top_806/vpd[2]
+ openDVS_pixel2x2_top_806/vpd[3] openDVS_pixel2x2_top_806/vpd[1] openDVS_pixel2x2_top_806/vpd[0]
+ rowReadON<21> rowReadOFF<20> openDVS_pixel2x2_top_951/GndD DiffBn GndA OnBn VddA18
+ openDVS_pixel2x2_top
XopenDVS_pixel2x2_top_669 rowReadOFF<1> rowReadON<0> RefrBp PrBp PrSFBp col_periphery_1x2_11/COL_LINE0
+ pixRst<24> pixRst<25> col_periphery_1x2_11/COL_LINE1 OffBn openDVS_pixel2x2_top_669/vpd[2]
+ openDVS_pixel2x2_top_669/vpd[3] openDVS_pixel2x2_top_669/vpd[1] openDVS_pixel2x2_top_669/vpd[0]
+ rowReadON<1> rowReadOFF<0> openDVS_pixel2x2_top_931/GndD DiffBn GndA OnBn VddA18
+ openDVS_pixel2x2_top
XopenDVS_pixel2x2_top_658 rowReadOFF<1> rowReadON<0> RefrBp PrBp PrSFBp col_periphery_1x2_1/COL_LINE0
+ pixRst<12> pixRst<13> col_periphery_1x2_1/COL_LINE1 OffBn openDVS_pixel2x2_top_658/vpd[2]
+ openDVS_pixel2x2_top_658/vpd[3] openDVS_pixel2x2_top_658/vpd[1] openDVS_pixel2x2_top_658/vpd[0]
+ rowReadON<1> rowReadOFF<0> openDVS_pixel2x2_top_931/GndD DiffBn GndA OnBn VddA18
+ openDVS_pixel2x2_top
XopenDVS_pixel2x2_top_647 rowReadOFF<5> rowReadON<4> RefrBp PrBp PrSFBp col_periphery_1x2_0/COL_LINE0
+ pixRst<10> pixRst<11> col_periphery_1x2_0/COL_LINE1 OffBn openDVS_pixel2x2_top_647/vpd[2]
+ openDVS_pixel2x2_top_647/vpd[3] openDVS_pixel2x2_top_647/vpd[1] openDVS_pixel2x2_top_647/vpd[0]
+ rowReadON<5> rowReadOFF<4> openDVS_pixel2x2_top_935/GndD DiffBn GndA OnBn VddA18
+ openDVS_pixel2x2_top
XopenDVS_pixel2x2_top_603 rowReadOFF<17> rowReadON<16> RefrBp PrBp PrSFBp col_periphery_1x2_0/COL_LINE0
+ pixRst<10> pixRst<11> col_periphery_1x2_0/COL_LINE1 OffBn openDVS_pixel2x2_top_603/vpd[2]
+ openDVS_pixel2x2_top_603/vpd[3] openDVS_pixel2x2_top_603/vpd[1] openDVS_pixel2x2_top_603/vpd[0]
+ rowReadON<17> rowReadOFF<16> openDVS_pixel2x2_top_947/GndD DiffBn GndA OnBn VddA18
+ openDVS_pixel2x2_top
XopenDVS_pixel2x2_top_625 rowReadOFF<11> rowReadON<10> RefrBp PrBp PrSFBp col_periphery_1x2_4/COL_LINE0
+ pixRst<4> pixRst<5> col_periphery_1x2_4/COL_LINE1 OffBn openDVS_pixel2x2_top_625/vpd[2]
+ openDVS_pixel2x2_top_625/vpd[3] openDVS_pixel2x2_top_625/vpd[1] openDVS_pixel2x2_top_625/vpd[0]
+ rowReadON<11> rowReadOFF<10> openDVS_pixel2x2_top_941/GndD DiffBn GndA OnBn VddA18
+ openDVS_pixel2x2_top
XopenDVS_pixel2x2_top_614 rowReadOFF<19> rowReadON<18> RefrBp PrBp PrSFBp col_periphery_1x2_2/COL_LINE0
+ pixRst<0> pixRst<1> col_periphery_1x2_2/COL_LINE1 OffBn openDVS_pixel2x2_top_614/vpd[2]
+ openDVS_pixel2x2_top_614/vpd[3] openDVS_pixel2x2_top_614/vpd[1] openDVS_pixel2x2_top_614/vpd[0]
+ rowReadON<19> rowReadOFF<18> openDVS_pixel2x2_top_949/GndD DiffBn GndA OnBn VddA18
+ openDVS_pixel2x2_top
XopenDVS_pixel2x2_top_636 rowReadOFF<25> rowReadON<24> RefrBp PrBp PrSFBp col_periphery_1x2_6/COL_LINE0
+ pixRst<8> pixRst<9> col_periphery_1x2_6/COL_LINE1 OffBn openDVS_pixel2x2_top_636/vpd[2]
+ openDVS_pixel2x2_top_636/vpd[3] openDVS_pixel2x2_top_636/vpd[1] openDVS_pixel2x2_top_636/vpd[0]
+ rowReadON<25> rowReadOFF<24> openDVS_pixel2x2_top_955/GndD DiffBn GndA OnBn VddA18
+ openDVS_pixel2x2_top
XopenDVS_pixel2x2_top_6 rowReadOFF<51> rowReadON<50> RefrBp PrBp PrSFBp col_periphery_1x2_30/COL_LINE0
+ pixRst<62> pixRst<63> col_periphery_1x2_30/COL_LINE1 OffBn openDVS_pixel2x2_top_6/vpd[2]
+ openDVS_pixel2x2_top_6/vpd[3] openDVS_pixel2x2_top_6/vpd[1] openDVS_pixel2x2_top_6/vpd[0]
+ rowReadON<51> rowReadOFF<50> openDVS_pixel2x2_top_6/GndD DiffBn GndA OnBn VddA18
+ openDVS_pixel2x2_top
XopenDVS_pixel2x2_top_477 rowReadOFF<29> rowReadON<28> RefrBp PrBp PrSFBp col_periphery_1x2_11/COL_LINE0
+ pixRst<24> pixRst<25> col_periphery_1x2_11/COL_LINE1 OffBn openDVS_pixel2x2_top_477/vpd[2]
+ openDVS_pixel2x2_top_477/vpd[3] openDVS_pixel2x2_top_477/vpd[1] openDVS_pixel2x2_top_477/vpd[0]
+ rowReadON<29> rowReadOFF<28> openDVS_pixel2x2_top_989/GndD DiffBn GndA OnBn VddA18
+ openDVS_pixel2x2_top
XopenDVS_pixel2x2_top_422 rowReadOFF<29> rowReadON<28> RefrBp PrBp PrSFBp col_periphery_1x2_1/COL_LINE0
+ pixRst<12> pixRst<13> col_periphery_1x2_1/COL_LINE1 OffBn openDVS_pixel2x2_top_422/vpd[2]
+ openDVS_pixel2x2_top_422/vpd[3] openDVS_pixel2x2_top_422/vpd[1] openDVS_pixel2x2_top_422/vpd[0]
+ rowReadON<29> rowReadOFF<28> openDVS_pixel2x2_top_989/GndD DiffBn GndA OnBn VddA18
+ openDVS_pixel2x2_top
XopenDVS_pixel2x2_top_433 rowReadOFF<31> rowReadON<30> RefrBp PrBp PrSFBp col_periphery_1x2_4/COL_LINE0
+ pixRst<4> pixRst<5> col_periphery_1x2_4/COL_LINE1 OffBn openDVS_pixel2x2_top_433/vpd[2]
+ openDVS_pixel2x2_top_433/vpd[3] openDVS_pixel2x2_top_433/vpd[1] openDVS_pixel2x2_top_433/vpd[0]
+ rowReadON<31> rowReadOFF<30> openDVS_pixel2x2_top_991/GndD DiffBn GndA OnBn VddA18
+ openDVS_pixel2x2_top
XopenDVS_pixel2x2_top_455 rowReadOFF<35> rowReadON<34> RefrBp PrBp PrSFBp col_periphery_1x2_13/COL_LINE0
+ pixRst<28> pixRst<29> col_periphery_1x2_13/COL_LINE1 OffBn openDVS_pixel2x2_top_455/vpd[2]
+ openDVS_pixel2x2_top_455/vpd[3] openDVS_pixel2x2_top_455/vpd[1] openDVS_pixel2x2_top_455/vpd[0]
+ rowReadON<35> rowReadOFF<34> openDVS_pixel2x2_top_995/GndD DiffBn GndA OnBn VddA18
+ openDVS_pixel2x2_top
XopenDVS_pixel2x2_top_444 rowReadOFF<33> rowReadON<32> RefrBp PrBp PrSFBp col_periphery_1x2_10/COL_LINE0
+ pixRst<22> pixRst<23> col_periphery_1x2_10/COL_LINE1 OffBn openDVS_pixel2x2_top_444/vpd[2]
+ openDVS_pixel2x2_top_444/vpd[3] openDVS_pixel2x2_top_444/vpd[1] openDVS_pixel2x2_top_444/vpd[0]
+ rowReadON<33> rowReadOFF<32> openDVS_pixel2x2_top_993/GndD DiffBn GndA OnBn VddA18
+ openDVS_pixel2x2_top
XopenDVS_pixel2x2_top_488 rowReadOFF<41> rowReadON<40> RefrBp PrBp PrSFBp col_periphery_1x2_8/COL_LINE0
+ pixRst<18> pixRst<19> col_periphery_1x2_8/COL_LINE1 OffBn openDVS_pixel2x2_top_488/vpd[2]
+ openDVS_pixel2x2_top_488/vpd[3] openDVS_pixel2x2_top_488/vpd[1] openDVS_pixel2x2_top_488/vpd[0]
+ rowReadON<41> rowReadOFF<40> openDVS_pixel2x2_top_535/GndD DiffBn GndA OnBn VddA18
+ openDVS_pixel2x2_top
XopenDVS_pixel2x2_top_466 rowReadOFF<43> rowReadON<42> RefrBp PrBp PrSFBp col_periphery_1x2_8/COL_LINE0
+ pixRst<18> pixRst<19> col_periphery_1x2_8/COL_LINE1 OffBn openDVS_pixel2x2_top_466/vpd[2]
+ openDVS_pixel2x2_top_466/vpd[3] openDVS_pixel2x2_top_466/vpd[1] openDVS_pixel2x2_top_466/vpd[0]
+ rowReadON<43> rowReadOFF<42> openDVS_pixel2x2_top_537/GndD DiffBn GndA OnBn VddA18
+ openDVS_pixel2x2_top
XopenDVS_pixel2x2_top_499 rowReadOFF<45> rowReadON<44> RefrBp PrBp PrSFBp col_periphery_1x2_9/COL_LINE0
+ pixRst<20> pixRst<21> col_periphery_1x2_9/COL_LINE1 OffBn openDVS_pixel2x2_top_499/vpd[2]
+ openDVS_pixel2x2_top_499/vpd[3] openDVS_pixel2x2_top_499/vpd[1] openDVS_pixel2x2_top_499/vpd[0]
+ rowReadON<45> rowReadOFF<44> openDVS_pixel2x2_top_539/GndD DiffBn GndA OnBn VddA18
+ openDVS_pixel2x2_top
XopenDVS_pixel2x2_top_400 rowReadOFF<41> rowReadON<40> RefrBp PrBp PrSFBp col_periphery_1x2_6/COL_LINE0
+ pixRst<8> pixRst<9> col_periphery_1x2_6/COL_LINE1 OffBn openDVS_pixel2x2_top_400/vpd[2]
+ openDVS_pixel2x2_top_400/vpd[3] openDVS_pixel2x2_top_400/vpd[1] openDVS_pixel2x2_top_400/vpd[0]
+ rowReadON<41> rowReadOFF<40> openDVS_pixel2x2_top_535/GndD DiffBn GndA OnBn VddA18
+ openDVS_pixel2x2_top
XopenDVS_pixel2x2_top_411 rowReadOFF<35> rowReadON<34> RefrBp PrBp PrSFBp col_periphery_1x2_1/COL_LINE0
+ pixRst<12> pixRst<13> col_periphery_1x2_1/COL_LINE1 OffBn openDVS_pixel2x2_top_411/vpd[2]
+ openDVS_pixel2x2_top_411/vpd[3] openDVS_pixel2x2_top_411/vpd[1] openDVS_pixel2x2_top_411/vpd[0]
+ rowReadON<35> rowReadOFF<34> openDVS_pixel2x2_top_995/GndD DiffBn GndA OnBn VddA18
+ openDVS_pixel2x2_top
XopenDVS_pixel2x2_top_285 rowReadOFF<63> rowReadON<62> RefrBp PrBp PrSFBp col_periphery_1x2_11/COL_LINE0
+ pixRst<24> pixRst<25> col_periphery_1x2_11/COL_LINE1 OffBn openDVS_pixel2x2_top_285/vpd[2]
+ openDVS_pixel2x2_top_285/vpd[3] openDVS_pixel2x2_top_285/vpd[1] openDVS_pixel2x2_top_285/vpd[0]
+ rowReadON<63> rowReadOFF<62> openDVS_pixel2x2_top_82/GndD DiffBn GndA OnBn VddA18
+ openDVS_pixel2x2_top
XopenDVS_pixel2x2_top_263 rowReadOFF<55> rowReadON<54> RefrBp PrBp PrSFBp col_periphery_1x2_31/COL_LINE0
+ pixRst<48> pixRst<49> col_periphery_1x2_31/COL_LINE1 OffBn openDVS_pixel2x2_top_263/vpd[2]
+ openDVS_pixel2x2_top_263/vpd[3] openDVS_pixel2x2_top_263/vpd[1] openDVS_pixel2x2_top_263/vpd[0]
+ rowReadON<55> rowReadOFF<54> openDVS_pixel2x2_top_67/GndD DiffBn GndA OnBn VddA18
+ openDVS_pixel2x2_top
XopenDVS_pixel2x2_top_274 rowReadOFF<51> rowReadON<50> RefrBp PrBp PrSFBp col_periphery_1x2_8/COL_LINE0
+ pixRst<18> pixRst<19> col_periphery_1x2_8/COL_LINE1 OffBn openDVS_pixel2x2_top_274/vpd[2]
+ openDVS_pixel2x2_top_274/vpd[3] openDVS_pixel2x2_top_274/vpd[1] openDVS_pixel2x2_top_274/vpd[0]
+ rowReadON<51> rowReadOFF<50> openDVS_pixel2x2_top_6/GndD DiffBn GndA OnBn VddA18
+ openDVS_pixel2x2_top
XopenDVS_pixel2x2_top_296 rowReadOFF<47> rowReadON<46> RefrBp PrBp PrSFBp col_periphery_1x2_10/COL_LINE0
+ pixRst<22> pixRst<23> col_periphery_1x2_10/COL_LINE1 OffBn openDVS_pixel2x2_top_296/vpd[2]
+ openDVS_pixel2x2_top_296/vpd[3] openDVS_pixel2x2_top_296/vpd[1] openDVS_pixel2x2_top_296/vpd[0]
+ rowReadON<47> rowReadOFF<46> openDVS_pixel2x2_top_78/GndD DiffBn GndA OnBn VddA18
+ openDVS_pixel2x2_top
XopenDVS_pixel2x2_top_241 rowReadOFF<45> rowReadON<44> RefrBp PrBp PrSFBp col_periphery_1x2_19/COL_LINE0
+ pixRst<38> pixRst<39> col_periphery_1x2_19/COL_LINE1 OffBn openDVS_pixel2x2_top_241/vpd[2]
+ openDVS_pixel2x2_top_241/vpd[3] openDVS_pixel2x2_top_241/vpd[1] openDVS_pixel2x2_top_241/vpd[0]
+ rowReadON<45> rowReadOFF<44> openDVS_pixel2x2_top_539/GndD DiffBn GndA OnBn VddA18
+ openDVS_pixel2x2_top
XopenDVS_pixel2x2_top_230 rowReadOFF<51> rowReadON<50> RefrBp PrBp PrSFBp col_periphery_1x2_31/COL_LINE0
+ pixRst<48> pixRst<49> col_periphery_1x2_31/COL_LINE1 OffBn openDVS_pixel2x2_top_230/vpd[2]
+ openDVS_pixel2x2_top_230/vpd[3] openDVS_pixel2x2_top_230/vpd[1] openDVS_pixel2x2_top_230/vpd[0]
+ rowReadON<51> rowReadOFF<50> openDVS_pixel2x2_top_6/GndD DiffBn GndA OnBn VddA18
+ openDVS_pixel2x2_top
XopenDVS_pixel2x2_top_252 rowReadOFF<45> rowReadON<44> RefrBp PrBp PrSFBp col_periphery_1x2_29/COL_LINE0
+ pixRst<60> pixRst<61> col_periphery_1x2_29/COL_LINE1 OffBn openDVS_pixel2x2_top_252/vpd[2]
+ openDVS_pixel2x2_top_252/vpd[3] openDVS_pixel2x2_top_252/vpd[1] openDVS_pixel2x2_top_252/vpd[0]
+ rowReadON<45> rowReadOFF<44> openDVS_pixel2x2_top_539/GndD DiffBn GndA OnBn VddA18
+ openDVS_pixel2x2_top
XopenDVS_pixel2x2_top_829 rowReadOFF<19> rowReadON<18> RefrBp PrBp PrSFBp col_periphery_1x2_18/COL_LINE0
+ pixRst<36> pixRst<37> col_periphery_1x2_18/COL_LINE1 OffBn openDVS_pixel2x2_top_829/vpd[2]
+ openDVS_pixel2x2_top_829/vpd[3] openDVS_pixel2x2_top_829/vpd[1] openDVS_pixel2x2_top_829/vpd[0]
+ rowReadON<19> rowReadOFF<18> openDVS_pixel2x2_top_949/GndD DiffBn GndA OnBn VddA18
+ openDVS_pixel2x2_top
XopenDVS_pixel2x2_top_818 rowReadOFF<23> rowReadON<22> RefrBp PrBp PrSFBp col_periphery_1x2_21/COL_LINE0
+ pixRst<42> pixRst<43> col_periphery_1x2_21/COL_LINE1 OffBn openDVS_pixel2x2_top_818/vpd[2]
+ openDVS_pixel2x2_top_818/vpd[3] openDVS_pixel2x2_top_818/vpd[1] openDVS_pixel2x2_top_818/vpd[0]
+ rowReadON<23> rowReadOFF<22> openDVS_pixel2x2_top_953/GndD DiffBn GndA OnBn VddA18
+ openDVS_pixel2x2_top
XopenDVS_pixel2x2_top_807 rowReadOFF<25> rowReadON<24> RefrBp PrBp PrSFBp col_periphery_1x2_20/COL_LINE0
+ pixRst<40> pixRst<41> col_periphery_1x2_20/COL_LINE1 OffBn openDVS_pixel2x2_top_807/vpd[2]
+ openDVS_pixel2x2_top_807/vpd[3] openDVS_pixel2x2_top_807/vpd[1] openDVS_pixel2x2_top_807/vpd[0]
+ rowReadON<25> rowReadOFF<24> openDVS_pixel2x2_top_955/GndD DiffBn GndA OnBn VddA18
+ openDVS_pixel2x2_top
XopenDVS_pixel2x2_top_659 rowReadOFF<3> rowReadON<2> RefrBp PrBp PrSFBp col_periphery_1x2_0/COL_LINE0
+ pixRst<10> pixRst<11> col_periphery_1x2_0/COL_LINE1 OffBn openDVS_pixel2x2_top_659/vpd[2]
+ openDVS_pixel2x2_top_659/vpd[3] openDVS_pixel2x2_top_659/vpd[1] openDVS_pixel2x2_top_659/vpd[0]
+ rowReadON<3> rowReadOFF<2> openDVS_pixel2x2_top_933/GndD DiffBn GndA OnBn VddA18
+ openDVS_pixel2x2_top
XopenDVS_pixel2x2_top_648 rowReadOFF<3> rowReadON<2> RefrBp PrBp PrSFBp col_periphery_1x2_2/COL_LINE0
+ pixRst<0> pixRst<1> col_periphery_1x2_2/COL_LINE1 OffBn openDVS_pixel2x2_top_648/vpd[2]
+ openDVS_pixel2x2_top_648/vpd[3] openDVS_pixel2x2_top_648/vpd[1] openDVS_pixel2x2_top_648/vpd[0]
+ rowReadON<3> rowReadOFF<2> openDVS_pixel2x2_top_933/GndD DiffBn GndA OnBn VddA18
+ openDVS_pixel2x2_top
XopenDVS_pixel2x2_top_604 rowReadOFF<17> rowReadON<16> RefrBp PrBp PrSFBp col_periphery_1x2_1/COL_LINE0
+ pixRst<12> pixRst<13> col_periphery_1x2_1/COL_LINE1 OffBn openDVS_pixel2x2_top_604/vpd[2]
+ openDVS_pixel2x2_top_604/vpd[3] openDVS_pixel2x2_top_604/vpd[1] openDVS_pixel2x2_top_604/vpd[0]
+ rowReadON<17> rowReadOFF<16> openDVS_pixel2x2_top_947/GndD DiffBn GndA OnBn VddA18
+ openDVS_pixel2x2_top
XopenDVS_pixel2x2_top_626 rowReadOFF<11> rowReadON<10> RefrBp PrBp PrSFBp col_periphery_1x2_5/COL_LINE0
+ pixRst<6> pixRst<7> col_periphery_1x2_5/COL_LINE1 OffBn openDVS_pixel2x2_top_626/vpd[2]
+ openDVS_pixel2x2_top_626/vpd[3] openDVS_pixel2x2_top_626/vpd[1] openDVS_pixel2x2_top_626/vpd[0]
+ rowReadON<11> rowReadOFF<10> openDVS_pixel2x2_top_941/GndD DiffBn GndA OnBn VddA18
+ openDVS_pixel2x2_top
XopenDVS_pixel2x2_top_637 rowReadOFF<13> rowReadON<12> RefrBp PrBp PrSFBp col_periphery_1x2_3/COL_LINE0
+ pixRst<2> pixRst<3> col_periphery_1x2_3/COL_LINE1 OffBn openDVS_pixel2x2_top_637/vpd[2]
+ openDVS_pixel2x2_top_637/vpd[3] openDVS_pixel2x2_top_637/vpd[1] openDVS_pixel2x2_top_637/vpd[0]
+ rowReadON<13> rowReadOFF<12> openDVS_pixel2x2_top_943/GndD DiffBn GndA OnBn VddA18
+ openDVS_pixel2x2_top
XopenDVS_pixel2x2_top_615 rowReadOFF<19> rowReadON<18> RefrBp PrBp PrSFBp col_periphery_1x2_3/COL_LINE0
+ pixRst<2> pixRst<3> col_periphery_1x2_3/COL_LINE1 OffBn openDVS_pixel2x2_top_615/vpd[2]
+ openDVS_pixel2x2_top_615/vpd[3] openDVS_pixel2x2_top_615/vpd[1] openDVS_pixel2x2_top_615/vpd[0]
+ rowReadON<19> rowReadOFF<18> openDVS_pixel2x2_top_949/GndD DiffBn GndA OnBn VddA18
+ openDVS_pixel2x2_top
XopenDVS_pixel2x2_top_7 rowReadOFF<57> rowReadON<56> RefrBp PrBp PrSFBp col_periphery_1x2_25/COL_LINE0
+ pixRst<52> pixRst<53> col_periphery_1x2_25/COL_LINE1 OffBn openDVS_pixel2x2_top_7/vpd[2]
+ openDVS_pixel2x2_top_7/vpd[3] openDVS_pixel2x2_top_7/vpd[1] openDVS_pixel2x2_top_7/vpd[0]
+ rowReadON<57> rowReadOFF<56> openDVS_pixel2x2_top_9/GndD DiffBn GndA OnBn VddA18
+ openDVS_pixel2x2_top
XopenDVS_pixel2x2_top_478 rowReadOFF<29> rowReadON<28> RefrBp PrBp PrSFBp col_periphery_1x2_12/COL_LINE0
+ pixRst<26> pixRst<27> col_periphery_1x2_12/COL_LINE1 OffBn openDVS_pixel2x2_top_478/vpd[2]
+ openDVS_pixel2x2_top_478/vpd[3] openDVS_pixel2x2_top_478/vpd[1] openDVS_pixel2x2_top_478/vpd[0]
+ rowReadON<29> rowReadOFF<28> openDVS_pixel2x2_top_989/GndD DiffBn GndA OnBn VddA18
+ openDVS_pixel2x2_top
XopenDVS_pixel2x2_top_434 rowReadOFF<31> rowReadON<30> RefrBp PrBp PrSFBp col_periphery_1x2_5/COL_LINE0
+ pixRst<6> pixRst<7> col_periphery_1x2_5/COL_LINE1 OffBn openDVS_pixel2x2_top_434/vpd[2]
+ openDVS_pixel2x2_top_434/vpd[3] openDVS_pixel2x2_top_434/vpd[1] openDVS_pixel2x2_top_434/vpd[0]
+ rowReadON<31> rowReadOFF<30> openDVS_pixel2x2_top_991/GndD DiffBn GndA OnBn VddA18
+ openDVS_pixel2x2_top
XopenDVS_pixel2x2_top_456 rowReadOFF<41> rowReadON<40> RefrBp PrBp PrSFBp col_periphery_1x2_12/COL_LINE0
+ pixRst<26> pixRst<27> col_periphery_1x2_12/COL_LINE1 OffBn openDVS_pixel2x2_top_456/vpd[2]
+ openDVS_pixel2x2_top_456/vpd[3] openDVS_pixel2x2_top_456/vpd[1] openDVS_pixel2x2_top_456/vpd[0]
+ rowReadON<41> rowReadOFF<40> openDVS_pixel2x2_top_535/GndD DiffBn GndA OnBn VddA18
+ openDVS_pixel2x2_top
XopenDVS_pixel2x2_top_445 rowReadOFF<33> rowReadON<32> RefrBp PrBp PrSFBp col_periphery_1x2_11/COL_LINE0
+ pixRst<24> pixRst<25> col_periphery_1x2_11/COL_LINE1 OffBn openDVS_pixel2x2_top_445/vpd[2]
+ openDVS_pixel2x2_top_445/vpd[3] openDVS_pixel2x2_top_445/vpd[1] openDVS_pixel2x2_top_445/vpd[0]
+ rowReadON<33> rowReadOFF<32> openDVS_pixel2x2_top_993/GndD DiffBn GndA OnBn VddA18
+ openDVS_pixel2x2_top
XopenDVS_pixel2x2_top_489 rowReadOFF<41> rowReadON<40> RefrBp PrBp PrSFBp col_periphery_1x2_9/COL_LINE0
+ pixRst<20> pixRst<21> col_periphery_1x2_9/COL_LINE1 OffBn openDVS_pixel2x2_top_489/vpd[2]
+ openDVS_pixel2x2_top_489/vpd[3] openDVS_pixel2x2_top_489/vpd[1] openDVS_pixel2x2_top_489/vpd[0]
+ rowReadON<41> rowReadOFF<40> openDVS_pixel2x2_top_535/GndD DiffBn GndA OnBn VddA18
+ openDVS_pixel2x2_top
XopenDVS_pixel2x2_top_467 rowReadOFF<39> rowReadON<38> RefrBp PrBp PrSFBp col_periphery_1x2_8/COL_LINE0
+ pixRst<18> pixRst<19> col_periphery_1x2_8/COL_LINE1 OffBn openDVS_pixel2x2_top_467/vpd[2]
+ openDVS_pixel2x2_top_467/vpd[3] openDVS_pixel2x2_top_467/vpd[1] openDVS_pixel2x2_top_467/vpd[0]
+ rowReadON<39> rowReadOFF<38> openDVS_pixel2x2_top_999/GndD DiffBn GndA OnBn VddA18
+ openDVS_pixel2x2_top
XopenDVS_pixel2x2_top_401 rowReadOFF<39> rowReadON<38> RefrBp PrBp PrSFBp col_periphery_1x2_2/COL_LINE0
+ pixRst<0> pixRst<1> col_periphery_1x2_2/COL_LINE1 OffBn openDVS_pixel2x2_top_401/vpd[2]
+ openDVS_pixel2x2_top_401/vpd[3] openDVS_pixel2x2_top_401/vpd[1] openDVS_pixel2x2_top_401/vpd[0]
+ rowReadON<39> rowReadOFF<38> openDVS_pixel2x2_top_999/GndD DiffBn GndA OnBn VddA18
+ openDVS_pixel2x2_top
XopenDVS_pixel2x2_top_412 rowReadOFF<39> rowReadON<38> RefrBp PrBp PrSFBp col_periphery_1x2_6/COL_LINE0
+ pixRst<8> pixRst<9> col_periphery_1x2_6/COL_LINE1 OffBn openDVS_pixel2x2_top_412/vpd[2]
+ openDVS_pixel2x2_top_412/vpd[3] openDVS_pixel2x2_top_412/vpd[1] openDVS_pixel2x2_top_412/vpd[0]
+ rowReadON<39> rowReadOFF<38> openDVS_pixel2x2_top_999/GndD DiffBn GndA OnBn VddA18
+ openDVS_pixel2x2_top
XopenDVS_pixel2x2_top_423 rowReadOFF<41> rowReadON<40> RefrBp PrBp PrSFBp col_periphery_1x2_1/COL_LINE0
+ pixRst<12> pixRst<13> col_periphery_1x2_1/COL_LINE1 OffBn openDVS_pixel2x2_top_423/vpd[2]
+ openDVS_pixel2x2_top_423/vpd[3] openDVS_pixel2x2_top_423/vpd[1] openDVS_pixel2x2_top_423/vpd[0]
+ rowReadON<41> rowReadOFF<40> openDVS_pixel2x2_top_535/GndD DiffBn GndA OnBn VddA18
+ openDVS_pixel2x2_top
XopenDVS_pixel2x2_top_990 rowReadOFF<31> rowReadON<30> RefrBp PrBp PrSFBp col_periphery_1x2_14/COL_LINE0
+ pixRst<30> pixRst<31> col_periphery_1x2_14/COL_LINE1 OffBn openDVS_pixel2x2_top_990/vpd[2]
+ openDVS_pixel2x2_top_990/vpd[3] openDVS_pixel2x2_top_990/vpd[1] openDVS_pixel2x2_top_990/vpd[0]
+ rowReadON<31> rowReadOFF<30> openDVS_pixel2x2_top_991/GndD DiffBn GndA OnBn VddA18
+ openDVS_pixel2x2_top
XopenDVS_pixel2x2_top_253 rowReadOFF<29> rowReadON<28> RefrBp PrBp PrSFBp col_periphery_1x2_23/COL_LINE0
+ pixRst<46> pixRst<47> col_periphery_1x2_23/COL_LINE1 OffBn openDVS_pixel2x2_top_253/vpd[2]
+ openDVS_pixel2x2_top_253/vpd[3] openDVS_pixel2x2_top_253/vpd[1] openDVS_pixel2x2_top_253/vpd[0]
+ rowReadON<29> rowReadOFF<28> openDVS_pixel2x2_top_989/GndD DiffBn GndA OnBn VddA18
+ openDVS_pixel2x2_top
XopenDVS_pixel2x2_top_220 rowReadOFF<35> rowReadON<34> RefrBp PrBp PrSFBp col_periphery_1x2_25/COL_LINE0
+ pixRst<52> pixRst<53> col_periphery_1x2_25/COL_LINE1 OffBn openDVS_pixel2x2_top_220/vpd[2]
+ openDVS_pixel2x2_top_220/vpd[3] openDVS_pixel2x2_top_220/vpd[1] openDVS_pixel2x2_top_220/vpd[0]
+ rowReadON<35> rowReadOFF<34> openDVS_pixel2x2_top_995/GndD DiffBn GndA OnBn VddA18
+ openDVS_pixel2x2_top
XopenDVS_pixel2x2_top_231 rowReadOFF<41> rowReadON<40> RefrBp PrBp PrSFBp col_periphery_1x2_23/COL_LINE0
+ pixRst<46> pixRst<47> col_periphery_1x2_23/COL_LINE1 OffBn openDVS_pixel2x2_top_231/vpd[2]
+ openDVS_pixel2x2_top_231/vpd[3] openDVS_pixel2x2_top_231/vpd[1] openDVS_pixel2x2_top_231/vpd[0]
+ rowReadON<41> rowReadOFF<40> openDVS_pixel2x2_top_535/GndD DiffBn GndA OnBn VddA18
+ openDVS_pixel2x2_top
XopenDVS_pixel2x2_top_264 rowReadOFF<33> rowReadON<32> RefrBp PrBp PrSFBp col_periphery_1x2_23/COL_LINE0
+ pixRst<46> pixRst<47> col_periphery_1x2_23/COL_LINE1 OffBn openDVS_pixel2x2_top_264/vpd[2]
+ openDVS_pixel2x2_top_264/vpd[3] openDVS_pixel2x2_top_264/vpd[1] openDVS_pixel2x2_top_264/vpd[0]
+ rowReadON<33> rowReadOFF<32> openDVS_pixel2x2_top_993/GndD DiffBn GndA OnBn VddA18
+ openDVS_pixel2x2_top
XopenDVS_pixel2x2_top_286 rowReadOFF<61> rowReadON<60> RefrBp PrBp PrSFBp col_periphery_1x2_10/COL_LINE0
+ pixRst<22> pixRst<23> col_periphery_1x2_10/COL_LINE1 OffBn openDVS_pixel2x2_top_286/vpd[2]
+ openDVS_pixel2x2_top_286/vpd[3] openDVS_pixel2x2_top_286/vpd[1] openDVS_pixel2x2_top_286/vpd[0]
+ rowReadON<61> rowReadOFF<60> openDVS_pixel2x2_top_96/GndD DiffBn GndA OnBn VddA18
+ openDVS_pixel2x2_top
XopenDVS_pixel2x2_top_275 rowReadOFF<51> rowReadON<50> RefrBp PrBp PrSFBp col_periphery_1x2_9/COL_LINE0
+ pixRst<20> pixRst<21> col_periphery_1x2_9/COL_LINE1 OffBn openDVS_pixel2x2_top_275/vpd[2]
+ openDVS_pixel2x2_top_275/vpd[3] openDVS_pixel2x2_top_275/vpd[1] openDVS_pixel2x2_top_275/vpd[0]
+ rowReadON<51> rowReadOFF<50> openDVS_pixel2x2_top_6/GndD DiffBn GndA OnBn VddA18
+ openDVS_pixel2x2_top
XopenDVS_pixel2x2_top_297 rowReadOFF<47> rowReadON<46> RefrBp PrBp PrSFBp col_periphery_1x2_11/COL_LINE0
+ pixRst<24> pixRst<25> col_periphery_1x2_11/COL_LINE1 OffBn openDVS_pixel2x2_top_297/vpd[2]
+ openDVS_pixel2x2_top_297/vpd[3] openDVS_pixel2x2_top_297/vpd[1] openDVS_pixel2x2_top_297/vpd[0]
+ rowReadON<47> rowReadOFF<46> openDVS_pixel2x2_top_78/GndD DiffBn GndA OnBn VddA18
+ openDVS_pixel2x2_top
XopenDVS_pixel2x2_top_242 rowReadOFF<45> rowReadON<44> RefrBp PrBp PrSFBp col_periphery_1x2_20/COL_LINE0
+ pixRst<40> pixRst<41> col_periphery_1x2_20/COL_LINE1 OffBn openDVS_pixel2x2_top_242/vpd[2]
+ openDVS_pixel2x2_top_242/vpd[3] openDVS_pixel2x2_top_242/vpd[1] openDVS_pixel2x2_top_242/vpd[0]
+ rowReadON<45> rowReadOFF<44> openDVS_pixel2x2_top_539/GndD DiffBn GndA OnBn VddA18
+ openDVS_pixel2x2_top
XopenDVS_pixel2x2_top_819 rowReadOFF<17> rowReadON<16> RefrBp PrBp PrSFBp col_periphery_1x2_17/COL_LINE0
+ pixRst<34> pixRst<35> col_periphery_1x2_17/COL_LINE1 OffBn openDVS_pixel2x2_top_819/vpd[2]
+ openDVS_pixel2x2_top_819/vpd[3] openDVS_pixel2x2_top_819/vpd[1] openDVS_pixel2x2_top_819/vpd[0]
+ rowReadON<17> rowReadOFF<16> openDVS_pixel2x2_top_947/GndD DiffBn GndA OnBn VddA18
+ openDVS_pixel2x2_top
XopenDVS_pixel2x2_top_808 rowReadOFF<25> rowReadON<24> RefrBp PrBp PrSFBp col_periphery_1x2_21/COL_LINE0
+ pixRst<42> pixRst<43> col_periphery_1x2_21/COL_LINE1 OffBn openDVS_pixel2x2_top_808/vpd[2]
+ openDVS_pixel2x2_top_808/vpd[3] openDVS_pixel2x2_top_808/vpd[1] openDVS_pixel2x2_top_808/vpd[0]
+ rowReadON<25> rowReadOFF<24> openDVS_pixel2x2_top_955/GndD DiffBn GndA OnBn VddA18
+ openDVS_pixel2x2_top
XopenDVS_pixel2x2_top_649 rowReadOFF<3> rowReadON<2> RefrBp PrBp PrSFBp col_periphery_1x2_3/COL_LINE0
+ pixRst<2> pixRst<3> col_periphery_1x2_3/COL_LINE1 OffBn openDVS_pixel2x2_top_649/vpd[2]
+ openDVS_pixel2x2_top_649/vpd[3] openDVS_pixel2x2_top_649/vpd[1] openDVS_pixel2x2_top_649/vpd[0]
+ rowReadON<3> rowReadOFF<2> openDVS_pixel2x2_top_933/GndD DiffBn GndA OnBn VddA18
+ openDVS_pixel2x2_top
XopenDVS_pixel2x2_top_627 rowReadOFF<11> rowReadON<10> RefrBp PrBp PrSFBp col_periphery_1x2_6/COL_LINE0
+ pixRst<8> pixRst<9> col_periphery_1x2_6/COL_LINE1 OffBn openDVS_pixel2x2_top_627/vpd[2]
+ openDVS_pixel2x2_top_627/vpd[3] openDVS_pixel2x2_top_627/vpd[1] openDVS_pixel2x2_top_627/vpd[0]
+ rowReadON<11> rowReadOFF<10> openDVS_pixel2x2_top_941/GndD DiffBn GndA OnBn VddA18
+ openDVS_pixel2x2_top
XopenDVS_pixel2x2_top_616 rowReadOFF<19> rowReadON<18> RefrBp PrBp PrSFBp col_periphery_1x2_4/COL_LINE0
+ pixRst<4> pixRst<5> col_periphery_1x2_4/COL_LINE1 OffBn openDVS_pixel2x2_top_616/vpd[2]
+ openDVS_pixel2x2_top_616/vpd[3] openDVS_pixel2x2_top_616/vpd[1] openDVS_pixel2x2_top_616/vpd[0]
+ rowReadON<19> rowReadOFF<18> openDVS_pixel2x2_top_949/GndD DiffBn GndA OnBn VddA18
+ openDVS_pixel2x2_top
XopenDVS_pixel2x2_top_638 rowReadOFF<13> rowReadON<12> RefrBp PrBp PrSFBp col_periphery_1x2_4/COL_LINE0
+ pixRst<4> pixRst<5> col_periphery_1x2_4/COL_LINE1 OffBn openDVS_pixel2x2_top_638/vpd[2]
+ openDVS_pixel2x2_top_638/vpd[3] openDVS_pixel2x2_top_638/vpd[1] openDVS_pixel2x2_top_638/vpd[0]
+ rowReadON<13> rowReadOFF<12> openDVS_pixel2x2_top_943/GndD DiffBn GndA OnBn VddA18
+ openDVS_pixel2x2_top
XopenDVS_pixel2x2_top_605 rowReadOFF<23> rowReadON<22> RefrBp PrBp PrSFBp col_periphery_1x2_0/COL_LINE0
+ pixRst<10> pixRst<11> col_periphery_1x2_0/COL_LINE1 OffBn openDVS_pixel2x2_top_605/vpd[2]
+ openDVS_pixel2x2_top_605/vpd[3] openDVS_pixel2x2_top_605/vpd[1] openDVS_pixel2x2_top_605/vpd[0]
+ rowReadON<23> rowReadOFF<22> openDVS_pixel2x2_top_953/GndD DiffBn GndA OnBn VddA18
+ openDVS_pixel2x2_top
XopenDVS_pixel2x2_top_8 rowReadOFF<57> rowReadON<56> RefrBp PrBp PrSFBp col_periphery_1x2_26/COL_LINE0
+ pixRst<54> pixRst<55> col_periphery_1x2_26/COL_LINE1 OffBn openDVS_pixel2x2_top_8/vpd[2]
+ openDVS_pixel2x2_top_8/vpd[3] openDVS_pixel2x2_top_8/vpd[1] openDVS_pixel2x2_top_8/vpd[0]
+ rowReadON<57> rowReadOFF<56> openDVS_pixel2x2_top_9/GndD DiffBn GndA OnBn VddA18
+ openDVS_pixel2x2_top
XopenDVS_pixel2x2_top_479 rowReadOFF<29> rowReadON<28> RefrBp PrBp PrSFBp col_periphery_1x2_13/COL_LINE0
+ pixRst<28> pixRst<29> col_periphery_1x2_13/COL_LINE1 OffBn openDVS_pixel2x2_top_479/vpd[2]
+ openDVS_pixel2x2_top_479/vpd[3] openDVS_pixel2x2_top_479/vpd[1] openDVS_pixel2x2_top_479/vpd[0]
+ rowReadON<29> rowReadOFF<28> openDVS_pixel2x2_top_989/GndD DiffBn GndA OnBn VddA18
+ openDVS_pixel2x2_top
XopenDVS_pixel2x2_top_435 rowReadOFF<31> rowReadON<30> RefrBp PrBp PrSFBp col_periphery_1x2_6/COL_LINE0
+ pixRst<8> pixRst<9> col_periphery_1x2_6/COL_LINE1 OffBn openDVS_pixel2x2_top_435/vpd[2]
+ openDVS_pixel2x2_top_435/vpd[3] openDVS_pixel2x2_top_435/vpd[1] openDVS_pixel2x2_top_435/vpd[0]
+ rowReadON<31> rowReadOFF<30> openDVS_pixel2x2_top_991/GndD DiffBn GndA OnBn VddA18
+ openDVS_pixel2x2_top
XopenDVS_pixel2x2_top_457 rowReadOFF<41> rowReadON<40> RefrBp PrBp PrSFBp col_periphery_1x2_13/COL_LINE0
+ pixRst<28> pixRst<29> col_periphery_1x2_13/COL_LINE1 OffBn openDVS_pixel2x2_top_457/vpd[2]
+ openDVS_pixel2x2_top_457/vpd[3] openDVS_pixel2x2_top_457/vpd[1] openDVS_pixel2x2_top_457/vpd[0]
+ rowReadON<41> rowReadOFF<40> openDVS_pixel2x2_top_535/GndD DiffBn GndA OnBn VddA18
+ openDVS_pixel2x2_top
XopenDVS_pixel2x2_top_446 rowReadOFF<33> rowReadON<32> RefrBp PrBp PrSFBp col_periphery_1x2_12/COL_LINE0
+ pixRst<26> pixRst<27> col_periphery_1x2_12/COL_LINE1 OffBn openDVS_pixel2x2_top_446/vpd[2]
+ openDVS_pixel2x2_top_446/vpd[3] openDVS_pixel2x2_top_446/vpd[1] openDVS_pixel2x2_top_446/vpd[0]
+ rowReadON<33> rowReadOFF<32> openDVS_pixel2x2_top_993/GndD DiffBn GndA OnBn VddA18
+ openDVS_pixel2x2_top
XopenDVS_pixel2x2_top_468 rowReadOFF<39> rowReadON<38> RefrBp PrBp PrSFBp col_periphery_1x2_9/COL_LINE0
+ pixRst<20> pixRst<21> col_periphery_1x2_9/COL_LINE1 OffBn openDVS_pixel2x2_top_468/vpd[2]
+ openDVS_pixel2x2_top_468/vpd[3] openDVS_pixel2x2_top_468/vpd[1] openDVS_pixel2x2_top_468/vpd[0]
+ rowReadON<39> rowReadOFF<38> openDVS_pixel2x2_top_999/GndD DiffBn GndA OnBn VddA18
+ openDVS_pixel2x2_top
XopenDVS_pixel2x2_top_424 rowReadOFF<43> rowReadON<42> RefrBp PrBp PrSFBp col_periphery_1x2_1/COL_LINE0
+ pixRst<12> pixRst<13> col_periphery_1x2_1/COL_LINE1 OffBn openDVS_pixel2x2_top_424/vpd[2]
+ openDVS_pixel2x2_top_424/vpd[3] openDVS_pixel2x2_top_424/vpd[1] openDVS_pixel2x2_top_424/vpd[0]
+ rowReadON<43> rowReadOFF<42> openDVS_pixel2x2_top_537/GndD DiffBn GndA OnBn VddA18
+ openDVS_pixel2x2_top
XopenDVS_pixel2x2_top_402 rowReadOFF<39> rowReadON<38> RefrBp PrBp PrSFBp col_periphery_1x2_3/COL_LINE0
+ pixRst<2> pixRst<3> col_periphery_1x2_3/COL_LINE1 OffBn openDVS_pixel2x2_top_402/vpd[2]
+ openDVS_pixel2x2_top_402/vpd[3] openDVS_pixel2x2_top_402/vpd[1] openDVS_pixel2x2_top_402/vpd[0]
+ rowReadON<39> rowReadOFF<38> openDVS_pixel2x2_top_999/GndD DiffBn GndA OnBn VddA18
+ openDVS_pixel2x2_top
XopenDVS_pixel2x2_top_413 rowReadOFF<39> rowReadON<38> RefrBp PrBp PrSFBp col_periphery_1x2_0/COL_LINE0
+ pixRst<10> pixRst<11> col_periphery_1x2_0/COL_LINE1 OffBn openDVS_pixel2x2_top_413/vpd[2]
+ openDVS_pixel2x2_top_413/vpd[3] openDVS_pixel2x2_top_413/vpd[1] openDVS_pixel2x2_top_413/vpd[0]
+ rowReadON<39> rowReadOFF<38> openDVS_pixel2x2_top_999/GndD DiffBn GndA OnBn VddA18
+ openDVS_pixel2x2_top
XopenDVS_pixel2x2_top_980 rowReadOFF<27> rowReadON<26> RefrBp PrBp PrSFBp col_periphery_1x2_31/COL_LINE0
+ pixRst<48> pixRst<49> col_periphery_1x2_31/COL_LINE1 OffBn openDVS_pixel2x2_top_980/vpd[2]
+ openDVS_pixel2x2_top_980/vpd[3] openDVS_pixel2x2_top_980/vpd[1] openDVS_pixel2x2_top_980/vpd[0]
+ rowReadON<27> rowReadOFF<26> openDVS_pixel2x2_top_987/GndD DiffBn GndA OnBn VddA18
+ openDVS_pixel2x2_top
XopenDVS_pixel2x2_top_991 rowReadOFF<31> rowReadON<30> RefrBp PrBp PrSFBp col_periphery_1x2_16/COL_LINE0
+ pixRst<32> pixRst<33> col_periphery_1x2_16/COL_LINE1 OffBn openDVS_pixel2x2_top_991/vpd[2]
+ openDVS_pixel2x2_top_991/vpd[3] openDVS_pixel2x2_top_991/vpd[1] openDVS_pixel2x2_top_991/vpd[0]
+ rowReadON<31> rowReadOFF<30> openDVS_pixel2x2_top_991/GndD DiffBn GndA OnBn VddA18
+ openDVS_pixel2x2_top
XopenDVS_pixel2x2_top_254 rowReadOFF<29> rowReadON<28> RefrBp PrBp PrSFBp col_periphery_1x2_31/COL_LINE0
+ pixRst<48> pixRst<49> col_periphery_1x2_31/COL_LINE1 OffBn openDVS_pixel2x2_top_254/vpd[2]
+ openDVS_pixel2x2_top_254/vpd[3] openDVS_pixel2x2_top_254/vpd[1] openDVS_pixel2x2_top_254/vpd[0]
+ rowReadON<29> rowReadOFF<28> openDVS_pixel2x2_top_989/GndD DiffBn GndA OnBn VddA18
+ openDVS_pixel2x2_top
XopenDVS_pixel2x2_top_210 rowReadOFF<35> rowReadON<34> RefrBp PrBp PrSFBp col_periphery_1x2_29/COL_LINE0
+ pixRst<60> pixRst<61> col_periphery_1x2_29/COL_LINE1 OffBn openDVS_pixel2x2_top_210/vpd[2]
+ openDVS_pixel2x2_top_210/vpd[3] openDVS_pixel2x2_top_210/vpd[1] openDVS_pixel2x2_top_210/vpd[0]
+ rowReadON<35> rowReadOFF<34> openDVS_pixel2x2_top_995/GndD DiffBn GndA OnBn VddA18
+ openDVS_pixel2x2_top
XopenDVS_pixel2x2_top_232 rowReadOFF<41> rowReadON<40> RefrBp PrBp PrSFBp col_periphery_1x2_31/COL_LINE0
+ pixRst<48> pixRst<49> col_periphery_1x2_31/COL_LINE1 OffBn openDVS_pixel2x2_top_232/vpd[2]
+ openDVS_pixel2x2_top_232/vpd[3] openDVS_pixel2x2_top_232/vpd[1] openDVS_pixel2x2_top_232/vpd[0]
+ rowReadON<41> rowReadOFF<40> openDVS_pixel2x2_top_535/GndD DiffBn GndA OnBn VddA18
+ openDVS_pixel2x2_top
XopenDVS_pixel2x2_top_265 rowReadOFF<33> rowReadON<32> RefrBp PrBp PrSFBp col_periphery_1x2_31/COL_LINE0
+ pixRst<48> pixRst<49> col_periphery_1x2_31/COL_LINE1 OffBn openDVS_pixel2x2_top_265/vpd[2]
+ openDVS_pixel2x2_top_265/vpd[3] openDVS_pixel2x2_top_265/vpd[1] openDVS_pixel2x2_top_265/vpd[0]
+ rowReadON<33> rowReadOFF<32> openDVS_pixel2x2_top_993/GndD DiffBn GndA OnBn VddA18
+ openDVS_pixel2x2_top
XopenDVS_pixel2x2_top_221 rowReadOFF<37> rowReadON<36> RefrBp PrBp PrSFBp col_periphery_1x2_23/COL_LINE0
+ pixRst<46> pixRst<47> col_periphery_1x2_23/COL_LINE1 OffBn openDVS_pixel2x2_top_221/vpd[2]
+ openDVS_pixel2x2_top_221/vpd[3] openDVS_pixel2x2_top_221/vpd[1] openDVS_pixel2x2_top_221/vpd[0]
+ rowReadON<37> rowReadOFF<36> openDVS_pixel2x2_top_997/GndD DiffBn GndA OnBn VddA18
+ openDVS_pixel2x2_top
XopenDVS_pixel2x2_top_287 rowReadOFF<61> rowReadON<60> RefrBp PrBp PrSFBp col_periphery_1x2_12/COL_LINE0
+ pixRst<26> pixRst<27> col_periphery_1x2_12/COL_LINE1 OffBn openDVS_pixel2x2_top_287/vpd[2]
+ openDVS_pixel2x2_top_287/vpd[3] openDVS_pixel2x2_top_287/vpd[1] openDVS_pixel2x2_top_287/vpd[0]
+ rowReadON<61> rowReadOFF<60> openDVS_pixel2x2_top_96/GndD DiffBn GndA OnBn VddA18
+ openDVS_pixel2x2_top
XopenDVS_pixel2x2_top_276 rowReadOFF<51> rowReadON<50> RefrBp PrBp PrSFBp col_periphery_1x2_10/COL_LINE0
+ pixRst<22> pixRst<23> col_periphery_1x2_10/COL_LINE1 OffBn openDVS_pixel2x2_top_276/vpd[2]
+ openDVS_pixel2x2_top_276/vpd[3] openDVS_pixel2x2_top_276/vpd[1] openDVS_pixel2x2_top_276/vpd[0]
+ rowReadON<51> rowReadOFF<50> openDVS_pixel2x2_top_6/GndD DiffBn GndA OnBn VddA18
+ openDVS_pixel2x2_top
XopenDVS_pixel2x2_top_298 rowReadOFF<47> rowReadON<46> RefrBp PrBp PrSFBp col_periphery_1x2_12/COL_LINE0
+ pixRst<26> pixRst<27> col_periphery_1x2_12/COL_LINE1 OffBn openDVS_pixel2x2_top_298/vpd[2]
+ openDVS_pixel2x2_top_298/vpd[3] openDVS_pixel2x2_top_298/vpd[1] openDVS_pixel2x2_top_298/vpd[0]
+ rowReadON<47> rowReadOFF<46> openDVS_pixel2x2_top_78/GndD DiffBn GndA OnBn VddA18
+ openDVS_pixel2x2_top
XopenDVS_pixel2x2_top_243 rowReadOFF<45> rowReadON<44> RefrBp PrBp PrSFBp col_periphery_1x2_21/COL_LINE0
+ pixRst<42> pixRst<43> col_periphery_1x2_21/COL_LINE1 OffBn openDVS_pixel2x2_top_243/vpd[2]
+ openDVS_pixel2x2_top_243/vpd[3] openDVS_pixel2x2_top_243/vpd[1] openDVS_pixel2x2_top_243/vpd[0]
+ rowReadON<45> rowReadOFF<44> openDVS_pixel2x2_top_539/GndD DiffBn GndA OnBn VddA18
+ openDVS_pixel2x2_top
XopenDVS_pixel2x2_top_809 rowReadOFF<15> rowReadON<14> RefrBp PrBp PrSFBp col_periphery_1x2_17/COL_LINE0
+ pixRst<34> pixRst<35> col_periphery_1x2_17/COL_LINE1 OffBn openDVS_pixel2x2_top_809/vpd[2]
+ openDVS_pixel2x2_top_809/vpd[3] openDVS_pixel2x2_top_809/vpd[1] openDVS_pixel2x2_top_809/vpd[0]
+ rowReadON<15> rowReadOFF<14> openDVS_pixel2x2_top_945/GndD DiffBn GndA OnBn VddA18
+ openDVS_pixel2x2_top
XopenDVS_pixel2x2_top_628 rowReadOFF<11> rowReadON<10> RefrBp PrBp PrSFBp col_periphery_1x2_0/COL_LINE0
+ pixRst<10> pixRst<11> col_periphery_1x2_0/COL_LINE1 OffBn openDVS_pixel2x2_top_628/vpd[2]
+ openDVS_pixel2x2_top_628/vpd[3] openDVS_pixel2x2_top_628/vpd[1] openDVS_pixel2x2_top_628/vpd[0]
+ rowReadON<11> rowReadOFF<10> openDVS_pixel2x2_top_941/GndD DiffBn GndA OnBn VddA18
+ openDVS_pixel2x2_top
XopenDVS_pixel2x2_top_639 rowReadOFF<13> rowReadON<12> RefrBp PrBp PrSFBp col_periphery_1x2_1/COL_LINE0
+ pixRst<12> pixRst<13> col_periphery_1x2_1/COL_LINE1 OffBn openDVS_pixel2x2_top_639/vpd[2]
+ openDVS_pixel2x2_top_639/vpd[3] openDVS_pixel2x2_top_639/vpd[1] openDVS_pixel2x2_top_639/vpd[0]
+ rowReadON<13> rowReadOFF<12> openDVS_pixel2x2_top_943/GndD DiffBn GndA OnBn VddA18
+ openDVS_pixel2x2_top
XopenDVS_pixel2x2_top_617 rowReadOFF<19> rowReadON<18> RefrBp PrBp PrSFBp col_periphery_1x2_5/COL_LINE0
+ pixRst<6> pixRst<7> col_periphery_1x2_5/COL_LINE1 OffBn openDVS_pixel2x2_top_617/vpd[2]
+ openDVS_pixel2x2_top_617/vpd[3] openDVS_pixel2x2_top_617/vpd[1] openDVS_pixel2x2_top_617/vpd[0]
+ rowReadON<19> rowReadOFF<18> openDVS_pixel2x2_top_949/GndD DiffBn GndA OnBn VddA18
+ openDVS_pixel2x2_top
XopenDVS_pixel2x2_top_606 rowReadOFF<23> rowReadON<22> RefrBp PrBp PrSFBp col_periphery_1x2_1/COL_LINE0
+ pixRst<12> pixRst<13> col_periphery_1x2_1/COL_LINE1 OffBn openDVS_pixel2x2_top_606/vpd[2]
+ openDVS_pixel2x2_top_606/vpd[3] openDVS_pixel2x2_top_606/vpd[1] openDVS_pixel2x2_top_606/vpd[0]
+ rowReadON<23> rowReadOFF<22> openDVS_pixel2x2_top_953/GndD DiffBn GndA OnBn VddA18
+ openDVS_pixel2x2_top
XopenDVS_pixel2x2_top_9 rowReadOFF<57> rowReadON<56> RefrBp PrBp PrSFBp col_periphery_1x2_27/COL_LINE0
+ pixRst<56> pixRst<57> col_periphery_1x2_27/COL_LINE1 OffBn openDVS_pixel2x2_top_9/vpd[2]
+ openDVS_pixel2x2_top_9/vpd[3] openDVS_pixel2x2_top_9/vpd[1] openDVS_pixel2x2_top_9/vpd[0]
+ rowReadON<57> rowReadOFF<56> openDVS_pixel2x2_top_9/GndD DiffBn GndA OnBn VddA18
+ openDVS_pixel2x2_top
XopenDVS_pixel2x2_top_436 rowReadOFF<31> rowReadON<30> RefrBp PrBp PrSFBp col_periphery_1x2_0/COL_LINE0
+ pixRst<10> pixRst<11> col_periphery_1x2_0/COL_LINE1 OffBn openDVS_pixel2x2_top_436/vpd[2]
+ openDVS_pixel2x2_top_436/vpd[3] openDVS_pixel2x2_top_436/vpd[1] openDVS_pixel2x2_top_436/vpd[0]
+ rowReadON<31> rowReadOFF<30> openDVS_pixel2x2_top_991/GndD DiffBn GndA OnBn VddA18
+ openDVS_pixel2x2_top
XopenDVS_pixel2x2_top_447 rowReadOFF<33> rowReadON<32> RefrBp PrBp PrSFBp col_periphery_1x2_13/COL_LINE0
+ pixRst<28> pixRst<29> col_periphery_1x2_13/COL_LINE1 OffBn openDVS_pixel2x2_top_447/vpd[2]
+ openDVS_pixel2x2_top_447/vpd[3] openDVS_pixel2x2_top_447/vpd[1] openDVS_pixel2x2_top_447/vpd[0]
+ rowReadON<33> rowReadOFF<32> openDVS_pixel2x2_top_993/GndD DiffBn GndA OnBn VddA18
+ openDVS_pixel2x2_top
XopenDVS_pixel2x2_top_469 rowReadOFF<39> rowReadON<38> RefrBp PrBp PrSFBp col_periphery_1x2_10/COL_LINE0
+ pixRst<22> pixRst<23> col_periphery_1x2_10/COL_LINE1 OffBn openDVS_pixel2x2_top_469/vpd[2]
+ openDVS_pixel2x2_top_469/vpd[3] openDVS_pixel2x2_top_469/vpd[1] openDVS_pixel2x2_top_469/vpd[0]
+ rowReadON<39> rowReadOFF<38> openDVS_pixel2x2_top_999/GndD DiffBn GndA OnBn VddA18
+ openDVS_pixel2x2_top
XopenDVS_pixel2x2_top_458 rowReadOFF<37> rowReadON<36> RefrBp PrBp PrSFBp col_periphery_1x2_8/COL_LINE0
+ pixRst<18> pixRst<19> col_periphery_1x2_8/COL_LINE1 OffBn openDVS_pixel2x2_top_458/vpd[2]
+ openDVS_pixel2x2_top_458/vpd[3] openDVS_pixel2x2_top_458/vpd[1] openDVS_pixel2x2_top_458/vpd[0]
+ rowReadON<37> rowReadOFF<36> openDVS_pixel2x2_top_997/GndD DiffBn GndA OnBn VddA18
+ openDVS_pixel2x2_top
XopenDVS_pixel2x2_top_425 rowReadOFF<43> rowReadON<42> RefrBp PrBp PrSFBp col_periphery_1x2_2/COL_LINE0
+ pixRst<0> pixRst<1> col_periphery_1x2_2/COL_LINE1 OffBn openDVS_pixel2x2_top_425/vpd[2]
+ openDVS_pixel2x2_top_425/vpd[3] openDVS_pixel2x2_top_425/vpd[1] openDVS_pixel2x2_top_425/vpd[0]
+ rowReadON<43> rowReadOFF<42> openDVS_pixel2x2_top_537/GndD DiffBn GndA OnBn VddA18
+ openDVS_pixel2x2_top
XopenDVS_pixel2x2_top_403 rowReadOFF<39> rowReadON<38> RefrBp PrBp PrSFBp col_periphery_1x2_4/COL_LINE0
+ pixRst<4> pixRst<5> col_periphery_1x2_4/COL_LINE1 OffBn openDVS_pixel2x2_top_403/vpd[2]
+ openDVS_pixel2x2_top_403/vpd[3] openDVS_pixel2x2_top_403/vpd[1] openDVS_pixel2x2_top_403/vpd[0]
+ rowReadON<39> rowReadOFF<38> openDVS_pixel2x2_top_999/GndD DiffBn GndA OnBn VddA18
+ openDVS_pixel2x2_top
XopenDVS_pixel2x2_top_414 rowReadOFF<39> rowReadON<38> RefrBp PrBp PrSFBp col_periphery_1x2_1/COL_LINE0
+ pixRst<12> pixRst<13> col_periphery_1x2_1/COL_LINE1 OffBn openDVS_pixel2x2_top_414/vpd[2]
+ openDVS_pixel2x2_top_414/vpd[3] openDVS_pixel2x2_top_414/vpd[1] openDVS_pixel2x2_top_414/vpd[0]
+ rowReadON<39> rowReadOFF<38> openDVS_pixel2x2_top_999/GndD DiffBn GndA OnBn VddA18
+ openDVS_pixel2x2_top
XopenDVS_pixel2x2_top_981 rowReadOFF<27> rowReadON<26> RefrBp PrBp PrSFBp col_periphery_1x2_24/COL_LINE0
+ pixRst<50> pixRst<51> col_periphery_1x2_24/COL_LINE1 OffBn openDVS_pixel2x2_top_981/vpd[2]
+ openDVS_pixel2x2_top_981/vpd[3] openDVS_pixel2x2_top_981/vpd[1] openDVS_pixel2x2_top_981/vpd[0]
+ rowReadON<27> rowReadOFF<26> openDVS_pixel2x2_top_987/GndD DiffBn GndA OnBn VddA18
+ openDVS_pixel2x2_top
XopenDVS_pixel2x2_top_970 rowReadOFF<27> rowReadON<26> RefrBp PrBp PrSFBp col_periphery_1x2_13/COL_LINE0
+ pixRst<28> pixRst<29> col_periphery_1x2_13/COL_LINE1 OffBn openDVS_pixel2x2_top_970/vpd[2]
+ openDVS_pixel2x2_top_970/vpd[3] openDVS_pixel2x2_top_970/vpd[1] openDVS_pixel2x2_top_970/vpd[0]
+ rowReadON<27> rowReadOFF<26> openDVS_pixel2x2_top_987/GndD DiffBn GndA OnBn VddA18
+ openDVS_pixel2x2_top
XopenDVS_pixel2x2_top_992 rowReadOFF<33> rowReadON<32> RefrBp PrBp PrSFBp col_periphery_1x2_14/COL_LINE0
+ pixRst<30> pixRst<31> col_periphery_1x2_14/COL_LINE1 OffBn openDVS_pixel2x2_top_992/vpd[2]
+ openDVS_pixel2x2_top_992/vpd[3] openDVS_pixel2x2_top_992/vpd[1] openDVS_pixel2x2_top_992/vpd[0]
+ rowReadON<33> rowReadOFF<32> openDVS_pixel2x2_top_993/GndD DiffBn GndA OnBn VddA18
+ openDVS_pixel2x2_top
XopenDVS_pixel2x2_top_211 rowReadOFF<31> rowReadON<30> RefrBp PrBp PrSFBp col_periphery_1x2_24/COL_LINE0
+ pixRst<50> pixRst<51> col_periphery_1x2_24/COL_LINE1 OffBn openDVS_pixel2x2_top_211/vpd[2]
+ openDVS_pixel2x2_top_211/vpd[3] openDVS_pixel2x2_top_211/vpd[1] openDVS_pixel2x2_top_211/vpd[0]
+ rowReadON<31> rowReadOFF<30> openDVS_pixel2x2_top_991/GndD DiffBn GndA OnBn VddA18
+ openDVS_pixel2x2_top
XopenDVS_pixel2x2_top_200 rowReadOFF<33> rowReadON<32> RefrBp PrBp PrSFBp col_periphery_1x2_28/COL_LINE0
+ pixRst<58> pixRst<59> col_periphery_1x2_28/COL_LINE1 OffBn openDVS_pixel2x2_top_200/vpd[2]
+ openDVS_pixel2x2_top_200/vpd[3] openDVS_pixel2x2_top_200/vpd[1] openDVS_pixel2x2_top_200/vpd[0]
+ rowReadON<33> rowReadOFF<32> openDVS_pixel2x2_top_993/GndD DiffBn GndA OnBn VddA18
+ openDVS_pixel2x2_top
XopenDVS_pixel2x2_top_222 rowReadOFF<37> rowReadON<36> RefrBp PrBp PrSFBp col_periphery_1x2_31/COL_LINE0
+ pixRst<48> pixRst<49> col_periphery_1x2_31/COL_LINE1 OffBn openDVS_pixel2x2_top_222/vpd[2]
+ openDVS_pixel2x2_top_222/vpd[3] openDVS_pixel2x2_top_222/vpd[1] openDVS_pixel2x2_top_222/vpd[0]
+ rowReadON<37> rowReadOFF<36> openDVS_pixel2x2_top_997/GndD DiffBn GndA OnBn VddA18
+ openDVS_pixel2x2_top
XopenDVS_pixel2x2_top_266 rowReadOFF<35> rowReadON<34> RefrBp PrBp PrSFBp col_periphery_1x2_23/COL_LINE0
+ pixRst<46> pixRst<47> col_periphery_1x2_23/COL_LINE1 OffBn openDVS_pixel2x2_top_266/vpd[2]
+ openDVS_pixel2x2_top_266/vpd[3] openDVS_pixel2x2_top_266/vpd[1] openDVS_pixel2x2_top_266/vpd[0]
+ rowReadON<35> rowReadOFF<34> openDVS_pixel2x2_top_995/GndD DiffBn GndA OnBn VddA18
+ openDVS_pixel2x2_top
XopenDVS_pixel2x2_top_288 rowReadOFF<61> rowReadON<60> RefrBp PrBp PrSFBp col_periphery_1x2_11/COL_LINE0
+ pixRst<24> pixRst<25> col_periphery_1x2_11/COL_LINE1 OffBn openDVS_pixel2x2_top_288/vpd[2]
+ openDVS_pixel2x2_top_288/vpd[3] openDVS_pixel2x2_top_288/vpd[1] openDVS_pixel2x2_top_288/vpd[0]
+ rowReadON<61> rowReadOFF<60> openDVS_pixel2x2_top_96/GndD DiffBn GndA OnBn VddA18
+ openDVS_pixel2x2_top
XopenDVS_pixel2x2_top_233 rowReadOFF<61> rowReadON<60> RefrBp PrBp PrSFBp col_periphery_1x2_23/COL_LINE0
+ pixRst<46> pixRst<47> col_periphery_1x2_23/COL_LINE1 OffBn openDVS_pixel2x2_top_233/vpd[2]
+ openDVS_pixel2x2_top_233/vpd[3] openDVS_pixel2x2_top_233/vpd[1] openDVS_pixel2x2_top_233/vpd[0]
+ rowReadON<61> rowReadOFF<60> openDVS_pixel2x2_top_96/GndD DiffBn GndA OnBn VddA18
+ openDVS_pixel2x2_top
XopenDVS_pixel2x2_top_277 rowReadOFF<51> rowReadON<50> RefrBp PrBp PrSFBp col_periphery_1x2_11/COL_LINE0
+ pixRst<24> pixRst<25> col_periphery_1x2_11/COL_LINE1 OffBn openDVS_pixel2x2_top_277/vpd[2]
+ openDVS_pixel2x2_top_277/vpd[3] openDVS_pixel2x2_top_277/vpd[1] openDVS_pixel2x2_top_277/vpd[0]
+ rowReadON<51> rowReadOFF<50> openDVS_pixel2x2_top_6/GndD DiffBn GndA OnBn VddA18
+ openDVS_pixel2x2_top
XopenDVS_pixel2x2_top_299 rowReadOFF<47> rowReadON<46> RefrBp PrBp PrSFBp col_periphery_1x2_13/COL_LINE0
+ pixRst<28> pixRst<29> col_periphery_1x2_13/COL_LINE1 OffBn openDVS_pixel2x2_top_299/vpd[2]
+ openDVS_pixel2x2_top_299/vpd[3] openDVS_pixel2x2_top_299/vpd[1] openDVS_pixel2x2_top_299/vpd[0]
+ rowReadON<47> rowReadOFF<46> openDVS_pixel2x2_top_78/GndD DiffBn GndA OnBn VddA18
+ openDVS_pixel2x2_top
XopenDVS_pixel2x2_top_244 rowReadOFF<45> rowReadON<44> RefrBp PrBp PrSFBp col_periphery_1x2_22/COL_LINE0
+ pixRst<44> pixRst<45> col_periphery_1x2_22/COL_LINE1 OffBn openDVS_pixel2x2_top_244/vpd[2]
+ openDVS_pixel2x2_top_244/vpd[3] openDVS_pixel2x2_top_244/vpd[1] openDVS_pixel2x2_top_244/vpd[0]
+ rowReadON<45> rowReadOFF<44> openDVS_pixel2x2_top_539/GndD DiffBn GndA OnBn VddA18
+ openDVS_pixel2x2_top
XopenDVS_pixel2x2_top_255 rowReadOFF<45> rowReadON<44> RefrBp PrBp PrSFBp col_periphery_1x2_30/COL_LINE0
+ pixRst<62> pixRst<63> col_periphery_1x2_30/COL_LINE1 OffBn openDVS_pixel2x2_top_255/vpd[2]
+ openDVS_pixel2x2_top_255/vpd[3] openDVS_pixel2x2_top_255/vpd[1] openDVS_pixel2x2_top_255/vpd[0]
+ rowReadON<45> rowReadOFF<44> openDVS_pixel2x2_top_539/GndD DiffBn GndA OnBn VddA18
+ openDVS_pixel2x2_top
Xcol_periphery_1x2_30 pixRst<63> col_periphery_1x2_30/COL_LINE0 col_periphery_1x2_30/COL_LINE1
+ nDETECT DETECT col_periphery_1x2_9/VDD VTHRESH pixRst<62> voutn<62> GndA voutn<63>
+ NCHARGE col_periphery_1x2
XopenDVS_pixel2x2_top_629 rowReadOFF<11> rowReadON<10> RefrBp PrBp PrSFBp col_periphery_1x2_1/COL_LINE0
+ pixRst<12> pixRst<13> col_periphery_1x2_1/COL_LINE1 OffBn openDVS_pixel2x2_top_629/vpd[2]
+ openDVS_pixel2x2_top_629/vpd[3] openDVS_pixel2x2_top_629/vpd[1] openDVS_pixel2x2_top_629/vpd[0]
+ rowReadON<11> rowReadOFF<10> openDVS_pixel2x2_top_941/GndD DiffBn GndA OnBn VddA18
+ openDVS_pixel2x2_top
XopenDVS_pixel2x2_top_618 rowReadOFF<19> rowReadON<18> RefrBp PrBp PrSFBp col_periphery_1x2_6/COL_LINE0
+ pixRst<8> pixRst<9> col_periphery_1x2_6/COL_LINE1 OffBn openDVS_pixel2x2_top_618/vpd[2]
+ openDVS_pixel2x2_top_618/vpd[3] openDVS_pixel2x2_top_618/vpd[1] openDVS_pixel2x2_top_618/vpd[0]
+ rowReadON<19> rowReadOFF<18> openDVS_pixel2x2_top_949/GndD DiffBn GndA OnBn VddA18
+ openDVS_pixel2x2_top
XopenDVS_pixel2x2_top_607 rowReadOFF<15> rowReadON<14> RefrBp PrBp PrSFBp col_periphery_1x2_2/COL_LINE0
+ pixRst<0> pixRst<1> col_periphery_1x2_2/COL_LINE1 OffBn openDVS_pixel2x2_top_607/vpd[2]
+ openDVS_pixel2x2_top_607/vpd[3] openDVS_pixel2x2_top_607/vpd[1] openDVS_pixel2x2_top_607/vpd[0]
+ rowReadON<15> rowReadOFF<14> openDVS_pixel2x2_top_945/GndD DiffBn GndA OnBn VddA18
+ openDVS_pixel2x2_top
XopenDVS_pixel2x2_top_437 rowReadOFF<31> rowReadON<30> RefrBp PrBp PrSFBp col_periphery_1x2_1/COL_LINE0
+ pixRst<12> pixRst<13> col_periphery_1x2_1/COL_LINE1 OffBn openDVS_pixel2x2_top_437/vpd[2]
+ openDVS_pixel2x2_top_437/vpd[3] openDVS_pixel2x2_top_437/vpd[1] openDVS_pixel2x2_top_437/vpd[0]
+ rowReadON<31> rowReadOFF<30> openDVS_pixel2x2_top_991/GndD DiffBn GndA OnBn VddA18
+ openDVS_pixel2x2_top
XopenDVS_pixel2x2_top_426 rowReadOFF<43> rowReadON<42> RefrBp PrBp PrSFBp col_periphery_1x2_3/COL_LINE0
+ pixRst<2> pixRst<3> col_periphery_1x2_3/COL_LINE1 OffBn openDVS_pixel2x2_top_426/vpd[2]
+ openDVS_pixel2x2_top_426/vpd[3] openDVS_pixel2x2_top_426/vpd[1] openDVS_pixel2x2_top_426/vpd[0]
+ rowReadON<43> rowReadOFF<42> openDVS_pixel2x2_top_537/GndD DiffBn GndA OnBn VddA18
+ openDVS_pixel2x2_top
XopenDVS_pixel2x2_top_404 rowReadOFF<39> rowReadON<38> RefrBp PrBp PrSFBp col_periphery_1x2_5/COL_LINE0
+ pixRst<6> pixRst<7> col_periphery_1x2_5/COL_LINE1 OffBn openDVS_pixel2x2_top_404/vpd[2]
+ openDVS_pixel2x2_top_404/vpd[3] openDVS_pixel2x2_top_404/vpd[1] openDVS_pixel2x2_top_404/vpd[0]
+ rowReadON<39> rowReadOFF<38> openDVS_pixel2x2_top_999/GndD DiffBn GndA OnBn VddA18
+ openDVS_pixel2x2_top
XopenDVS_pixel2x2_top_415 rowReadOFF<41> rowReadON<40> RefrBp PrBp PrSFBp col_periphery_1x2_0/COL_LINE0
+ pixRst<10> pixRst<11> col_periphery_1x2_0/COL_LINE1 OffBn openDVS_pixel2x2_top_415/vpd[2]
+ openDVS_pixel2x2_top_415/vpd[3] openDVS_pixel2x2_top_415/vpd[1] openDVS_pixel2x2_top_415/vpd[0]
+ rowReadON<41> rowReadOFF<40> openDVS_pixel2x2_top_535/GndD DiffBn GndA OnBn VddA18
+ openDVS_pixel2x2_top
XopenDVS_pixel2x2_top_982 rowReadOFF<27> rowReadON<26> RefrBp PrBp PrSFBp col_periphery_1x2_25/COL_LINE0
+ pixRst<52> pixRst<53> col_periphery_1x2_25/COL_LINE1 OffBn openDVS_pixel2x2_top_982/vpd[2]
+ openDVS_pixel2x2_top_982/vpd[3] openDVS_pixel2x2_top_982/vpd[1] openDVS_pixel2x2_top_982/vpd[0]
+ rowReadON<27> rowReadOFF<26> openDVS_pixel2x2_top_987/GndD DiffBn GndA OnBn VddA18
+ openDVS_pixel2x2_top
XopenDVS_pixel2x2_top_971 rowReadOFF<27> rowReadON<26> RefrBp PrBp PrSFBp col_periphery_1x2_14/COL_LINE0
+ pixRst<30> pixRst<31> col_periphery_1x2_14/COL_LINE1 OffBn openDVS_pixel2x2_top_971/vpd[2]
+ openDVS_pixel2x2_top_971/vpd[3] openDVS_pixel2x2_top_971/vpd[1] openDVS_pixel2x2_top_971/vpd[0]
+ rowReadON<27> rowReadOFF<26> openDVS_pixel2x2_top_987/GndD DiffBn GndA OnBn VddA18
+ openDVS_pixel2x2_top
XopenDVS_pixel2x2_top_960 rowReadOFF<27> rowReadON<26> RefrBp PrBp PrSFBp col_periphery_1x2_6/COL_LINE0
+ pixRst<8> pixRst<9> col_periphery_1x2_6/COL_LINE1 OffBn openDVS_pixel2x2_top_960/vpd[2]
+ openDVS_pixel2x2_top_960/vpd[3] openDVS_pixel2x2_top_960/vpd[1] openDVS_pixel2x2_top_960/vpd[0]
+ rowReadON<27> rowReadOFF<26> openDVS_pixel2x2_top_987/GndD DiffBn GndA OnBn VddA18
+ openDVS_pixel2x2_top
XopenDVS_pixel2x2_top_459 rowReadOFF<37> rowReadON<36> RefrBp PrBp PrSFBp col_periphery_1x2_9/COL_LINE0
+ pixRst<20> pixRst<21> col_periphery_1x2_9/COL_LINE1 OffBn openDVS_pixel2x2_top_459/vpd[2]
+ openDVS_pixel2x2_top_459/vpd[3] openDVS_pixel2x2_top_459/vpd[1] openDVS_pixel2x2_top_459/vpd[0]
+ rowReadON<37> rowReadOFF<36> openDVS_pixel2x2_top_997/GndD DiffBn GndA OnBn VddA18
+ openDVS_pixel2x2_top
XopenDVS_pixel2x2_top_448 rowReadOFF<41> rowReadON<40> RefrBp PrBp PrSFBp col_periphery_1x2_10/COL_LINE0
+ pixRst<22> pixRst<23> col_periphery_1x2_10/COL_LINE1 OffBn openDVS_pixel2x2_top_448/vpd[2]
+ openDVS_pixel2x2_top_448/vpd[3] openDVS_pixel2x2_top_448/vpd[1] openDVS_pixel2x2_top_448/vpd[0]
+ rowReadON<41> rowReadOFF<40> openDVS_pixel2x2_top_535/GndD DiffBn GndA OnBn VddA18
+ openDVS_pixel2x2_top
XopenDVS_pixel2x2_top_993 rowReadOFF<33> rowReadON<32> RefrBp PrBp PrSFBp col_periphery_1x2_16/COL_LINE0
+ pixRst<32> pixRst<33> col_periphery_1x2_16/COL_LINE1 OffBn openDVS_pixel2x2_top_993/vpd[2]
+ openDVS_pixel2x2_top_993/vpd[3] openDVS_pixel2x2_top_993/vpd[1] openDVS_pixel2x2_top_993/vpd[0]
+ rowReadON<33> rowReadOFF<32> openDVS_pixel2x2_top_993/GndD DiffBn GndA OnBn VddA18
+ openDVS_pixel2x2_top
XopenDVS_pixel2x2_top_212 rowReadOFF<31> rowReadON<30> RefrBp PrBp PrSFBp col_periphery_1x2_25/COL_LINE0
+ pixRst<52> pixRst<53> col_periphery_1x2_25/COL_LINE1 OffBn openDVS_pixel2x2_top_212/vpd[2]
+ openDVS_pixel2x2_top_212/vpd[3] openDVS_pixel2x2_top_212/vpd[1] openDVS_pixel2x2_top_212/vpd[0]
+ rowReadON<31> rowReadOFF<30> openDVS_pixel2x2_top_991/GndD DiffBn GndA OnBn VddA18
+ openDVS_pixel2x2_top
XopenDVS_pixel2x2_top_267 rowReadOFF<35> rowReadON<34> RefrBp PrBp PrSFBp col_periphery_1x2_31/COL_LINE0
+ pixRst<48> pixRst<49> col_periphery_1x2_31/COL_LINE1 OffBn openDVS_pixel2x2_top_267/vpd[2]
+ openDVS_pixel2x2_top_267/vpd[3] openDVS_pixel2x2_top_267/vpd[1] openDVS_pixel2x2_top_267/vpd[0]
+ rowReadON<35> rowReadOFF<34> openDVS_pixel2x2_top_995/GndD DiffBn GndA OnBn VddA18
+ openDVS_pixel2x2_top
XopenDVS_pixel2x2_top_289 rowReadOFF<61> rowReadON<60> RefrBp PrBp PrSFBp col_periphery_1x2_9/COL_LINE0
+ pixRst<20> pixRst<21> col_periphery_1x2_9/COL_LINE1 OffBn openDVS_pixel2x2_top_289/vpd[2]
+ openDVS_pixel2x2_top_289/vpd[3] openDVS_pixel2x2_top_289/vpd[1] openDVS_pixel2x2_top_289/vpd[0]
+ rowReadON<61> rowReadOFF<60> openDVS_pixel2x2_top_96/GndD DiffBn GndA OnBn VddA18
+ openDVS_pixel2x2_top
XopenDVS_pixel2x2_top_256 rowReadOFF<59> rowReadON<58> RefrBp PrBp PrSFBp col_periphery_1x2_23/COL_LINE0
+ pixRst<46> pixRst<47> col_periphery_1x2_23/COL_LINE1 OffBn openDVS_pixel2x2_top_256/vpd[2]
+ openDVS_pixel2x2_top_256/vpd[3] openDVS_pixel2x2_top_256/vpd[1] openDVS_pixel2x2_top_256/vpd[0]
+ rowReadON<59> rowReadOFF<58> openDVS_pixel2x2_top_74/GndD DiffBn GndA OnBn VddA18
+ openDVS_pixel2x2_top
XopenDVS_pixel2x2_top_223 rowReadOFF<63> rowReadON<62> RefrBp PrBp PrSFBp col_periphery_1x2_23/COL_LINE0
+ pixRst<46> pixRst<47> col_periphery_1x2_23/COL_LINE1 OffBn openDVS_pixel2x2_top_223/vpd[2]
+ openDVS_pixel2x2_top_223/vpd[3] openDVS_pixel2x2_top_223/vpd[1] openDVS_pixel2x2_top_223/vpd[0]
+ rowReadON<63> rowReadOFF<62> openDVS_pixel2x2_top_82/GndD DiffBn GndA OnBn VddA18
+ openDVS_pixel2x2_top
XopenDVS_pixel2x2_top_278 rowReadOFF<51> rowReadON<50> RefrBp PrBp PrSFBp col_periphery_1x2_12/COL_LINE0
+ pixRst<26> pixRst<27> col_periphery_1x2_12/COL_LINE1 OffBn openDVS_pixel2x2_top_278/vpd[2]
+ openDVS_pixel2x2_top_278/vpd[3] openDVS_pixel2x2_top_278/vpd[1] openDVS_pixel2x2_top_278/vpd[0]
+ rowReadON<51> rowReadOFF<50> openDVS_pixel2x2_top_6/GndD DiffBn GndA OnBn VddA18
+ openDVS_pixel2x2_top
XopenDVS_pixel2x2_top_245 rowReadOFF<45> rowReadON<44> RefrBp PrBp PrSFBp col_periphery_1x2_23/COL_LINE0
+ pixRst<46> pixRst<47> col_periphery_1x2_23/COL_LINE1 OffBn openDVS_pixel2x2_top_245/vpd[2]
+ openDVS_pixel2x2_top_245/vpd[3] openDVS_pixel2x2_top_245/vpd[1] openDVS_pixel2x2_top_245/vpd[0]
+ rowReadON<45> rowReadOFF<44> openDVS_pixel2x2_top_539/GndD DiffBn GndA OnBn VddA18
+ openDVS_pixel2x2_top
XopenDVS_pixel2x2_top_234 rowReadOFF<43> rowReadON<42> RefrBp PrBp PrSFBp col_periphery_1x2_23/COL_LINE0
+ pixRst<46> pixRst<47> col_periphery_1x2_23/COL_LINE1 OffBn openDVS_pixel2x2_top_234/vpd[2]
+ openDVS_pixel2x2_top_234/vpd[3] openDVS_pixel2x2_top_234/vpd[1] openDVS_pixel2x2_top_234/vpd[0]
+ rowReadON<43> rowReadOFF<42> openDVS_pixel2x2_top_537/GndD DiffBn GndA OnBn VddA18
+ openDVS_pixel2x2_top
XopenDVS_pixel2x2_top_201 rowReadOFF<43> rowReadON<42> RefrBp PrBp PrSFBp col_periphery_1x2_24/COL_LINE0
+ pixRst<50> pixRst<51> col_periphery_1x2_24/COL_LINE1 OffBn openDVS_pixel2x2_top_201/vpd[2]
+ openDVS_pixel2x2_top_201/vpd[3] openDVS_pixel2x2_top_201/vpd[1] openDVS_pixel2x2_top_201/vpd[0]
+ rowReadON<43> rowReadOFF<42> openDVS_pixel2x2_top_537/GndD DiffBn GndA OnBn VddA18
+ openDVS_pixel2x2_top
XopenDVS_pixel2x2_top_790 rowReadOFF<25> rowReadON<24> RefrBp PrBp PrSFBp col_periphery_1x2_26/COL_LINE0
+ pixRst<54> pixRst<55> col_periphery_1x2_26/COL_LINE1 OffBn openDVS_pixel2x2_top_790/vpd[2]
+ openDVS_pixel2x2_top_790/vpd[3] openDVS_pixel2x2_top_790/vpd[1] openDVS_pixel2x2_top_790/vpd[0]
+ rowReadON<25> rowReadOFF<24> openDVS_pixel2x2_top_955/GndD DiffBn GndA OnBn VddA18
+ openDVS_pixel2x2_top
Xcol_periphery_1x2_31 pixRst<49> col_periphery_1x2_31/COL_LINE0 col_periphery_1x2_31/COL_LINE1
+ nDETECT DETECT col_periphery_1x2_9/VDD VTHRESH pixRst<48> voutn<48> GndA voutn<49>
+ NCHARGE col_periphery_1x2
Xcol_periphery_1x2_20 pixRst<41> col_periphery_1x2_20/COL_LINE0 col_periphery_1x2_20/COL_LINE1
+ nDETECT DETECT col_periphery_1x2_9/VDD VTHRESH pixRst<40> voutn<40> GndA voutn<41>
+ NCHARGE col_periphery_1x2
XopenDVS_pixel2x2_top_619 rowReadOFF<19> rowReadON<18> RefrBp PrBp PrSFBp col_periphery_1x2_0/COL_LINE0
+ pixRst<10> pixRst<11> col_periphery_1x2_0/COL_LINE1 OffBn openDVS_pixel2x2_top_619/vpd[2]
+ openDVS_pixel2x2_top_619/vpd[3] openDVS_pixel2x2_top_619/vpd[1] openDVS_pixel2x2_top_619/vpd[0]
+ rowReadON<19> rowReadOFF<18> openDVS_pixel2x2_top_949/GndD DiffBn GndA OnBn VddA18
+ openDVS_pixel2x2_top
XopenDVS_pixel2x2_top_608 rowReadOFF<15> rowReadON<14> RefrBp PrBp PrSFBp col_periphery_1x2_3/COL_LINE0
+ pixRst<2> pixRst<3> col_periphery_1x2_3/COL_LINE1 OffBn openDVS_pixel2x2_top_608/vpd[2]
+ openDVS_pixel2x2_top_608/vpd[3] openDVS_pixel2x2_top_608/vpd[1] openDVS_pixel2x2_top_608/vpd[0]
+ rowReadON<15> rowReadOFF<14> openDVS_pixel2x2_top_945/GndD DiffBn GndA OnBn VddA18
+ openDVS_pixel2x2_top
XopenDVS_pixel2x2_top_416 rowReadOFF<29> rowReadON<28> RefrBp PrBp PrSFBp col_periphery_1x2_2/COL_LINE0
+ pixRst<0> pixRst<1> col_periphery_1x2_2/COL_LINE1 OffBn openDVS_pixel2x2_top_416/vpd[2]
+ openDVS_pixel2x2_top_416/vpd[3] openDVS_pixel2x2_top_416/vpd[1] openDVS_pixel2x2_top_416/vpd[0]
+ rowReadON<29> rowReadOFF<28> openDVS_pixel2x2_top_989/GndD DiffBn GndA OnBn VddA18
+ openDVS_pixel2x2_top
XopenDVS_pixel2x2_top_449 rowReadOFF<41> rowReadON<40> RefrBp PrBp PrSFBp col_periphery_1x2_11/COL_LINE0
+ pixRst<24> pixRst<25> col_periphery_1x2_11/COL_LINE1 OffBn openDVS_pixel2x2_top_449/vpd[2]
+ openDVS_pixel2x2_top_449/vpd[3] openDVS_pixel2x2_top_449/vpd[1] openDVS_pixel2x2_top_449/vpd[0]
+ rowReadON<41> rowReadOFF<40> openDVS_pixel2x2_top_535/GndD DiffBn GndA OnBn VddA18
+ openDVS_pixel2x2_top
XopenDVS_pixel2x2_top_427 rowReadOFF<37> rowReadON<36> RefrBp PrBp PrSFBp col_periphery_1x2_2/COL_LINE0
+ pixRst<0> pixRst<1> col_periphery_1x2_2/COL_LINE1 OffBn openDVS_pixel2x2_top_427/vpd[2]
+ openDVS_pixel2x2_top_427/vpd[3] openDVS_pixel2x2_top_427/vpd[1] openDVS_pixel2x2_top_427/vpd[0]
+ rowReadON<37> rowReadOFF<36> openDVS_pixel2x2_top_997/GndD DiffBn GndA OnBn VddA18
+ openDVS_pixel2x2_top
XopenDVS_pixel2x2_top_405 rowReadOFF<35> rowReadON<34> RefrBp PrBp PrSFBp col_periphery_1x2_2/COL_LINE0
+ pixRst<0> pixRst<1> col_periphery_1x2_2/COL_LINE1 OffBn openDVS_pixel2x2_top_405/vpd[2]
+ openDVS_pixel2x2_top_405/vpd[3] openDVS_pixel2x2_top_405/vpd[1] openDVS_pixel2x2_top_405/vpd[0]
+ rowReadON<35> rowReadOFF<34> openDVS_pixel2x2_top_995/GndD DiffBn GndA OnBn VddA18
+ openDVS_pixel2x2_top
XopenDVS_pixel2x2_top_438 rowReadOFF<37> rowReadON<36> RefrBp PrBp PrSFBp col_periphery_1x2_6/COL_LINE0
+ pixRst<8> pixRst<9> col_periphery_1x2_6/COL_LINE1 OffBn openDVS_pixel2x2_top_438/vpd[2]
+ openDVS_pixel2x2_top_438/vpd[3] openDVS_pixel2x2_top_438/vpd[1] openDVS_pixel2x2_top_438/vpd[0]
+ rowReadON<37> rowReadOFF<36> openDVS_pixel2x2_top_997/GndD DiffBn GndA OnBn VddA18
+ openDVS_pixel2x2_top
XopenDVS_pixel2x2_top_983 rowReadOFF<27> rowReadON<26> RefrBp PrBp PrSFBp col_periphery_1x2_26/COL_LINE0
+ pixRst<54> pixRst<55> col_periphery_1x2_26/COL_LINE1 OffBn openDVS_pixel2x2_top_983/vpd[2]
+ openDVS_pixel2x2_top_983/vpd[3] openDVS_pixel2x2_top_983/vpd[1] openDVS_pixel2x2_top_983/vpd[0]
+ rowReadON<27> rowReadOFF<26> openDVS_pixel2x2_top_987/GndD DiffBn GndA OnBn VddA18
+ openDVS_pixel2x2_top
XopenDVS_pixel2x2_top_972 rowReadOFF<27> rowReadON<26> RefrBp PrBp PrSFBp col_periphery_1x2_16/COL_LINE0
+ pixRst<32> pixRst<33> col_periphery_1x2_16/COL_LINE1 OffBn openDVS_pixel2x2_top_972/vpd[2]
+ openDVS_pixel2x2_top_972/vpd[3] openDVS_pixel2x2_top_972/vpd[1] openDVS_pixel2x2_top_972/vpd[0]
+ rowReadON<27> rowReadOFF<26> openDVS_pixel2x2_top_987/GndD DiffBn GndA OnBn VddA18
+ openDVS_pixel2x2_top
XopenDVS_pixel2x2_top_950 rowReadOFF<21> rowReadON<20> RefrBp PrBp PrSFBp col_periphery_1x2_14/COL_LINE0
+ pixRst<30> pixRst<31> col_periphery_1x2_14/COL_LINE1 OffBn openDVS_pixel2x2_top_950/vpd[2]
+ openDVS_pixel2x2_top_950/vpd[3] openDVS_pixel2x2_top_950/vpd[1] openDVS_pixel2x2_top_950/vpd[0]
+ rowReadON<21> rowReadOFF<20> openDVS_pixel2x2_top_951/GndD DiffBn GndA OnBn VddA18
+ openDVS_pixel2x2_top
XopenDVS_pixel2x2_top_961 rowReadOFF<27> rowReadON<26> RefrBp PrBp PrSFBp col_periphery_1x2_0/COL_LINE0
+ pixRst<10> pixRst<11> col_periphery_1x2_0/COL_LINE1 OffBn openDVS_pixel2x2_top_961/vpd[2]
+ openDVS_pixel2x2_top_961/vpd[3] openDVS_pixel2x2_top_961/vpd[1] openDVS_pixel2x2_top_961/vpd[0]
+ rowReadON<27> rowReadOFF<26> openDVS_pixel2x2_top_987/GndD DiffBn GndA OnBn VddA18
+ openDVS_pixel2x2_top
XopenDVS_pixel2x2_top_994 rowReadOFF<35> rowReadON<34> RefrBp PrBp PrSFBp col_periphery_1x2_14/COL_LINE0
+ pixRst<30> pixRst<31> col_periphery_1x2_14/COL_LINE1 OffBn openDVS_pixel2x2_top_994/vpd[2]
+ openDVS_pixel2x2_top_994/vpd[3] openDVS_pixel2x2_top_994/vpd[1] openDVS_pixel2x2_top_994/vpd[0]
+ rowReadON<35> rowReadOFF<34> openDVS_pixel2x2_top_995/GndD DiffBn GndA OnBn VddA18
+ openDVS_pixel2x2_top
XopenDVS_pixel2x2_top_213 rowReadOFF<31> rowReadON<30> RefrBp PrBp PrSFBp col_periphery_1x2_26/COL_LINE0
+ pixRst<54> pixRst<55> col_periphery_1x2_26/COL_LINE1 OffBn openDVS_pixel2x2_top_213/vpd[2]
+ openDVS_pixel2x2_top_213/vpd[3] openDVS_pixel2x2_top_213/vpd[1] openDVS_pixel2x2_top_213/vpd[0]
+ rowReadON<31> rowReadOFF<30> openDVS_pixel2x2_top_991/GndD DiffBn GndA OnBn VddA18
+ openDVS_pixel2x2_top
XopenDVS_pixel2x2_top_257 rowReadOFF<59> rowReadON<58> RefrBp PrBp PrSFBp col_periphery_1x2_31/COL_LINE0
+ pixRst<48> pixRst<49> col_periphery_1x2_31/COL_LINE1 OffBn openDVS_pixel2x2_top_257/vpd[2]
+ openDVS_pixel2x2_top_257/vpd[3] openDVS_pixel2x2_top_257/vpd[1] openDVS_pixel2x2_top_257/vpd[0]
+ rowReadON<59> rowReadOFF<58> openDVS_pixel2x2_top_74/GndD DiffBn GndA OnBn VddA18
+ openDVS_pixel2x2_top
XopenDVS_pixel2x2_top_224 rowReadOFF<63> rowReadON<62> RefrBp PrBp PrSFBp col_periphery_1x2_31/COL_LINE0
+ pixRst<48> pixRst<49> col_periphery_1x2_31/COL_LINE1 OffBn openDVS_pixel2x2_top_224/vpd[2]
+ openDVS_pixel2x2_top_224/vpd[3] openDVS_pixel2x2_top_224/vpd[1] openDVS_pixel2x2_top_224/vpd[0]
+ rowReadON<63> rowReadOFF<62> openDVS_pixel2x2_top_82/GndD DiffBn GndA OnBn VddA18
+ openDVS_pixel2x2_top
XopenDVS_pixel2x2_top_279 rowReadOFF<51> rowReadON<50> RefrBp PrBp PrSFBp col_periphery_1x2_13/COL_LINE0
+ pixRst<28> pixRst<29> col_periphery_1x2_13/COL_LINE1 OffBn openDVS_pixel2x2_top_279/vpd[2]
+ openDVS_pixel2x2_top_279/vpd[3] openDVS_pixel2x2_top_279/vpd[1] openDVS_pixel2x2_top_279/vpd[0]
+ rowReadON<51> rowReadOFF<50> openDVS_pixel2x2_top_6/GndD DiffBn GndA OnBn VddA18
+ openDVS_pixel2x2_top
XopenDVS_pixel2x2_top_268 rowReadOFF<49> rowReadON<48> RefrBp PrBp PrSFBp col_periphery_1x2_23/COL_LINE0
+ pixRst<46> pixRst<47> col_periphery_1x2_23/COL_LINE1 OffBn openDVS_pixel2x2_top_268/vpd[2]
+ openDVS_pixel2x2_top_268/vpd[3] openDVS_pixel2x2_top_268/vpd[1] openDVS_pixel2x2_top_268/vpd[0]
+ rowReadON<49> rowReadOFF<48> openDVS_pixel2x2_top_3/GndD DiffBn GndA OnBn VddA18
+ openDVS_pixel2x2_top
XopenDVS_pixel2x2_top_246 rowReadOFF<45> rowReadON<44> RefrBp PrBp PrSFBp col_periphery_1x2_31/COL_LINE0
+ pixRst<48> pixRst<49> col_periphery_1x2_31/COL_LINE1 OffBn openDVS_pixel2x2_top_246/vpd[2]
+ openDVS_pixel2x2_top_246/vpd[3] openDVS_pixel2x2_top_246/vpd[1] openDVS_pixel2x2_top_246/vpd[0]
+ rowReadON<45> rowReadOFF<44> openDVS_pixel2x2_top_539/GndD DiffBn GndA OnBn VddA18
+ openDVS_pixel2x2_top
XopenDVS_pixel2x2_top_235 rowReadOFF<43> rowReadON<42> RefrBp PrBp PrSFBp col_periphery_1x2_31/COL_LINE0
+ pixRst<48> pixRst<49> col_periphery_1x2_31/COL_LINE1 OffBn openDVS_pixel2x2_top_235/vpd[2]
+ openDVS_pixel2x2_top_235/vpd[3] openDVS_pixel2x2_top_235/vpd[1] openDVS_pixel2x2_top_235/vpd[0]
+ rowReadON<43> rowReadOFF<42> openDVS_pixel2x2_top_537/GndD DiffBn GndA OnBn VddA18
+ openDVS_pixel2x2_top
XopenDVS_pixel2x2_top_202 rowReadOFF<43> rowReadON<42> RefrBp PrBp PrSFBp col_periphery_1x2_25/COL_LINE0
+ pixRst<52> pixRst<53> col_periphery_1x2_25/COL_LINE1 OffBn openDVS_pixel2x2_top_202/vpd[2]
+ openDVS_pixel2x2_top_202/vpd[3] openDVS_pixel2x2_top_202/vpd[1] openDVS_pixel2x2_top_202/vpd[0]
+ rowReadON<43> rowReadOFF<42> openDVS_pixel2x2_top_537/GndD DiffBn GndA OnBn VddA18
+ openDVS_pixel2x2_top
XopenDVS_pixel2x2_top_780 rowReadOFF<11> rowReadON<10> RefrBp PrBp PrSFBp col_periphery_1x2_26/COL_LINE0
+ pixRst<54> pixRst<55> col_periphery_1x2_26/COL_LINE1 OffBn openDVS_pixel2x2_top_780/vpd[2]
+ openDVS_pixel2x2_top_780/vpd[3] openDVS_pixel2x2_top_780/vpd[1] openDVS_pixel2x2_top_780/vpd[0]
+ rowReadON<11> rowReadOFF<10> openDVS_pixel2x2_top_941/GndD DiffBn GndA OnBn VddA18
+ openDVS_pixel2x2_top
XopenDVS_pixel2x2_top_791 rowReadOFF<11> rowReadON<10> RefrBp PrBp PrSFBp col_periphery_1x2_19/COL_LINE0
+ pixRst<38> pixRst<39> col_periphery_1x2_19/COL_LINE1 OffBn openDVS_pixel2x2_top_791/vpd[2]
+ openDVS_pixel2x2_top_791/vpd[3] openDVS_pixel2x2_top_791/vpd[1] openDVS_pixel2x2_top_791/vpd[0]
+ rowReadON<11> rowReadOFF<10> openDVS_pixel2x2_top_941/GndD DiffBn GndA OnBn VddA18
+ openDVS_pixel2x2_top
Xcol_periphery_1x2_21 pixRst<43> col_periphery_1x2_21/COL_LINE0 col_periphery_1x2_21/COL_LINE1
+ nDETECT DETECT col_periphery_1x2_9/VDD VTHRESH pixRst<42> voutn<42> GndA voutn<43>
+ NCHARGE col_periphery_1x2
Xcol_periphery_1x2_10 pixRst<23> col_periphery_1x2_10/COL_LINE0 col_periphery_1x2_10/COL_LINE1
+ nDETECT DETECT col_periphery_1x2_9/VDD VTHRESH pixRst<22> voutn<22> GndA voutn<23>
+ NCHARGE col_periphery_1x2
XopenDVS_pixel2x2_top_609 rowReadOFF<15> rowReadON<14> RefrBp PrBp PrSFBp col_periphery_1x2_4/COL_LINE0
+ pixRst<4> pixRst<5> col_periphery_1x2_4/COL_LINE1 OffBn openDVS_pixel2x2_top_609/vpd[2]
+ openDVS_pixel2x2_top_609/vpd[3] openDVS_pixel2x2_top_609/vpd[1] openDVS_pixel2x2_top_609/vpd[0]
+ rowReadON<15> rowReadOFF<14> openDVS_pixel2x2_top_945/GndD DiffBn GndA OnBn VddA18
+ openDVS_pixel2x2_top
XopenDVS_pixel2x2_top_417 rowReadOFF<29> rowReadON<28> RefrBp PrBp PrSFBp col_periphery_1x2_3/COL_LINE0
+ pixRst<2> pixRst<3> col_periphery_1x2_3/COL_LINE1 OffBn openDVS_pixel2x2_top_417/vpd[2]
+ openDVS_pixel2x2_top_417/vpd[3] openDVS_pixel2x2_top_417/vpd[1] openDVS_pixel2x2_top_417/vpd[0]
+ rowReadON<29> rowReadOFF<28> openDVS_pixel2x2_top_989/GndD DiffBn GndA OnBn VddA18
+ openDVS_pixel2x2_top
XopenDVS_pixel2x2_top_428 rowReadOFF<37> rowReadON<36> RefrBp PrBp PrSFBp col_periphery_1x2_3/COL_LINE0
+ pixRst<2> pixRst<3> col_periphery_1x2_3/COL_LINE1 OffBn openDVS_pixel2x2_top_428/vpd[2]
+ openDVS_pixel2x2_top_428/vpd[3] openDVS_pixel2x2_top_428/vpd[1] openDVS_pixel2x2_top_428/vpd[0]
+ rowReadON<37> rowReadOFF<36> openDVS_pixel2x2_top_997/GndD DiffBn GndA OnBn VddA18
+ openDVS_pixel2x2_top
XopenDVS_pixel2x2_top_406 rowReadOFF<35> rowReadON<34> RefrBp PrBp PrSFBp col_periphery_1x2_3/COL_LINE0
+ pixRst<2> pixRst<3> col_periphery_1x2_3/COL_LINE1 OffBn openDVS_pixel2x2_top_406/vpd[2]
+ openDVS_pixel2x2_top_406/vpd[3] openDVS_pixel2x2_top_406/vpd[1] openDVS_pixel2x2_top_406/vpd[0]
+ rowReadON<35> rowReadOFF<34> openDVS_pixel2x2_top_995/GndD DiffBn GndA OnBn VddA18
+ openDVS_pixel2x2_top
XopenDVS_pixel2x2_top_439 rowReadOFF<37> rowReadON<36> RefrBp PrBp PrSFBp col_periphery_1x2_0/COL_LINE0
+ pixRst<10> pixRst<11> col_periphery_1x2_0/COL_LINE1 OffBn openDVS_pixel2x2_top_439/vpd[2]
+ openDVS_pixel2x2_top_439/vpd[3] openDVS_pixel2x2_top_439/vpd[1] openDVS_pixel2x2_top_439/vpd[0]
+ rowReadON<37> rowReadOFF<36> openDVS_pixel2x2_top_997/GndD DiffBn GndA OnBn VddA18
+ openDVS_pixel2x2_top
XopenDVS_pixel2x2_top_940 rowReadOFF<11> rowReadON<10> RefrBp PrBp PrSFBp col_periphery_1x2_14/COL_LINE0
+ pixRst<30> pixRst<31> col_periphery_1x2_14/COL_LINE1 OffBn openDVS_pixel2x2_top_940/vpd[2]
+ openDVS_pixel2x2_top_940/vpd[3] openDVS_pixel2x2_top_940/vpd[1] openDVS_pixel2x2_top_940/vpd[0]
+ rowReadON<11> rowReadOFF<10> openDVS_pixel2x2_top_941/GndD DiffBn GndA OnBn VddA18
+ openDVS_pixel2x2_top
XopenDVS_pixel2x2_top_984 rowReadOFF<27> rowReadON<26> RefrBp PrBp PrSFBp col_periphery_1x2_27/COL_LINE0
+ pixRst<56> pixRst<57> col_periphery_1x2_27/COL_LINE1 OffBn openDVS_pixel2x2_top_984/vpd[2]
+ openDVS_pixel2x2_top_984/vpd[3] openDVS_pixel2x2_top_984/vpd[1] openDVS_pixel2x2_top_984/vpd[0]
+ rowReadON<27> rowReadOFF<26> openDVS_pixel2x2_top_987/GndD DiffBn GndA OnBn VddA18
+ openDVS_pixel2x2_top
XopenDVS_pixel2x2_top_951 rowReadOFF<21> rowReadON<20> RefrBp PrBp PrSFBp col_periphery_1x2_16/COL_LINE0
+ pixRst<32> pixRst<33> col_periphery_1x2_16/COL_LINE1 OffBn openDVS_pixel2x2_top_951/vpd[2]
+ openDVS_pixel2x2_top_951/vpd[3] openDVS_pixel2x2_top_951/vpd[1] openDVS_pixel2x2_top_951/vpd[0]
+ rowReadON<21> rowReadOFF<20> openDVS_pixel2x2_top_951/GndD DiffBn GndA OnBn VddA18
+ openDVS_pixel2x2_top
XopenDVS_pixel2x2_top_973 rowReadOFF<27> rowReadON<26> RefrBp PrBp PrSFBp col_periphery_1x2_17/COL_LINE0
+ pixRst<34> pixRst<35> col_periphery_1x2_17/COL_LINE1 OffBn openDVS_pixel2x2_top_973/vpd[2]
+ openDVS_pixel2x2_top_973/vpd[3] openDVS_pixel2x2_top_973/vpd[1] openDVS_pixel2x2_top_973/vpd[0]
+ rowReadON<27> rowReadOFF<26> openDVS_pixel2x2_top_987/GndD DiffBn GndA OnBn VddA18
+ openDVS_pixel2x2_top
XopenDVS_pixel2x2_top_962 rowReadOFF<27> rowReadON<26> RefrBp PrBp PrSFBp col_periphery_1x2_1/COL_LINE0
+ pixRst<12> pixRst<13> col_periphery_1x2_1/COL_LINE1 OffBn openDVS_pixel2x2_top_962/vpd[2]
+ openDVS_pixel2x2_top_962/vpd[3] openDVS_pixel2x2_top_962/vpd[1] openDVS_pixel2x2_top_962/vpd[0]
+ rowReadON<27> rowReadOFF<26> openDVS_pixel2x2_top_987/GndD DiffBn GndA OnBn VddA18
+ openDVS_pixel2x2_top
XopenDVS_pixel2x2_top_995 rowReadOFF<35> rowReadON<34> RefrBp PrBp PrSFBp col_periphery_1x2_16/COL_LINE0
+ pixRst<32> pixRst<33> col_periphery_1x2_16/COL_LINE1 OffBn openDVS_pixel2x2_top_995/vpd[2]
+ openDVS_pixel2x2_top_995/vpd[3] openDVS_pixel2x2_top_995/vpd[1] openDVS_pixel2x2_top_995/vpd[0]
+ rowReadON<35> rowReadOFF<34> openDVS_pixel2x2_top_995/GndD DiffBn GndA OnBn VddA18
+ openDVS_pixel2x2_top
XopenDVS_pixel2x2_top_214 rowReadOFF<31> rowReadON<30> RefrBp PrBp PrSFBp col_periphery_1x2_27/COL_LINE0
+ pixRst<56> pixRst<57> col_periphery_1x2_27/COL_LINE1 OffBn openDVS_pixel2x2_top_214/vpd[2]
+ openDVS_pixel2x2_top_214/vpd[3] openDVS_pixel2x2_top_214/vpd[1] openDVS_pixel2x2_top_214/vpd[0]
+ rowReadON<31> rowReadOFF<30> openDVS_pixel2x2_top_991/GndD DiffBn GndA OnBn VddA18
+ openDVS_pixel2x2_top
XopenDVS_pixel2x2_top_258 rowReadOFF<31> rowReadON<30> RefrBp PrBp PrSFBp col_periphery_1x2_23/COL_LINE0
+ pixRst<46> pixRst<47> col_periphery_1x2_23/COL_LINE1 OffBn openDVS_pixel2x2_top_258/vpd[2]
+ openDVS_pixel2x2_top_258/vpd[3] openDVS_pixel2x2_top_258/vpd[1] openDVS_pixel2x2_top_258/vpd[0]
+ rowReadON<31> rowReadOFF<30> openDVS_pixel2x2_top_991/GndD DiffBn GndA OnBn VddA18
+ openDVS_pixel2x2_top
XopenDVS_pixel2x2_top_236 rowReadOFF<53> rowReadON<52> RefrBp PrBp PrSFBp col_periphery_1x2_23/COL_LINE0
+ pixRst<46> pixRst<47> col_periphery_1x2_23/COL_LINE1 OffBn openDVS_pixel2x2_top_236/vpd[2]
+ openDVS_pixel2x2_top_236/vpd[3] openDVS_pixel2x2_top_236/vpd[1] openDVS_pixel2x2_top_236/vpd[0]
+ rowReadON<53> rowReadOFF<52> openDVS_pixel2x2_top_99/GndD DiffBn GndA OnBn VddA18
+ openDVS_pixel2x2_top
XopenDVS_pixel2x2_top_225 rowReadOFF<57> rowReadON<56> RefrBp PrBp PrSFBp col_periphery_1x2_23/COL_LINE0
+ pixRst<46> pixRst<47> col_periphery_1x2_23/COL_LINE1 OffBn openDVS_pixel2x2_top_225/vpd[2]
+ openDVS_pixel2x2_top_225/vpd[3] openDVS_pixel2x2_top_225/vpd[1] openDVS_pixel2x2_top_225/vpd[0]
+ rowReadON<57> rowReadOFF<56> openDVS_pixel2x2_top_9/GndD DiffBn GndA OnBn VddA18
+ openDVS_pixel2x2_top
XopenDVS_pixel2x2_top_269 rowReadOFF<49> rowReadON<48> RefrBp PrBp PrSFBp col_periphery_1x2_31/COL_LINE0
+ pixRst<48> pixRst<49> col_periphery_1x2_31/COL_LINE1 OffBn openDVS_pixel2x2_top_269/vpd[2]
+ openDVS_pixel2x2_top_269/vpd[3] openDVS_pixel2x2_top_269/vpd[1] openDVS_pixel2x2_top_269/vpd[0]
+ rowReadON<49> rowReadOFF<48> openDVS_pixel2x2_top_3/GndD DiffBn GndA OnBn VddA18
+ openDVS_pixel2x2_top
XopenDVS_pixel2x2_top_247 rowReadOFF<45> rowReadON<44> RefrBp PrBp PrSFBp col_periphery_1x2_24/COL_LINE0
+ pixRst<50> pixRst<51> col_periphery_1x2_24/COL_LINE1 OffBn openDVS_pixel2x2_top_247/vpd[2]
+ openDVS_pixel2x2_top_247/vpd[3] openDVS_pixel2x2_top_247/vpd[1] openDVS_pixel2x2_top_247/vpd[0]
+ rowReadON<45> rowReadOFF<44> openDVS_pixel2x2_top_539/GndD DiffBn GndA OnBn VddA18
+ openDVS_pixel2x2_top
XopenDVS_pixel2x2_top_203 rowReadOFF<43> rowReadON<42> RefrBp PrBp PrSFBp col_periphery_1x2_26/COL_LINE0
+ pixRst<54> pixRst<55> col_periphery_1x2_26/COL_LINE1 OffBn openDVS_pixel2x2_top_203/vpd[2]
+ openDVS_pixel2x2_top_203/vpd[3] openDVS_pixel2x2_top_203/vpd[1] openDVS_pixel2x2_top_203/vpd[0]
+ rowReadON<43> rowReadOFF<42> openDVS_pixel2x2_top_537/GndD DiffBn GndA OnBn VddA18
+ openDVS_pixel2x2_top
XopenDVS_pixel2x2_top_781 rowReadOFF<11> rowReadON<10> RefrBp PrBp PrSFBp col_periphery_1x2_27/COL_LINE0
+ pixRst<56> pixRst<57> col_periphery_1x2_27/COL_LINE1 OffBn openDVS_pixel2x2_top_781/vpd[2]
+ openDVS_pixel2x2_top_781/vpd[3] openDVS_pixel2x2_top_781/vpd[1] openDVS_pixel2x2_top_781/vpd[0]
+ rowReadON<11> rowReadOFF<10> openDVS_pixel2x2_top_941/GndD DiffBn GndA OnBn VddA18
+ openDVS_pixel2x2_top
XopenDVS_pixel2x2_top_792 rowReadOFF<11> rowReadON<10> RefrBp PrBp PrSFBp col_periphery_1x2_20/COL_LINE0
+ pixRst<40> pixRst<41> col_periphery_1x2_20/COL_LINE1 OffBn openDVS_pixel2x2_top_792/vpd[2]
+ openDVS_pixel2x2_top_792/vpd[3] openDVS_pixel2x2_top_792/vpd[1] openDVS_pixel2x2_top_792/vpd[0]
+ rowReadON<11> rowReadOFF<10> openDVS_pixel2x2_top_941/GndD DiffBn GndA OnBn VddA18
+ openDVS_pixel2x2_top
XopenDVS_pixel2x2_top_770 rowReadOFF<23> rowReadON<22> RefrBp PrBp PrSFBp col_periphery_1x2_27/COL_LINE0
+ pixRst<56> pixRst<57> col_periphery_1x2_27/COL_LINE1 OffBn openDVS_pixel2x2_top_770/vpd[2]
+ openDVS_pixel2x2_top_770/vpd[3] openDVS_pixel2x2_top_770/vpd[1] openDVS_pixel2x2_top_770/vpd[0]
+ rowReadON<23> rowReadOFF<22> openDVS_pixel2x2_top_953/GndD DiffBn GndA OnBn VddA18
+ openDVS_pixel2x2_top
Xcol_periphery_1x2_22 pixRst<45> col_periphery_1x2_22/COL_LINE0 col_periphery_1x2_22/COL_LINE1
+ nDETECT DETECT col_periphery_1x2_9/VDD VTHRESH pixRst<44> voutn<44> GndA voutn<45>
+ NCHARGE col_periphery_1x2
Xcol_periphery_1x2_11 pixRst<25> col_periphery_1x2_11/COL_LINE0 col_periphery_1x2_11/COL_LINE1
+ nDETECT DETECT col_periphery_1x2_9/VDD VTHRESH pixRst<24> voutn<24> GndA voutn<25>
+ NCHARGE col_periphery_1x2
XopenDVS_pixel2x2_top_418 rowReadOFF<29> rowReadON<28> RefrBp PrBp PrSFBp col_periphery_1x2_4/COL_LINE0
+ pixRst<4> pixRst<5> col_periphery_1x2_4/COL_LINE1 OffBn openDVS_pixel2x2_top_418/vpd[2]
+ openDVS_pixel2x2_top_418/vpd[3] openDVS_pixel2x2_top_418/vpd[1] openDVS_pixel2x2_top_418/vpd[0]
+ rowReadON<29> rowReadOFF<28> openDVS_pixel2x2_top_989/GndD DiffBn GndA OnBn VddA18
+ openDVS_pixel2x2_top
XopenDVS_pixel2x2_top_429 rowReadOFF<37> rowReadON<36> RefrBp PrBp PrSFBp col_periphery_1x2_4/COL_LINE0
+ pixRst<4> pixRst<5> col_periphery_1x2_4/COL_LINE1 OffBn openDVS_pixel2x2_top_429/vpd[2]
+ openDVS_pixel2x2_top_429/vpd[3] openDVS_pixel2x2_top_429/vpd[1] openDVS_pixel2x2_top_429/vpd[0]
+ rowReadON<37> rowReadOFF<36> openDVS_pixel2x2_top_997/GndD DiffBn GndA OnBn VddA18
+ openDVS_pixel2x2_top
XopenDVS_pixel2x2_top_407 rowReadOFF<35> rowReadON<34> RefrBp PrBp PrSFBp col_periphery_1x2_4/COL_LINE0
+ pixRst<4> pixRst<5> col_periphery_1x2_4/COL_LINE1 OffBn openDVS_pixel2x2_top_407/vpd[2]
+ openDVS_pixel2x2_top_407/vpd[3] openDVS_pixel2x2_top_407/vpd[1] openDVS_pixel2x2_top_407/vpd[0]
+ rowReadON<35> rowReadOFF<34> openDVS_pixel2x2_top_995/GndD DiffBn GndA OnBn VddA18
+ openDVS_pixel2x2_top
XopenDVS_pixel2x2_top_930 rowReadOFF<1> rowReadON<0> RefrBp PrBp PrSFBp col_periphery_1x2_14/COL_LINE0
+ pixRst<30> pixRst<31> col_periphery_1x2_14/COL_LINE1 OffBn openDVS_pixel2x2_top_930/vpd[2]
+ openDVS_pixel2x2_top_930/vpd[3] openDVS_pixel2x2_top_930/vpd[1] openDVS_pixel2x2_top_930/vpd[0]
+ rowReadON<1> rowReadOFF<0> openDVS_pixel2x2_top_931/GndD DiffBn GndA OnBn VddA18
+ openDVS_pixel2x2_top
XopenDVS_pixel2x2_top_941 rowReadOFF<11> rowReadON<10> RefrBp PrBp PrSFBp col_periphery_1x2_16/COL_LINE0
+ pixRst<32> pixRst<33> col_periphery_1x2_16/COL_LINE1 OffBn openDVS_pixel2x2_top_941/vpd[2]
+ openDVS_pixel2x2_top_941/vpd[3] openDVS_pixel2x2_top_941/vpd[1] openDVS_pixel2x2_top_941/vpd[0]
+ rowReadON<11> rowReadOFF<10> openDVS_pixel2x2_top_941/GndD DiffBn GndA OnBn VddA18
+ openDVS_pixel2x2_top
XopenDVS_pixel2x2_top_985 rowReadOFF<27> rowReadON<26> RefrBp PrBp PrSFBp col_periphery_1x2_28/COL_LINE0
+ pixRst<58> pixRst<59> col_periphery_1x2_28/COL_LINE1 OffBn openDVS_pixel2x2_top_985/vpd[2]
+ openDVS_pixel2x2_top_985/vpd[3] openDVS_pixel2x2_top_985/vpd[1] openDVS_pixel2x2_top_985/vpd[0]
+ rowReadON<27> rowReadOFF<26> openDVS_pixel2x2_top_987/GndD DiffBn GndA OnBn VddA18
+ openDVS_pixel2x2_top
XopenDVS_pixel2x2_top_974 rowReadOFF<27> rowReadON<26> RefrBp PrBp PrSFBp col_periphery_1x2_18/COL_LINE0
+ pixRst<36> pixRst<37> col_periphery_1x2_18/COL_LINE1 OffBn openDVS_pixel2x2_top_974/vpd[2]
+ openDVS_pixel2x2_top_974/vpd[3] openDVS_pixel2x2_top_974/vpd[1] openDVS_pixel2x2_top_974/vpd[0]
+ rowReadON<27> rowReadOFF<26> openDVS_pixel2x2_top_987/GndD DiffBn GndA OnBn VddA18
+ openDVS_pixel2x2_top
XopenDVS_pixel2x2_top_952 rowReadOFF<23> rowReadON<22> RefrBp PrBp PrSFBp col_periphery_1x2_14/COL_LINE0
+ pixRst<30> pixRst<31> col_periphery_1x2_14/COL_LINE1 OffBn openDVS_pixel2x2_top_952/vpd[2]
+ openDVS_pixel2x2_top_952/vpd[3] openDVS_pixel2x2_top_952/vpd[1] openDVS_pixel2x2_top_952/vpd[0]
+ rowReadON<23> rowReadOFF<22> openDVS_pixel2x2_top_953/GndD DiffBn GndA OnBn VddA18
+ openDVS_pixel2x2_top
XopenDVS_pixel2x2_top_963 rowReadOFF<27> rowReadON<26> RefrBp PrBp PrSFBp col_periphery_1x2_15/COL_LINE0
+ pixRst<14> pixRst<15> col_periphery_1x2_15/COL_LINE1 OffBn openDVS_pixel2x2_top_963/vpd[2]
+ openDVS_pixel2x2_top_963/vpd[3] openDVS_pixel2x2_top_963/vpd[1] openDVS_pixel2x2_top_963/vpd[0]
+ rowReadON<27> rowReadOFF<26> openDVS_pixel2x2_top_987/GndD DiffBn GndA OnBn VddA18
+ openDVS_pixel2x2_top
XopenDVS_pixel2x2_top_996 rowReadOFF<37> rowReadON<36> RefrBp PrBp PrSFBp col_periphery_1x2_14/COL_LINE0
+ pixRst<30> pixRst<31> col_periphery_1x2_14/COL_LINE1 OffBn openDVS_pixel2x2_top_996/vpd[2]
+ openDVS_pixel2x2_top_996/vpd[3] openDVS_pixel2x2_top_996/vpd[1] openDVS_pixel2x2_top_996/vpd[0]
+ rowReadON<37> rowReadOFF<36> openDVS_pixel2x2_top_997/GndD DiffBn GndA OnBn VddA18
+ openDVS_pixel2x2_top
XopenDVS_pixel2x2_top_215 rowReadOFF<31> rowReadON<30> RefrBp PrBp PrSFBp col_periphery_1x2_28/COL_LINE0
+ pixRst<58> pixRst<59> col_periphery_1x2_28/COL_LINE1 OffBn openDVS_pixel2x2_top_215/vpd[2]
+ openDVS_pixel2x2_top_215/vpd[3] openDVS_pixel2x2_top_215/vpd[1] openDVS_pixel2x2_top_215/vpd[0]
+ rowReadON<31> rowReadOFF<30> openDVS_pixel2x2_top_991/GndD DiffBn GndA OnBn VddA18
+ openDVS_pixel2x2_top
XopenDVS_pixel2x2_top_259 rowReadOFF<31> rowReadON<30> RefrBp PrBp PrSFBp col_periphery_1x2_31/COL_LINE0
+ pixRst<48> pixRst<49> col_periphery_1x2_31/COL_LINE1 OffBn openDVS_pixel2x2_top_259/vpd[2]
+ openDVS_pixel2x2_top_259/vpd[3] openDVS_pixel2x2_top_259/vpd[1] openDVS_pixel2x2_top_259/vpd[0]
+ rowReadON<31> rowReadOFF<30> openDVS_pixel2x2_top_991/GndD DiffBn GndA OnBn VddA18
+ openDVS_pixel2x2_top
XopenDVS_pixel2x2_top_237 rowReadOFF<53> rowReadON<52> RefrBp PrBp PrSFBp col_periphery_1x2_31/COL_LINE0
+ pixRst<48> pixRst<49> col_periphery_1x2_31/COL_LINE1 OffBn openDVS_pixel2x2_top_237/vpd[2]
+ openDVS_pixel2x2_top_237/vpd[3] openDVS_pixel2x2_top_237/vpd[1] openDVS_pixel2x2_top_237/vpd[0]
+ rowReadON<53> rowReadOFF<52> openDVS_pixel2x2_top_99/GndD DiffBn GndA OnBn VddA18
+ openDVS_pixel2x2_top
XopenDVS_pixel2x2_top_226 rowReadOFF<57> rowReadON<56> RefrBp PrBp PrSFBp col_periphery_1x2_31/COL_LINE0
+ pixRst<48> pixRst<49> col_periphery_1x2_31/COL_LINE1 OffBn openDVS_pixel2x2_top_226/vpd[2]
+ openDVS_pixel2x2_top_226/vpd[3] openDVS_pixel2x2_top_226/vpd[1] openDVS_pixel2x2_top_226/vpd[0]
+ rowReadON<57> rowReadOFF<56> openDVS_pixel2x2_top_9/GndD DiffBn GndA OnBn VddA18
+ openDVS_pixel2x2_top
XopenDVS_pixel2x2_top_248 rowReadOFF<45> rowReadON<44> RefrBp PrBp PrSFBp col_periphery_1x2_25/COL_LINE0
+ pixRst<52> pixRst<53> col_periphery_1x2_25/COL_LINE1 OffBn openDVS_pixel2x2_top_248/vpd[2]
+ openDVS_pixel2x2_top_248/vpd[3] openDVS_pixel2x2_top_248/vpd[1] openDVS_pixel2x2_top_248/vpd[0]
+ rowReadON<45> rowReadOFF<44> openDVS_pixel2x2_top_539/GndD DiffBn GndA OnBn VddA18
+ openDVS_pixel2x2_top
XopenDVS_pixel2x2_top_204 rowReadOFF<43> rowReadON<42> RefrBp PrBp PrSFBp col_periphery_1x2_27/COL_LINE0
+ pixRst<56> pixRst<57> col_periphery_1x2_27/COL_LINE1 OffBn openDVS_pixel2x2_top_204/vpd[2]
+ openDVS_pixel2x2_top_204/vpd[3] openDVS_pixel2x2_top_204/vpd[1] openDVS_pixel2x2_top_204/vpd[0]
+ rowReadON<43> rowReadOFF<42> openDVS_pixel2x2_top_537/GndD DiffBn GndA OnBn VddA18
+ openDVS_pixel2x2_top
XopenDVS_pixel2x2_top_771 rowReadOFF<15> rowReadON<14> RefrBp PrBp PrSFBp col_periphery_1x2_30/COL_LINE0
+ pixRst<62> pixRst<63> col_periphery_1x2_30/COL_LINE1 OffBn openDVS_pixel2x2_top_771/vpd[2]
+ openDVS_pixel2x2_top_771/vpd[3] openDVS_pixel2x2_top_771/vpd[1] openDVS_pixel2x2_top_771/vpd[0]
+ rowReadON<15> rowReadOFF<14> openDVS_pixel2x2_top_945/GndD DiffBn GndA OnBn VddA18
+ openDVS_pixel2x2_top
XopenDVS_pixel2x2_top_782 rowReadOFF<11> rowReadON<10> RefrBp PrBp PrSFBp col_periphery_1x2_28/COL_LINE0
+ pixRst<58> pixRst<59> col_periphery_1x2_28/COL_LINE1 OffBn openDVS_pixel2x2_top_782/vpd[2]
+ openDVS_pixel2x2_top_782/vpd[3] openDVS_pixel2x2_top_782/vpd[1] openDVS_pixel2x2_top_782/vpd[0]
+ rowReadON<11> rowReadOFF<10> openDVS_pixel2x2_top_941/GndD DiffBn GndA OnBn VddA18
+ openDVS_pixel2x2_top
XopenDVS_pixel2x2_top_793 rowReadOFF<11> rowReadON<10> RefrBp PrBp PrSFBp col_periphery_1x2_21/COL_LINE0
+ pixRst<42> pixRst<43> col_periphery_1x2_21/COL_LINE1 OffBn openDVS_pixel2x2_top_793/vpd[2]
+ openDVS_pixel2x2_top_793/vpd[3] openDVS_pixel2x2_top_793/vpd[1] openDVS_pixel2x2_top_793/vpd[0]
+ rowReadON<11> rowReadOFF<10> openDVS_pixel2x2_top_941/GndD DiffBn GndA OnBn VddA18
+ openDVS_pixel2x2_top
XopenDVS_pixel2x2_top_760 rowReadOFF<25> rowReadON<24> RefrBp PrBp PrSFBp col_periphery_1x2_27/COL_LINE0
+ pixRst<56> pixRst<57> col_periphery_1x2_27/COL_LINE1 OffBn openDVS_pixel2x2_top_760/vpd[2]
+ openDVS_pixel2x2_top_760/vpd[3] openDVS_pixel2x2_top_760/vpd[1] openDVS_pixel2x2_top_760/vpd[0]
+ rowReadON<25> rowReadOFF<24> openDVS_pixel2x2_top_955/GndD DiffBn GndA OnBn VddA18
+ openDVS_pixel2x2_top
Xcol_periphery_1x2_23 pixRst<47> col_periphery_1x2_23/COL_LINE0 col_periphery_1x2_23/COL_LINE1
+ nDETECT DETECT col_periphery_1x2_9/VDD VTHRESH pixRst<46> voutn<46> GndA voutn<47>
+ NCHARGE col_periphery_1x2
Xcol_periphery_1x2_12 pixRst<27> col_periphery_1x2_12/COL_LINE0 col_periphery_1x2_12/COL_LINE1
+ nDETECT DETECT col_periphery_1x2_9/VDD VTHRESH pixRst<26> voutn<26> GndA voutn<27>
+ NCHARGE col_periphery_1x2
XopenDVS_pixel2x2_top_590 rowReadOFF<21> rowReadON<20> RefrBp PrBp PrSFBp col_periphery_1x2_3/COL_LINE0
+ pixRst<2> pixRst<3> col_periphery_1x2_3/COL_LINE1 OffBn openDVS_pixel2x2_top_590/vpd[2]
+ openDVS_pixel2x2_top_590/vpd[3] openDVS_pixel2x2_top_590/vpd[1] openDVS_pixel2x2_top_590/vpd[0]
+ rowReadON<21> rowReadOFF<20> openDVS_pixel2x2_top_951/GndD DiffBn GndA OnBn VddA18
+ openDVS_pixel2x2_top
XopenDVS_pixel2x2_top_90 rowReadOFF<57> rowReadON<56> RefrBp PrBp PrSFBp col_periphery_1x2_22/COL_LINE0
+ pixRst<44> pixRst<45> col_periphery_1x2_22/COL_LINE1 OffBn openDVS_pixel2x2_top_90/vpd[2]
+ openDVS_pixel2x2_top_90/vpd[3] openDVS_pixel2x2_top_90/vpd[1] openDVS_pixel2x2_top_90/vpd[0]
+ rowReadON<57> rowReadOFF<56> openDVS_pixel2x2_top_9/GndD DiffBn GndA OnBn VddA18
+ openDVS_pixel2x2_top
XopenDVS_pixel2x2_top_419 rowReadOFF<29> rowReadON<28> RefrBp PrBp PrSFBp col_periphery_1x2_5/COL_LINE0
+ pixRst<6> pixRst<7> col_periphery_1x2_5/COL_LINE1 OffBn openDVS_pixel2x2_top_419/vpd[2]
+ openDVS_pixel2x2_top_419/vpd[3] openDVS_pixel2x2_top_419/vpd[1] openDVS_pixel2x2_top_419/vpd[0]
+ rowReadON<29> rowReadOFF<28> openDVS_pixel2x2_top_989/GndD DiffBn GndA OnBn VddA18
+ openDVS_pixel2x2_top
XopenDVS_pixel2x2_top_408 rowReadOFF<35> rowReadON<34> RefrBp PrBp PrSFBp col_periphery_1x2_5/COL_LINE0
+ pixRst<6> pixRst<7> col_periphery_1x2_5/COL_LINE1 OffBn openDVS_pixel2x2_top_408/vpd[2]
+ openDVS_pixel2x2_top_408/vpd[3] openDVS_pixel2x2_top_408/vpd[1] openDVS_pixel2x2_top_408/vpd[0]
+ rowReadON<35> rowReadOFF<34> openDVS_pixel2x2_top_995/GndD DiffBn GndA OnBn VddA18
+ openDVS_pixel2x2_top
XopenDVS_pixel2x2_top_931 rowReadOFF<1> rowReadON<0> RefrBp PrBp PrSFBp col_periphery_1x2_16/COL_LINE0
+ pixRst<32> pixRst<33> col_periphery_1x2_16/COL_LINE1 OffBn openDVS_pixel2x2_top_931/vpd[2]
+ openDVS_pixel2x2_top_931/vpd[3] openDVS_pixel2x2_top_931/vpd[1] openDVS_pixel2x2_top_931/vpd[0]
+ rowReadON<1> rowReadOFF<0> openDVS_pixel2x2_top_931/GndD DiffBn GndA OnBn VddA18
+ openDVS_pixel2x2_top
XopenDVS_pixel2x2_top_920 rowReadOFF<15> rowReadON<14> RefrBp PrBp PrSFBp col_periphery_1x2_23/COL_LINE0
+ pixRst<46> pixRst<47> col_periphery_1x2_23/COL_LINE1 OffBn openDVS_pixel2x2_top_920/vpd[2]
+ openDVS_pixel2x2_top_920/vpd[3] openDVS_pixel2x2_top_920/vpd[1] openDVS_pixel2x2_top_920/vpd[0]
+ rowReadON<15> rowReadOFF<14> openDVS_pixel2x2_top_945/GndD DiffBn GndA OnBn VddA18
+ openDVS_pixel2x2_top
XopenDVS_pixel2x2_top_942 rowReadOFF<13> rowReadON<12> RefrBp PrBp PrSFBp col_periphery_1x2_14/COL_LINE0
+ pixRst<30> pixRst<31> col_periphery_1x2_14/COL_LINE1 OffBn openDVS_pixel2x2_top_942/vpd[2]
+ openDVS_pixel2x2_top_942/vpd[3] openDVS_pixel2x2_top_942/vpd[1] openDVS_pixel2x2_top_942/vpd[0]
+ rowReadON<13> rowReadOFF<12> openDVS_pixel2x2_top_943/GndD DiffBn GndA OnBn VddA18
+ openDVS_pixel2x2_top
XopenDVS_pixel2x2_top_986 rowReadOFF<27> rowReadON<26> RefrBp PrBp PrSFBp col_periphery_1x2_29/COL_LINE0
+ pixRst<60> pixRst<61> col_periphery_1x2_29/COL_LINE1 OffBn openDVS_pixel2x2_top_986/vpd[2]
+ openDVS_pixel2x2_top_986/vpd[3] openDVS_pixel2x2_top_986/vpd[1] openDVS_pixel2x2_top_986/vpd[0]
+ rowReadON<27> rowReadOFF<26> openDVS_pixel2x2_top_987/GndD DiffBn GndA OnBn VddA18
+ openDVS_pixel2x2_top
XopenDVS_pixel2x2_top_975 rowReadOFF<27> rowReadON<26> RefrBp PrBp PrSFBp col_periphery_1x2_19/COL_LINE0
+ pixRst<38> pixRst<39> col_periphery_1x2_19/COL_LINE1 OffBn openDVS_pixel2x2_top_975/vpd[2]
+ openDVS_pixel2x2_top_975/vpd[3] openDVS_pixel2x2_top_975/vpd[1] openDVS_pixel2x2_top_975/vpd[0]
+ rowReadON<27> rowReadOFF<26> openDVS_pixel2x2_top_987/GndD DiffBn GndA OnBn VddA18
+ openDVS_pixel2x2_top
XopenDVS_pixel2x2_top_953 rowReadOFF<23> rowReadON<22> RefrBp PrBp PrSFBp col_periphery_1x2_16/COL_LINE0
+ pixRst<32> pixRst<33> col_periphery_1x2_16/COL_LINE1 OffBn openDVS_pixel2x2_top_953/vpd[2]
+ openDVS_pixel2x2_top_953/vpd[3] openDVS_pixel2x2_top_953/vpd[1] openDVS_pixel2x2_top_953/vpd[0]
+ rowReadON<23> rowReadOFF<22> openDVS_pixel2x2_top_953/GndD DiffBn GndA OnBn VddA18
+ openDVS_pixel2x2_top
XopenDVS_pixel2x2_top_964 rowReadOFF<27> rowReadON<26> RefrBp PrBp PrSFBp col_periphery_1x2_7/COL_LINE0
+ pixRst<16> pixRst<17> col_periphery_1x2_7/COL_LINE1 OffBn openDVS_pixel2x2_top_964/vpd[2]
+ openDVS_pixel2x2_top_964/vpd[3] openDVS_pixel2x2_top_964/vpd[1] openDVS_pixel2x2_top_964/vpd[0]
+ rowReadON<27> rowReadOFF<26> openDVS_pixel2x2_top_987/GndD DiffBn GndA OnBn VddA18
+ openDVS_pixel2x2_top
XopenDVS_pixel2x2_top_997 rowReadOFF<37> rowReadON<36> RefrBp PrBp PrSFBp col_periphery_1x2_16/COL_LINE0
+ pixRst<32> pixRst<33> col_periphery_1x2_16/COL_LINE1 OffBn openDVS_pixel2x2_top_997/vpd[2]
+ openDVS_pixel2x2_top_997/vpd[3] openDVS_pixel2x2_top_997/vpd[1] openDVS_pixel2x2_top_997/vpd[0]
+ rowReadON<37> rowReadOFF<36> openDVS_pixel2x2_top_997/GndD DiffBn GndA OnBn VddA18
+ openDVS_pixel2x2_top
XopenDVS_pixel2x2_top_216 rowReadOFF<31> rowReadON<30> RefrBp PrBp PrSFBp col_periphery_1x2_29/COL_LINE0
+ pixRst<60> pixRst<61> col_periphery_1x2_29/COL_LINE1 OffBn openDVS_pixel2x2_top_216/vpd[2]
+ openDVS_pixel2x2_top_216/vpd[3] openDVS_pixel2x2_top_216/vpd[1] openDVS_pixel2x2_top_216/vpd[0]
+ rowReadON<31> rowReadOFF<30> openDVS_pixel2x2_top_991/GndD DiffBn GndA OnBn VddA18
+ openDVS_pixel2x2_top
XopenDVS_pixel2x2_top_227 rowReadOFF<39> rowReadON<38> RefrBp PrBp PrSFBp col_periphery_1x2_23/COL_LINE0
+ pixRst<46> pixRst<47> col_periphery_1x2_23/COL_LINE1 OffBn openDVS_pixel2x2_top_227/vpd[2]
+ openDVS_pixel2x2_top_227/vpd[3] openDVS_pixel2x2_top_227/vpd[1] openDVS_pixel2x2_top_227/vpd[0]
+ rowReadON<39> rowReadOFF<38> openDVS_pixel2x2_top_999/GndD DiffBn GndA OnBn VddA18
+ openDVS_pixel2x2_top
XopenDVS_pixel2x2_top_238 rowReadOFF<61> rowReadON<60> RefrBp PrBp PrSFBp col_periphery_1x2_31/COL_LINE0
+ pixRst<48> pixRst<49> col_periphery_1x2_31/COL_LINE1 OffBn openDVS_pixel2x2_top_238/vpd[2]
+ openDVS_pixel2x2_top_238/vpd[3] openDVS_pixel2x2_top_238/vpd[1] openDVS_pixel2x2_top_238/vpd[0]
+ rowReadON<61> rowReadOFF<60> openDVS_pixel2x2_top_96/GndD DiffBn GndA OnBn VddA18
+ openDVS_pixel2x2_top
XopenDVS_pixel2x2_top_249 rowReadOFF<45> rowReadON<44> RefrBp PrBp PrSFBp col_periphery_1x2_26/COL_LINE0
+ pixRst<54> pixRst<55> col_periphery_1x2_26/COL_LINE1 OffBn openDVS_pixel2x2_top_249/vpd[2]
+ openDVS_pixel2x2_top_249/vpd[3] openDVS_pixel2x2_top_249/vpd[1] openDVS_pixel2x2_top_249/vpd[0]
+ rowReadON<45> rowReadOFF<44> openDVS_pixel2x2_top_539/GndD DiffBn GndA OnBn VddA18
+ openDVS_pixel2x2_top
XopenDVS_pixel2x2_top_205 rowReadOFF<43> rowReadON<42> RefrBp PrBp PrSFBp col_periphery_1x2_28/COL_LINE0
+ pixRst<58> pixRst<59> col_periphery_1x2_28/COL_LINE1 OffBn openDVS_pixel2x2_top_205/vpd[2]
+ openDVS_pixel2x2_top_205/vpd[3] openDVS_pixel2x2_top_205/vpd[1] openDVS_pixel2x2_top_205/vpd[0]
+ rowReadON<43> rowReadOFF<42> openDVS_pixel2x2_top_537/GndD DiffBn GndA OnBn VddA18
+ openDVS_pixel2x2_top
XopenDVS_pixel2x2_top_750 rowReadOFF<17> rowReadON<16> RefrBp PrBp PrSFBp col_periphery_1x2_30/COL_LINE0
+ pixRst<62> pixRst<63> col_periphery_1x2_30/COL_LINE1 OffBn openDVS_pixel2x2_top_750/vpd[2]
+ openDVS_pixel2x2_top_750/vpd[3] openDVS_pixel2x2_top_750/vpd[1] openDVS_pixel2x2_top_750/vpd[0]
+ rowReadON<17> rowReadOFF<16> openDVS_pixel2x2_top_947/GndD DiffBn GndA OnBn VddA18
+ openDVS_pixel2x2_top
XopenDVS_pixel2x2_top_783 rowReadOFF<11> rowReadON<10> RefrBp PrBp PrSFBp col_periphery_1x2_29/COL_LINE0
+ pixRst<60> pixRst<61> col_periphery_1x2_29/COL_LINE1 OffBn openDVS_pixel2x2_top_783/vpd[2]
+ openDVS_pixel2x2_top_783/vpd[3] openDVS_pixel2x2_top_783/vpd[1] openDVS_pixel2x2_top_783/vpd[0]
+ rowReadON<11> rowReadOFF<10> openDVS_pixel2x2_top_941/GndD DiffBn GndA OnBn VddA18
+ openDVS_pixel2x2_top
XopenDVS_pixel2x2_top_794 rowReadOFF<11> rowReadON<10> RefrBp PrBp PrSFBp col_periphery_1x2_22/COL_LINE0
+ pixRst<44> pixRst<45> col_periphery_1x2_22/COL_LINE1 OffBn openDVS_pixel2x2_top_794/vpd[2]
+ openDVS_pixel2x2_top_794/vpd[3] openDVS_pixel2x2_top_794/vpd[1] openDVS_pixel2x2_top_794/vpd[0]
+ rowReadON<11> rowReadOFF<10> openDVS_pixel2x2_top_941/GndD DiffBn GndA OnBn VddA18
+ openDVS_pixel2x2_top
XopenDVS_pixel2x2_top_761 rowReadOFF<25> rowReadON<24> RefrBp PrBp PrSFBp col_periphery_1x2_28/COL_LINE0
+ pixRst<58> pixRst<59> col_periphery_1x2_28/COL_LINE1 OffBn openDVS_pixel2x2_top_761/vpd[2]
+ openDVS_pixel2x2_top_761/vpd[3] openDVS_pixel2x2_top_761/vpd[1] openDVS_pixel2x2_top_761/vpd[0]
+ rowReadON<25> rowReadOFF<24> openDVS_pixel2x2_top_955/GndD DiffBn GndA OnBn VddA18
+ openDVS_pixel2x2_top
XopenDVS_pixel2x2_top_772 rowReadOFF<21> rowReadON<20> RefrBp PrBp PrSFBp col_periphery_1x2_24/COL_LINE0
+ pixRst<50> pixRst<51> col_periphery_1x2_24/COL_LINE1 OffBn openDVS_pixel2x2_top_772/vpd[2]
+ openDVS_pixel2x2_top_772/vpd[3] openDVS_pixel2x2_top_772/vpd[1] openDVS_pixel2x2_top_772/vpd[0]
+ rowReadON<21> rowReadOFF<20> openDVS_pixel2x2_top_951/GndD DiffBn GndA OnBn VddA18
+ openDVS_pixel2x2_top
Xcol_periphery_1x2_24 pixRst<51> col_periphery_1x2_24/COL_LINE0 col_periphery_1x2_24/COL_LINE1
+ nDETECT DETECT col_periphery_1x2_9/VDD VTHRESH pixRst<50> voutn<50> GndA voutn<51>
+ NCHARGE col_periphery_1x2
Xcol_periphery_1x2_13 pixRst<29> col_periphery_1x2_13/COL_LINE0 col_periphery_1x2_13/COL_LINE1
+ nDETECT DETECT col_periphery_1x2_9/VDD VTHRESH pixRst<28> voutn<28> GndA voutn<29>
+ NCHARGE col_periphery_1x2
XopenDVS_pixel2x2_top_580 rowReadOFF<25> rowReadON<24> RefrBp PrBp PrSFBp col_periphery_1x2_9/COL_LINE0
+ pixRst<20> pixRst<21> col_periphery_1x2_9/COL_LINE1 OffBn openDVS_pixel2x2_top_580/vpd[2]
+ openDVS_pixel2x2_top_580/vpd[3] openDVS_pixel2x2_top_580/vpd[1] openDVS_pixel2x2_top_580/vpd[0]
+ rowReadON<25> rowReadOFF<24> openDVS_pixel2x2_top_955/GndD DiffBn GndA OnBn VddA18
+ openDVS_pixel2x2_top
XopenDVS_pixel2x2_top_591 rowReadOFF<21> rowReadON<20> RefrBp PrBp PrSFBp col_periphery_1x2_4/COL_LINE0
+ pixRst<4> pixRst<5> col_periphery_1x2_4/COL_LINE1 OffBn openDVS_pixel2x2_top_591/vpd[2]
+ openDVS_pixel2x2_top_591/vpd[3] openDVS_pixel2x2_top_591/vpd[1] openDVS_pixel2x2_top_591/vpd[0]
+ rowReadON<21> rowReadOFF<20> openDVS_pixel2x2_top_951/GndD DiffBn GndA OnBn VddA18
+ openDVS_pixel2x2_top
XopenDVS_pixel2x2_top_80 rowReadOFF<61> rowReadON<60> RefrBp PrBp PrSFBp col_periphery_1x2_17/COL_LINE0
+ pixRst<34> pixRst<35> col_periphery_1x2_17/COL_LINE1 OffBn openDVS_pixel2x2_top_80/vpd[2]
+ openDVS_pixel2x2_top_80/vpd[3] openDVS_pixel2x2_top_80/vpd[1] openDVS_pixel2x2_top_80/vpd[0]
+ rowReadON<61> rowReadOFF<60> openDVS_pixel2x2_top_96/GndD DiffBn GndA OnBn VddA18
+ openDVS_pixel2x2_top
XopenDVS_pixel2x2_top_91 rowReadOFF<61> rowReadON<60> RefrBp PrBp PrSFBp col_periphery_1x2_20/COL_LINE0
+ pixRst<40> pixRst<41> col_periphery_1x2_20/COL_LINE1 OffBn openDVS_pixel2x2_top_91/vpd[2]
+ openDVS_pixel2x2_top_91/vpd[3] openDVS_pixel2x2_top_91/vpd[1] openDVS_pixel2x2_top_91/vpd[0]
+ rowReadON<61> rowReadOFF<60> openDVS_pixel2x2_top_96/GndD DiffBn GndA OnBn VddA18
+ openDVS_pixel2x2_top
XopenDVS_pixel2x2_top_409 rowReadOFF<35> rowReadON<34> RefrBp PrBp PrSFBp col_periphery_1x2_6/COL_LINE0
+ pixRst<8> pixRst<9> col_periphery_1x2_6/COL_LINE1 OffBn openDVS_pixel2x2_top_409/vpd[2]
+ openDVS_pixel2x2_top_409/vpd[3] openDVS_pixel2x2_top_409/vpd[1] openDVS_pixel2x2_top_409/vpd[0]
+ rowReadON<35> rowReadOFF<34> openDVS_pixel2x2_top_995/GndD DiffBn GndA OnBn VddA18
+ openDVS_pixel2x2_top
XopenDVS_pixel2x2_top_910 rowReadOFF<9> rowReadON<8> RefrBp PrBp PrSFBp col_periphery_1x2_25/COL_LINE0
+ pixRst<52> pixRst<53> col_periphery_1x2_25/COL_LINE1 OffBn openDVS_pixel2x2_top_910/vpd[2]
+ openDVS_pixel2x2_top_910/vpd[3] openDVS_pixel2x2_top_910/vpd[1] openDVS_pixel2x2_top_910/vpd[0]
+ rowReadON<9> rowReadOFF<8> openDVS_pixel2x2_top_939/GndD DiffBn GndA OnBn VddA18
+ openDVS_pixel2x2_top
XopenDVS_pixel2x2_top_932 rowReadOFF<3> rowReadON<2> RefrBp PrBp PrSFBp col_periphery_1x2_14/COL_LINE0
+ pixRst<30> pixRst<31> col_periphery_1x2_14/COL_LINE1 OffBn openDVS_pixel2x2_top_932/vpd[2]
+ openDVS_pixel2x2_top_932/vpd[3] openDVS_pixel2x2_top_932/vpd[1] openDVS_pixel2x2_top_932/vpd[0]
+ rowReadON<3> rowReadOFF<2> openDVS_pixel2x2_top_933/GndD DiffBn GndA OnBn VddA18
+ openDVS_pixel2x2_top
XopenDVS_pixel2x2_top_921 rowReadOFF<15> rowReadON<14> RefrBp PrBp PrSFBp col_periphery_1x2_31/COL_LINE0
+ pixRst<48> pixRst<49> col_periphery_1x2_31/COL_LINE1 OffBn openDVS_pixel2x2_top_921/vpd[2]
+ openDVS_pixel2x2_top_921/vpd[3] openDVS_pixel2x2_top_921/vpd[1] openDVS_pixel2x2_top_921/vpd[0]
+ rowReadON<15> rowReadOFF<14> openDVS_pixel2x2_top_945/GndD DiffBn GndA OnBn VddA18
+ openDVS_pixel2x2_top
XopenDVS_pixel2x2_top_943 rowReadOFF<13> rowReadON<12> RefrBp PrBp PrSFBp col_periphery_1x2_16/COL_LINE0
+ pixRst<32> pixRst<33> col_periphery_1x2_16/COL_LINE1 OffBn openDVS_pixel2x2_top_943/vpd[2]
+ openDVS_pixel2x2_top_943/vpd[3] openDVS_pixel2x2_top_943/vpd[1] openDVS_pixel2x2_top_943/vpd[0]
+ rowReadON<13> rowReadOFF<12> openDVS_pixel2x2_top_943/GndD DiffBn GndA OnBn VddA18
+ openDVS_pixel2x2_top
XopenDVS_pixel2x2_top_987 rowReadOFF<27> rowReadON<26> RefrBp PrBp PrSFBp col_periphery_1x2_30/COL_LINE0
+ pixRst<62> pixRst<63> col_periphery_1x2_30/COL_LINE1 OffBn openDVS_pixel2x2_top_987/vpd[2]
+ openDVS_pixel2x2_top_987/vpd[3] openDVS_pixel2x2_top_987/vpd[1] openDVS_pixel2x2_top_987/vpd[0]
+ rowReadON<27> rowReadOFF<26> openDVS_pixel2x2_top_987/GndD DiffBn GndA OnBn VddA18
+ openDVS_pixel2x2_top
XopenDVS_pixel2x2_top_976 rowReadOFF<27> rowReadON<26> RefrBp PrBp PrSFBp col_periphery_1x2_20/COL_LINE0
+ pixRst<40> pixRst<41> col_periphery_1x2_20/COL_LINE1 OffBn openDVS_pixel2x2_top_976/vpd[2]
+ openDVS_pixel2x2_top_976/vpd[3] openDVS_pixel2x2_top_976/vpd[1] openDVS_pixel2x2_top_976/vpd[0]
+ rowReadON<27> rowReadOFF<26> openDVS_pixel2x2_top_987/GndD DiffBn GndA OnBn VddA18
+ openDVS_pixel2x2_top
XopenDVS_pixel2x2_top_954 rowReadOFF<25> rowReadON<24> RefrBp PrBp PrSFBp col_periphery_1x2_14/COL_LINE0
+ pixRst<30> pixRst<31> col_periphery_1x2_14/COL_LINE1 OffBn openDVS_pixel2x2_top_954/vpd[2]
+ openDVS_pixel2x2_top_954/vpd[3] openDVS_pixel2x2_top_954/vpd[1] openDVS_pixel2x2_top_954/vpd[0]
+ rowReadON<25> rowReadOFF<24> openDVS_pixel2x2_top_955/GndD DiffBn GndA OnBn VddA18
+ openDVS_pixel2x2_top
XopenDVS_pixel2x2_top_965 rowReadOFF<27> rowReadON<26> RefrBp PrBp PrSFBp col_periphery_1x2_8/COL_LINE0
+ pixRst<18> pixRst<19> col_periphery_1x2_8/COL_LINE1 OffBn openDVS_pixel2x2_top_965/vpd[2]
+ openDVS_pixel2x2_top_965/vpd[3] openDVS_pixel2x2_top_965/vpd[1] openDVS_pixel2x2_top_965/vpd[0]
+ rowReadON<27> rowReadOFF<26> openDVS_pixel2x2_top_987/GndD DiffBn GndA OnBn VddA18
+ openDVS_pixel2x2_top
XopenDVS_pixel2x2_top_998 rowReadOFF<39> rowReadON<38> RefrBp PrBp PrSFBp col_periphery_1x2_14/COL_LINE0
+ pixRst<30> pixRst<31> col_periphery_1x2_14/COL_LINE1 OffBn openDVS_pixel2x2_top_998/vpd[2]
+ openDVS_pixel2x2_top_998/vpd[3] openDVS_pixel2x2_top_998/vpd[1] openDVS_pixel2x2_top_998/vpd[0]
+ rowReadON<39> rowReadOFF<38> openDVS_pixel2x2_top_999/GndD DiffBn GndA OnBn VddA18
+ openDVS_pixel2x2_top
XopenDVS_pixel2x2_top_217 rowReadOFF<31> rowReadON<30> RefrBp PrBp PrSFBp col_periphery_1x2_30/COL_LINE0
+ pixRst<62> pixRst<63> col_periphery_1x2_30/COL_LINE1 OffBn openDVS_pixel2x2_top_217/vpd[2]
+ openDVS_pixel2x2_top_217/vpd[3] openDVS_pixel2x2_top_217/vpd[1] openDVS_pixel2x2_top_217/vpd[0]
+ rowReadON<31> rowReadOFF<30> openDVS_pixel2x2_top_991/GndD DiffBn GndA OnBn VddA18
+ openDVS_pixel2x2_top
XopenDVS_pixel2x2_top_228 rowReadOFF<39> rowReadON<38> RefrBp PrBp PrSFBp col_periphery_1x2_31/COL_LINE0
+ pixRst<48> pixRst<49> col_periphery_1x2_31/COL_LINE1 OffBn openDVS_pixel2x2_top_228/vpd[2]
+ openDVS_pixel2x2_top_228/vpd[3] openDVS_pixel2x2_top_228/vpd[1] openDVS_pixel2x2_top_228/vpd[0]
+ rowReadON<39> rowReadOFF<38> openDVS_pixel2x2_top_999/GndD DiffBn GndA OnBn VddA18
+ openDVS_pixel2x2_top
XopenDVS_pixel2x2_top_239 rowReadOFF<45> rowReadON<44> RefrBp PrBp PrSFBp col_periphery_1x2_17/COL_LINE0
+ pixRst<34> pixRst<35> col_periphery_1x2_17/COL_LINE1 OffBn openDVS_pixel2x2_top_239/vpd[2]
+ openDVS_pixel2x2_top_239/vpd[3] openDVS_pixel2x2_top_239/vpd[1] openDVS_pixel2x2_top_239/vpd[0]
+ rowReadON<45> rowReadOFF<44> openDVS_pixel2x2_top_539/GndD DiffBn GndA OnBn VddA18
+ openDVS_pixel2x2_top
XopenDVS_pixel2x2_top_206 rowReadOFF<43> rowReadON<42> RefrBp PrBp PrSFBp col_periphery_1x2_29/COL_LINE0
+ pixRst<60> pixRst<61> col_periphery_1x2_29/COL_LINE1 OffBn openDVS_pixel2x2_top_206/vpd[2]
+ openDVS_pixel2x2_top_206/vpd[3] openDVS_pixel2x2_top_206/vpd[1] openDVS_pixel2x2_top_206/vpd[0]
+ rowReadON<43> rowReadOFF<42> openDVS_pixel2x2_top_537/GndD DiffBn GndA OnBn VddA18
+ openDVS_pixel2x2_top
XopenDVS_pixel2x2_top_784 rowReadOFF<11> rowReadON<10> RefrBp PrBp PrSFBp col_periphery_1x2_30/COL_LINE0
+ pixRst<62> pixRst<63> col_periphery_1x2_30/COL_LINE1 OffBn openDVS_pixel2x2_top_784/vpd[2]
+ openDVS_pixel2x2_top_784/vpd[3] openDVS_pixel2x2_top_784/vpd[1] openDVS_pixel2x2_top_784/vpd[0]
+ rowReadON<11> rowReadOFF<10> openDVS_pixel2x2_top_941/GndD DiffBn GndA OnBn VddA18
+ openDVS_pixel2x2_top
XopenDVS_pixel2x2_top_740 rowReadOFF<17> rowReadON<16> RefrBp PrBp PrSFBp col_periphery_1x2_29/COL_LINE0
+ pixRst<60> pixRst<61> col_periphery_1x2_29/COL_LINE1 OffBn openDVS_pixel2x2_top_740/vpd[2]
+ openDVS_pixel2x2_top_740/vpd[3] openDVS_pixel2x2_top_740/vpd[1] openDVS_pixel2x2_top_740/vpd[0]
+ rowReadON<17> rowReadOFF<16> openDVS_pixel2x2_top_947/GndD DiffBn GndA OnBn VddA18
+ openDVS_pixel2x2_top
XopenDVS_pixel2x2_top_762 rowReadOFF<15> rowReadON<14> RefrBp PrBp PrSFBp col_periphery_1x2_24/COL_LINE0
+ pixRst<50> pixRst<51> col_periphery_1x2_24/COL_LINE1 OffBn openDVS_pixel2x2_top_762/vpd[2]
+ openDVS_pixel2x2_top_762/vpd[3] openDVS_pixel2x2_top_762/vpd[1] openDVS_pixel2x2_top_762/vpd[0]
+ rowReadON<15> rowReadOFF<14> openDVS_pixel2x2_top_945/GndD DiffBn GndA OnBn VddA18
+ openDVS_pixel2x2_top
XopenDVS_pixel2x2_top_773 rowReadOFF<19> rowReadON<18> RefrBp PrBp PrSFBp col_periphery_1x2_24/COL_LINE0
+ pixRst<50> pixRst<51> col_periphery_1x2_24/COL_LINE1 OffBn openDVS_pixel2x2_top_773/vpd[2]
+ openDVS_pixel2x2_top_773/vpd[3] openDVS_pixel2x2_top_773/vpd[1] openDVS_pixel2x2_top_773/vpd[0]
+ rowReadON<19> rowReadOFF<18> openDVS_pixel2x2_top_949/GndD DiffBn GndA OnBn VddA18
+ openDVS_pixel2x2_top
XopenDVS_pixel2x2_top_751 rowReadOFF<21> rowReadON<20> RefrBp PrBp PrSFBp col_periphery_1x2_25/COL_LINE0
+ pixRst<52> pixRst<53> col_periphery_1x2_25/COL_LINE1 OffBn openDVS_pixel2x2_top_751/vpd[2]
+ openDVS_pixel2x2_top_751/vpd[3] openDVS_pixel2x2_top_751/vpd[1] openDVS_pixel2x2_top_751/vpd[0]
+ rowReadON<21> rowReadOFF<20> openDVS_pixel2x2_top_951/GndD DiffBn GndA OnBn VddA18
+ openDVS_pixel2x2_top
XopenDVS_pixel2x2_top_795 rowReadOFF<21> rowReadON<20> RefrBp PrBp PrSFBp col_periphery_1x2_17/COL_LINE0
+ pixRst<34> pixRst<35> col_periphery_1x2_17/COL_LINE1 OffBn openDVS_pixel2x2_top_795/vpd[2]
+ openDVS_pixel2x2_top_795/vpd[3] openDVS_pixel2x2_top_795/vpd[1] openDVS_pixel2x2_top_795/vpd[0]
+ rowReadON<21> rowReadOFF<20> openDVS_pixel2x2_top_951/GndD DiffBn GndA OnBn VddA18
+ openDVS_pixel2x2_top
Xcol_periphery_1x2_25 pixRst<53> col_periphery_1x2_25/COL_LINE0 col_periphery_1x2_25/COL_LINE1
+ nDETECT DETECT col_periphery_1x2_9/VDD VTHRESH pixRst<52> voutn<52> GndA voutn<53>
+ NCHARGE col_periphery_1x2
Xcol_periphery_1x2_14 pixRst<31> col_periphery_1x2_14/COL_LINE0 col_periphery_1x2_14/COL_LINE1
+ nDETECT DETECT col_periphery_1x2_9/VDD VTHRESH pixRst<30> voutn<30> GndA voutn<31>
+ NCHARGE col_periphery_1x2
XopenDVS_pixel2x2_top_570 rowReadOFF<21> rowReadON<20> RefrBp PrBp PrSFBp col_periphery_1x2_10/COL_LINE0
+ pixRst<22> pixRst<23> col_periphery_1x2_10/COL_LINE1 OffBn openDVS_pixel2x2_top_570/vpd[2]
+ openDVS_pixel2x2_top_570/vpd[3] openDVS_pixel2x2_top_570/vpd[1] openDVS_pixel2x2_top_570/vpd[0]
+ rowReadON<21> rowReadOFF<20> openDVS_pixel2x2_top_951/GndD DiffBn GndA OnBn VddA18
+ openDVS_pixel2x2_top
XopenDVS_pixel2x2_top_581 rowReadOFF<25> rowReadON<24> RefrBp PrBp PrSFBp col_periphery_1x2_10/COL_LINE0
+ pixRst<22> pixRst<23> col_periphery_1x2_10/COL_LINE1 OffBn openDVS_pixel2x2_top_581/vpd[2]
+ openDVS_pixel2x2_top_581/vpd[3] openDVS_pixel2x2_top_581/vpd[1] openDVS_pixel2x2_top_581/vpd[0]
+ rowReadON<25> rowReadOFF<24> openDVS_pixel2x2_top_955/GndD DiffBn GndA OnBn VddA18
+ openDVS_pixel2x2_top
XopenDVS_pixel2x2_top_592 rowReadOFF<21> rowReadON<20> RefrBp PrBp PrSFBp col_periphery_1x2_5/COL_LINE0
+ pixRst<6> pixRst<7> col_periphery_1x2_5/COL_LINE1 OffBn openDVS_pixel2x2_top_592/vpd[2]
+ openDVS_pixel2x2_top_592/vpd[3] openDVS_pixel2x2_top_592/vpd[1] openDVS_pixel2x2_top_592/vpd[0]
+ rowReadON<21> rowReadOFF<20> openDVS_pixel2x2_top_951/GndD DiffBn GndA OnBn VddA18
+ openDVS_pixel2x2_top
XopenDVS_pixel2x2_top_81 rowReadOFF<63> rowReadON<62> RefrBp PrBp PrSFBp col_periphery_1x2_21/COL_LINE0
+ pixRst<42> pixRst<43> col_periphery_1x2_21/COL_LINE1 OffBn openDVS_pixel2x2_top_81/vpd[2]
+ openDVS_pixel2x2_top_81/vpd[3] openDVS_pixel2x2_top_81/vpd[1] openDVS_pixel2x2_top_81/vpd[0]
+ rowReadON<63> rowReadOFF<62> openDVS_pixel2x2_top_82/GndD DiffBn GndA OnBn VddA18
+ openDVS_pixel2x2_top
XopenDVS_pixel2x2_top_92 rowReadOFF<61> rowReadON<60> RefrBp PrBp PrSFBp col_periphery_1x2_21/COL_LINE0
+ pixRst<42> pixRst<43> col_periphery_1x2_21/COL_LINE1 OffBn openDVS_pixel2x2_top_92/vpd[2]
+ openDVS_pixel2x2_top_92/vpd[3] openDVS_pixel2x2_top_92/vpd[1] openDVS_pixel2x2_top_92/vpd[0]
+ rowReadON<61> rowReadOFF<60> openDVS_pixel2x2_top_96/GndD DiffBn GndA OnBn VddA18
+ openDVS_pixel2x2_top
XopenDVS_pixel2x2_top_70 rowReadOFF<53> rowReadON<52> RefrBp PrBp PrSFBp col_periphery_1x2_22/COL_LINE0
+ pixRst<44> pixRst<45> col_periphery_1x2_22/COL_LINE1 OffBn openDVS_pixel2x2_top_70/vpd[2]
+ openDVS_pixel2x2_top_70/vpd[3] openDVS_pixel2x2_top_70/vpd[1] openDVS_pixel2x2_top_70/vpd[0]
+ rowReadON<53> rowReadOFF<52> openDVS_pixel2x2_top_99/GndD DiffBn GndA OnBn VddA18
+ openDVS_pixel2x2_top
XopenDVS_pixel2x2_top_911 rowReadOFF<9> rowReadON<8> RefrBp PrBp PrSFBp col_periphery_1x2_26/COL_LINE0
+ pixRst<54> pixRst<55> col_periphery_1x2_26/COL_LINE1 OffBn openDVS_pixel2x2_top_911/vpd[2]
+ openDVS_pixel2x2_top_911/vpd[3] openDVS_pixel2x2_top_911/vpd[1] openDVS_pixel2x2_top_911/vpd[0]
+ rowReadON<9> rowReadOFF<8> openDVS_pixel2x2_top_939/GndD DiffBn GndA OnBn VddA18
+ openDVS_pixel2x2_top
XopenDVS_pixel2x2_top_900 rowReadOFF<7> rowReadON<6> RefrBp PrBp PrSFBp col_periphery_1x2_31/COL_LINE0
+ pixRst<48> pixRst<49> col_periphery_1x2_31/COL_LINE1 OffBn openDVS_pixel2x2_top_900/vpd[2]
+ openDVS_pixel2x2_top_900/vpd[3] openDVS_pixel2x2_top_900/vpd[1] openDVS_pixel2x2_top_900/vpd[0]
+ rowReadON<7> rowReadOFF<6> openDVS_pixel2x2_top_937/GndD DiffBn GndA OnBn VddA18
+ openDVS_pixel2x2_top
XopenDVS_pixel2x2_top_933 rowReadOFF<3> rowReadON<2> RefrBp PrBp PrSFBp col_periphery_1x2_16/COL_LINE0
+ pixRst<32> pixRst<33> col_periphery_1x2_16/COL_LINE1 OffBn openDVS_pixel2x2_top_933/vpd[2]
+ openDVS_pixel2x2_top_933/vpd[3] openDVS_pixel2x2_top_933/vpd[1] openDVS_pixel2x2_top_933/vpd[0]
+ rowReadON<3> rowReadOFF<2> openDVS_pixel2x2_top_933/GndD DiffBn GndA OnBn VddA18
+ openDVS_pixel2x2_top
XopenDVS_pixel2x2_top_944 rowReadOFF<15> rowReadON<14> RefrBp PrBp PrSFBp col_periphery_1x2_14/COL_LINE0
+ pixRst<30> pixRst<31> col_periphery_1x2_14/COL_LINE1 OffBn openDVS_pixel2x2_top_944/vpd[2]
+ openDVS_pixel2x2_top_944/vpd[3] openDVS_pixel2x2_top_944/vpd[1] openDVS_pixel2x2_top_944/vpd[0]
+ rowReadON<15> rowReadOFF<14> openDVS_pixel2x2_top_945/GndD DiffBn GndA OnBn VddA18
+ openDVS_pixel2x2_top
XopenDVS_pixel2x2_top_922 rowReadOFF<25> rowReadON<24> RefrBp PrBp PrSFBp col_periphery_1x2_23/COL_LINE0
+ pixRst<46> pixRst<47> col_periphery_1x2_23/COL_LINE1 OffBn openDVS_pixel2x2_top_922/vpd[2]
+ openDVS_pixel2x2_top_922/vpd[3] openDVS_pixel2x2_top_922/vpd[1] openDVS_pixel2x2_top_922/vpd[0]
+ rowReadON<25> rowReadOFF<24> openDVS_pixel2x2_top_955/GndD DiffBn GndA OnBn VddA18
+ openDVS_pixel2x2_top
XopenDVS_pixel2x2_top_977 rowReadOFF<27> rowReadON<26> RefrBp PrBp PrSFBp col_periphery_1x2_21/COL_LINE0
+ pixRst<42> pixRst<43> col_periphery_1x2_21/COL_LINE1 OffBn openDVS_pixel2x2_top_977/vpd[2]
+ openDVS_pixel2x2_top_977/vpd[3] openDVS_pixel2x2_top_977/vpd[1] openDVS_pixel2x2_top_977/vpd[0]
+ rowReadON<27> rowReadOFF<26> openDVS_pixel2x2_top_987/GndD DiffBn GndA OnBn VddA18
+ openDVS_pixel2x2_top
XopenDVS_pixel2x2_top_955 rowReadOFF<25> rowReadON<24> RefrBp PrBp PrSFBp col_periphery_1x2_16/COL_LINE0
+ pixRst<32> pixRst<33> col_periphery_1x2_16/COL_LINE1 OffBn openDVS_pixel2x2_top_955/vpd[2]
+ openDVS_pixel2x2_top_955/vpd[3] openDVS_pixel2x2_top_955/vpd[1] openDVS_pixel2x2_top_955/vpd[0]
+ rowReadON<25> rowReadOFF<24> openDVS_pixel2x2_top_955/GndD DiffBn GndA OnBn VddA18
+ openDVS_pixel2x2_top
XopenDVS_pixel2x2_top_988 rowReadOFF<29> rowReadON<28> RefrBp PrBp PrSFBp col_periphery_1x2_14/COL_LINE0
+ pixRst<30> pixRst<31> col_periphery_1x2_14/COL_LINE1 OffBn openDVS_pixel2x2_top_988/vpd[2]
+ openDVS_pixel2x2_top_988/vpd[3] openDVS_pixel2x2_top_988/vpd[1] openDVS_pixel2x2_top_988/vpd[0]
+ rowReadON<29> rowReadOFF<28> openDVS_pixel2x2_top_989/GndD DiffBn GndA OnBn VddA18
+ openDVS_pixel2x2_top
XopenDVS_pixel2x2_top_966 rowReadOFF<27> rowReadON<26> RefrBp PrBp PrSFBp col_periphery_1x2_9/COL_LINE0
+ pixRst<20> pixRst<21> col_periphery_1x2_9/COL_LINE1 OffBn openDVS_pixel2x2_top_966/vpd[2]
+ openDVS_pixel2x2_top_966/vpd[3] openDVS_pixel2x2_top_966/vpd[1] openDVS_pixel2x2_top_966/vpd[0]
+ rowReadON<27> rowReadOFF<26> openDVS_pixel2x2_top_987/GndD DiffBn GndA OnBn VddA18
+ openDVS_pixel2x2_top
XopenDVS_pixel2x2_top_999 rowReadOFF<39> rowReadON<38> RefrBp PrBp PrSFBp col_periphery_1x2_16/COL_LINE0
+ pixRst<32> pixRst<33> col_periphery_1x2_16/COL_LINE1 OffBn openDVS_pixel2x2_top_999/vpd[2]
+ openDVS_pixel2x2_top_999/vpd[3] openDVS_pixel2x2_top_999/vpd[1] openDVS_pixel2x2_top_999/vpd[0]
+ rowReadON<39> rowReadOFF<38> openDVS_pixel2x2_top_999/GndD DiffBn GndA OnBn VddA18
+ openDVS_pixel2x2_top
XopenDVS_pixel2x2_top_218 rowReadOFF<35> rowReadON<34> RefrBp PrBp PrSFBp col_periphery_1x2_30/COL_LINE0
+ pixRst<62> pixRst<63> col_periphery_1x2_30/COL_LINE1 OffBn openDVS_pixel2x2_top_218/vpd[2]
+ openDVS_pixel2x2_top_218/vpd[3] openDVS_pixel2x2_top_218/vpd[1] openDVS_pixel2x2_top_218/vpd[0]
+ rowReadON<35> rowReadOFF<34> openDVS_pixel2x2_top_995/GndD DiffBn GndA OnBn VddA18
+ openDVS_pixel2x2_top
XopenDVS_pixel2x2_top_229 rowReadOFF<51> rowReadON<50> RefrBp PrBp PrSFBp col_periphery_1x2_23/COL_LINE0
+ pixRst<46> pixRst<47> col_periphery_1x2_23/COL_LINE1 OffBn openDVS_pixel2x2_top_229/vpd[2]
+ openDVS_pixel2x2_top_229/vpd[3] openDVS_pixel2x2_top_229/vpd[1] openDVS_pixel2x2_top_229/vpd[0]
+ rowReadON<51> rowReadOFF<50> openDVS_pixel2x2_top_6/GndD DiffBn GndA OnBn VddA18
+ openDVS_pixel2x2_top
XopenDVS_pixel2x2_top_207 rowReadOFF<43> rowReadON<42> RefrBp PrBp PrSFBp col_periphery_1x2_30/COL_LINE0
+ pixRst<62> pixRst<63> col_periphery_1x2_30/COL_LINE1 OffBn openDVS_pixel2x2_top_207/vpd[2]
+ openDVS_pixel2x2_top_207/vpd[3] openDVS_pixel2x2_top_207/vpd[1] openDVS_pixel2x2_top_207/vpd[0]
+ rowReadON<43> rowReadOFF<42> openDVS_pixel2x2_top_537/GndD DiffBn GndA OnBn VddA18
+ openDVS_pixel2x2_top
XopenDVS_pixel2x2_top_730 rowReadOFF<3> rowReadON<2> RefrBp PrBp PrSFBp col_periphery_1x2_7/COL_LINE0
+ pixRst<16> pixRst<17> col_periphery_1x2_7/COL_LINE1 OffBn openDVS_pixel2x2_top_730/vpd[2]
+ openDVS_pixel2x2_top_730/vpd[3] openDVS_pixel2x2_top_730/vpd[1] openDVS_pixel2x2_top_730/vpd[0]
+ rowReadON<3> rowReadOFF<2> openDVS_pixel2x2_top_933/GndD DiffBn GndA OnBn VddA18
+ openDVS_pixel2x2_top
XopenDVS_pixel2x2_top_785 rowReadOFF<19> rowReadON<18> RefrBp PrBp PrSFBp col_periphery_1x2_29/COL_LINE0
+ pixRst<60> pixRst<61> col_periphery_1x2_29/COL_LINE1 OffBn openDVS_pixel2x2_top_785/vpd[2]
+ openDVS_pixel2x2_top_785/vpd[3] openDVS_pixel2x2_top_785/vpd[1] openDVS_pixel2x2_top_785/vpd[0]
+ rowReadON<19> rowReadOFF<18> openDVS_pixel2x2_top_949/GndD DiffBn GndA OnBn VddA18
+ openDVS_pixel2x2_top
XopenDVS_pixel2x2_top_763 rowReadOFF<15> rowReadON<14> RefrBp PrBp PrSFBp col_periphery_1x2_25/COL_LINE0
+ pixRst<52> pixRst<53> col_periphery_1x2_25/COL_LINE1 OffBn openDVS_pixel2x2_top_763/vpd[2]
+ openDVS_pixel2x2_top_763/vpd[3] openDVS_pixel2x2_top_763/vpd[1] openDVS_pixel2x2_top_763/vpd[0]
+ rowReadON<15> rowReadOFF<14> openDVS_pixel2x2_top_945/GndD DiffBn GndA OnBn VddA18
+ openDVS_pixel2x2_top
XopenDVS_pixel2x2_top_774 rowReadOFF<19> rowReadON<18> RefrBp PrBp PrSFBp col_periphery_1x2_25/COL_LINE0
+ pixRst<52> pixRst<53> col_periphery_1x2_25/COL_LINE1 OffBn openDVS_pixel2x2_top_774/vpd[2]
+ openDVS_pixel2x2_top_774/vpd[3] openDVS_pixel2x2_top_774/vpd[1] openDVS_pixel2x2_top_774/vpd[0]
+ rowReadON<19> rowReadOFF<18> openDVS_pixel2x2_top_949/GndD DiffBn GndA OnBn VddA18
+ openDVS_pixel2x2_top
XopenDVS_pixel2x2_top_741 rowReadOFF<13> rowReadON<12> RefrBp PrBp PrSFBp col_periphery_1x2_24/COL_LINE0
+ pixRst<50> pixRst<51> col_periphery_1x2_24/COL_LINE1 OffBn openDVS_pixel2x2_top_741/vpd[2]
+ openDVS_pixel2x2_top_741/vpd[3] openDVS_pixel2x2_top_741/vpd[1] openDVS_pixel2x2_top_741/vpd[0]
+ rowReadON<13> rowReadOFF<12> openDVS_pixel2x2_top_943/GndD DiffBn GndA OnBn VddA18
+ openDVS_pixel2x2_top
XopenDVS_pixel2x2_top_752 rowReadOFF<23> rowReadON<22> RefrBp PrBp PrSFBp col_periphery_1x2_24/COL_LINE0
+ pixRst<50> pixRst<51> col_periphery_1x2_24/COL_LINE1 OffBn openDVS_pixel2x2_top_752/vpd[2]
+ openDVS_pixel2x2_top_752/vpd[3] openDVS_pixel2x2_top_752/vpd[1] openDVS_pixel2x2_top_752/vpd[0]
+ rowReadON<23> rowReadOFF<22> openDVS_pixel2x2_top_953/GndD DiffBn GndA OnBn VddA18
+ openDVS_pixel2x2_top
XopenDVS_pixel2x2_top_796 rowReadOFF<21> rowReadON<20> RefrBp PrBp PrSFBp col_periphery_1x2_18/COL_LINE0
+ pixRst<36> pixRst<37> col_periphery_1x2_18/COL_LINE1 OffBn openDVS_pixel2x2_top_796/vpd[2]
+ openDVS_pixel2x2_top_796/vpd[3] openDVS_pixel2x2_top_796/vpd[1] openDVS_pixel2x2_top_796/vpd[0]
+ rowReadON<21> rowReadOFF<20> openDVS_pixel2x2_top_951/GndD DiffBn GndA OnBn VddA18
+ openDVS_pixel2x2_top
Xcol_periphery_1x2_26 pixRst<55> col_periphery_1x2_26/COL_LINE0 col_periphery_1x2_26/COL_LINE1
+ nDETECT DETECT col_periphery_1x2_9/VDD VTHRESH pixRst<54> voutn<54> GndA voutn<55>
+ NCHARGE col_periphery_1x2
Xcol_periphery_1x2_15 pixRst<15> col_periphery_1x2_15/COL_LINE0 col_periphery_1x2_15/COL_LINE1
+ nDETECT DETECT col_periphery_1x2_9/VDD VTHRESH pixRst<14> voutn<14> GndA voutn<15>
+ NCHARGE col_periphery_1x2
XopenDVS_pixel2x2_top_560 rowReadOFF<19> rowReadON<18> RefrBp PrBp PrSFBp col_periphery_1x2_11/COL_LINE0
+ pixRst<24> pixRst<25> col_periphery_1x2_11/COL_LINE1 OffBn openDVS_pixel2x2_top_560/vpd[2]
+ openDVS_pixel2x2_top_560/vpd[3] openDVS_pixel2x2_top_560/vpd[1] openDVS_pixel2x2_top_560/vpd[0]
+ rowReadON<19> rowReadOFF<18> openDVS_pixel2x2_top_949/GndD DiffBn GndA OnBn VddA18
+ openDVS_pixel2x2_top
XopenDVS_pixel2x2_top_571 rowReadOFF<21> rowReadON<20> RefrBp PrBp PrSFBp col_periphery_1x2_11/COL_LINE0
+ pixRst<24> pixRst<25> col_periphery_1x2_11/COL_LINE1 OffBn openDVS_pixel2x2_top_571/vpd[2]
+ openDVS_pixel2x2_top_571/vpd[3] openDVS_pixel2x2_top_571/vpd[1] openDVS_pixel2x2_top_571/vpd[0]
+ rowReadON<21> rowReadOFF<20> openDVS_pixel2x2_top_951/GndD DiffBn GndA OnBn VddA18
+ openDVS_pixel2x2_top
XopenDVS_pixel2x2_top_582 rowReadOFF<25> rowReadON<24> RefrBp PrBp PrSFBp col_periphery_1x2_11/COL_LINE0
+ pixRst<24> pixRst<25> col_periphery_1x2_11/COL_LINE1 OffBn openDVS_pixel2x2_top_582/vpd[2]
+ openDVS_pixel2x2_top_582/vpd[3] openDVS_pixel2x2_top_582/vpd[1] openDVS_pixel2x2_top_582/vpd[0]
+ rowReadON<25> rowReadOFF<24> openDVS_pixel2x2_top_955/GndD DiffBn GndA OnBn VddA18
+ openDVS_pixel2x2_top
XopenDVS_pixel2x2_top_593 rowReadOFF<21> rowReadON<20> RefrBp PrBp PrSFBp col_periphery_1x2_6/COL_LINE0
+ pixRst<8> pixRst<9> col_periphery_1x2_6/COL_LINE1 OffBn openDVS_pixel2x2_top_593/vpd[2]
+ openDVS_pixel2x2_top_593/vpd[3] openDVS_pixel2x2_top_593/vpd[1] openDVS_pixel2x2_top_593/vpd[0]
+ rowReadON<21> rowReadOFF<20> openDVS_pixel2x2_top_951/GndD DiffBn GndA OnBn VddA18
+ openDVS_pixel2x2_top
XopenDVS_pixel2x2_top_390 rowReadOFF<33> rowReadON<32> RefrBp PrBp PrSFBp col_periphery_1x2_2/COL_LINE0
+ pixRst<0> pixRst<1> col_periphery_1x2_2/COL_LINE1 OffBn openDVS_pixel2x2_top_390/vpd[2]
+ openDVS_pixel2x2_top_390/vpd[3] openDVS_pixel2x2_top_390/vpd[1] openDVS_pixel2x2_top_390/vpd[0]
+ rowReadON<33> rowReadOFF<32> openDVS_pixel2x2_top_993/GndD DiffBn GndA OnBn VddA18
+ openDVS_pixel2x2_top
XopenDVS_pixel2x2_top_82 rowReadOFF<63> rowReadON<62> RefrBp PrBp PrSFBp col_periphery_1x2_22/COL_LINE0
+ pixRst<44> pixRst<45> col_periphery_1x2_22/COL_LINE1 OffBn openDVS_pixel2x2_top_82/vpd[2]
+ openDVS_pixel2x2_top_82/vpd[3] openDVS_pixel2x2_top_82/vpd[1] openDVS_pixel2x2_top_82/vpd[0]
+ rowReadON<63> rowReadOFF<62> openDVS_pixel2x2_top_82/GndD DiffBn GndA OnBn VddA18
+ openDVS_pixel2x2_top
XopenDVS_pixel2x2_top_93 rowReadOFF<51> rowReadON<50> RefrBp PrBp PrSFBp col_periphery_1x2_17/COL_LINE0
+ pixRst<34> pixRst<35> col_periphery_1x2_17/COL_LINE1 OffBn openDVS_pixel2x2_top_93/vpd[2]
+ openDVS_pixel2x2_top_93/vpd[3] openDVS_pixel2x2_top_93/vpd[1] openDVS_pixel2x2_top_93/vpd[0]
+ rowReadON<51> rowReadOFF<50> openDVS_pixel2x2_top_6/GndD DiffBn GndA OnBn VddA18
+ openDVS_pixel2x2_top
XopenDVS_pixel2x2_top_71 rowReadOFF<49> rowReadON<48> RefrBp PrBp PrSFBp col_periphery_1x2_18/COL_LINE0
+ pixRst<36> pixRst<37> col_periphery_1x2_18/COL_LINE1 OffBn openDVS_pixel2x2_top_71/vpd[2]
+ openDVS_pixel2x2_top_71/vpd[3] openDVS_pixel2x2_top_71/vpd[1] openDVS_pixel2x2_top_71/vpd[0]
+ rowReadON<49> rowReadOFF<48> openDVS_pixel2x2_top_3/GndD DiffBn GndA OnBn VddA18
+ openDVS_pixel2x2_top
XopenDVS_pixel2x2_top_60 rowReadOFF<51> rowReadON<50> RefrBp PrBp PrSFBp col_periphery_1x2_25/COL_LINE0
+ pixRst<52> pixRst<53> col_periphery_1x2_25/COL_LINE1 OffBn openDVS_pixel2x2_top_60/vpd[2]
+ openDVS_pixel2x2_top_60/vpd[3] openDVS_pixel2x2_top_60/vpd[1] openDVS_pixel2x2_top_60/vpd[0]
+ rowReadON<51> rowReadOFF<50> openDVS_pixel2x2_top_6/GndD DiffBn GndA OnBn VddA18
+ openDVS_pixel2x2_top
XopenDVS_pixel2x2_top_912 rowReadOFF<9> rowReadON<8> RefrBp PrBp PrSFBp col_periphery_1x2_27/COL_LINE0
+ pixRst<56> pixRst<57> col_periphery_1x2_27/COL_LINE1 OffBn openDVS_pixel2x2_top_912/vpd[2]
+ openDVS_pixel2x2_top_912/vpd[3] openDVS_pixel2x2_top_912/vpd[1] openDVS_pixel2x2_top_912/vpd[0]
+ rowReadON<9> rowReadOFF<8> openDVS_pixel2x2_top_939/GndD DiffBn GndA OnBn VddA18
+ openDVS_pixel2x2_top
XopenDVS_pixel2x2_top_901 rowReadOFF<9> rowReadON<8> RefrBp PrBp PrSFBp col_periphery_1x2_17/COL_LINE0
+ pixRst<34> pixRst<35> col_periphery_1x2_17/COL_LINE1 OffBn openDVS_pixel2x2_top_901/vpd[2]
+ openDVS_pixel2x2_top_901/vpd[3] openDVS_pixel2x2_top_901/vpd[1] openDVS_pixel2x2_top_901/vpd[0]
+ rowReadON<9> rowReadOFF<8> openDVS_pixel2x2_top_939/GndD DiffBn GndA OnBn VddA18
+ openDVS_pixel2x2_top
XopenDVS_pixel2x2_top_934 rowReadOFF<5> rowReadON<4> RefrBp PrBp PrSFBp col_periphery_1x2_14/COL_LINE0
+ pixRst<30> pixRst<31> col_periphery_1x2_14/COL_LINE1 OffBn openDVS_pixel2x2_top_934/vpd[2]
+ openDVS_pixel2x2_top_934/vpd[3] openDVS_pixel2x2_top_934/vpd[1] openDVS_pixel2x2_top_934/vpd[0]
+ rowReadON<5> rowReadOFF<4> openDVS_pixel2x2_top_935/GndD DiffBn GndA OnBn VddA18
+ openDVS_pixel2x2_top
XopenDVS_pixel2x2_top_923 rowReadOFF<17> rowReadON<16> RefrBp PrBp PrSFBp col_periphery_1x2_23/COL_LINE0
+ pixRst<46> pixRst<47> col_periphery_1x2_23/COL_LINE1 OffBn openDVS_pixel2x2_top_923/vpd[2]
+ openDVS_pixel2x2_top_923/vpd[3] openDVS_pixel2x2_top_923/vpd[1] openDVS_pixel2x2_top_923/vpd[0]
+ rowReadON<17> rowReadOFF<16> openDVS_pixel2x2_top_947/GndD DiffBn GndA OnBn VddA18
+ openDVS_pixel2x2_top
XopenDVS_pixel2x2_top_945 rowReadOFF<15> rowReadON<14> RefrBp PrBp PrSFBp col_periphery_1x2_16/COL_LINE0
+ pixRst<32> pixRst<33> col_periphery_1x2_16/COL_LINE1 OffBn openDVS_pixel2x2_top_945/vpd[2]
+ openDVS_pixel2x2_top_945/vpd[3] openDVS_pixel2x2_top_945/vpd[1] openDVS_pixel2x2_top_945/vpd[0]
+ rowReadON<15> rowReadOFF<14> openDVS_pixel2x2_top_945/GndD DiffBn GndA OnBn VddA18
+ openDVS_pixel2x2_top
XopenDVS_pixel2x2_top_978 rowReadOFF<27> rowReadON<26> RefrBp PrBp PrSFBp col_periphery_1x2_22/COL_LINE0
+ pixRst<44> pixRst<45> col_periphery_1x2_22/COL_LINE1 OffBn openDVS_pixel2x2_top_978/vpd[2]
+ openDVS_pixel2x2_top_978/vpd[3] openDVS_pixel2x2_top_978/vpd[1] openDVS_pixel2x2_top_978/vpd[0]
+ rowReadON<27> rowReadOFF<26> openDVS_pixel2x2_top_987/GndD DiffBn GndA OnBn VddA18
+ openDVS_pixel2x2_top
XopenDVS_pixel2x2_top_989 rowReadOFF<29> rowReadON<28> RefrBp PrBp PrSFBp col_periphery_1x2_16/COL_LINE0
+ pixRst<32> pixRst<33> col_periphery_1x2_16/COL_LINE1 OffBn openDVS_pixel2x2_top_989/vpd[2]
+ openDVS_pixel2x2_top_989/vpd[3] openDVS_pixel2x2_top_989/vpd[1] openDVS_pixel2x2_top_989/vpd[0]
+ rowReadON<29> rowReadOFF<28> openDVS_pixel2x2_top_989/GndD DiffBn GndA OnBn VddA18
+ openDVS_pixel2x2_top
XopenDVS_pixel2x2_top_967 rowReadOFF<27> rowReadON<26> RefrBp PrBp PrSFBp col_periphery_1x2_10/COL_LINE0
+ pixRst<22> pixRst<23> col_periphery_1x2_10/COL_LINE1 OffBn openDVS_pixel2x2_top_967/vpd[2]
+ openDVS_pixel2x2_top_967/vpd[3] openDVS_pixel2x2_top_967/vpd[1] openDVS_pixel2x2_top_967/vpd[0]
+ rowReadON<27> rowReadOFF<26> openDVS_pixel2x2_top_987/GndD DiffBn GndA OnBn VddA18
+ openDVS_pixel2x2_top
XopenDVS_pixel2x2_top_956 rowReadOFF<27> rowReadON<26> RefrBp PrBp PrSFBp col_periphery_1x2_2/COL_LINE0
+ pixRst<0> pixRst<1> col_periphery_1x2_2/COL_LINE1 OffBn openDVS_pixel2x2_top_956/vpd[2]
+ openDVS_pixel2x2_top_956/vpd[3] openDVS_pixel2x2_top_956/vpd[1] openDVS_pixel2x2_top_956/vpd[0]
+ rowReadON<27> rowReadOFF<26> openDVS_pixel2x2_top_987/GndD DiffBn GndA OnBn VddA18
+ openDVS_pixel2x2_top
XopenDVS_pixel2x2_top_208 rowReadOFF<33> rowReadON<32> RefrBp PrBp PrSFBp col_periphery_1x2_29/COL_LINE0
+ pixRst<60> pixRst<61> col_periphery_1x2_29/COL_LINE1 OffBn openDVS_pixel2x2_top_208/vpd[2]
+ openDVS_pixel2x2_top_208/vpd[3] openDVS_pixel2x2_top_208/vpd[1] openDVS_pixel2x2_top_208/vpd[0]
+ rowReadON<33> rowReadOFF<32> openDVS_pixel2x2_top_993/GndD DiffBn GndA OnBn VddA18
+ openDVS_pixel2x2_top
XopenDVS_pixel2x2_top_731 rowReadOFF<5> rowReadON<4> RefrBp PrBp PrSFBp col_periphery_1x2_15/COL_LINE0
+ pixRst<14> pixRst<15> col_periphery_1x2_15/COL_LINE1 OffBn openDVS_pixel2x2_top_731/vpd[2]
+ openDVS_pixel2x2_top_731/vpd[3] openDVS_pixel2x2_top_731/vpd[1] openDVS_pixel2x2_top_731/vpd[0]
+ rowReadON<5> rowReadOFF<4> openDVS_pixel2x2_top_935/GndD DiffBn GndA OnBn VddA18
+ openDVS_pixel2x2_top
XopenDVS_pixel2x2_top_764 rowReadOFF<15> rowReadON<14> RefrBp PrBp PrSFBp col_periphery_1x2_26/COL_LINE0
+ pixRst<54> pixRst<55> col_periphery_1x2_26/COL_LINE1 OffBn openDVS_pixel2x2_top_764/vpd[2]
+ openDVS_pixel2x2_top_764/vpd[3] openDVS_pixel2x2_top_764/vpd[1] openDVS_pixel2x2_top_764/vpd[0]
+ rowReadON<15> rowReadOFF<14> openDVS_pixel2x2_top_945/GndD DiffBn GndA OnBn VddA18
+ openDVS_pixel2x2_top
XopenDVS_pixel2x2_top_742 rowReadOFF<13> rowReadON<12> RefrBp PrBp PrSFBp col_periphery_1x2_25/COL_LINE0
+ pixRst<52> pixRst<53> col_periphery_1x2_25/COL_LINE1 OffBn openDVS_pixel2x2_top_742/vpd[2]
+ openDVS_pixel2x2_top_742/vpd[3] openDVS_pixel2x2_top_742/vpd[1] openDVS_pixel2x2_top_742/vpd[0]
+ rowReadON<13> rowReadOFF<12> openDVS_pixel2x2_top_943/GndD DiffBn GndA OnBn VddA18
+ openDVS_pixel2x2_top
XopenDVS_pixel2x2_top_720 rowReadOFF<11> rowReadON<10> RefrBp PrBp PrSFBp col_periphery_1x2_7/COL_LINE0
+ pixRst<16> pixRst<17> col_periphery_1x2_7/COL_LINE1 OffBn openDVS_pixel2x2_top_720/vpd[2]
+ openDVS_pixel2x2_top_720/vpd[3] openDVS_pixel2x2_top_720/vpd[1] openDVS_pixel2x2_top_720/vpd[0]
+ rowReadON<11> rowReadOFF<10> openDVS_pixel2x2_top_941/GndD DiffBn GndA OnBn VddA18
+ openDVS_pixel2x2_top
XopenDVS_pixel2x2_top_753 rowReadOFF<23> rowReadON<22> RefrBp PrBp PrSFBp col_periphery_1x2_25/COL_LINE0
+ pixRst<52> pixRst<53> col_periphery_1x2_25/COL_LINE1 OffBn openDVS_pixel2x2_top_753/vpd[2]
+ openDVS_pixel2x2_top_753/vpd[3] openDVS_pixel2x2_top_753/vpd[1] openDVS_pixel2x2_top_753/vpd[0]
+ rowReadON<23> rowReadOFF<22> openDVS_pixel2x2_top_953/GndD DiffBn GndA OnBn VddA18
+ openDVS_pixel2x2_top
XopenDVS_pixel2x2_top_219 rowReadOFF<35> rowReadON<34> RefrBp PrBp PrSFBp col_periphery_1x2_24/COL_LINE0
+ pixRst<50> pixRst<51> col_periphery_1x2_24/COL_LINE1 OffBn openDVS_pixel2x2_top_219/vpd[2]
+ openDVS_pixel2x2_top_219/vpd[3] openDVS_pixel2x2_top_219/vpd[1] openDVS_pixel2x2_top_219/vpd[0]
+ rowReadON<35> rowReadOFF<34> openDVS_pixel2x2_top_995/GndD DiffBn GndA OnBn VddA18
+ openDVS_pixel2x2_top
XopenDVS_pixel2x2_top_775 rowReadOFF<19> rowReadON<18> RefrBp PrBp PrSFBp col_periphery_1x2_26/COL_LINE0
+ pixRst<54> pixRst<55> col_periphery_1x2_26/COL_LINE1 OffBn openDVS_pixel2x2_top_775/vpd[2]
+ openDVS_pixel2x2_top_775/vpd[3] openDVS_pixel2x2_top_775/vpd[1] openDVS_pixel2x2_top_775/vpd[0]
+ rowReadON<19> rowReadOFF<18> openDVS_pixel2x2_top_949/GndD DiffBn GndA OnBn VddA18
+ openDVS_pixel2x2_top
XopenDVS_pixel2x2_top_786 rowReadOFF<23> rowReadON<22> RefrBp PrBp PrSFBp col_periphery_1x2_28/COL_LINE0
+ pixRst<58> pixRst<59> col_periphery_1x2_28/COL_LINE1 OffBn openDVS_pixel2x2_top_786/vpd[2]
+ openDVS_pixel2x2_top_786/vpd[3] openDVS_pixel2x2_top_786/vpd[1] openDVS_pixel2x2_top_786/vpd[0]
+ rowReadON<23> rowReadOFF<22> openDVS_pixel2x2_top_953/GndD DiffBn GndA OnBn VddA18
+ openDVS_pixel2x2_top
XopenDVS_pixel2x2_top_797 rowReadOFF<25> rowReadON<24> RefrBp PrBp PrSFBp col_periphery_1x2_18/COL_LINE0
+ pixRst<36> pixRst<37> col_periphery_1x2_18/COL_LINE1 OffBn openDVS_pixel2x2_top_797/vpd[2]
+ openDVS_pixel2x2_top_797/vpd[3] openDVS_pixel2x2_top_797/vpd[1] openDVS_pixel2x2_top_797/vpd[0]
+ rowReadON<25> rowReadOFF<24> openDVS_pixel2x2_top_955/GndD DiffBn GndA OnBn VddA18
+ openDVS_pixel2x2_top
Xcol_periphery_1x2_27 pixRst<57> col_periphery_1x2_27/COL_LINE0 col_periphery_1x2_27/COL_LINE1
+ nDETECT DETECT col_periphery_1x2_9/VDD VTHRESH pixRst<56> voutn<56> GndA voutn<57>
+ NCHARGE col_periphery_1x2
Xcol_periphery_1x2_16 pixRst<33> col_periphery_1x2_16/COL_LINE0 col_periphery_1x2_16/COL_LINE1
+ nDETECT DETECT col_periphery_1x2_9/VDD VTHRESH pixRst<32> voutn<32> GndA voutn<33>
+ NCHARGE col_periphery_1x2
XopenDVS_pixel2x2_top_561 rowReadOFF<19> rowReadON<18> RefrBp PrBp PrSFBp col_periphery_1x2_12/COL_LINE0
+ pixRst<26> pixRst<27> col_periphery_1x2_12/COL_LINE1 OffBn openDVS_pixel2x2_top_561/vpd[2]
+ openDVS_pixel2x2_top_561/vpd[3] openDVS_pixel2x2_top_561/vpd[1] openDVS_pixel2x2_top_561/vpd[0]
+ rowReadON<19> rowReadOFF<18> openDVS_pixel2x2_top_949/GndD DiffBn GndA OnBn VddA18
+ openDVS_pixel2x2_top
XopenDVS_pixel2x2_top_583 rowReadOFF<13> rowReadON<12> RefrBp PrBp PrSFBp col_periphery_1x2_8/COL_LINE0
+ pixRst<18> pixRst<19> col_periphery_1x2_8/COL_LINE1 OffBn openDVS_pixel2x2_top_583/vpd[2]
+ openDVS_pixel2x2_top_583/vpd[3] openDVS_pixel2x2_top_583/vpd[1] openDVS_pixel2x2_top_583/vpd[0]
+ rowReadON<13> rowReadOFF<12> openDVS_pixel2x2_top_943/GndD DiffBn GndA OnBn VddA18
+ openDVS_pixel2x2_top
XopenDVS_pixel2x2_top_572 rowReadOFF<21> rowReadON<20> RefrBp PrBp PrSFBp col_periphery_1x2_12/COL_LINE0
+ pixRst<26> pixRst<27> col_periphery_1x2_12/COL_LINE1 OffBn openDVS_pixel2x2_top_572/vpd[2]
+ openDVS_pixel2x2_top_572/vpd[3] openDVS_pixel2x2_top_572/vpd[1] openDVS_pixel2x2_top_572/vpd[0]
+ rowReadON<21> rowReadOFF<20> openDVS_pixel2x2_top_951/GndD DiffBn GndA OnBn VddA18
+ openDVS_pixel2x2_top
XopenDVS_pixel2x2_top_550 rowReadOFF<23> rowReadON<22> RefrBp PrBp PrSFBp col_periphery_1x2_10/COL_LINE0
+ pixRst<22> pixRst<23> col_periphery_1x2_10/COL_LINE1 OffBn openDVS_pixel2x2_top_550/vpd[2]
+ openDVS_pixel2x2_top_550/vpd[3] openDVS_pixel2x2_top_550/vpd[1] openDVS_pixel2x2_top_550/vpd[0]
+ rowReadON<23> rowReadOFF<22> openDVS_pixel2x2_top_953/GndD DiffBn GndA OnBn VddA18
+ openDVS_pixel2x2_top
XopenDVS_pixel2x2_top_594 rowReadOFF<21> rowReadON<20> RefrBp PrBp PrSFBp col_periphery_1x2_0/COL_LINE0
+ pixRst<10> pixRst<11> col_periphery_1x2_0/COL_LINE1 OffBn openDVS_pixel2x2_top_594/vpd[2]
+ openDVS_pixel2x2_top_594/vpd[3] openDVS_pixel2x2_top_594/vpd[1] openDVS_pixel2x2_top_594/vpd[0]
+ rowReadON<21> rowReadOFF<20> openDVS_pixel2x2_top_951/GndD DiffBn GndA OnBn VddA18
+ openDVS_pixel2x2_top
XopenDVS_pixel2x2_top_380 rowReadOFF<55> rowReadON<54> RefrBp PrBp PrSFBp col_periphery_1x2_2/COL_LINE0
+ pixRst<0> pixRst<1> col_periphery_1x2_2/COL_LINE1 OffBn openDVS_pixel2x2_top_380/vpd[2]
+ openDVS_pixel2x2_top_380/vpd[3] openDVS_pixel2x2_top_380/vpd[1] openDVS_pixel2x2_top_380/vpd[0]
+ rowReadON<55> rowReadOFF<54> openDVS_pixel2x2_top_67/GndD DiffBn GndA OnBn VddA18
+ openDVS_pixel2x2_top
XopenDVS_pixel2x2_top_391 rowReadOFF<33> rowReadON<32> RefrBp PrBp PrSFBp col_periphery_1x2_3/COL_LINE0
+ pixRst<2> pixRst<3> col_periphery_1x2_3/COL_LINE1 OffBn openDVS_pixel2x2_top_391/vpd[2]
+ openDVS_pixel2x2_top_391/vpd[3] openDVS_pixel2x2_top_391/vpd[1] openDVS_pixel2x2_top_391/vpd[0]
+ rowReadON<33> rowReadOFF<32> openDVS_pixel2x2_top_993/GndD DiffBn GndA OnBn VddA18
+ openDVS_pixel2x2_top
XopenDVS_pixel2x2_top_83 rowReadOFF<61> rowReadON<60> RefrBp PrBp PrSFBp col_periphery_1x2_18/COL_LINE0
+ pixRst<36> pixRst<37> col_periphery_1x2_18/COL_LINE1 OffBn openDVS_pixel2x2_top_83/vpd[2]
+ openDVS_pixel2x2_top_83/vpd[3] openDVS_pixel2x2_top_83/vpd[1] openDVS_pixel2x2_top_83/vpd[0]
+ rowReadON<61> rowReadOFF<60> openDVS_pixel2x2_top_96/GndD DiffBn GndA OnBn VddA18
+ openDVS_pixel2x2_top
XopenDVS_pixel2x2_top_72 rowReadOFF<47> rowReadON<46> RefrBp PrBp PrSFBp col_periphery_1x2_17/COL_LINE0
+ pixRst<34> pixRst<35> col_periphery_1x2_17/COL_LINE1 OffBn openDVS_pixel2x2_top_72/vpd[2]
+ openDVS_pixel2x2_top_72/vpd[3] openDVS_pixel2x2_top_72/vpd[1] openDVS_pixel2x2_top_72/vpd[0]
+ rowReadON<47> rowReadOFF<46> openDVS_pixel2x2_top_78/GndD DiffBn GndA OnBn VddA18
+ openDVS_pixel2x2_top
XopenDVS_pixel2x2_top_94 rowReadOFF<51> rowReadON<50> RefrBp PrBp PrSFBp col_periphery_1x2_18/COL_LINE0
+ pixRst<36> pixRst<37> col_periphery_1x2_18/COL_LINE1 OffBn openDVS_pixel2x2_top_94/vpd[2]
+ openDVS_pixel2x2_top_94/vpd[3] openDVS_pixel2x2_top_94/vpd[1] openDVS_pixel2x2_top_94/vpd[0]
+ rowReadON<51> rowReadOFF<50> openDVS_pixel2x2_top_6/GndD DiffBn GndA OnBn VddA18
+ openDVS_pixel2x2_top
XopenDVS_pixel2x2_top_50 rowReadOFF<49> rowReadON<48> RefrBp PrBp PrSFBp col_periphery_1x2_24/COL_LINE0
+ pixRst<50> pixRst<51> col_periphery_1x2_24/COL_LINE1 OffBn openDVS_pixel2x2_top_50/vpd[2]
+ openDVS_pixel2x2_top_50/vpd[3] openDVS_pixel2x2_top_50/vpd[1] openDVS_pixel2x2_top_50/vpd[0]
+ rowReadON<49> rowReadOFF<48> openDVS_pixel2x2_top_3/GndD DiffBn GndA OnBn VddA18
+ openDVS_pixel2x2_top
XopenDVS_pixel2x2_top_61 rowReadOFF<51> rowReadON<50> RefrBp PrBp PrSFBp col_periphery_1x2_26/COL_LINE0
+ pixRst<54> pixRst<55> col_periphery_1x2_26/COL_LINE1 OffBn openDVS_pixel2x2_top_61/vpd[2]
+ openDVS_pixel2x2_top_61/vpd[3] openDVS_pixel2x2_top_61/vpd[1] openDVS_pixel2x2_top_61/vpd[0]
+ rowReadON<51> rowReadOFF<50> openDVS_pixel2x2_top_6/GndD DiffBn GndA OnBn VddA18
+ openDVS_pixel2x2_top
XopenDVS_pixel2x2_top_913 rowReadOFF<9> rowReadON<8> RefrBp PrBp PrSFBp col_periphery_1x2_28/COL_LINE0
+ pixRst<58> pixRst<59> col_periphery_1x2_28/COL_LINE1 OffBn openDVS_pixel2x2_top_913/vpd[2]
+ openDVS_pixel2x2_top_913/vpd[3] openDVS_pixel2x2_top_913/vpd[1] openDVS_pixel2x2_top_913/vpd[0]
+ rowReadON<9> rowReadOFF<8> openDVS_pixel2x2_top_939/GndD DiffBn GndA OnBn VddA18
+ openDVS_pixel2x2_top
XopenDVS_pixel2x2_top_902 rowReadOFF<9> rowReadON<8> RefrBp PrBp PrSFBp col_periphery_1x2_18/COL_LINE0
+ pixRst<36> pixRst<37> col_periphery_1x2_18/COL_LINE1 OffBn openDVS_pixel2x2_top_902/vpd[2]
+ openDVS_pixel2x2_top_902/vpd[3] openDVS_pixel2x2_top_902/vpd[1] openDVS_pixel2x2_top_902/vpd[0]
+ rowReadON<9> rowReadOFF<8> openDVS_pixel2x2_top_939/GndD DiffBn GndA OnBn VddA18
+ openDVS_pixel2x2_top
XopenDVS_pixel2x2_top_935 rowReadOFF<5> rowReadON<4> RefrBp PrBp PrSFBp col_periphery_1x2_16/COL_LINE0
+ pixRst<32> pixRst<33> col_periphery_1x2_16/COL_LINE1 OffBn openDVS_pixel2x2_top_935/vpd[2]
+ openDVS_pixel2x2_top_935/vpd[3] openDVS_pixel2x2_top_935/vpd[1] openDVS_pixel2x2_top_935/vpd[0]
+ rowReadON<5> rowReadOFF<4> openDVS_pixel2x2_top_935/GndD DiffBn GndA OnBn VddA18
+ openDVS_pixel2x2_top
XopenDVS_pixel2x2_top_924 rowReadOFF<17> rowReadON<16> RefrBp PrBp PrSFBp col_periphery_1x2_31/COL_LINE0
+ pixRst<48> pixRst<49> col_periphery_1x2_31/COL_LINE1 OffBn openDVS_pixel2x2_top_924/vpd[2]
+ openDVS_pixel2x2_top_924/vpd[3] openDVS_pixel2x2_top_924/vpd[1] openDVS_pixel2x2_top_924/vpd[0]
+ rowReadON<17> rowReadOFF<16> openDVS_pixel2x2_top_947/GndD DiffBn GndA OnBn VddA18
+ openDVS_pixel2x2_top
XopenDVS_pixel2x2_top_946 rowReadOFF<17> rowReadON<16> RefrBp PrBp PrSFBp col_periphery_1x2_14/COL_LINE0
+ pixRst<30> pixRst<31> col_periphery_1x2_14/COL_LINE1 OffBn openDVS_pixel2x2_top_946/vpd[2]
+ openDVS_pixel2x2_top_946/vpd[3] openDVS_pixel2x2_top_946/vpd[1] openDVS_pixel2x2_top_946/vpd[0]
+ rowReadON<17> rowReadOFF<16> openDVS_pixel2x2_top_947/GndD DiffBn GndA OnBn VddA18
+ openDVS_pixel2x2_top
XopenDVS_pixel2x2_top_979 rowReadOFF<27> rowReadON<26> RefrBp PrBp PrSFBp col_periphery_1x2_23/COL_LINE0
+ pixRst<46> pixRst<47> col_periphery_1x2_23/COL_LINE1 OffBn openDVS_pixel2x2_top_979/vpd[2]
+ openDVS_pixel2x2_top_979/vpd[3] openDVS_pixel2x2_top_979/vpd[1] openDVS_pixel2x2_top_979/vpd[0]
+ rowReadON<27> rowReadOFF<26> openDVS_pixel2x2_top_987/GndD DiffBn GndA OnBn VddA18
+ openDVS_pixel2x2_top
XopenDVS_pixel2x2_top_968 rowReadOFF<27> rowReadON<26> RefrBp PrBp PrSFBp col_periphery_1x2_11/COL_LINE0
+ pixRst<24> pixRst<25> col_periphery_1x2_11/COL_LINE1 OffBn openDVS_pixel2x2_top_968/vpd[2]
+ openDVS_pixel2x2_top_968/vpd[3] openDVS_pixel2x2_top_968/vpd[1] openDVS_pixel2x2_top_968/vpd[0]
+ rowReadON<27> rowReadOFF<26> openDVS_pixel2x2_top_987/GndD DiffBn GndA OnBn VddA18
+ openDVS_pixel2x2_top
XopenDVS_pixel2x2_top_957 rowReadOFF<27> rowReadON<26> RefrBp PrBp PrSFBp col_periphery_1x2_3/COL_LINE0
+ pixRst<2> pixRst<3> col_periphery_1x2_3/COL_LINE1 OffBn openDVS_pixel2x2_top_957/vpd[2]
+ openDVS_pixel2x2_top_957/vpd[3] openDVS_pixel2x2_top_957/vpd[1] openDVS_pixel2x2_top_957/vpd[0]
+ rowReadON<27> rowReadOFF<26> openDVS_pixel2x2_top_987/GndD DiffBn GndA OnBn VddA18
+ openDVS_pixel2x2_top
XopenDVS_pixel2x2_top_209 rowReadOFF<33> rowReadON<32> RefrBp PrBp PrSFBp col_periphery_1x2_30/COL_LINE0
+ pixRst<62> pixRst<63> col_periphery_1x2_30/COL_LINE1 OffBn openDVS_pixel2x2_top_209/vpd[2]
+ openDVS_pixel2x2_top_209/vpd[3] openDVS_pixel2x2_top_209/vpd[1] openDVS_pixel2x2_top_209/vpd[0]
+ rowReadON<33> rowReadOFF<32> openDVS_pixel2x2_top_993/GndD DiffBn GndA OnBn VddA18
+ openDVS_pixel2x2_top
XopenDVS_pixel2x2_top_710 rowReadOFF<9> rowReadON<8> RefrBp PrBp PrSFBp col_periphery_1x2_7/COL_LINE0
+ pixRst<16> pixRst<17> col_periphery_1x2_7/COL_LINE1 OffBn openDVS_pixel2x2_top_710/vpd[2]
+ openDVS_pixel2x2_top_710/vpd[3] openDVS_pixel2x2_top_710/vpd[1] openDVS_pixel2x2_top_710/vpd[0]
+ rowReadON<9> rowReadOFF<8> openDVS_pixel2x2_top_939/GndD DiffBn GndA OnBn VddA18
+ openDVS_pixel2x2_top
XopenDVS_pixel2x2_top_732 rowReadOFF<5> rowReadON<4> RefrBp PrBp PrSFBp col_periphery_1x2_7/COL_LINE0
+ pixRst<16> pixRst<17> col_periphery_1x2_7/COL_LINE1 OffBn openDVS_pixel2x2_top_732/vpd[2]
+ openDVS_pixel2x2_top_732/vpd[3] openDVS_pixel2x2_top_732/vpd[1] openDVS_pixel2x2_top_732/vpd[0]
+ rowReadON<5> rowReadOFF<4> openDVS_pixel2x2_top_935/GndD DiffBn GndA OnBn VddA18
+ openDVS_pixel2x2_top
XopenDVS_pixel2x2_top_743 rowReadOFF<13> rowReadON<12> RefrBp PrBp PrSFBp col_periphery_1x2_26/COL_LINE0
+ pixRst<54> pixRst<55> col_periphery_1x2_26/COL_LINE1 OffBn openDVS_pixel2x2_top_743/vpd[2]
+ openDVS_pixel2x2_top_743/vpd[3] openDVS_pixel2x2_top_743/vpd[1] openDVS_pixel2x2_top_743/vpd[0]
+ rowReadON<13> rowReadOFF<12> openDVS_pixel2x2_top_943/GndD DiffBn GndA OnBn VddA18
+ openDVS_pixel2x2_top
XopenDVS_pixel2x2_top_765 rowReadOFF<15> rowReadON<14> RefrBp PrBp PrSFBp col_periphery_1x2_27/COL_LINE0
+ pixRst<56> pixRst<57> col_periphery_1x2_27/COL_LINE1 OffBn openDVS_pixel2x2_top_765/vpd[2]
+ openDVS_pixel2x2_top_765/vpd[3] openDVS_pixel2x2_top_765/vpd[1] openDVS_pixel2x2_top_765/vpd[0]
+ rowReadON<15> rowReadOFF<14> openDVS_pixel2x2_top_945/GndD DiffBn GndA OnBn VddA18
+ openDVS_pixel2x2_top
XopenDVS_pixel2x2_top_776 rowReadOFF<19> rowReadON<18> RefrBp PrBp PrSFBp col_periphery_1x2_27/COL_LINE0
+ pixRst<56> pixRst<57> col_periphery_1x2_27/COL_LINE1 OffBn openDVS_pixel2x2_top_776/vpd[2]
+ openDVS_pixel2x2_top_776/vpd[3] openDVS_pixel2x2_top_776/vpd[1] openDVS_pixel2x2_top_776/vpd[0]
+ rowReadON<19> rowReadOFF<18> openDVS_pixel2x2_top_949/GndD DiffBn GndA OnBn VddA18
+ openDVS_pixel2x2_top
XopenDVS_pixel2x2_top_787 rowReadOFF<23> rowReadON<22> RefrBp PrBp PrSFBp col_periphery_1x2_29/COL_LINE0
+ pixRst<60> pixRst<61> col_periphery_1x2_29/COL_LINE1 OffBn openDVS_pixel2x2_top_787/vpd[2]
+ openDVS_pixel2x2_top_787/vpd[3] openDVS_pixel2x2_top_787/vpd[1] openDVS_pixel2x2_top_787/vpd[0]
+ rowReadON<23> rowReadOFF<22> openDVS_pixel2x2_top_953/GndD DiffBn GndA OnBn VddA18
+ openDVS_pixel2x2_top
XopenDVS_pixel2x2_top_754 rowReadOFF<25> rowReadON<24> RefrBp PrBp PrSFBp col_periphery_1x2_24/COL_LINE0
+ pixRst<50> pixRst<51> col_periphery_1x2_24/COL_LINE1 OffBn openDVS_pixel2x2_top_754/vpd[2]
+ openDVS_pixel2x2_top_754/vpd[3] openDVS_pixel2x2_top_754/vpd[1] openDVS_pixel2x2_top_754/vpd[0]
+ rowReadON<25> rowReadOFF<24> openDVS_pixel2x2_top_955/GndD DiffBn GndA OnBn VddA18
+ openDVS_pixel2x2_top
XopenDVS_pixel2x2_top_798 rowReadOFF<25> rowReadON<24> RefrBp PrBp PrSFBp col_periphery_1x2_19/COL_LINE0
+ pixRst<38> pixRst<39> col_periphery_1x2_19/COL_LINE1 OffBn openDVS_pixel2x2_top_798/vpd[2]
+ openDVS_pixel2x2_top_798/vpd[3] openDVS_pixel2x2_top_798/vpd[1] openDVS_pixel2x2_top_798/vpd[0]
+ rowReadON<25> rowReadOFF<24> openDVS_pixel2x2_top_955/GndD DiffBn GndA OnBn VddA18
+ openDVS_pixel2x2_top
XopenDVS_pixel2x2_top_721 rowReadOFF<25> rowReadON<24> RefrBp PrBp PrSFBp col_periphery_1x2_15/COL_LINE0
+ pixRst<14> pixRst<15> col_periphery_1x2_15/COL_LINE1 OffBn openDVS_pixel2x2_top_721/vpd[2]
+ openDVS_pixel2x2_top_721/vpd[3] openDVS_pixel2x2_top_721/vpd[1] openDVS_pixel2x2_top_721/vpd[0]
+ rowReadON<25> rowReadOFF<24> openDVS_pixel2x2_top_955/GndD DiffBn GndA OnBn VddA18
+ openDVS_pixel2x2_top
Xcol_periphery_1x2_28 pixRst<59> col_periphery_1x2_28/COL_LINE0 col_periphery_1x2_28/COL_LINE1
+ nDETECT DETECT col_periphery_1x2_9/VDD VTHRESH pixRst<58> voutn<58> GndA voutn<59>
+ NCHARGE col_periphery_1x2
Xcol_periphery_1x2_17 pixRst<35> col_periphery_1x2_17/COL_LINE0 col_periphery_1x2_17/COL_LINE1
+ nDETECT DETECT col_periphery_1x2_9/VDD VTHRESH pixRst<34> voutn<34> GndA voutn<35>
+ NCHARGE col_periphery_1x2
XopenDVS_pixel2x2_top_562 rowReadOFF<19> rowReadON<18> RefrBp PrBp PrSFBp col_periphery_1x2_13/COL_LINE0
+ pixRst<28> pixRst<29> col_periphery_1x2_13/COL_LINE1 OffBn openDVS_pixel2x2_top_562/vpd[2]
+ openDVS_pixel2x2_top_562/vpd[3] openDVS_pixel2x2_top_562/vpd[1] openDVS_pixel2x2_top_562/vpd[0]
+ rowReadON<19> rowReadOFF<18> openDVS_pixel2x2_top_949/GndD DiffBn GndA OnBn VddA18
+ openDVS_pixel2x2_top
XopenDVS_pixel2x2_top_584 rowReadOFF<13> rowReadON<12> RefrBp PrBp PrSFBp col_periphery_1x2_9/COL_LINE0
+ pixRst<20> pixRst<21> col_periphery_1x2_9/COL_LINE1 OffBn openDVS_pixel2x2_top_584/vpd[2]
+ openDVS_pixel2x2_top_584/vpd[3] openDVS_pixel2x2_top_584/vpd[1] openDVS_pixel2x2_top_584/vpd[0]
+ rowReadON<13> rowReadOFF<12> openDVS_pixel2x2_top_943/GndD DiffBn GndA OnBn VddA18
+ openDVS_pixel2x2_top
XopenDVS_pixel2x2_top_540 rowReadOFF<15> rowReadON<14> RefrBp PrBp PrSFBp col_periphery_1x2_8/COL_LINE0
+ pixRst<18> pixRst<19> col_periphery_1x2_8/COL_LINE1 OffBn openDVS_pixel2x2_top_540/vpd[2]
+ openDVS_pixel2x2_top_540/vpd[3] openDVS_pixel2x2_top_540/vpd[1] openDVS_pixel2x2_top_540/vpd[0]
+ rowReadON<15> rowReadOFF<14> openDVS_pixel2x2_top_945/GndD DiffBn GndA OnBn VddA18
+ openDVS_pixel2x2_top
XopenDVS_pixel2x2_top_573 rowReadOFF<21> rowReadON<20> RefrBp PrBp PrSFBp col_periphery_1x2_13/COL_LINE0
+ pixRst<28> pixRst<29> col_periphery_1x2_13/COL_LINE1 OffBn openDVS_pixel2x2_top_573/vpd[2]
+ openDVS_pixel2x2_top_573/vpd[3] openDVS_pixel2x2_top_573/vpd[1] openDVS_pixel2x2_top_573/vpd[0]
+ rowReadON<21> rowReadOFF<20> openDVS_pixel2x2_top_951/GndD DiffBn GndA OnBn VddA18
+ openDVS_pixel2x2_top
XopenDVS_pixel2x2_top_551 rowReadOFF<23> rowReadON<22> RefrBp PrBp PrSFBp col_periphery_1x2_11/COL_LINE0
+ pixRst<24> pixRst<25> col_periphery_1x2_11/COL_LINE1 OffBn openDVS_pixel2x2_top_551/vpd[2]
+ openDVS_pixel2x2_top_551/vpd[3] openDVS_pixel2x2_top_551/vpd[1] openDVS_pixel2x2_top_551/vpd[0]
+ rowReadON<23> rowReadOFF<22> openDVS_pixel2x2_top_953/GndD DiffBn GndA OnBn VddA18
+ openDVS_pixel2x2_top
XopenDVS_pixel2x2_top_595 rowReadOFF<21> rowReadON<20> RefrBp PrBp PrSFBp col_periphery_1x2_1/COL_LINE0
+ pixRst<12> pixRst<13> col_periphery_1x2_1/COL_LINE1 OffBn openDVS_pixel2x2_top_595/vpd[2]
+ openDVS_pixel2x2_top_595/vpd[3] openDVS_pixel2x2_top_595/vpd[1] openDVS_pixel2x2_top_595/vpd[0]
+ rowReadON<21> rowReadOFF<20> openDVS_pixel2x2_top_951/GndD DiffBn GndA OnBn VddA18
+ openDVS_pixel2x2_top
XopenDVS_pixel2x2_top_370 rowReadOFF<53> rowReadON<52> RefrBp PrBp PrSFBp col_periphery_1x2_3/COL_LINE0
+ pixRst<2> pixRst<3> col_periphery_1x2_3/COL_LINE1 OffBn openDVS_pixel2x2_top_370/vpd[2]
+ openDVS_pixel2x2_top_370/vpd[3] openDVS_pixel2x2_top_370/vpd[1] openDVS_pixel2x2_top_370/vpd[0]
+ rowReadON<53> rowReadOFF<52> openDVS_pixel2x2_top_99/GndD DiffBn GndA OnBn VddA18
+ openDVS_pixel2x2_top
XopenDVS_pixel2x2_top_381 rowReadOFF<55> rowReadON<54> RefrBp PrBp PrSFBp col_periphery_1x2_3/COL_LINE0
+ pixRst<2> pixRst<3> col_periphery_1x2_3/COL_LINE1 OffBn openDVS_pixel2x2_top_381/vpd[2]
+ openDVS_pixel2x2_top_381/vpd[3] openDVS_pixel2x2_top_381/vpd[1] openDVS_pixel2x2_top_381/vpd[0]
+ rowReadON<55> rowReadOFF<54> openDVS_pixel2x2_top_67/GndD DiffBn GndA OnBn VddA18
+ openDVS_pixel2x2_top
XopenDVS_pixel2x2_top_392 rowReadOFF<33> rowReadON<32> RefrBp PrBp PrSFBp col_periphery_1x2_4/COL_LINE0
+ pixRst<4> pixRst<5> col_periphery_1x2_4/COL_LINE1 OffBn openDVS_pixel2x2_top_392/vpd[2]
+ openDVS_pixel2x2_top_392/vpd[3] openDVS_pixel2x2_top_392/vpd[1] openDVS_pixel2x2_top_392/vpd[0]
+ rowReadON<33> rowReadOFF<32> openDVS_pixel2x2_top_993/GndD DiffBn GndA OnBn VddA18
+ openDVS_pixel2x2_top
XopenDVS_pixel2x2_top_84 rowReadOFF<61> rowReadON<60> RefrBp PrBp PrSFBp col_periphery_1x2_19/COL_LINE0
+ pixRst<38> pixRst<39> col_periphery_1x2_19/COL_LINE1 OffBn openDVS_pixel2x2_top_84/vpd[2]
+ openDVS_pixel2x2_top_84/vpd[3] openDVS_pixel2x2_top_84/vpd[1] openDVS_pixel2x2_top_84/vpd[0]
+ rowReadON<61> rowReadOFF<60> openDVS_pixel2x2_top_96/GndD DiffBn GndA OnBn VddA18
+ openDVS_pixel2x2_top
XopenDVS_pixel2x2_top_40 rowReadOFF<59> rowReadON<58> RefrBp PrBp PrSFBp col_periphery_1x2_28/COL_LINE0
+ pixRst<58> pixRst<59> col_periphery_1x2_28/COL_LINE1 OffBn openDVS_pixel2x2_top_40/vpd[2]
+ openDVS_pixel2x2_top_40/vpd[3] openDVS_pixel2x2_top_40/vpd[1] openDVS_pixel2x2_top_40/vpd[0]
+ rowReadON<59> rowReadOFF<58> openDVS_pixel2x2_top_74/GndD DiffBn GndA OnBn VddA18
+ openDVS_pixel2x2_top
XopenDVS_pixel2x2_top_73 rowReadOFF<47> rowReadON<46> RefrBp PrBp PrSFBp col_periphery_1x2_18/COL_LINE0
+ pixRst<36> pixRst<37> col_periphery_1x2_18/COL_LINE1 OffBn openDVS_pixel2x2_top_73/vpd[2]
+ openDVS_pixel2x2_top_73/vpd[3] openDVS_pixel2x2_top_73/vpd[1] openDVS_pixel2x2_top_73/vpd[0]
+ rowReadON<47> rowReadOFF<46> openDVS_pixel2x2_top_78/GndD DiffBn GndA OnBn VddA18
+ openDVS_pixel2x2_top
XopenDVS_pixel2x2_top_95 rowReadOFF<51> rowReadON<50> RefrBp PrBp PrSFBp col_periphery_1x2_19/COL_LINE0
+ pixRst<38> pixRst<39> col_periphery_1x2_19/COL_LINE1 OffBn openDVS_pixel2x2_top_95/vpd[2]
+ openDVS_pixel2x2_top_95/vpd[3] openDVS_pixel2x2_top_95/vpd[1] openDVS_pixel2x2_top_95/vpd[0]
+ rowReadON<51> rowReadOFF<50> openDVS_pixel2x2_top_6/GndD DiffBn GndA OnBn VddA18
+ openDVS_pixel2x2_top
XopenDVS_pixel2x2_top_51 rowReadOFF<49> rowReadON<48> RefrBp PrBp PrSFBp col_periphery_1x2_25/COL_LINE0
+ pixRst<52> pixRst<53> col_periphery_1x2_25/COL_LINE1 OffBn openDVS_pixel2x2_top_51/vpd[2]
+ openDVS_pixel2x2_top_51/vpd[3] openDVS_pixel2x2_top_51/vpd[1] openDVS_pixel2x2_top_51/vpd[0]
+ rowReadON<49> rowReadOFF<48> openDVS_pixel2x2_top_3/GndD DiffBn GndA OnBn VddA18
+ openDVS_pixel2x2_top
XopenDVS_pixel2x2_top_62 rowReadOFF<51> rowReadON<50> RefrBp PrBp PrSFBp col_periphery_1x2_27/COL_LINE0
+ pixRst<56> pixRst<57> col_periphery_1x2_27/COL_LINE1 OffBn openDVS_pixel2x2_top_62/vpd[2]
+ openDVS_pixel2x2_top_62/vpd[3] openDVS_pixel2x2_top_62/vpd[1] openDVS_pixel2x2_top_62/vpd[0]
+ rowReadON<51> rowReadOFF<50> openDVS_pixel2x2_top_6/GndD DiffBn GndA OnBn VddA18
+ openDVS_pixel2x2_top
XopenDVS_pixel2x2_top_914 rowReadOFF<9> rowReadON<8> RefrBp PrBp PrSFBp col_periphery_1x2_29/COL_LINE0
+ pixRst<60> pixRst<61> col_periphery_1x2_29/COL_LINE1 OffBn openDVS_pixel2x2_top_914/vpd[2]
+ openDVS_pixel2x2_top_914/vpd[3] openDVS_pixel2x2_top_914/vpd[1] openDVS_pixel2x2_top_914/vpd[0]
+ rowReadON<9> rowReadOFF<8> openDVS_pixel2x2_top_939/GndD DiffBn GndA OnBn VddA18
+ openDVS_pixel2x2_top
XopenDVS_pixel2x2_top_903 rowReadOFF<9> rowReadON<8> RefrBp PrBp PrSFBp col_periphery_1x2_19/COL_LINE0
+ pixRst<38> pixRst<39> col_periphery_1x2_19/COL_LINE1 OffBn openDVS_pixel2x2_top_903/vpd[2]
+ openDVS_pixel2x2_top_903/vpd[3] openDVS_pixel2x2_top_903/vpd[1] openDVS_pixel2x2_top_903/vpd[0]
+ rowReadON<9> rowReadOFF<8> openDVS_pixel2x2_top_939/GndD DiffBn GndA OnBn VddA18
+ openDVS_pixel2x2_top
XopenDVS_pixel2x2_top_936 rowReadOFF<7> rowReadON<6> RefrBp PrBp PrSFBp col_periphery_1x2_14/COL_LINE0
+ pixRst<30> pixRst<31> col_periphery_1x2_14/COL_LINE1 OffBn openDVS_pixel2x2_top_936/vpd[2]
+ openDVS_pixel2x2_top_936/vpd[3] openDVS_pixel2x2_top_936/vpd[1] openDVS_pixel2x2_top_936/vpd[0]
+ rowReadON<7> rowReadOFF<6> openDVS_pixel2x2_top_937/GndD DiffBn GndA OnBn VddA18
+ openDVS_pixel2x2_top
XopenDVS_pixel2x2_top_947 rowReadOFF<17> rowReadON<16> RefrBp PrBp PrSFBp col_periphery_1x2_16/COL_LINE0
+ pixRst<32> pixRst<33> col_periphery_1x2_16/COL_LINE1 OffBn openDVS_pixel2x2_top_947/vpd[2]
+ openDVS_pixel2x2_top_947/vpd[3] openDVS_pixel2x2_top_947/vpd[1] openDVS_pixel2x2_top_947/vpd[0]
+ rowReadON<17> rowReadOFF<16> openDVS_pixel2x2_top_947/GndD DiffBn GndA OnBn VddA18
+ openDVS_pixel2x2_top
XopenDVS_pixel2x2_top_925 rowReadOFF<25> rowReadON<24> RefrBp PrBp PrSFBp col_periphery_1x2_31/COL_LINE0
+ pixRst<48> pixRst<49> col_periphery_1x2_31/COL_LINE1 OffBn openDVS_pixel2x2_top_925/vpd[2]
+ openDVS_pixel2x2_top_925/vpd[3] openDVS_pixel2x2_top_925/vpd[1] openDVS_pixel2x2_top_925/vpd[0]
+ rowReadON<25> rowReadOFF<24> openDVS_pixel2x2_top_955/GndD DiffBn GndA OnBn VddA18
+ openDVS_pixel2x2_top
XopenDVS_pixel2x2_top_969 rowReadOFF<27> rowReadON<26> RefrBp PrBp PrSFBp col_periphery_1x2_12/COL_LINE0
+ pixRst<26> pixRst<27> col_periphery_1x2_12/COL_LINE1 OffBn openDVS_pixel2x2_top_969/vpd[2]
+ openDVS_pixel2x2_top_969/vpd[3] openDVS_pixel2x2_top_969/vpd[1] openDVS_pixel2x2_top_969/vpd[0]
+ rowReadON<27> rowReadOFF<26> openDVS_pixel2x2_top_987/GndD DiffBn GndA OnBn VddA18
+ openDVS_pixel2x2_top
XopenDVS_pixel2x2_top_958 rowReadOFF<27> rowReadON<26> RefrBp PrBp PrSFBp col_periphery_1x2_4/COL_LINE0
+ pixRst<4> pixRst<5> col_periphery_1x2_4/COL_LINE1 OffBn openDVS_pixel2x2_top_958/vpd[2]
+ openDVS_pixel2x2_top_958/vpd[3] openDVS_pixel2x2_top_958/vpd[1] openDVS_pixel2x2_top_958/vpd[0]
+ rowReadON<27> rowReadOFF<26> openDVS_pixel2x2_top_987/GndD DiffBn GndA OnBn VddA18
+ openDVS_pixel2x2_top
XopenDVS_pixel2x2_top_711 rowReadOFF<9> rowReadON<8> RefrBp PrBp PrSFBp col_periphery_1x2_8/COL_LINE0
+ pixRst<18> pixRst<19> col_periphery_1x2_8/COL_LINE1 OffBn openDVS_pixel2x2_top_711/vpd[2]
+ openDVS_pixel2x2_top_711/vpd[3] openDVS_pixel2x2_top_711/vpd[1] openDVS_pixel2x2_top_711/vpd[0]
+ rowReadON<9> rowReadOFF<8> openDVS_pixel2x2_top_939/GndD DiffBn GndA OnBn VddA18
+ openDVS_pixel2x2_top
XopenDVS_pixel2x2_top_788 rowReadOFF<19> rowReadON<18> RefrBp PrBp PrSFBp col_periphery_1x2_30/COL_LINE0
+ pixRst<62> pixRst<63> col_periphery_1x2_30/COL_LINE1 OffBn openDVS_pixel2x2_top_788/vpd[2]
+ openDVS_pixel2x2_top_788/vpd[3] openDVS_pixel2x2_top_788/vpd[1] openDVS_pixel2x2_top_788/vpd[0]
+ rowReadON<19> rowReadOFF<18> openDVS_pixel2x2_top_949/GndD DiffBn GndA OnBn VddA18
+ openDVS_pixel2x2_top
XopenDVS_pixel2x2_top_777 rowReadOFF<19> rowReadON<18> RefrBp PrBp PrSFBp col_periphery_1x2_28/COL_LINE0
+ pixRst<58> pixRst<59> col_periphery_1x2_28/COL_LINE1 OffBn openDVS_pixel2x2_top_777/vpd[2]
+ openDVS_pixel2x2_top_777/vpd[3] openDVS_pixel2x2_top_777/vpd[1] openDVS_pixel2x2_top_777/vpd[0]
+ rowReadON<19> rowReadOFF<18> openDVS_pixel2x2_top_949/GndD DiffBn GndA OnBn VddA18
+ openDVS_pixel2x2_top
XopenDVS_pixel2x2_top_744 rowReadOFF<13> rowReadON<12> RefrBp PrBp PrSFBp col_periphery_1x2_27/COL_LINE0
+ pixRst<56> pixRst<57> col_periphery_1x2_27/COL_LINE1 OffBn openDVS_pixel2x2_top_744/vpd[2]
+ openDVS_pixel2x2_top_744/vpd[3] openDVS_pixel2x2_top_744/vpd[1] openDVS_pixel2x2_top_744/vpd[0]
+ rowReadON<13> rowReadOFF<12> openDVS_pixel2x2_top_943/GndD DiffBn GndA OnBn VddA18
+ openDVS_pixel2x2_top
XopenDVS_pixel2x2_top_799 rowReadOFF<13> rowReadON<12> RefrBp PrBp PrSFBp col_periphery_1x2_17/COL_LINE0
+ pixRst<34> pixRst<35> col_periphery_1x2_17/COL_LINE1 OffBn openDVS_pixel2x2_top_799/vpd[2]
+ openDVS_pixel2x2_top_799/vpd[3] openDVS_pixel2x2_top_799/vpd[1] openDVS_pixel2x2_top_799/vpd[0]
+ rowReadON<13> rowReadOFF<12> openDVS_pixel2x2_top_943/GndD DiffBn GndA OnBn VddA18
+ openDVS_pixel2x2_top
XopenDVS_pixel2x2_top_733 rowReadOFF<15> rowReadON<14> RefrBp PrBp PrSFBp col_periphery_1x2_15/COL_LINE0
+ pixRst<14> pixRst<15> col_periphery_1x2_15/COL_LINE1 OffBn openDVS_pixel2x2_top_733/vpd[2]
+ openDVS_pixel2x2_top_733/vpd[3] openDVS_pixel2x2_top_733/vpd[1] openDVS_pixel2x2_top_733/vpd[0]
+ rowReadON<15> rowReadOFF<14> openDVS_pixel2x2_top_945/GndD DiffBn GndA OnBn VddA18
+ openDVS_pixel2x2_top
XopenDVS_pixel2x2_top_766 rowReadOFF<25> rowReadON<24> RefrBp PrBp PrSFBp col_periphery_1x2_30/COL_LINE0
+ pixRst<62> pixRst<63> col_periphery_1x2_30/COL_LINE1 OffBn openDVS_pixel2x2_top_766/vpd[2]
+ openDVS_pixel2x2_top_766/vpd[3] openDVS_pixel2x2_top_766/vpd[1] openDVS_pixel2x2_top_766/vpd[0]
+ rowReadON<25> rowReadOFF<24> openDVS_pixel2x2_top_955/GndD DiffBn GndA OnBn VddA18
+ openDVS_pixel2x2_top
XopenDVS_pixel2x2_top_755 rowReadOFF<21> rowReadON<20> RefrBp PrBp PrSFBp col_periphery_1x2_26/COL_LINE0
+ pixRst<54> pixRst<55> col_periphery_1x2_26/COL_LINE1 OffBn openDVS_pixel2x2_top_755/vpd[2]
+ openDVS_pixel2x2_top_755/vpd[3] openDVS_pixel2x2_top_755/vpd[1] openDVS_pixel2x2_top_755/vpd[0]
+ rowReadON<21> rowReadOFF<20> openDVS_pixel2x2_top_951/GndD DiffBn GndA OnBn VddA18
+ openDVS_pixel2x2_top
XopenDVS_pixel2x2_top_722 rowReadOFF<25> rowReadON<24> RefrBp PrBp PrSFBp col_periphery_1x2_7/COL_LINE0
+ pixRst<16> pixRst<17> col_periphery_1x2_7/COL_LINE1 OffBn openDVS_pixel2x2_top_722/vpd[2]
+ openDVS_pixel2x2_top_722/vpd[3] openDVS_pixel2x2_top_722/vpd[1] openDVS_pixel2x2_top_722/vpd[0]
+ rowReadON<25> rowReadOFF<24> openDVS_pixel2x2_top_955/GndD DiffBn GndA OnBn VddA18
+ openDVS_pixel2x2_top
XopenDVS_pixel2x2_top_700 rowReadOFF<21> rowReadON<20> RefrBp PrBp PrSFBp col_periphery_1x2_15/COL_LINE0
+ pixRst<14> pixRst<15> col_periphery_1x2_15/COL_LINE1 OffBn openDVS_pixel2x2_top_700/vpd[2]
+ openDVS_pixel2x2_top_700/vpd[3] openDVS_pixel2x2_top_700/vpd[1] openDVS_pixel2x2_top_700/vpd[0]
+ rowReadON<21> rowReadOFF<20> openDVS_pixel2x2_top_951/GndD DiffBn GndA OnBn VddA18
+ openDVS_pixel2x2_top
Xcol_periphery_1x2_29 pixRst<61> col_periphery_1x2_29/COL_LINE0 col_periphery_1x2_29/COL_LINE1
+ nDETECT DETECT col_periphery_1x2_9/VDD VTHRESH pixRst<60> voutn<60> GndA voutn<61>
+ NCHARGE col_periphery_1x2
Xcol_periphery_1x2_18 pixRst<37> col_periphery_1x2_18/COL_LINE0 col_periphery_1x2_18/COL_LINE1
+ nDETECT DETECT col_periphery_1x2_9/VDD VTHRESH pixRst<36> voutn<36> GndA voutn<37>
+ NCHARGE col_periphery_1x2
XopenDVS_pixel2x2_top_530 rowReadOFF<61> rowReadON<60> RefrBp PrBp PrSFBp col_periphery_1x2_15/COL_LINE0
+ pixRst<14> pixRst<15> col_periphery_1x2_15/COL_LINE1 OffBn openDVS_pixel2x2_top_530/vpd[2]
+ openDVS_pixel2x2_top_530/vpd[3] openDVS_pixel2x2_top_530/vpd[1] openDVS_pixel2x2_top_530/vpd[0]
+ rowReadON<61> rowReadOFF<60> openDVS_pixel2x2_top_96/GndD DiffBn GndA OnBn VddA18
+ openDVS_pixel2x2_top
XopenDVS_pixel2x2_top_541 rowReadOFF<15> rowReadON<14> RefrBp PrBp PrSFBp col_periphery_1x2_9/COL_LINE0
+ pixRst<20> pixRst<21> col_periphery_1x2_9/COL_LINE1 OffBn openDVS_pixel2x2_top_541/vpd[2]
+ openDVS_pixel2x2_top_541/vpd[3] openDVS_pixel2x2_top_541/vpd[1] openDVS_pixel2x2_top_541/vpd[0]
+ rowReadON<15> rowReadOFF<14> openDVS_pixel2x2_top_945/GndD DiffBn GndA OnBn VddA18
+ openDVS_pixel2x2_top
XopenDVS_pixel2x2_top_585 rowReadOFF<13> rowReadON<12> RefrBp PrBp PrSFBp col_periphery_1x2_10/COL_LINE0
+ pixRst<22> pixRst<23> col_periphery_1x2_10/COL_LINE1 OffBn openDVS_pixel2x2_top_585/vpd[2]
+ openDVS_pixel2x2_top_585/vpd[3] openDVS_pixel2x2_top_585/vpd[1] openDVS_pixel2x2_top_585/vpd[0]
+ rowReadON<13> rowReadOFF<12> openDVS_pixel2x2_top_943/GndD DiffBn GndA OnBn VddA18
+ openDVS_pixel2x2_top
XopenDVS_pixel2x2_top_552 rowReadOFF<11> rowReadON<10> RefrBp PrBp PrSFBp col_periphery_1x2_8/COL_LINE0
+ pixRst<18> pixRst<19> col_periphery_1x2_8/COL_LINE1 OffBn openDVS_pixel2x2_top_552/vpd[2]
+ openDVS_pixel2x2_top_552/vpd[3] openDVS_pixel2x2_top_552/vpd[1] openDVS_pixel2x2_top_552/vpd[0]
+ rowReadON<11> rowReadOFF<10> openDVS_pixel2x2_top_941/GndD DiffBn GndA OnBn VddA18
+ openDVS_pixel2x2_top
XopenDVS_pixel2x2_top_574 rowReadOFF<23> rowReadON<22> RefrBp PrBp PrSFBp col_periphery_1x2_12/COL_LINE0
+ pixRst<26> pixRst<27> col_periphery_1x2_12/COL_LINE1 OffBn openDVS_pixel2x2_top_574/vpd[2]
+ openDVS_pixel2x2_top_574/vpd[3] openDVS_pixel2x2_top_574/vpd[1] openDVS_pixel2x2_top_574/vpd[0]
+ rowReadON<23> rowReadOFF<22> openDVS_pixel2x2_top_953/GndD DiffBn GndA OnBn VddA18
+ openDVS_pixel2x2_top
XopenDVS_pixel2x2_top_563 rowReadOFF<25> rowReadON<24> RefrBp PrBp PrSFBp col_periphery_1x2_8/COL_LINE0
+ pixRst<18> pixRst<19> col_periphery_1x2_8/COL_LINE1 OffBn openDVS_pixel2x2_top_563/vpd[2]
+ openDVS_pixel2x2_top_563/vpd[3] openDVS_pixel2x2_top_563/vpd[1] openDVS_pixel2x2_top_563/vpd[0]
+ rowReadON<25> rowReadOFF<24> openDVS_pixel2x2_top_955/GndD DiffBn GndA OnBn VddA18
+ openDVS_pixel2x2_top
XopenDVS_pixel2x2_top_596 rowReadOFF<23> rowReadON<22> RefrBp PrBp PrSFBp col_periphery_1x2_5/COL_LINE0
+ pixRst<6> pixRst<7> col_periphery_1x2_5/COL_LINE1 OffBn openDVS_pixel2x2_top_596/vpd[2]
+ openDVS_pixel2x2_top_596/vpd[3] openDVS_pixel2x2_top_596/vpd[1] openDVS_pixel2x2_top_596/vpd[0]
+ rowReadON<23> rowReadOFF<22> openDVS_pixel2x2_top_953/GndD DiffBn GndA OnBn VddA18
+ openDVS_pixel2x2_top
XopenDVS_pixel2x2_top_371 rowReadOFF<53> rowReadON<52> RefrBp PrBp PrSFBp col_periphery_1x2_4/COL_LINE0
+ pixRst<4> pixRst<5> col_periphery_1x2_4/COL_LINE1 OffBn openDVS_pixel2x2_top_371/vpd[2]
+ openDVS_pixel2x2_top_371/vpd[3] openDVS_pixel2x2_top_371/vpd[1] openDVS_pixel2x2_top_371/vpd[0]
+ rowReadON<53> rowReadOFF<52> openDVS_pixel2x2_top_99/GndD DiffBn GndA OnBn VddA18
+ openDVS_pixel2x2_top
XopenDVS_pixel2x2_top_382 rowReadOFF<55> rowReadON<54> RefrBp PrBp PrSFBp col_periphery_1x2_4/COL_LINE0
+ pixRst<4> pixRst<5> col_periphery_1x2_4/COL_LINE1 OffBn openDVS_pixel2x2_top_382/vpd[2]
+ openDVS_pixel2x2_top_382/vpd[3] openDVS_pixel2x2_top_382/vpd[1] openDVS_pixel2x2_top_382/vpd[0]
+ rowReadON<55> rowReadOFF<54> openDVS_pixel2x2_top_67/GndD DiffBn GndA OnBn VddA18
+ openDVS_pixel2x2_top
XopenDVS_pixel2x2_top_360 rowReadOFF<51> rowReadON<50> RefrBp PrBp PrSFBp col_periphery_1x2_4/COL_LINE0
+ pixRst<4> pixRst<5> col_periphery_1x2_4/COL_LINE1 OffBn openDVS_pixel2x2_top_360/vpd[2]
+ openDVS_pixel2x2_top_360/vpd[3] openDVS_pixel2x2_top_360/vpd[1] openDVS_pixel2x2_top_360/vpd[0]
+ rowReadON<51> rowReadOFF<50> openDVS_pixel2x2_top_6/GndD DiffBn GndA OnBn VddA18
+ openDVS_pixel2x2_top
XopenDVS_pixel2x2_top_393 rowReadOFF<33> rowReadON<32> RefrBp PrBp PrSFBp col_periphery_1x2_5/COL_LINE0
+ pixRst<6> pixRst<7> col_periphery_1x2_5/COL_LINE1 OffBn openDVS_pixel2x2_top_393/vpd[2]
+ openDVS_pixel2x2_top_393/vpd[3] openDVS_pixel2x2_top_393/vpd[1] openDVS_pixel2x2_top_393/vpd[0]
+ rowReadON<33> rowReadOFF<32> openDVS_pixel2x2_top_993/GndD DiffBn GndA OnBn VddA18
+ openDVS_pixel2x2_top
XopenDVS_pixel2x2_top_190 rowReadOFF<29> rowReadON<28> RefrBp PrBp PrSFBp col_periphery_1x2_29/COL_LINE0
+ pixRst<60> pixRst<61> col_periphery_1x2_29/COL_LINE1 OffBn openDVS_pixel2x2_top_190/vpd[2]
+ openDVS_pixel2x2_top_190/vpd[3] openDVS_pixel2x2_top_190/vpd[1] openDVS_pixel2x2_top_190/vpd[0]
+ rowReadON<29> rowReadOFF<28> openDVS_pixel2x2_top_989/GndD DiffBn GndA OnBn VddA18
+ openDVS_pixel2x2_top
XopenDVS_pixel2x2_top_74 rowReadOFF<59> rowReadON<58> RefrBp PrBp PrSFBp col_periphery_1x2_17/COL_LINE0
+ pixRst<34> pixRst<35> col_periphery_1x2_17/COL_LINE1 OffBn openDVS_pixel2x2_top_74/vpd[2]
+ openDVS_pixel2x2_top_74/vpd[3] openDVS_pixel2x2_top_74/vpd[1] openDVS_pixel2x2_top_74/vpd[0]
+ rowReadON<59> rowReadOFF<58> openDVS_pixel2x2_top_74/GndD DiffBn GndA OnBn VddA18
+ openDVS_pixel2x2_top
XopenDVS_pixel2x2_top_85 rowReadOFF<57> rowReadON<56> RefrBp PrBp PrSFBp col_periphery_1x2_17/COL_LINE0
+ pixRst<34> pixRst<35> col_periphery_1x2_17/COL_LINE1 OffBn openDVS_pixel2x2_top_85/vpd[2]
+ openDVS_pixel2x2_top_85/vpd[3] openDVS_pixel2x2_top_85/vpd[1] openDVS_pixel2x2_top_85/vpd[0]
+ rowReadON<57> rowReadOFF<56> openDVS_pixel2x2_top_9/GndD DiffBn GndA OnBn VddA18
+ openDVS_pixel2x2_top
XopenDVS_pixel2x2_top_63 rowReadOFF<63> rowReadON<62> RefrBp PrBp PrSFBp col_periphery_1x2_18/COL_LINE0
+ pixRst<36> pixRst<37> col_periphery_1x2_18/COL_LINE1 OffBn openDVS_pixel2x2_top_63/vpd[2]
+ openDVS_pixel2x2_top_63/vpd[3] openDVS_pixel2x2_top_63/vpd[1] openDVS_pixel2x2_top_63/vpd[0]
+ rowReadON<63> rowReadOFF<62> openDVS_pixel2x2_top_82/GndD DiffBn GndA OnBn VddA18
+ openDVS_pixel2x2_top
XopenDVS_pixel2x2_top_96 rowReadOFF<61> rowReadON<60> RefrBp PrBp PrSFBp col_periphery_1x2_22/COL_LINE0
+ pixRst<44> pixRst<45> col_periphery_1x2_22/COL_LINE1 OffBn openDVS_pixel2x2_top_96/vpd[2]
+ openDVS_pixel2x2_top_96/vpd[3] openDVS_pixel2x2_top_96/vpd[1] openDVS_pixel2x2_top_96/vpd[0]
+ rowReadON<61> rowReadOFF<60> openDVS_pixel2x2_top_96/GndD DiffBn GndA OnBn VddA18
+ openDVS_pixel2x2_top
XopenDVS_pixel2x2_top_30 rowReadOFF<63> rowReadON<62> RefrBp PrBp PrSFBp col_periphery_1x2_26/COL_LINE0
+ pixRst<54> pixRst<55> col_periphery_1x2_26/COL_LINE1 OffBn openDVS_pixel2x2_top_30/vpd[2]
+ openDVS_pixel2x2_top_30/vpd[3] openDVS_pixel2x2_top_30/vpd[1] openDVS_pixel2x2_top_30/vpd[0]
+ rowReadON<63> rowReadOFF<62> openDVS_pixel2x2_top_82/GndD DiffBn GndA OnBn VddA18
+ openDVS_pixel2x2_top
XopenDVS_pixel2x2_top_41 rowReadOFF<59> rowReadON<58> RefrBp PrBp PrSFBp col_periphery_1x2_29/COL_LINE0
+ pixRst<60> pixRst<61> col_periphery_1x2_29/COL_LINE1 OffBn openDVS_pixel2x2_top_41/vpd[2]
+ openDVS_pixel2x2_top_41/vpd[3] openDVS_pixel2x2_top_41/vpd[1] openDVS_pixel2x2_top_41/vpd[0]
+ rowReadON<59> rowReadOFF<58> openDVS_pixel2x2_top_74/GndD DiffBn GndA OnBn VddA18
+ openDVS_pixel2x2_top
XopenDVS_pixel2x2_top_52 rowReadOFF<49> rowReadON<48> RefrBp PrBp PrSFBp col_periphery_1x2_26/COL_LINE0
+ pixRst<54> pixRst<55> col_periphery_1x2_26/COL_LINE1 OffBn openDVS_pixel2x2_top_52/vpd[2]
+ openDVS_pixel2x2_top_52/vpd[3] openDVS_pixel2x2_top_52/vpd[1] openDVS_pixel2x2_top_52/vpd[0]
+ rowReadON<49> rowReadOFF<48> openDVS_pixel2x2_top_3/GndD DiffBn GndA OnBn VddA18
+ openDVS_pixel2x2_top
XopenDVS_pixel2x2_top_915 rowReadOFF<9> rowReadON<8> RefrBp PrBp PrSFBp col_periphery_1x2_30/COL_LINE0
+ pixRst<62> pixRst<63> col_periphery_1x2_30/COL_LINE1 OffBn openDVS_pixel2x2_top_915/vpd[2]
+ openDVS_pixel2x2_top_915/vpd[3] openDVS_pixel2x2_top_915/vpd[1] openDVS_pixel2x2_top_915/vpd[0]
+ rowReadON<9> rowReadOFF<8> openDVS_pixel2x2_top_939/GndD DiffBn GndA OnBn VddA18
+ openDVS_pixel2x2_top
XopenDVS_pixel2x2_top_904 rowReadOFF<9> rowReadON<8> RefrBp PrBp PrSFBp col_periphery_1x2_20/COL_LINE0
+ pixRst<40> pixRst<41> col_periphery_1x2_20/COL_LINE1 OffBn openDVS_pixel2x2_top_904/vpd[2]
+ openDVS_pixel2x2_top_904/vpd[3] openDVS_pixel2x2_top_904/vpd[1] openDVS_pixel2x2_top_904/vpd[0]
+ rowReadON<9> rowReadOFF<8> openDVS_pixel2x2_top_939/GndD DiffBn GndA OnBn VddA18
+ openDVS_pixel2x2_top
XopenDVS_pixel2x2_top_937 rowReadOFF<7> rowReadON<6> RefrBp PrBp PrSFBp col_periphery_1x2_16/COL_LINE0
+ pixRst<32> pixRst<33> col_periphery_1x2_16/COL_LINE1 OffBn openDVS_pixel2x2_top_937/vpd[2]
+ openDVS_pixel2x2_top_937/vpd[3] openDVS_pixel2x2_top_937/vpd[1] openDVS_pixel2x2_top_937/vpd[0]
+ rowReadON<7> rowReadOFF<6> openDVS_pixel2x2_top_937/GndD DiffBn GndA OnBn VddA18
+ openDVS_pixel2x2_top
XopenDVS_pixel2x2_top_926 rowReadOFF<19> rowReadON<18> RefrBp PrBp PrSFBp col_periphery_1x2_23/COL_LINE0
+ pixRst<46> pixRst<47> col_periphery_1x2_23/COL_LINE1 OffBn openDVS_pixel2x2_top_926/vpd[2]
+ openDVS_pixel2x2_top_926/vpd[3] openDVS_pixel2x2_top_926/vpd[1] openDVS_pixel2x2_top_926/vpd[0]
+ rowReadON<19> rowReadOFF<18> openDVS_pixel2x2_top_949/GndD DiffBn GndA OnBn VddA18
+ openDVS_pixel2x2_top
XopenDVS_pixel2x2_top_948 rowReadOFF<19> rowReadON<18> RefrBp PrBp PrSFBp col_periphery_1x2_14/COL_LINE0
+ pixRst<30> pixRst<31> col_periphery_1x2_14/COL_LINE1 OffBn openDVS_pixel2x2_top_948/vpd[2]
+ openDVS_pixel2x2_top_948/vpd[3] openDVS_pixel2x2_top_948/vpd[1] openDVS_pixel2x2_top_948/vpd[0]
+ rowReadON<19> rowReadOFF<18> openDVS_pixel2x2_top_949/GndD DiffBn GndA OnBn VddA18
+ openDVS_pixel2x2_top
XopenDVS_pixel2x2_top_959 rowReadOFF<27> rowReadON<26> RefrBp PrBp PrSFBp col_periphery_1x2_5/COL_LINE0
+ pixRst<6> pixRst<7> col_periphery_1x2_5/COL_LINE1 OffBn openDVS_pixel2x2_top_959/vpd[2]
+ openDVS_pixel2x2_top_959/vpd[3] openDVS_pixel2x2_top_959/vpd[1] openDVS_pixel2x2_top_959/vpd[0]
+ rowReadON<27> rowReadOFF<26> openDVS_pixel2x2_top_987/GndD DiffBn GndA OnBn VddA18
+ openDVS_pixel2x2_top
XopenDVS_pixel2x2_top_712 rowReadOFF<9> rowReadON<8> RefrBp PrBp PrSFBp col_periphery_1x2_9/COL_LINE0
+ pixRst<20> pixRst<21> col_periphery_1x2_9/COL_LINE1 OffBn openDVS_pixel2x2_top_712/vpd[2]
+ openDVS_pixel2x2_top_712/vpd[3] openDVS_pixel2x2_top_712/vpd[1] openDVS_pixel2x2_top_712/vpd[0]
+ rowReadON<9> rowReadOFF<8> openDVS_pixel2x2_top_939/GndD DiffBn GndA OnBn VddA18
+ openDVS_pixel2x2_top
XopenDVS_pixel2x2_top_745 rowReadOFF<13> rowReadON<12> RefrBp PrBp PrSFBp col_periphery_1x2_28/COL_LINE0
+ pixRst<58> pixRst<59> col_periphery_1x2_28/COL_LINE1 OffBn openDVS_pixel2x2_top_745/vpd[2]
+ openDVS_pixel2x2_top_745/vpd[3] openDVS_pixel2x2_top_745/vpd[1] openDVS_pixel2x2_top_745/vpd[0]
+ rowReadON<13> rowReadOFF<12> openDVS_pixel2x2_top_943/GndD DiffBn GndA OnBn VddA18
+ openDVS_pixel2x2_top
XopenDVS_pixel2x2_top_767 rowReadOFF<15> rowReadON<14> RefrBp PrBp PrSFBp col_periphery_1x2_28/COL_LINE0
+ pixRst<58> pixRst<59> col_periphery_1x2_28/COL_LINE1 OffBn openDVS_pixel2x2_top_767/vpd[2]
+ openDVS_pixel2x2_top_767/vpd[3] openDVS_pixel2x2_top_767/vpd[1] openDVS_pixel2x2_top_767/vpd[0]
+ rowReadON<15> rowReadOFF<14> openDVS_pixel2x2_top_945/GndD DiffBn GndA OnBn VddA18
+ openDVS_pixel2x2_top
XopenDVS_pixel2x2_top_778 rowReadOFF<11> rowReadON<10> RefrBp PrBp PrSFBp col_periphery_1x2_24/COL_LINE0
+ pixRst<50> pixRst<51> col_periphery_1x2_24/COL_LINE1 OffBn openDVS_pixel2x2_top_778/vpd[2]
+ openDVS_pixel2x2_top_778/vpd[3] openDVS_pixel2x2_top_778/vpd[1] openDVS_pixel2x2_top_778/vpd[0]
+ rowReadON<11> rowReadOFF<10> openDVS_pixel2x2_top_941/GndD DiffBn GndA OnBn VddA18
+ openDVS_pixel2x2_top
XopenDVS_pixel2x2_top_734 rowReadOFF<15> rowReadON<14> RefrBp PrBp PrSFBp col_periphery_1x2_7/COL_LINE0
+ pixRst<16> pixRst<17> col_periphery_1x2_7/COL_LINE1 OffBn openDVS_pixel2x2_top_734/vpd[2]
+ openDVS_pixel2x2_top_734/vpd[3] openDVS_pixel2x2_top_734/vpd[1] openDVS_pixel2x2_top_734/vpd[0]
+ rowReadON<15> rowReadOFF<14> openDVS_pixel2x2_top_945/GndD DiffBn GndA OnBn VddA18
+ openDVS_pixel2x2_top
XopenDVS_pixel2x2_top_723 rowReadOFF<19> rowReadON<18> RefrBp PrBp PrSFBp col_periphery_1x2_15/COL_LINE0
+ pixRst<14> pixRst<15> col_periphery_1x2_15/COL_LINE1 OffBn openDVS_pixel2x2_top_723/vpd[2]
+ openDVS_pixel2x2_top_723/vpd[3] openDVS_pixel2x2_top_723/vpd[1] openDVS_pixel2x2_top_723/vpd[0]
+ rowReadON<19> rowReadOFF<18> openDVS_pixel2x2_top_949/GndD DiffBn GndA OnBn VddA18
+ openDVS_pixel2x2_top
XopenDVS_pixel2x2_top_756 rowReadOFF<21> rowReadON<20> RefrBp PrBp PrSFBp col_periphery_1x2_27/COL_LINE0
+ pixRst<56> pixRst<57> col_periphery_1x2_27/COL_LINE1 OffBn openDVS_pixel2x2_top_756/vpd[2]
+ openDVS_pixel2x2_top_756/vpd[3] openDVS_pixel2x2_top_756/vpd[1] openDVS_pixel2x2_top_756/vpd[0]
+ rowReadON<21> rowReadOFF<20> openDVS_pixel2x2_top_951/GndD DiffBn GndA OnBn VddA18
+ openDVS_pixel2x2_top
XopenDVS_pixel2x2_top_789 rowReadOFF<25> rowReadON<24> RefrBp PrBp PrSFBp col_periphery_1x2_25/COL_LINE0
+ pixRst<52> pixRst<53> col_periphery_1x2_25/COL_LINE1 OffBn openDVS_pixel2x2_top_789/vpd[2]
+ openDVS_pixel2x2_top_789/vpd[3] openDVS_pixel2x2_top_789/vpd[1] openDVS_pixel2x2_top_789/vpd[0]
+ rowReadON<25> rowReadOFF<24> openDVS_pixel2x2_top_955/GndD DiffBn GndA OnBn VddA18
+ openDVS_pixel2x2_top
XopenDVS_pixel2x2_top_701 rowReadOFF<21> rowReadON<20> RefrBp PrBp PrSFBp col_periphery_1x2_7/COL_LINE0
+ pixRst<16> pixRst<17> col_periphery_1x2_7/COL_LINE1 OffBn openDVS_pixel2x2_top_701/vpd[2]
+ openDVS_pixel2x2_top_701/vpd[3] openDVS_pixel2x2_top_701/vpd[1] openDVS_pixel2x2_top_701/vpd[0]
+ rowReadON<21> rowReadOFF<20> openDVS_pixel2x2_top_951/GndD DiffBn GndA OnBn VddA18
+ openDVS_pixel2x2_top
Xcol_periphery_1x2_19 pixRst<39> col_periphery_1x2_19/COL_LINE0 col_periphery_1x2_19/COL_LINE1
+ nDETECT DETECT col_periphery_1x2_9/VDD VTHRESH pixRst<38> voutn<38> GndA voutn<39>
+ NCHARGE col_periphery_1x2
XopenDVS_pixel2x2_top_586 rowReadOFF<13> rowReadON<12> RefrBp PrBp PrSFBp col_periphery_1x2_11/COL_LINE0
+ pixRst<24> pixRst<25> col_periphery_1x2_11/COL_LINE1 OffBn openDVS_pixel2x2_top_586/vpd[2]
+ openDVS_pixel2x2_top_586/vpd[3] openDVS_pixel2x2_top_586/vpd[1] openDVS_pixel2x2_top_586/vpd[0]
+ rowReadON<13> rowReadOFF<12> openDVS_pixel2x2_top_943/GndD DiffBn GndA OnBn VddA18
+ openDVS_pixel2x2_top
XopenDVS_pixel2x2_top_553 rowReadOFF<11> rowReadON<10> RefrBp PrBp PrSFBp col_periphery_1x2_9/COL_LINE0
+ pixRst<20> pixRst<21> col_periphery_1x2_9/COL_LINE1 OffBn openDVS_pixel2x2_top_553/vpd[2]
+ openDVS_pixel2x2_top_553/vpd[3] openDVS_pixel2x2_top_553/vpd[1] openDVS_pixel2x2_top_553/vpd[0]
+ rowReadON<11> rowReadOFF<10> openDVS_pixel2x2_top_941/GndD DiffBn GndA OnBn VddA18
+ openDVS_pixel2x2_top
XopenDVS_pixel2x2_top_542 rowReadOFF<15> rowReadON<14> RefrBp PrBp PrSFBp col_periphery_1x2_10/COL_LINE0
+ pixRst<22> pixRst<23> col_periphery_1x2_10/COL_LINE1 OffBn openDVS_pixel2x2_top_542/vpd[2]
+ openDVS_pixel2x2_top_542/vpd[3] openDVS_pixel2x2_top_542/vpd[1] openDVS_pixel2x2_top_542/vpd[0]
+ rowReadON<15> rowReadOFF<14> openDVS_pixel2x2_top_945/GndD DiffBn GndA OnBn VddA18
+ openDVS_pixel2x2_top
XopenDVS_pixel2x2_top_564 rowReadOFF<17> rowReadON<16> RefrBp PrBp PrSFBp col_periphery_1x2_8/COL_LINE0
+ pixRst<18> pixRst<19> col_periphery_1x2_8/COL_LINE1 OffBn openDVS_pixel2x2_top_564/vpd[2]
+ openDVS_pixel2x2_top_564/vpd[3] openDVS_pixel2x2_top_564/vpd[1] openDVS_pixel2x2_top_564/vpd[0]
+ rowReadON<17> rowReadOFF<16> openDVS_pixel2x2_top_947/GndD DiffBn GndA OnBn VddA18
+ openDVS_pixel2x2_top
XopenDVS_pixel2x2_top_575 rowReadOFF<23> rowReadON<22> RefrBp PrBp PrSFBp col_periphery_1x2_13/COL_LINE0
+ pixRst<28> pixRst<29> col_periphery_1x2_13/COL_LINE1 OffBn openDVS_pixel2x2_top_575/vpd[2]
+ openDVS_pixel2x2_top_575/vpd[3] openDVS_pixel2x2_top_575/vpd[1] openDVS_pixel2x2_top_575/vpd[0]
+ rowReadON<23> rowReadOFF<22> openDVS_pixel2x2_top_953/GndD DiffBn GndA OnBn VddA18
+ openDVS_pixel2x2_top
XopenDVS_pixel2x2_top_520 rowReadOFF<29> rowReadON<28> RefrBp PrBp PrSFBp col_periphery_1x2_15/COL_LINE0
+ pixRst<14> pixRst<15> col_periphery_1x2_15/COL_LINE1 OffBn openDVS_pixel2x2_top_520/vpd[2]
+ openDVS_pixel2x2_top_520/vpd[3] openDVS_pixel2x2_top_520/vpd[1] openDVS_pixel2x2_top_520/vpd[0]
+ rowReadON<29> rowReadOFF<28> openDVS_pixel2x2_top_989/GndD DiffBn GndA OnBn VddA18
+ openDVS_pixel2x2_top
XopenDVS_pixel2x2_top_597 rowReadOFF<23> rowReadON<22> RefrBp PrBp PrSFBp col_periphery_1x2_6/COL_LINE0
+ pixRst<8> pixRst<9> col_periphery_1x2_6/COL_LINE1 OffBn openDVS_pixel2x2_top_597/vpd[2]
+ openDVS_pixel2x2_top_597/vpd[3] openDVS_pixel2x2_top_597/vpd[1] openDVS_pixel2x2_top_597/vpd[0]
+ rowReadON<23> rowReadOFF<22> openDVS_pixel2x2_top_953/GndD DiffBn GndA OnBn VddA18
+ openDVS_pixel2x2_top
XopenDVS_pixel2x2_top_531 rowReadOFF<39> rowReadON<38> RefrBp PrBp PrSFBp col_periphery_1x2_15/COL_LINE0
+ pixRst<14> pixRst<15> col_periphery_1x2_15/COL_LINE1 OffBn openDVS_pixel2x2_top_531/vpd[2]
+ openDVS_pixel2x2_top_531/vpd[3] openDVS_pixel2x2_top_531/vpd[1] openDVS_pixel2x2_top_531/vpd[0]
+ rowReadON<39> rowReadOFF<38> openDVS_pixel2x2_top_999/GndD DiffBn GndA OnBn VddA18
+ openDVS_pixel2x2_top
XopenDVS_pixel2x2_top_372 rowReadOFF<53> rowReadON<52> RefrBp PrBp PrSFBp col_periphery_1x2_5/COL_LINE0
+ pixRst<6> pixRst<7> col_periphery_1x2_5/COL_LINE1 OffBn openDVS_pixel2x2_top_372/vpd[2]
+ openDVS_pixel2x2_top_372/vpd[3] openDVS_pixel2x2_top_372/vpd[1] openDVS_pixel2x2_top_372/vpd[0]
+ rowReadON<53> rowReadOFF<52> openDVS_pixel2x2_top_99/GndD DiffBn GndA OnBn VddA18
+ openDVS_pixel2x2_top
XopenDVS_pixel2x2_top_383 rowReadOFF<55> rowReadON<54> RefrBp PrBp PrSFBp col_periphery_1x2_5/COL_LINE0
+ pixRst<6> pixRst<7> col_periphery_1x2_5/COL_LINE1 OffBn openDVS_pixel2x2_top_383/vpd[2]
+ openDVS_pixel2x2_top_383/vpd[3] openDVS_pixel2x2_top_383/vpd[1] openDVS_pixel2x2_top_383/vpd[0]
+ rowReadON<55> rowReadOFF<54> openDVS_pixel2x2_top_67/GndD DiffBn GndA OnBn VddA18
+ openDVS_pixel2x2_top
XopenDVS_pixel2x2_top_361 rowReadOFF<51> rowReadON<50> RefrBp PrBp PrSFBp col_periphery_1x2_5/COL_LINE0
+ pixRst<6> pixRst<7> col_periphery_1x2_5/COL_LINE1 OffBn openDVS_pixel2x2_top_361/vpd[2]
+ openDVS_pixel2x2_top_361/vpd[3] openDVS_pixel2x2_top_361/vpd[1] openDVS_pixel2x2_top_361/vpd[0]
+ rowReadON<51> rowReadOFF<50> openDVS_pixel2x2_top_6/GndD DiffBn GndA OnBn VddA18
+ openDVS_pixel2x2_top
XopenDVS_pixel2x2_top_350 rowReadOFF<49> rowReadON<48> RefrBp PrBp PrSFBp col_periphery_1x2_5/COL_LINE0
+ pixRst<6> pixRst<7> col_periphery_1x2_5/COL_LINE1 OffBn openDVS_pixel2x2_top_350/vpd[2]
+ openDVS_pixel2x2_top_350/vpd[3] openDVS_pixel2x2_top_350/vpd[1] openDVS_pixel2x2_top_350/vpd[0]
+ rowReadON<49> rowReadOFF<48> openDVS_pixel2x2_top_3/GndD DiffBn GndA OnBn VddA18
+ openDVS_pixel2x2_top
XopenDVS_pixel2x2_top_394 rowReadOFF<33> rowReadON<32> RefrBp PrBp PrSFBp col_periphery_1x2_6/COL_LINE0
+ pixRst<8> pixRst<9> col_periphery_1x2_6/COL_LINE1 OffBn openDVS_pixel2x2_top_394/vpd[2]
+ openDVS_pixel2x2_top_394/vpd[3] openDVS_pixel2x2_top_394/vpd[1] openDVS_pixel2x2_top_394/vpd[0]
+ rowReadON<33> rowReadOFF<32> openDVS_pixel2x2_top_993/GndD DiffBn GndA OnBn VddA18
+ openDVS_pixel2x2_top
XopenDVS_pixel2x2_top_180 rowReadOFF<39> rowReadON<38> RefrBp PrBp PrSFBp col_periphery_1x2_24/COL_LINE0
+ pixRst<50> pixRst<51> col_periphery_1x2_24/COL_LINE1 OffBn openDVS_pixel2x2_top_180/vpd[2]
+ openDVS_pixel2x2_top_180/vpd[3] openDVS_pixel2x2_top_180/vpd[1] openDVS_pixel2x2_top_180/vpd[0]
+ rowReadON<39> rowReadOFF<38> openDVS_pixel2x2_top_999/GndD DiffBn GndA OnBn VddA18
+ openDVS_pixel2x2_top
XopenDVS_pixel2x2_top_191 rowReadOFF<41> rowReadON<40> RefrBp PrBp PrSFBp col_periphery_1x2_24/COL_LINE0
+ pixRst<50> pixRst<51> col_periphery_1x2_24/COL_LINE1 OffBn openDVS_pixel2x2_top_191/vpd[2]
+ openDVS_pixel2x2_top_191/vpd[3] openDVS_pixel2x2_top_191/vpd[1] openDVS_pixel2x2_top_191/vpd[0]
+ rowReadON<41> rowReadOFF<40> openDVS_pixel2x2_top_535/GndD DiffBn GndA OnBn VddA18
+ openDVS_pixel2x2_top
XopenDVS_pixel2x2_top_86 rowReadOFF<57> rowReadON<56> RefrBp PrBp PrSFBp col_periphery_1x2_18/COL_LINE0
+ pixRst<36> pixRst<37> col_periphery_1x2_18/COL_LINE1 OffBn openDVS_pixel2x2_top_86/vpd[2]
+ openDVS_pixel2x2_top_86/vpd[3] openDVS_pixel2x2_top_86/vpd[1] openDVS_pixel2x2_top_86/vpd[0]
+ rowReadON<57> rowReadOFF<56> openDVS_pixel2x2_top_9/GndD DiffBn GndA OnBn VddA18
+ openDVS_pixel2x2_top
XopenDVS_pixel2x2_top_64 rowReadOFF<63> rowReadON<62> RefrBp PrBp PrSFBp col_periphery_1x2_19/COL_LINE0
+ pixRst<38> pixRst<39> col_periphery_1x2_19/COL_LINE1 OffBn openDVS_pixel2x2_top_64/vpd[2]
+ openDVS_pixel2x2_top_64/vpd[3] openDVS_pixel2x2_top_64/vpd[1] openDVS_pixel2x2_top_64/vpd[0]
+ rowReadON<63> rowReadOFF<62> openDVS_pixel2x2_top_82/GndD DiffBn GndA OnBn VddA18
+ openDVS_pixel2x2_top
XopenDVS_pixel2x2_top_53 rowReadOFF<55> rowReadON<54> RefrBp PrBp PrSFBp col_periphery_1x2_24/COL_LINE0
+ pixRst<50> pixRst<51> col_periphery_1x2_24/COL_LINE1 OffBn openDVS_pixel2x2_top_53/vpd[2]
+ openDVS_pixel2x2_top_53/vpd[3] openDVS_pixel2x2_top_53/vpd[1] openDVS_pixel2x2_top_53/vpd[0]
+ rowReadON<55> rowReadOFF<54> openDVS_pixel2x2_top_67/GndD DiffBn GndA OnBn VddA18
+ openDVS_pixel2x2_top
XopenDVS_pixel2x2_top_31 rowReadOFF<63> rowReadON<62> RefrBp PrBp PrSFBp col_periphery_1x2_27/COL_LINE0
+ pixRst<56> pixRst<57> col_periphery_1x2_27/COL_LINE1 OffBn openDVS_pixel2x2_top_31/vpd[2]
+ openDVS_pixel2x2_top_31/vpd[3] openDVS_pixel2x2_top_31/vpd[1] openDVS_pixel2x2_top_31/vpd[0]
+ rowReadON<63> rowReadOFF<62> openDVS_pixel2x2_top_82/GndD DiffBn GndA OnBn VddA18
+ openDVS_pixel2x2_top
XopenDVS_pixel2x2_top_20 rowReadOFF<53> rowReadON<52> RefrBp PrBp PrSFBp col_periphery_1x2_27/COL_LINE0
+ pixRst<56> pixRst<57> col_periphery_1x2_27/COL_LINE1 OffBn openDVS_pixel2x2_top_20/vpd[2]
+ openDVS_pixel2x2_top_20/vpd[3] openDVS_pixel2x2_top_20/vpd[1] openDVS_pixel2x2_top_20/vpd[0]
+ rowReadON<53> rowReadOFF<52> openDVS_pixel2x2_top_99/GndD DiffBn GndA OnBn VddA18
+ openDVS_pixel2x2_top
XopenDVS_pixel2x2_top_42 rowReadOFF<59> rowReadON<58> RefrBp PrBp PrSFBp col_periphery_1x2_30/COL_LINE0
+ pixRst<62> pixRst<63> col_periphery_1x2_30/COL_LINE1 OffBn openDVS_pixel2x2_top_42/vpd[2]
+ openDVS_pixel2x2_top_42/vpd[3] openDVS_pixel2x2_top_42/vpd[1] openDVS_pixel2x2_top_42/vpd[0]
+ rowReadON<59> rowReadOFF<58> openDVS_pixel2x2_top_74/GndD DiffBn GndA OnBn VddA18
+ openDVS_pixel2x2_top
XopenDVS_pixel2x2_top_75 rowReadOFF<47> rowReadON<46> RefrBp PrBp PrSFBp col_periphery_1x2_19/COL_LINE0
+ pixRst<38> pixRst<39> col_periphery_1x2_19/COL_LINE1 OffBn openDVS_pixel2x2_top_75/vpd[2]
+ openDVS_pixel2x2_top_75/vpd[3] openDVS_pixel2x2_top_75/vpd[1] openDVS_pixel2x2_top_75/vpd[0]
+ rowReadON<47> rowReadOFF<46> openDVS_pixel2x2_top_78/GndD DiffBn GndA OnBn VddA18
+ openDVS_pixel2x2_top
XopenDVS_pixel2x2_top_97 rowReadOFF<49> rowReadON<48> RefrBp PrBp PrSFBp col_periphery_1x2_20/COL_LINE0
+ pixRst<40> pixRst<41> col_periphery_1x2_20/COL_LINE1 OffBn openDVS_pixel2x2_top_97/vpd[2]
+ openDVS_pixel2x2_top_97/vpd[3] openDVS_pixel2x2_top_97/vpd[1] openDVS_pixel2x2_top_97/vpd[0]
+ rowReadON<49> rowReadOFF<48> openDVS_pixel2x2_top_3/GndD DiffBn GndA OnBn VddA18
+ openDVS_pixel2x2_top
Xcol_periphery_1x2_0 pixRst<11> col_periphery_1x2_0/COL_LINE0 col_periphery_1x2_0/COL_LINE1
+ nDETECT DETECT col_periphery_1x2_9/VDD VTHRESH pixRst<10> voutn<10> GndA voutn<11>
+ NCHARGE col_periphery_1x2
XopenDVS_pixel2x2_top_905 rowReadOFF<9> rowReadON<8> RefrBp PrBp PrSFBp col_periphery_1x2_21/COL_LINE0
+ pixRst<42> pixRst<43> col_periphery_1x2_21/COL_LINE1 OffBn openDVS_pixel2x2_top_905/vpd[2]
+ openDVS_pixel2x2_top_905/vpd[3] openDVS_pixel2x2_top_905/vpd[1] openDVS_pixel2x2_top_905/vpd[0]
+ rowReadON<9> rowReadOFF<8> openDVS_pixel2x2_top_939/GndD DiffBn GndA OnBn VddA18
+ openDVS_pixel2x2_top
XopenDVS_pixel2x2_top_938 rowReadOFF<9> rowReadON<8> RefrBp PrBp PrSFBp col_periphery_1x2_14/COL_LINE0
+ pixRst<30> pixRst<31> col_periphery_1x2_14/COL_LINE1 OffBn openDVS_pixel2x2_top_938/vpd[2]
+ openDVS_pixel2x2_top_938/vpd[3] openDVS_pixel2x2_top_938/vpd[1] openDVS_pixel2x2_top_938/vpd[0]
+ rowReadON<9> rowReadOFF<8> openDVS_pixel2x2_top_939/GndD DiffBn GndA OnBn VddA18
+ openDVS_pixel2x2_top
XopenDVS_pixel2x2_top_927 rowReadOFF<19> rowReadON<18> RefrBp PrBp PrSFBp col_periphery_1x2_31/COL_LINE0
+ pixRst<48> pixRst<49> col_periphery_1x2_31/COL_LINE1 OffBn openDVS_pixel2x2_top_927/vpd[2]
+ openDVS_pixel2x2_top_927/vpd[3] openDVS_pixel2x2_top_927/vpd[1] openDVS_pixel2x2_top_927/vpd[0]
+ rowReadON<19> rowReadOFF<18> openDVS_pixel2x2_top_949/GndD DiffBn GndA OnBn VddA18
+ openDVS_pixel2x2_top
XopenDVS_pixel2x2_top_916 rowReadOFF<11> rowReadON<10> RefrBp PrBp PrSFBp col_periphery_1x2_23/COL_LINE0
+ pixRst<46> pixRst<47> col_periphery_1x2_23/COL_LINE1 OffBn openDVS_pixel2x2_top_916/vpd[2]
+ openDVS_pixel2x2_top_916/vpd[3] openDVS_pixel2x2_top_916/vpd[1] openDVS_pixel2x2_top_916/vpd[0]
+ rowReadON<11> rowReadOFF<10> openDVS_pixel2x2_top_941/GndD DiffBn GndA OnBn VddA18
+ openDVS_pixel2x2_top
XopenDVS_pixel2x2_top_949 rowReadOFF<19> rowReadON<18> RefrBp PrBp PrSFBp col_periphery_1x2_16/COL_LINE0
+ pixRst<32> pixRst<33> col_periphery_1x2_16/COL_LINE1 OffBn openDVS_pixel2x2_top_949/vpd[2]
+ openDVS_pixel2x2_top_949/vpd[3] openDVS_pixel2x2_top_949/vpd[1] openDVS_pixel2x2_top_949/vpd[0]
+ rowReadON<19> rowReadOFF<18> openDVS_pixel2x2_top_949/GndD DiffBn GndA OnBn VddA18
+ openDVS_pixel2x2_top
XopenDVS_pixel2x2_top_713 rowReadOFF<9> rowReadON<8> RefrBp PrBp PrSFBp col_periphery_1x2_10/COL_LINE0
+ pixRst<22> pixRst<23> col_periphery_1x2_10/COL_LINE1 OffBn openDVS_pixel2x2_top_713/vpd[2]
+ openDVS_pixel2x2_top_713/vpd[3] openDVS_pixel2x2_top_713/vpd[1] openDVS_pixel2x2_top_713/vpd[0]
+ rowReadON<9> rowReadOFF<8> openDVS_pixel2x2_top_939/GndD DiffBn GndA OnBn VddA18
+ openDVS_pixel2x2_top
XopenDVS_pixel2x2_top_702 rowReadOFF<9> rowReadON<8> RefrBp PrBp PrSFBp col_periphery_1x2_2/COL_LINE0
+ pixRst<0> pixRst<1> col_periphery_1x2_2/COL_LINE1 OffBn openDVS_pixel2x2_top_702/vpd[2]
+ openDVS_pixel2x2_top_702/vpd[3] openDVS_pixel2x2_top_702/vpd[1] openDVS_pixel2x2_top_702/vpd[0]
+ rowReadON<9> rowReadOFF<8> openDVS_pixel2x2_top_939/GndD DiffBn GndA OnBn VddA18
+ openDVS_pixel2x2_top
XopenDVS_pixel2x2_top_746 rowReadOFF<13> rowReadON<12> RefrBp PrBp PrSFBp col_periphery_1x2_29/COL_LINE0
+ pixRst<60> pixRst<61> col_periphery_1x2_29/COL_LINE1 OffBn openDVS_pixel2x2_top_746/vpd[2]
+ openDVS_pixel2x2_top_746/vpd[3] openDVS_pixel2x2_top_746/vpd[1] openDVS_pixel2x2_top_746/vpd[0]
+ rowReadON<13> rowReadOFF<12> openDVS_pixel2x2_top_943/GndD DiffBn GndA OnBn VddA18
+ openDVS_pixel2x2_top
XopenDVS_pixel2x2_top_768 rowReadOFF<15> rowReadON<14> RefrBp PrBp PrSFBp col_periphery_1x2_29/COL_LINE0
+ pixRst<60> pixRst<61> col_periphery_1x2_29/COL_LINE1 OffBn openDVS_pixel2x2_top_768/vpd[2]
+ openDVS_pixel2x2_top_768/vpd[3] openDVS_pixel2x2_top_768/vpd[1] openDVS_pixel2x2_top_768/vpd[0]
+ rowReadON<15> rowReadOFF<14> openDVS_pixel2x2_top_945/GndD DiffBn GndA OnBn VddA18
+ openDVS_pixel2x2_top
XopenDVS_pixel2x2_top_779 rowReadOFF<11> rowReadON<10> RefrBp PrBp PrSFBp col_periphery_1x2_25/COL_LINE0
+ pixRst<52> pixRst<53> col_periphery_1x2_25/COL_LINE1 OffBn openDVS_pixel2x2_top_779/vpd[2]
+ openDVS_pixel2x2_top_779/vpd[3] openDVS_pixel2x2_top_779/vpd[1] openDVS_pixel2x2_top_779/vpd[0]
+ rowReadON<11> rowReadOFF<10> openDVS_pixel2x2_top_941/GndD DiffBn GndA OnBn VddA18
+ openDVS_pixel2x2_top
XopenDVS_pixel2x2_top_735 rowReadOFF<17> rowReadON<16> RefrBp PrBp PrSFBp col_periphery_1x2_24/COL_LINE0
+ pixRst<50> pixRst<51> col_periphery_1x2_24/COL_LINE1 OffBn openDVS_pixel2x2_top_735/vpd[2]
+ openDVS_pixel2x2_top_735/vpd[3] openDVS_pixel2x2_top_735/vpd[1] openDVS_pixel2x2_top_735/vpd[0]
+ rowReadON<17> rowReadOFF<16> openDVS_pixel2x2_top_947/GndD DiffBn GndA OnBn VddA18
+ openDVS_pixel2x2_top
XopenDVS_pixel2x2_top_724 rowReadOFF<19> rowReadON<18> RefrBp PrBp PrSFBp col_periphery_1x2_7/COL_LINE0
+ pixRst<16> pixRst<17> col_periphery_1x2_7/COL_LINE1 OffBn openDVS_pixel2x2_top_724/vpd[2]
+ openDVS_pixel2x2_top_724/vpd[3] openDVS_pixel2x2_top_724/vpd[1] openDVS_pixel2x2_top_724/vpd[0]
+ rowReadON<19> rowReadOFF<18> openDVS_pixel2x2_top_949/GndD DiffBn GndA OnBn VddA18
+ openDVS_pixel2x2_top
XopenDVS_pixel2x2_top_757 rowReadOFF<21> rowReadON<20> RefrBp PrBp PrSFBp col_periphery_1x2_28/COL_LINE0
+ pixRst<58> pixRst<59> col_periphery_1x2_28/COL_LINE1 OffBn openDVS_pixel2x2_top_757/vpd[2]
+ openDVS_pixel2x2_top_757/vpd[3] openDVS_pixel2x2_top_757/vpd[1] openDVS_pixel2x2_top_757/vpd[0]
+ rowReadON<21> rowReadOFF<20> openDVS_pixel2x2_top_951/GndD DiffBn GndA OnBn VddA18
+ openDVS_pixel2x2_top
XopenDVS_pixel2x2_top_587 rowReadOFF<13> rowReadON<12> RefrBp PrBp PrSFBp col_periphery_1x2_12/COL_LINE0
+ pixRst<26> pixRst<27> col_periphery_1x2_12/COL_LINE1 OffBn openDVS_pixel2x2_top_587/vpd[2]
+ openDVS_pixel2x2_top_587/vpd[3] openDVS_pixel2x2_top_587/vpd[1] openDVS_pixel2x2_top_587/vpd[0]
+ rowReadON<13> rowReadOFF<12> openDVS_pixel2x2_top_943/GndD DiffBn GndA OnBn VddA18
+ openDVS_pixel2x2_top
XopenDVS_pixel2x2_top_543 rowReadOFF<15> rowReadON<14> RefrBp PrBp PrSFBp col_periphery_1x2_11/COL_LINE0
+ pixRst<24> pixRst<25> col_periphery_1x2_11/COL_LINE1 OffBn openDVS_pixel2x2_top_543/vpd[2]
+ openDVS_pixel2x2_top_543/vpd[3] openDVS_pixel2x2_top_543/vpd[1] openDVS_pixel2x2_top_543/vpd[0]
+ rowReadON<15> rowReadOFF<14> openDVS_pixel2x2_top_945/GndD DiffBn GndA OnBn VddA18
+ openDVS_pixel2x2_top
XopenDVS_pixel2x2_top_554 rowReadOFF<11> rowReadON<10> RefrBp PrBp PrSFBp col_periphery_1x2_10/COL_LINE0
+ pixRst<22> pixRst<23> col_periphery_1x2_10/COL_LINE1 OffBn openDVS_pixel2x2_top_554/vpd[2]
+ openDVS_pixel2x2_top_554/vpd[3] openDVS_pixel2x2_top_554/vpd[1] openDVS_pixel2x2_top_554/vpd[0]
+ rowReadON<11> rowReadOFF<10> openDVS_pixel2x2_top_941/GndD DiffBn GndA OnBn VddA18
+ openDVS_pixel2x2_top
XopenDVS_pixel2x2_top_565 rowReadOFF<17> rowReadON<16> RefrBp PrBp PrSFBp col_periphery_1x2_9/COL_LINE0
+ pixRst<20> pixRst<21> col_periphery_1x2_9/COL_LINE1 OffBn openDVS_pixel2x2_top_565/vpd[2]
+ openDVS_pixel2x2_top_565/vpd[3] openDVS_pixel2x2_top_565/vpd[1] openDVS_pixel2x2_top_565/vpd[0]
+ rowReadON<17> rowReadOFF<16> openDVS_pixel2x2_top_947/GndD DiffBn GndA OnBn VddA18
+ openDVS_pixel2x2_top
XopenDVS_pixel2x2_top_598 rowReadOFF<17> rowReadON<16> RefrBp PrBp PrSFBp col_periphery_1x2_2/COL_LINE0
+ pixRst<0> pixRst<1> col_periphery_1x2_2/COL_LINE1 OffBn openDVS_pixel2x2_top_598/vpd[2]
+ openDVS_pixel2x2_top_598/vpd[3] openDVS_pixel2x2_top_598/vpd[1] openDVS_pixel2x2_top_598/vpd[0]
+ rowReadON<17> rowReadOFF<16> openDVS_pixel2x2_top_947/GndD DiffBn GndA OnBn VddA18
+ openDVS_pixel2x2_top
XopenDVS_pixel2x2_top_576 rowReadOFF<21> rowReadON<20> RefrBp PrBp PrSFBp col_periphery_1x2_8/COL_LINE0
+ pixRst<18> pixRst<19> col_periphery_1x2_8/COL_LINE1 OffBn openDVS_pixel2x2_top_576/vpd[2]
+ openDVS_pixel2x2_top_576/vpd[3] openDVS_pixel2x2_top_576/vpd[1] openDVS_pixel2x2_top_576/vpd[0]
+ rowReadON<21> rowReadOFF<20> openDVS_pixel2x2_top_951/GndD DiffBn GndA OnBn VddA18
+ openDVS_pixel2x2_top
XopenDVS_pixel2x2_top_521 rowReadOFF<29> rowReadON<28> RefrBp PrBp PrSFBp col_periphery_1x2_7/COL_LINE0
+ pixRst<16> pixRst<17> col_periphery_1x2_7/COL_LINE1 OffBn openDVS_pixel2x2_top_521/vpd[2]
+ openDVS_pixel2x2_top_521/vpd[3] openDVS_pixel2x2_top_521/vpd[1] openDVS_pixel2x2_top_521/vpd[0]
+ rowReadON<29> rowReadOFF<28> openDVS_pixel2x2_top_989/GndD DiffBn GndA OnBn VddA18
+ openDVS_pixel2x2_top
XopenDVS_pixel2x2_top_532 rowReadOFF<39> rowReadON<38> RefrBp PrBp PrSFBp col_periphery_1x2_7/COL_LINE0
+ pixRst<16> pixRst<17> col_periphery_1x2_7/COL_LINE1 OffBn openDVS_pixel2x2_top_532/vpd[2]
+ openDVS_pixel2x2_top_532/vpd[3] openDVS_pixel2x2_top_532/vpd[1] openDVS_pixel2x2_top_532/vpd[0]
+ rowReadON<39> rowReadOFF<38> openDVS_pixel2x2_top_999/GndD DiffBn GndA OnBn VddA18
+ openDVS_pixel2x2_top
XopenDVS_pixel2x2_top_510 rowReadOFF<53> rowReadON<52> RefrBp PrBp PrSFBp col_periphery_1x2_15/COL_LINE0
+ pixRst<14> pixRst<15> col_periphery_1x2_15/COL_LINE1 OffBn openDVS_pixel2x2_top_510/vpd[2]
+ openDVS_pixel2x2_top_510/vpd[3] openDVS_pixel2x2_top_510/vpd[1] openDVS_pixel2x2_top_510/vpd[0]
+ rowReadON<53> rowReadOFF<52> openDVS_pixel2x2_top_99/GndD DiffBn GndA OnBn VddA18
+ openDVS_pixel2x2_top
XopenDVS_pixel2x2_top_395 rowReadOFF<33> rowReadON<32> RefrBp PrBp PrSFBp col_periphery_1x2_0/COL_LINE0
+ pixRst<10> pixRst<11> col_periphery_1x2_0/COL_LINE1 OffBn openDVS_pixel2x2_top_395/vpd[2]
+ openDVS_pixel2x2_top_395/vpd[3] openDVS_pixel2x2_top_395/vpd[1] openDVS_pixel2x2_top_395/vpd[0]
+ rowReadON<33> rowReadOFF<32> openDVS_pixel2x2_top_993/GndD DiffBn GndA OnBn VddA18
+ openDVS_pixel2x2_top
XopenDVS_pixel2x2_top_373 rowReadOFF<53> rowReadON<52> RefrBp PrBp PrSFBp col_periphery_1x2_6/COL_LINE0
+ pixRst<8> pixRst<9> col_periphery_1x2_6/COL_LINE1 OffBn openDVS_pixel2x2_top_373/vpd[2]
+ openDVS_pixel2x2_top_373/vpd[3] openDVS_pixel2x2_top_373/vpd[1] openDVS_pixel2x2_top_373/vpd[0]
+ rowReadON<53> rowReadOFF<52> openDVS_pixel2x2_top_99/GndD DiffBn GndA OnBn VddA18
+ openDVS_pixel2x2_top
XopenDVS_pixel2x2_top_384 rowReadOFF<55> rowReadON<54> RefrBp PrBp PrSFBp col_periphery_1x2_6/COL_LINE0
+ pixRst<8> pixRst<9> col_periphery_1x2_6/COL_LINE1 OffBn openDVS_pixel2x2_top_384/vpd[2]
+ openDVS_pixel2x2_top_384/vpd[3] openDVS_pixel2x2_top_384/vpd[1] openDVS_pixel2x2_top_384/vpd[0]
+ rowReadON<55> rowReadOFF<54> openDVS_pixel2x2_top_67/GndD DiffBn GndA OnBn VddA18
+ openDVS_pixel2x2_top
XopenDVS_pixel2x2_top_340 rowReadOFF<47> rowReadON<46> RefrBp PrBp PrSFBp col_periphery_1x2_5/COL_LINE0
+ pixRst<6> pixRst<7> col_periphery_1x2_5/COL_LINE1 OffBn openDVS_pixel2x2_top_340/vpd[2]
+ openDVS_pixel2x2_top_340/vpd[3] openDVS_pixel2x2_top_340/vpd[1] openDVS_pixel2x2_top_340/vpd[0]
+ rowReadON<47> rowReadOFF<46> openDVS_pixel2x2_top_78/GndD DiffBn GndA OnBn VddA18
+ openDVS_pixel2x2_top
XopenDVS_pixel2x2_top_362 rowReadOFF<51> rowReadON<50> RefrBp PrBp PrSFBp col_periphery_1x2_6/COL_LINE0
+ pixRst<8> pixRst<9> col_periphery_1x2_6/COL_LINE1 OffBn openDVS_pixel2x2_top_362/vpd[2]
+ openDVS_pixel2x2_top_362/vpd[3] openDVS_pixel2x2_top_362/vpd[1] openDVS_pixel2x2_top_362/vpd[0]
+ rowReadON<51> rowReadOFF<50> openDVS_pixel2x2_top_6/GndD DiffBn GndA OnBn VddA18
+ openDVS_pixel2x2_top
XopenDVS_pixel2x2_top_351 rowReadOFF<49> rowReadON<48> RefrBp PrBp PrSFBp col_periphery_1x2_6/COL_LINE0
+ pixRst<8> pixRst<9> col_periphery_1x2_6/COL_LINE1 OffBn openDVS_pixel2x2_top_351/vpd[2]
+ openDVS_pixel2x2_top_351/vpd[3] openDVS_pixel2x2_top_351/vpd[1] openDVS_pixel2x2_top_351/vpd[0]
+ rowReadON<49> rowReadOFF<48> openDVS_pixel2x2_top_3/GndD DiffBn GndA OnBn VddA18
+ openDVS_pixel2x2_top
XopenDVS_pixel2x2_top_170 rowReadOFF<37> rowReadON<36> RefrBp PrBp PrSFBp col_periphery_1x2_27/COL_LINE0
+ pixRst<56> pixRst<57> col_periphery_1x2_27/COL_LINE1 OffBn openDVS_pixel2x2_top_170/vpd[2]
+ openDVS_pixel2x2_top_170/vpd[3] openDVS_pixel2x2_top_170/vpd[1] openDVS_pixel2x2_top_170/vpd[0]
+ rowReadON<37> rowReadOFF<36> openDVS_pixel2x2_top_997/GndD DiffBn GndA OnBn VddA18
+ openDVS_pixel2x2_top
XopenDVS_pixel2x2_top_181 rowReadOFF<39> rowReadON<38> RefrBp PrBp PrSFBp col_periphery_1x2_25/COL_LINE0
+ pixRst<52> pixRst<53> col_periphery_1x2_25/COL_LINE1 OffBn openDVS_pixel2x2_top_181/vpd[2]
+ openDVS_pixel2x2_top_181/vpd[3] openDVS_pixel2x2_top_181/vpd[1] openDVS_pixel2x2_top_181/vpd[0]
+ rowReadON<39> rowReadOFF<38> openDVS_pixel2x2_top_999/GndD DiffBn GndA OnBn VddA18
+ openDVS_pixel2x2_top
XopenDVS_pixel2x2_top_192 rowReadOFF<41> rowReadON<40> RefrBp PrBp PrSFBp col_periphery_1x2_25/COL_LINE0
+ pixRst<52> pixRst<53> col_periphery_1x2_25/COL_LINE1 OffBn openDVS_pixel2x2_top_192/vpd[2]
+ openDVS_pixel2x2_top_192/vpd[3] openDVS_pixel2x2_top_192/vpd[1] openDVS_pixel2x2_top_192/vpd[0]
+ rowReadON<41> rowReadOFF<40> openDVS_pixel2x2_top_535/GndD DiffBn GndA OnBn VddA18
+ openDVS_pixel2x2_top
Xcol_periphery_1x2_1 pixRst<13> col_periphery_1x2_1/COL_LINE0 col_periphery_1x2_1/COL_LINE1
+ nDETECT DETECT col_periphery_1x2_9/VDD VTHRESH pixRst<12> voutn<12> GndA voutn<13>
+ NCHARGE col_periphery_1x2
XopenDVS_pixel2x2_top_98 rowReadOFF<53> rowReadON<52> RefrBp PrBp PrSFBp col_periphery_1x2_17/COL_LINE0
+ pixRst<34> pixRst<35> col_periphery_1x2_17/COL_LINE1 OffBn openDVS_pixel2x2_top_98/vpd[2]
+ openDVS_pixel2x2_top_98/vpd[3] openDVS_pixel2x2_top_98/vpd[1] openDVS_pixel2x2_top_98/vpd[0]
+ rowReadON<53> rowReadOFF<52> openDVS_pixel2x2_top_99/GndD DiffBn GndA OnBn VddA18
+ openDVS_pixel2x2_top
XopenDVS_pixel2x2_top_87 rowReadOFF<57> rowReadON<56> RefrBp PrBp PrSFBp col_periphery_1x2_19/COL_LINE0
+ pixRst<38> pixRst<39> col_periphery_1x2_19/COL_LINE1 OffBn openDVS_pixel2x2_top_87/vpd[2]
+ openDVS_pixel2x2_top_87/vpd[3] openDVS_pixel2x2_top_87/vpd[1] openDVS_pixel2x2_top_87/vpd[0]
+ rowReadON<57> rowReadOFF<56> openDVS_pixel2x2_top_9/GndD DiffBn GndA OnBn VddA18
+ openDVS_pixel2x2_top
XopenDVS_pixel2x2_top_65 rowReadOFF<63> rowReadON<62> RefrBp PrBp PrSFBp col_periphery_1x2_20/COL_LINE0
+ pixRst<40> pixRst<41> col_periphery_1x2_20/COL_LINE1 OffBn openDVS_pixel2x2_top_65/vpd[2]
+ openDVS_pixel2x2_top_65/vpd[3] openDVS_pixel2x2_top_65/vpd[1] openDVS_pixel2x2_top_65/vpd[0]
+ rowReadON<63> rowReadOFF<62> openDVS_pixel2x2_top_82/GndD DiffBn GndA OnBn VddA18
+ openDVS_pixel2x2_top
XopenDVS_pixel2x2_top_54 rowReadOFF<55> rowReadON<54> RefrBp PrBp PrSFBp col_periphery_1x2_25/COL_LINE0
+ pixRst<52> pixRst<53> col_periphery_1x2_25/COL_LINE1 OffBn openDVS_pixel2x2_top_54/vpd[2]
+ openDVS_pixel2x2_top_54/vpd[3] openDVS_pixel2x2_top_54/vpd[1] openDVS_pixel2x2_top_54/vpd[0]
+ rowReadON<55> rowReadOFF<54> openDVS_pixel2x2_top_67/GndD DiffBn GndA OnBn VddA18
+ openDVS_pixel2x2_top
XopenDVS_pixel2x2_top_32 rowReadOFF<63> rowReadON<62> RefrBp PrBp PrSFBp col_periphery_1x2_28/COL_LINE0
+ pixRst<58> pixRst<59> col_periphery_1x2_28/COL_LINE1 OffBn openDVS_pixel2x2_top_32/vpd[2]
+ openDVS_pixel2x2_top_32/vpd[3] openDVS_pixel2x2_top_32/vpd[1] openDVS_pixel2x2_top_32/vpd[0]
+ rowReadON<63> rowReadOFF<62> openDVS_pixel2x2_top_82/GndD DiffBn GndA OnBn VddA18
+ openDVS_pixel2x2_top
XopenDVS_pixel2x2_top_21 rowReadOFF<53> rowReadON<52> RefrBp PrBp PrSFBp col_periphery_1x2_28/COL_LINE0
+ pixRst<58> pixRst<59> col_periphery_1x2_28/COL_LINE1 OffBn openDVS_pixel2x2_top_21/vpd[2]
+ openDVS_pixel2x2_top_21/vpd[3] openDVS_pixel2x2_top_21/vpd[1] openDVS_pixel2x2_top_21/vpd[0]
+ rowReadON<53> rowReadOFF<52> openDVS_pixel2x2_top_99/GndD DiffBn GndA OnBn VddA18
+ openDVS_pixel2x2_top
XopenDVS_pixel2x2_top_10 rowReadOFF<57> rowReadON<56> RefrBp PrBp PrSFBp col_periphery_1x2_28/COL_LINE0
+ pixRst<58> pixRst<59> col_periphery_1x2_28/COL_LINE1 OffBn openDVS_pixel2x2_top_10/vpd[2]
+ openDVS_pixel2x2_top_10/vpd[3] openDVS_pixel2x2_top_10/vpd[1] openDVS_pixel2x2_top_10/vpd[0]
+ rowReadON<57> rowReadOFF<56> openDVS_pixel2x2_top_9/GndD DiffBn GndA OnBn VddA18
+ openDVS_pixel2x2_top
XopenDVS_pixel2x2_top_43 rowReadOFF<61> rowReadON<60> RefrBp PrBp PrSFBp col_periphery_1x2_29/COL_LINE0
+ pixRst<60> pixRst<61> col_periphery_1x2_29/COL_LINE1 OffBn openDVS_pixel2x2_top_43/vpd[2]
+ openDVS_pixel2x2_top_43/vpd[3] openDVS_pixel2x2_top_43/vpd[1] openDVS_pixel2x2_top_43/vpd[0]
+ rowReadON<61> rowReadOFF<60> openDVS_pixel2x2_top_96/GndD DiffBn GndA OnBn VddA18
+ openDVS_pixel2x2_top
XopenDVS_pixel2x2_top_76 rowReadOFF<47> rowReadON<46> RefrBp PrBp PrSFBp col_periphery_1x2_20/COL_LINE0
+ pixRst<40> pixRst<41> col_periphery_1x2_20/COL_LINE1 OffBn openDVS_pixel2x2_top_76/vpd[2]
+ openDVS_pixel2x2_top_76/vpd[3] openDVS_pixel2x2_top_76/vpd[1] openDVS_pixel2x2_top_76/vpd[0]
+ rowReadON<47> rowReadOFF<46> openDVS_pixel2x2_top_78/GndD DiffBn GndA OnBn VddA18
+ openDVS_pixel2x2_top
XopenDVS_pixel2x2_top_906 rowReadOFF<9> rowReadON<8> RefrBp PrBp PrSFBp col_periphery_1x2_22/COL_LINE0
+ pixRst<44> pixRst<45> col_periphery_1x2_22/COL_LINE1 OffBn openDVS_pixel2x2_top_906/vpd[2]
+ openDVS_pixel2x2_top_906/vpd[3] openDVS_pixel2x2_top_906/vpd[1] openDVS_pixel2x2_top_906/vpd[0]
+ rowReadON<9> rowReadOFF<8> openDVS_pixel2x2_top_939/GndD DiffBn GndA OnBn VddA18
+ openDVS_pixel2x2_top
XopenDVS_pixel2x2_top_939 rowReadOFF<9> rowReadON<8> RefrBp PrBp PrSFBp col_periphery_1x2_16/COL_LINE0
+ pixRst<32> pixRst<33> col_periphery_1x2_16/COL_LINE1 OffBn openDVS_pixel2x2_top_939/vpd[2]
+ openDVS_pixel2x2_top_939/vpd[3] openDVS_pixel2x2_top_939/vpd[1] openDVS_pixel2x2_top_939/vpd[0]
+ rowReadON<9> rowReadOFF<8> openDVS_pixel2x2_top_939/GndD DiffBn GndA OnBn VddA18
+ openDVS_pixel2x2_top
XopenDVS_pixel2x2_top_917 rowReadOFF<11> rowReadON<10> RefrBp PrBp PrSFBp col_periphery_1x2_31/COL_LINE0
+ pixRst<48> pixRst<49> col_periphery_1x2_31/COL_LINE1 OffBn openDVS_pixel2x2_top_917/vpd[2]
+ openDVS_pixel2x2_top_917/vpd[3] openDVS_pixel2x2_top_917/vpd[1] openDVS_pixel2x2_top_917/vpd[0]
+ rowReadON<11> rowReadOFF<10> openDVS_pixel2x2_top_941/GndD DiffBn GndA OnBn VddA18
+ openDVS_pixel2x2_top
XopenDVS_pixel2x2_top_928 rowReadOFF<21> rowReadON<20> RefrBp PrBp PrSFBp col_periphery_1x2_23/COL_LINE0
+ pixRst<46> pixRst<47> col_periphery_1x2_23/COL_LINE1 OffBn openDVS_pixel2x2_top_928/vpd[2]
+ openDVS_pixel2x2_top_928/vpd[3] openDVS_pixel2x2_top_928/vpd[1] openDVS_pixel2x2_top_928/vpd[0]
+ rowReadON<21> rowReadOFF<20> openDVS_pixel2x2_top_951/GndD DiffBn GndA OnBn VddA18
+ openDVS_pixel2x2_top
XopenDVS_pixel2x2_top_714 rowReadOFF<9> rowReadON<8> RefrBp PrBp PrSFBp col_periphery_1x2_11/COL_LINE0
+ pixRst<24> pixRst<25> col_periphery_1x2_11/COL_LINE1 OffBn openDVS_pixel2x2_top_714/vpd[2]
+ openDVS_pixel2x2_top_714/vpd[3] openDVS_pixel2x2_top_714/vpd[1] openDVS_pixel2x2_top_714/vpd[0]
+ rowReadON<9> rowReadOFF<8> openDVS_pixel2x2_top_939/GndD DiffBn GndA OnBn VddA18
+ openDVS_pixel2x2_top
XopenDVS_pixel2x2_top_725 rowReadOFF<1> rowReadON<0> RefrBp PrBp PrSFBp col_periphery_1x2_15/COL_LINE0
+ pixRst<14> pixRst<15> col_periphery_1x2_15/COL_LINE1 OffBn openDVS_pixel2x2_top_725/vpd[2]
+ openDVS_pixel2x2_top_725/vpd[3] openDVS_pixel2x2_top_725/vpd[1] openDVS_pixel2x2_top_725/vpd[0]
+ rowReadON<1> rowReadOFF<0> openDVS_pixel2x2_top_931/GndD DiffBn GndA OnBn VddA18
+ openDVS_pixel2x2_top
XopenDVS_pixel2x2_top_703 rowReadOFF<9> rowReadON<8> RefrBp PrBp PrSFBp col_periphery_1x2_3/COL_LINE0
+ pixRst<2> pixRst<3> col_periphery_1x2_3/COL_LINE1 OffBn openDVS_pixel2x2_top_703/vpd[2]
+ openDVS_pixel2x2_top_703/vpd[3] openDVS_pixel2x2_top_703/vpd[1] openDVS_pixel2x2_top_703/vpd[0]
+ rowReadON<9> rowReadOFF<8> openDVS_pixel2x2_top_939/GndD DiffBn GndA OnBn VddA18
+ openDVS_pixel2x2_top
XopenDVS_pixel2x2_top_736 rowReadOFF<17> rowReadON<16> RefrBp PrBp PrSFBp col_periphery_1x2_25/COL_LINE0
+ pixRst<52> pixRst<53> col_periphery_1x2_25/COL_LINE1 OffBn openDVS_pixel2x2_top_736/vpd[2]
+ openDVS_pixel2x2_top_736/vpd[3] openDVS_pixel2x2_top_736/vpd[1] openDVS_pixel2x2_top_736/vpd[0]
+ rowReadON<17> rowReadOFF<16> openDVS_pixel2x2_top_947/GndD DiffBn GndA OnBn VddA18
+ openDVS_pixel2x2_top
XopenDVS_pixel2x2_top_747 rowReadOFF<23> rowReadON<22> RefrBp PrBp PrSFBp col_periphery_1x2_30/COL_LINE0
+ pixRst<62> pixRst<63> col_periphery_1x2_30/COL_LINE1 OffBn openDVS_pixel2x2_top_747/vpd[2]
+ openDVS_pixel2x2_top_747/vpd[3] openDVS_pixel2x2_top_747/vpd[1] openDVS_pixel2x2_top_747/vpd[0]
+ rowReadON<23> rowReadOFF<22> openDVS_pixel2x2_top_953/GndD DiffBn GndA OnBn VddA18
+ openDVS_pixel2x2_top
XopenDVS_pixel2x2_top_758 rowReadOFF<21> rowReadON<20> RefrBp PrBp PrSFBp col_periphery_1x2_29/COL_LINE0
+ pixRst<60> pixRst<61> col_periphery_1x2_29/COL_LINE1 OffBn openDVS_pixel2x2_top_758/vpd[2]
+ openDVS_pixel2x2_top_758/vpd[3] openDVS_pixel2x2_top_758/vpd[1] openDVS_pixel2x2_top_758/vpd[0]
+ rowReadON<21> rowReadOFF<20> openDVS_pixel2x2_top_951/GndD DiffBn GndA OnBn VddA18
+ openDVS_pixel2x2_top
XopenDVS_pixel2x2_top_769 rowReadOFF<23> rowReadON<22> RefrBp PrBp PrSFBp col_periphery_1x2_26/COL_LINE0
+ pixRst<54> pixRst<55> col_periphery_1x2_26/COL_LINE1 OffBn openDVS_pixel2x2_top_769/vpd[2]
+ openDVS_pixel2x2_top_769/vpd[3] openDVS_pixel2x2_top_769/vpd[1] openDVS_pixel2x2_top_769/vpd[0]
+ rowReadON<23> rowReadOFF<22> openDVS_pixel2x2_top_953/GndD DiffBn GndA OnBn VddA18
+ openDVS_pixel2x2_top
XopenDVS_pixel2x2_top_544 rowReadOFF<15> rowReadON<14> RefrBp PrBp PrSFBp col_periphery_1x2_12/COL_LINE0
+ pixRst<26> pixRst<27> col_periphery_1x2_12/COL_LINE1 OffBn openDVS_pixel2x2_top_544/vpd[2]
+ openDVS_pixel2x2_top_544/vpd[3] openDVS_pixel2x2_top_544/vpd[1] openDVS_pixel2x2_top_544/vpd[0]
+ rowReadON<15> rowReadOFF<14> openDVS_pixel2x2_top_945/GndD DiffBn GndA OnBn VddA18
+ openDVS_pixel2x2_top
XopenDVS_pixel2x2_top_555 rowReadOFF<11> rowReadON<10> RefrBp PrBp PrSFBp col_periphery_1x2_11/COL_LINE0
+ pixRst<24> pixRst<25> col_periphery_1x2_11/COL_LINE1 OffBn openDVS_pixel2x2_top_555/vpd[2]
+ openDVS_pixel2x2_top_555/vpd[3] openDVS_pixel2x2_top_555/vpd[1] openDVS_pixel2x2_top_555/vpd[0]
+ rowReadON<11> rowReadOFF<10> openDVS_pixel2x2_top_941/GndD DiffBn GndA OnBn VddA18
+ openDVS_pixel2x2_top
XopenDVS_pixel2x2_top_566 rowReadOFF<17> rowReadON<16> RefrBp PrBp PrSFBp col_periphery_1x2_10/COL_LINE0
+ pixRst<22> pixRst<23> col_periphery_1x2_10/COL_LINE1 OffBn openDVS_pixel2x2_top_566/vpd[2]
+ openDVS_pixel2x2_top_566/vpd[3] openDVS_pixel2x2_top_566/vpd[1] openDVS_pixel2x2_top_566/vpd[0]
+ rowReadON<17> rowReadOFF<16> openDVS_pixel2x2_top_947/GndD DiffBn GndA OnBn VddA18
+ openDVS_pixel2x2_top
XopenDVS_pixel2x2_top_599 rowReadOFF<17> rowReadON<16> RefrBp PrBp PrSFBp col_periphery_1x2_3/COL_LINE0
+ pixRst<2> pixRst<3> col_periphery_1x2_3/COL_LINE1 OffBn openDVS_pixel2x2_top_599/vpd[2]
+ openDVS_pixel2x2_top_599/vpd[3] openDVS_pixel2x2_top_599/vpd[1] openDVS_pixel2x2_top_599/vpd[0]
+ rowReadON<17> rowReadOFF<16> openDVS_pixel2x2_top_947/GndD DiffBn GndA OnBn VddA18
+ openDVS_pixel2x2_top
XopenDVS_pixel2x2_top_577 rowReadOFF<21> rowReadON<20> RefrBp PrBp PrSFBp col_periphery_1x2_9/COL_LINE0
+ pixRst<20> pixRst<21> col_periphery_1x2_9/COL_LINE1 OffBn openDVS_pixel2x2_top_577/vpd[2]
+ openDVS_pixel2x2_top_577/vpd[3] openDVS_pixel2x2_top_577/vpd[1] openDVS_pixel2x2_top_577/vpd[0]
+ rowReadON<21> rowReadOFF<20> openDVS_pixel2x2_top_951/GndD DiffBn GndA OnBn VddA18
+ openDVS_pixel2x2_top
XopenDVS_pixel2x2_top_522 rowReadOFF<31> rowReadON<30> RefrBp PrBp PrSFBp col_periphery_1x2_15/COL_LINE0
+ pixRst<14> pixRst<15> col_periphery_1x2_15/COL_LINE1 OffBn openDVS_pixel2x2_top_522/vpd[2]
+ openDVS_pixel2x2_top_522/vpd[3] openDVS_pixel2x2_top_522/vpd[1] openDVS_pixel2x2_top_522/vpd[0]
+ rowReadON<31> rowReadOFF<30> openDVS_pixel2x2_top_991/GndD DiffBn GndA OnBn VddA18
+ openDVS_pixel2x2_top
XopenDVS_pixel2x2_top_588 rowReadOFF<23> rowReadON<22> RefrBp PrBp PrSFBp col_periphery_1x2_3/COL_LINE0
+ pixRst<2> pixRst<3> col_periphery_1x2_3/COL_LINE1 OffBn openDVS_pixel2x2_top_588/vpd[2]
+ openDVS_pixel2x2_top_588/vpd[3] openDVS_pixel2x2_top_588/vpd[1] openDVS_pixel2x2_top_588/vpd[0]
+ rowReadON<23> rowReadOFF<22> openDVS_pixel2x2_top_953/GndD DiffBn GndA OnBn VddA18
+ openDVS_pixel2x2_top
XopenDVS_pixel2x2_top_511 rowReadOFF<53> rowReadON<52> RefrBp PrBp PrSFBp col_periphery_1x2_7/COL_LINE0
+ pixRst<16> pixRst<17> col_periphery_1x2_7/COL_LINE1 OffBn openDVS_pixel2x2_top_511/vpd[2]
+ openDVS_pixel2x2_top_511/vpd[3] openDVS_pixel2x2_top_511/vpd[1] openDVS_pixel2x2_top_511/vpd[0]
+ rowReadON<53> rowReadOFF<52> openDVS_pixel2x2_top_99/GndD DiffBn GndA OnBn VddA18
+ openDVS_pixel2x2_top
XopenDVS_pixel2x2_top_533 rowReadOFF<61> rowReadON<60> RefrBp PrBp PrSFBp col_periphery_1x2_7/COL_LINE0
+ pixRst<16> pixRst<17> col_periphery_1x2_7/COL_LINE1 OffBn openDVS_pixel2x2_top_533/vpd[2]
+ openDVS_pixel2x2_top_533/vpd[3] openDVS_pixel2x2_top_533/vpd[1] openDVS_pixel2x2_top_533/vpd[0]
+ rowReadON<61> rowReadOFF<60> openDVS_pixel2x2_top_96/GndD DiffBn GndA OnBn VddA18
+ openDVS_pixel2x2_top
XopenDVS_pixel2x2_top_500 rowReadOFF<45> rowReadON<44> RefrBp PrBp PrSFBp col_periphery_1x2_10/COL_LINE0
+ pixRst<22> pixRst<23> col_periphery_1x2_10/COL_LINE1 OffBn openDVS_pixel2x2_top_500/vpd[2]
+ openDVS_pixel2x2_top_500/vpd[3] openDVS_pixel2x2_top_500/vpd[1] openDVS_pixel2x2_top_500/vpd[0]
+ rowReadON<45> rowReadOFF<44> openDVS_pixel2x2_top_539/GndD DiffBn GndA OnBn VddA18
+ openDVS_pixel2x2_top
XopenDVS_pixel2x2_top_396 rowReadOFF<33> rowReadON<32> RefrBp PrBp PrSFBp col_periphery_1x2_1/COL_LINE0
+ pixRst<12> pixRst<13> col_periphery_1x2_1/COL_LINE1 OffBn openDVS_pixel2x2_top_396/vpd[2]
+ openDVS_pixel2x2_top_396/vpd[3] openDVS_pixel2x2_top_396/vpd[1] openDVS_pixel2x2_top_396/vpd[0]
+ rowReadON<33> rowReadOFF<32> openDVS_pixel2x2_top_993/GndD DiffBn GndA OnBn VddA18
+ openDVS_pixel2x2_top
XopenDVS_pixel2x2_top_374 rowReadOFF<53> rowReadON<52> RefrBp PrBp PrSFBp col_periphery_1x2_0/COL_LINE0
+ pixRst<10> pixRst<11> col_periphery_1x2_0/COL_LINE1 OffBn openDVS_pixel2x2_top_374/vpd[2]
+ openDVS_pixel2x2_top_374/vpd[3] openDVS_pixel2x2_top_374/vpd[1] openDVS_pixel2x2_top_374/vpd[0]
+ rowReadON<53> rowReadOFF<52> openDVS_pixel2x2_top_99/GndD DiffBn GndA OnBn VddA18
+ openDVS_pixel2x2_top
XopenDVS_pixel2x2_top_385 rowReadOFF<55> rowReadON<54> RefrBp PrBp PrSFBp col_periphery_1x2_0/COL_LINE0
+ pixRst<10> pixRst<11> col_periphery_1x2_0/COL_LINE1 OffBn openDVS_pixel2x2_top_385/vpd[2]
+ openDVS_pixel2x2_top_385/vpd[3] openDVS_pixel2x2_top_385/vpd[1] openDVS_pixel2x2_top_385/vpd[0]
+ rowReadON<55> rowReadOFF<54> openDVS_pixel2x2_top_67/GndD DiffBn GndA OnBn VddA18
+ openDVS_pixel2x2_top
XopenDVS_pixel2x2_top_330 rowReadOFF<57> rowReadON<56> RefrBp PrBp PrSFBp col_periphery_1x2_4/COL_LINE0
+ pixRst<4> pixRst<5> col_periphery_1x2_4/COL_LINE1 OffBn openDVS_pixel2x2_top_330/vpd[2]
+ openDVS_pixel2x2_top_330/vpd[3] openDVS_pixel2x2_top_330/vpd[1] openDVS_pixel2x2_top_330/vpd[0]
+ rowReadON<57> rowReadOFF<56> openDVS_pixel2x2_top_9/GndD DiffBn GndA OnBn VddA18
+ openDVS_pixel2x2_top
XopenDVS_pixel2x2_top_341 rowReadOFF<47> rowReadON<46> RefrBp PrBp PrSFBp col_periphery_1x2_6/COL_LINE0
+ pixRst<8> pixRst<9> col_periphery_1x2_6/COL_LINE1 OffBn openDVS_pixel2x2_top_341/vpd[2]
+ openDVS_pixel2x2_top_341/vpd[3] openDVS_pixel2x2_top_341/vpd[1] openDVS_pixel2x2_top_341/vpd[0]
+ rowReadON<47> rowReadOFF<46> openDVS_pixel2x2_top_78/GndD DiffBn GndA OnBn VddA18
+ openDVS_pixel2x2_top
XopenDVS_pixel2x2_top_363 rowReadOFF<51> rowReadON<50> RefrBp PrBp PrSFBp col_periphery_1x2_0/COL_LINE0
+ pixRst<10> pixRst<11> col_periphery_1x2_0/COL_LINE1 OffBn openDVS_pixel2x2_top_363/vpd[2]
+ openDVS_pixel2x2_top_363/vpd[3] openDVS_pixel2x2_top_363/vpd[1] openDVS_pixel2x2_top_363/vpd[0]
+ rowReadON<51> rowReadOFF<50> openDVS_pixel2x2_top_6/GndD DiffBn GndA OnBn VddA18
+ openDVS_pixel2x2_top
XopenDVS_pixel2x2_top_352 rowReadOFF<49> rowReadON<48> RefrBp PrBp PrSFBp col_periphery_1x2_0/COL_LINE0
+ pixRst<10> pixRst<11> col_periphery_1x2_0/COL_LINE1 OffBn openDVS_pixel2x2_top_352/vpd[2]
+ openDVS_pixel2x2_top_352/vpd[3] openDVS_pixel2x2_top_352/vpd[1] openDVS_pixel2x2_top_352/vpd[0]
+ rowReadON<49> rowReadOFF<48> openDVS_pixel2x2_top_3/GndD DiffBn GndA OnBn VddA18
+ openDVS_pixel2x2_top
XopenDVS_pixel2x2_top_171 rowReadOFF<37> rowReadON<36> RefrBp PrBp PrSFBp col_periphery_1x2_28/COL_LINE0
+ pixRst<58> pixRst<59> col_periphery_1x2_28/COL_LINE1 OffBn openDVS_pixel2x2_top_171/vpd[2]
+ openDVS_pixel2x2_top_171/vpd[3] openDVS_pixel2x2_top_171/vpd[1] openDVS_pixel2x2_top_171/vpd[0]
+ rowReadON<37> rowReadOFF<36> openDVS_pixel2x2_top_997/GndD DiffBn GndA OnBn VddA18
+ openDVS_pixel2x2_top
XopenDVS_pixel2x2_top_160 rowReadOFF<35> rowReadON<34> RefrBp PrBp PrSFBp col_periphery_1x2_20/COL_LINE0
+ pixRst<40> pixRst<41> col_periphery_1x2_20/COL_LINE1 OffBn openDVS_pixel2x2_top_160/vpd[2]
+ openDVS_pixel2x2_top_160/vpd[3] openDVS_pixel2x2_top_160/vpd[1] openDVS_pixel2x2_top_160/vpd[0]
+ rowReadON<35> rowReadOFF<34> openDVS_pixel2x2_top_995/GndD DiffBn GndA OnBn VddA18
+ openDVS_pixel2x2_top
XopenDVS_pixel2x2_top_182 rowReadOFF<39> rowReadON<38> RefrBp PrBp PrSFBp col_periphery_1x2_26/COL_LINE0
+ pixRst<54> pixRst<55> col_periphery_1x2_26/COL_LINE1 OffBn openDVS_pixel2x2_top_182/vpd[2]
+ openDVS_pixel2x2_top_182/vpd[3] openDVS_pixel2x2_top_182/vpd[1] openDVS_pixel2x2_top_182/vpd[0]
+ rowReadON<39> rowReadOFF<38> openDVS_pixel2x2_top_999/GndD DiffBn GndA OnBn VddA18
+ openDVS_pixel2x2_top
XopenDVS_pixel2x2_top_193 rowReadOFF<41> rowReadON<40> RefrBp PrBp PrSFBp col_periphery_1x2_26/COL_LINE0
+ pixRst<54> pixRst<55> col_periphery_1x2_26/COL_LINE1 OffBn openDVS_pixel2x2_top_193/vpd[2]
+ openDVS_pixel2x2_top_193/vpd[3] openDVS_pixel2x2_top_193/vpd[1] openDVS_pixel2x2_top_193/vpd[0]
+ rowReadON<41> rowReadOFF<40> openDVS_pixel2x2_top_535/GndD DiffBn GndA OnBn VddA18
+ openDVS_pixel2x2_top
Xcol_periphery_1x2_2 pixRst<1> col_periphery_1x2_2/COL_LINE0 col_periphery_1x2_2/COL_LINE1
+ nDETECT DETECT col_periphery_1x2_9/VDD VTHRESH pixRst<0> voutn<0> GndA voutn<1>
+ NCHARGE col_periphery_1x2
XopenDVS_pixel2x2_top_99 rowReadOFF<53> rowReadON<52> RefrBp PrBp PrSFBp col_periphery_1x2_18/COL_LINE0
+ pixRst<36> pixRst<37> col_periphery_1x2_18/COL_LINE1 OffBn openDVS_pixel2x2_top_99/vpd[2]
+ openDVS_pixel2x2_top_99/vpd[3] openDVS_pixel2x2_top_99/vpd[1] openDVS_pixel2x2_top_99/vpd[0]
+ rowReadON<53> rowReadOFF<52> openDVS_pixel2x2_top_99/GndD DiffBn GndA OnBn VddA18
+ openDVS_pixel2x2_top
XopenDVS_pixel2x2_top_88 rowReadOFF<57> rowReadON<56> RefrBp PrBp PrSFBp col_periphery_1x2_20/COL_LINE0
+ pixRst<40> pixRst<41> col_periphery_1x2_20/COL_LINE1 OffBn openDVS_pixel2x2_top_88/vpd[2]
+ openDVS_pixel2x2_top_88/vpd[3] openDVS_pixel2x2_top_88/vpd[1] openDVS_pixel2x2_top_88/vpd[0]
+ rowReadON<57> rowReadOFF<56> openDVS_pixel2x2_top_9/GndD DiffBn GndA OnBn VddA18
+ openDVS_pixel2x2_top
XopenDVS_pixel2x2_top_66 rowReadOFF<55> rowReadON<54> RefrBp PrBp PrSFBp col_periphery_1x2_21/COL_LINE0
+ pixRst<42> pixRst<43> col_periphery_1x2_21/COL_LINE1 OffBn openDVS_pixel2x2_top_66/vpd[2]
+ openDVS_pixel2x2_top_66/vpd[3] openDVS_pixel2x2_top_66/vpd[1] openDVS_pixel2x2_top_66/vpd[0]
+ rowReadON<55> rowReadOFF<54> openDVS_pixel2x2_top_67/GndD DiffBn GndA OnBn VddA18
+ openDVS_pixel2x2_top
XopenDVS_pixel2x2_top_33 rowReadOFF<61> rowReadON<60> RefrBp PrBp PrSFBp col_periphery_1x2_26/COL_LINE0
+ pixRst<54> pixRst<55> col_periphery_1x2_26/COL_LINE1 OffBn openDVS_pixel2x2_top_33/vpd[2]
+ openDVS_pixel2x2_top_33/vpd[3] openDVS_pixel2x2_top_33/vpd[1] openDVS_pixel2x2_top_33/vpd[0]
+ rowReadON<61> rowReadOFF<60> openDVS_pixel2x2_top_96/GndD DiffBn GndA OnBn VddA18
+ openDVS_pixel2x2_top
XopenDVS_pixel2x2_top_22 rowReadOFF<53> rowReadON<52> RefrBp PrBp PrSFBp col_periphery_1x2_29/COL_LINE0
+ pixRst<60> pixRst<61> col_periphery_1x2_29/COL_LINE1 OffBn openDVS_pixel2x2_top_22/vpd[2]
+ openDVS_pixel2x2_top_22/vpd[3] openDVS_pixel2x2_top_22/vpd[1] openDVS_pixel2x2_top_22/vpd[0]
+ rowReadON<53> rowReadOFF<52> openDVS_pixel2x2_top_99/GndD DiffBn GndA OnBn VddA18
+ openDVS_pixel2x2_top
XopenDVS_pixel2x2_top_11 rowReadOFF<57> rowReadON<56> RefrBp PrBp PrSFBp col_periphery_1x2_29/COL_LINE0
+ pixRst<60> pixRst<61> col_periphery_1x2_29/COL_LINE1 OffBn openDVS_pixel2x2_top_11/vpd[2]
+ openDVS_pixel2x2_top_11/vpd[3] openDVS_pixel2x2_top_11/vpd[1] openDVS_pixel2x2_top_11/vpd[0]
+ rowReadON<57> rowReadOFF<56> openDVS_pixel2x2_top_9/GndD DiffBn GndA OnBn VddA18
+ openDVS_pixel2x2_top
XopenDVS_pixel2x2_top_44 rowReadOFF<61> rowReadON<60> RefrBp PrBp PrSFBp col_periphery_1x2_30/COL_LINE0
+ pixRst<62> pixRst<63> col_periphery_1x2_30/COL_LINE1 OffBn openDVS_pixel2x2_top_44/vpd[2]
+ openDVS_pixel2x2_top_44/vpd[3] openDVS_pixel2x2_top_44/vpd[1] openDVS_pixel2x2_top_44/vpd[0]
+ rowReadON<61> rowReadOFF<60> openDVS_pixel2x2_top_96/GndD DiffBn GndA OnBn VddA18
+ openDVS_pixel2x2_top
XopenDVS_pixel2x2_top_77 rowReadOFF<47> rowReadON<46> RefrBp PrBp PrSFBp col_periphery_1x2_21/COL_LINE0
+ pixRst<42> pixRst<43> col_periphery_1x2_21/COL_LINE1 OffBn openDVS_pixel2x2_top_77/vpd[2]
+ openDVS_pixel2x2_top_77/vpd[3] openDVS_pixel2x2_top_77/vpd[1] openDVS_pixel2x2_top_77/vpd[0]
+ rowReadON<47> rowReadOFF<46> openDVS_pixel2x2_top_78/GndD DiffBn GndA OnBn VddA18
+ openDVS_pixel2x2_top
XopenDVS_pixel2x2_top_55 rowReadOFF<47> rowReadON<46> RefrBp PrBp PrSFBp col_periphery_1x2_24/COL_LINE0
+ pixRst<50> pixRst<51> col_periphery_1x2_24/COL_LINE1 OffBn openDVS_pixel2x2_top_55/vpd[2]
+ openDVS_pixel2x2_top_55/vpd[3] openDVS_pixel2x2_top_55/vpd[1] openDVS_pixel2x2_top_55/vpd[0]
+ rowReadON<47> rowReadOFF<46> openDVS_pixel2x2_top_78/GndD DiffBn GndA OnBn VddA18
+ openDVS_pixel2x2_top
XopenDVS_pixel2x2_top_907 rowReadOFF<9> rowReadON<8> RefrBp PrBp PrSFBp col_periphery_1x2_23/COL_LINE0
+ pixRst<46> pixRst<47> col_periphery_1x2_23/COL_LINE1 OffBn openDVS_pixel2x2_top_907/vpd[2]
+ openDVS_pixel2x2_top_907/vpd[3] openDVS_pixel2x2_top_907/vpd[1] openDVS_pixel2x2_top_907/vpd[0]
+ rowReadON<9> rowReadOFF<8> openDVS_pixel2x2_top_939/GndD DiffBn GndA OnBn VddA18
+ openDVS_pixel2x2_top
XopenDVS_pixel2x2_top_918 rowReadOFF<13> rowReadON<12> RefrBp PrBp PrSFBp col_periphery_1x2_23/COL_LINE0
+ pixRst<46> pixRst<47> col_periphery_1x2_23/COL_LINE1 OffBn openDVS_pixel2x2_top_918/vpd[2]
+ openDVS_pixel2x2_top_918/vpd[3] openDVS_pixel2x2_top_918/vpd[1] openDVS_pixel2x2_top_918/vpd[0]
+ rowReadON<13> rowReadOFF<12> openDVS_pixel2x2_top_943/GndD DiffBn GndA OnBn VddA18
+ openDVS_pixel2x2_top
XopenDVS_pixel2x2_top_929 rowReadOFF<21> rowReadON<20> RefrBp PrBp PrSFBp col_periphery_1x2_31/COL_LINE0
+ pixRst<48> pixRst<49> col_periphery_1x2_31/COL_LINE1 OffBn openDVS_pixel2x2_top_929/vpd[2]
+ openDVS_pixel2x2_top_929/vpd[3] openDVS_pixel2x2_top_929/vpd[1] openDVS_pixel2x2_top_929/vpd[0]
+ rowReadON<21> rowReadOFF<20> openDVS_pixel2x2_top_951/GndD DiffBn GndA OnBn VddA18
+ openDVS_pixel2x2_top
XopenDVS_pixel2x2_top_715 rowReadOFF<9> rowReadON<8> RefrBp PrBp PrSFBp col_periphery_1x2_12/COL_LINE0
+ pixRst<26> pixRst<27> col_periphery_1x2_12/COL_LINE1 OffBn openDVS_pixel2x2_top_715/vpd[2]
+ openDVS_pixel2x2_top_715/vpd[3] openDVS_pixel2x2_top_715/vpd[1] openDVS_pixel2x2_top_715/vpd[0]
+ rowReadON<9> rowReadOFF<8> openDVS_pixel2x2_top_939/GndD DiffBn GndA OnBn VddA18
+ openDVS_pixel2x2_top
XopenDVS_pixel2x2_top_726 rowReadOFF<1> rowReadON<0> RefrBp PrBp PrSFBp col_periphery_1x2_7/COL_LINE0
+ pixRst<16> pixRst<17> col_periphery_1x2_7/COL_LINE1 OffBn openDVS_pixel2x2_top_726/vpd[2]
+ openDVS_pixel2x2_top_726/vpd[3] openDVS_pixel2x2_top_726/vpd[1] openDVS_pixel2x2_top_726/vpd[0]
+ rowReadON<1> rowReadOFF<0> openDVS_pixel2x2_top_931/GndD DiffBn GndA OnBn VddA18
+ openDVS_pixel2x2_top
XopenDVS_pixel2x2_top_704 rowReadOFF<9> rowReadON<8> RefrBp PrBp PrSFBp col_periphery_1x2_4/COL_LINE0
+ pixRst<4> pixRst<5> col_periphery_1x2_4/COL_LINE1 OffBn openDVS_pixel2x2_top_704/vpd[2]
+ openDVS_pixel2x2_top_704/vpd[3] openDVS_pixel2x2_top_704/vpd[1] openDVS_pixel2x2_top_704/vpd[0]
+ rowReadON<9> rowReadOFF<8> openDVS_pixel2x2_top_939/GndD DiffBn GndA OnBn VddA18
+ openDVS_pixel2x2_top
XopenDVS_pixel2x2_top_737 rowReadOFF<17> rowReadON<16> RefrBp PrBp PrSFBp col_periphery_1x2_26/COL_LINE0
+ pixRst<54> pixRst<55> col_periphery_1x2_26/COL_LINE1 OffBn openDVS_pixel2x2_top_737/vpd[2]
+ openDVS_pixel2x2_top_737/vpd[3] openDVS_pixel2x2_top_737/vpd[1] openDVS_pixel2x2_top_737/vpd[0]
+ rowReadON<17> rowReadOFF<16> openDVS_pixel2x2_top_947/GndD DiffBn GndA OnBn VddA18
+ openDVS_pixel2x2_top
XopenDVS_pixel2x2_top_759 rowReadOFF<21> rowReadON<20> RefrBp PrBp PrSFBp col_periphery_1x2_30/COL_LINE0
+ pixRst<62> pixRst<63> col_periphery_1x2_30/COL_LINE1 OffBn openDVS_pixel2x2_top_759/vpd[2]
+ openDVS_pixel2x2_top_759/vpd[3] openDVS_pixel2x2_top_759/vpd[1] openDVS_pixel2x2_top_759/vpd[0]
+ rowReadON<21> rowReadOFF<20> openDVS_pixel2x2_top_951/GndD DiffBn GndA OnBn VddA18
+ openDVS_pixel2x2_top
XopenDVS_pixel2x2_top_748 rowReadOFF<25> rowReadON<24> RefrBp PrBp PrSFBp col_periphery_1x2_29/COL_LINE0
+ pixRst<60> pixRst<61> col_periphery_1x2_29/COL_LINE1 OffBn openDVS_pixel2x2_top_748/vpd[2]
+ openDVS_pixel2x2_top_748/vpd[3] openDVS_pixel2x2_top_748/vpd[1] openDVS_pixel2x2_top_748/vpd[0]
+ rowReadON<25> rowReadOFF<24> openDVS_pixel2x2_top_955/GndD DiffBn GndA OnBn VddA18
+ openDVS_pixel2x2_top
XopenDVS_pixel2x2_top_545 rowReadOFF<15> rowReadON<14> RefrBp PrBp PrSFBp col_periphery_1x2_13/COL_LINE0
+ pixRst<28> pixRst<29> col_periphery_1x2_13/COL_LINE1 OffBn openDVS_pixel2x2_top_545/vpd[2]
+ openDVS_pixel2x2_top_545/vpd[3] openDVS_pixel2x2_top_545/vpd[1] openDVS_pixel2x2_top_545/vpd[0]
+ rowReadON<15> rowReadOFF<14> openDVS_pixel2x2_top_945/GndD DiffBn GndA OnBn VddA18
+ openDVS_pixel2x2_top
XopenDVS_pixel2x2_top_556 rowReadOFF<11> rowReadON<10> RefrBp PrBp PrSFBp col_periphery_1x2_12/COL_LINE0
+ pixRst<26> pixRst<27> col_periphery_1x2_12/COL_LINE1 OffBn openDVS_pixel2x2_top_556/vpd[2]
+ openDVS_pixel2x2_top_556/vpd[3] openDVS_pixel2x2_top_556/vpd[1] openDVS_pixel2x2_top_556/vpd[0]
+ rowReadON<11> rowReadOFF<10> openDVS_pixel2x2_top_941/GndD DiffBn GndA OnBn VddA18
+ openDVS_pixel2x2_top
XopenDVS_pixel2x2_top_567 rowReadOFF<17> rowReadON<16> RefrBp PrBp PrSFBp col_periphery_1x2_11/COL_LINE0
+ pixRst<24> pixRst<25> col_periphery_1x2_11/COL_LINE1 OffBn openDVS_pixel2x2_top_567/vpd[2]
+ openDVS_pixel2x2_top_567/vpd[3] openDVS_pixel2x2_top_567/vpd[1] openDVS_pixel2x2_top_567/vpd[0]
+ rowReadON<17> rowReadOFF<16> openDVS_pixel2x2_top_947/GndD DiffBn GndA OnBn VddA18
+ openDVS_pixel2x2_top
XopenDVS_pixel2x2_top_578 rowReadOFF<25> rowReadON<24> RefrBp PrBp PrSFBp col_periphery_1x2_12/COL_LINE0
+ pixRst<26> pixRst<27> col_periphery_1x2_12/COL_LINE1 OffBn openDVS_pixel2x2_top_578/vpd[2]
+ openDVS_pixel2x2_top_578/vpd[3] openDVS_pixel2x2_top_578/vpd[1] openDVS_pixel2x2_top_578/vpd[0]
+ rowReadON<25> rowReadOFF<24> openDVS_pixel2x2_top_955/GndD DiffBn GndA OnBn VddA18
+ openDVS_pixel2x2_top
XopenDVS_pixel2x2_top_523 rowReadOFF<31> rowReadON<30> RefrBp PrBp PrSFBp col_periphery_1x2_7/COL_LINE0
+ pixRst<16> pixRst<17> col_periphery_1x2_7/COL_LINE1 OffBn openDVS_pixel2x2_top_523/vpd[2]
+ openDVS_pixel2x2_top_523/vpd[3] openDVS_pixel2x2_top_523/vpd[1] openDVS_pixel2x2_top_523/vpd[0]
+ rowReadON<31> rowReadOFF<30> openDVS_pixel2x2_top_991/GndD DiffBn GndA OnBn VddA18
+ openDVS_pixel2x2_top
XopenDVS_pixel2x2_top_589 rowReadOFF<23> rowReadON<22> RefrBp PrBp PrSFBp col_periphery_1x2_4/COL_LINE0
+ pixRst<4> pixRst<5> col_periphery_1x2_4/COL_LINE1 OffBn openDVS_pixel2x2_top_589/vpd[2]
+ openDVS_pixel2x2_top_589/vpd[3] openDVS_pixel2x2_top_589/vpd[1] openDVS_pixel2x2_top_589/vpd[0]
+ rowReadON<23> rowReadOFF<22> openDVS_pixel2x2_top_953/GndD DiffBn GndA OnBn VddA18
+ openDVS_pixel2x2_top
XopenDVS_pixel2x2_top_534 rowReadOFF<41> rowReadON<40> RefrBp PrBp PrSFBp col_periphery_1x2_15/COL_LINE0
+ pixRst<14> pixRst<15> col_periphery_1x2_15/COL_LINE1 OffBn openDVS_pixel2x2_top_534/vpd[2]
+ openDVS_pixel2x2_top_534/vpd[3] openDVS_pixel2x2_top_534/vpd[1] openDVS_pixel2x2_top_534/vpd[0]
+ rowReadON<41> rowReadOFF<40> openDVS_pixel2x2_top_535/GndD DiffBn GndA OnBn VddA18
+ openDVS_pixel2x2_top
XopenDVS_pixel2x2_top_512 rowReadOFF<55> rowReadON<54> RefrBp PrBp PrSFBp col_periphery_1x2_15/COL_LINE0
+ pixRst<14> pixRst<15> col_periphery_1x2_15/COL_LINE1 OffBn openDVS_pixel2x2_top_512/vpd[2]
+ openDVS_pixel2x2_top_512/vpd[3] openDVS_pixel2x2_top_512/vpd[1] openDVS_pixel2x2_top_512/vpd[0]
+ rowReadON<55> rowReadOFF<54> openDVS_pixel2x2_top_67/GndD DiffBn GndA OnBn VddA18
+ openDVS_pixel2x2_top
XopenDVS_pixel2x2_top_501 rowReadOFF<45> rowReadON<44> RefrBp PrBp PrSFBp col_periphery_1x2_11/COL_LINE0
+ pixRst<24> pixRst<25> col_periphery_1x2_11/COL_LINE1 OffBn openDVS_pixel2x2_top_501/vpd[2]
+ openDVS_pixel2x2_top_501/vpd[3] openDVS_pixel2x2_top_501/vpd[1] openDVS_pixel2x2_top_501/vpd[0]
+ rowReadON<45> rowReadOFF<44> openDVS_pixel2x2_top_539/GndD DiffBn GndA OnBn VddA18
+ openDVS_pixel2x2_top
XopenDVS_pixel2x2_top_320 rowReadOFF<63> rowReadON<62> RefrBp PrBp PrSFBp col_periphery_1x2_9/COL_LINE0
+ pixRst<20> pixRst<21> col_periphery_1x2_9/COL_LINE1 OffBn openDVS_pixel2x2_top_320/vpd[2]
+ openDVS_pixel2x2_top_320/vpd[3] openDVS_pixel2x2_top_320/vpd[1] openDVS_pixel2x2_top_320/vpd[0]
+ rowReadON<63> rowReadOFF<62> openDVS_pixel2x2_top_82/GndD DiffBn GndA OnBn VddA18
+ openDVS_pixel2x2_top
XopenDVS_pixel2x2_top_375 rowReadOFF<53> rowReadON<52> RefrBp PrBp PrSFBp col_periphery_1x2_1/COL_LINE0
+ pixRst<12> pixRst<13> col_periphery_1x2_1/COL_LINE1 OffBn openDVS_pixel2x2_top_375/vpd[2]
+ openDVS_pixel2x2_top_375/vpd[3] openDVS_pixel2x2_top_375/vpd[1] openDVS_pixel2x2_top_375/vpd[0]
+ rowReadON<53> rowReadOFF<52> openDVS_pixel2x2_top_99/GndD DiffBn GndA OnBn VddA18
+ openDVS_pixel2x2_top
XopenDVS_pixel2x2_top_386 rowReadOFF<55> rowReadON<54> RefrBp PrBp PrSFBp col_periphery_1x2_1/COL_LINE0
+ pixRst<12> pixRst<13> col_periphery_1x2_1/COL_LINE1 OffBn openDVS_pixel2x2_top_386/vpd[2]
+ openDVS_pixel2x2_top_386/vpd[3] openDVS_pixel2x2_top_386/vpd[1] openDVS_pixel2x2_top_386/vpd[0]
+ rowReadON<55> rowReadOFF<54> openDVS_pixel2x2_top_67/GndD DiffBn GndA OnBn VddA18
+ openDVS_pixel2x2_top
XopenDVS_pixel2x2_top_331 rowReadOFF<57> rowReadON<56> RefrBp PrBp PrSFBp col_periphery_1x2_5/COL_LINE0
+ pixRst<6> pixRst<7> col_periphery_1x2_5/COL_LINE1 OffBn openDVS_pixel2x2_top_331/vpd[2]
+ openDVS_pixel2x2_top_331/vpd[3] openDVS_pixel2x2_top_331/vpd[1] openDVS_pixel2x2_top_331/vpd[0]
+ rowReadON<57> rowReadOFF<56> openDVS_pixel2x2_top_9/GndD DiffBn GndA OnBn VddA18
+ openDVS_pixel2x2_top
XopenDVS_pixel2x2_top_364 rowReadOFF<51> rowReadON<50> RefrBp PrBp PrSFBp col_periphery_1x2_1/COL_LINE0
+ pixRst<12> pixRst<13> col_periphery_1x2_1/COL_LINE1 OffBn openDVS_pixel2x2_top_364/vpd[2]
+ openDVS_pixel2x2_top_364/vpd[3] openDVS_pixel2x2_top_364/vpd[1] openDVS_pixel2x2_top_364/vpd[0]
+ rowReadON<51> rowReadOFF<50> openDVS_pixel2x2_top_6/GndD DiffBn GndA OnBn VddA18
+ openDVS_pixel2x2_top
XopenDVS_pixel2x2_top_353 rowReadOFF<49> rowReadON<48> RefrBp PrBp PrSFBp col_periphery_1x2_1/COL_LINE0
+ pixRst<12> pixRst<13> col_periphery_1x2_1/COL_LINE1 OffBn openDVS_pixel2x2_top_353/vpd[2]
+ openDVS_pixel2x2_top_353/vpd[3] openDVS_pixel2x2_top_353/vpd[1] openDVS_pixel2x2_top_353/vpd[0]
+ rowReadON<49> rowReadOFF<48> openDVS_pixel2x2_top_3/GndD DiffBn GndA OnBn VddA18
+ openDVS_pixel2x2_top
XopenDVS_pixel2x2_top_342 rowReadOFF<47> rowReadON<46> RefrBp PrBp PrSFBp col_periphery_1x2_0/COL_LINE0
+ pixRst<10> pixRst<11> col_periphery_1x2_0/COL_LINE1 OffBn openDVS_pixel2x2_top_342/vpd[2]
+ openDVS_pixel2x2_top_342/vpd[3] openDVS_pixel2x2_top_342/vpd[1] openDVS_pixel2x2_top_342/vpd[0]
+ rowReadON<47> rowReadOFF<46> openDVS_pixel2x2_top_78/GndD DiffBn GndA OnBn VddA18
+ openDVS_pixel2x2_top
XopenDVS_pixel2x2_top_397 rowReadOFF<41> rowReadON<40> RefrBp PrBp PrSFBp col_periphery_1x2_3/COL_LINE0
+ pixRst<2> pixRst<3> col_periphery_1x2_3/COL_LINE1 OffBn openDVS_pixel2x2_top_397/vpd[2]
+ openDVS_pixel2x2_top_397/vpd[3] openDVS_pixel2x2_top_397/vpd[1] openDVS_pixel2x2_top_397/vpd[0]
+ rowReadON<41> rowReadOFF<40> openDVS_pixel2x2_top_535/GndD DiffBn GndA OnBn VddA18
+ openDVS_pixel2x2_top
XopenDVS_pixel2x2_top_172 rowReadOFF<37> rowReadON<36> RefrBp PrBp PrSFBp col_periphery_1x2_29/COL_LINE0
+ pixRst<60> pixRst<61> col_periphery_1x2_29/COL_LINE1 OffBn openDVS_pixel2x2_top_172/vpd[2]
+ openDVS_pixel2x2_top_172/vpd[3] openDVS_pixel2x2_top_172/vpd[1] openDVS_pixel2x2_top_172/vpd[0]
+ rowReadON<37> rowReadOFF<36> openDVS_pixel2x2_top_997/GndD DiffBn GndA OnBn VddA18
+ openDVS_pixel2x2_top
XopenDVS_pixel2x2_top_183 rowReadOFF<39> rowReadON<38> RefrBp PrBp PrSFBp col_periphery_1x2_27/COL_LINE0
+ pixRst<56> pixRst<57> col_periphery_1x2_27/COL_LINE1 OffBn openDVS_pixel2x2_top_183/vpd[2]
+ openDVS_pixel2x2_top_183/vpd[3] openDVS_pixel2x2_top_183/vpd[1] openDVS_pixel2x2_top_183/vpd[0]
+ rowReadON<39> rowReadOFF<38> openDVS_pixel2x2_top_999/GndD DiffBn GndA OnBn VddA18
+ openDVS_pixel2x2_top
XopenDVS_pixel2x2_top_194 rowReadOFF<41> rowReadON<40> RefrBp PrBp PrSFBp col_periphery_1x2_27/COL_LINE0
+ pixRst<56> pixRst<57> col_periphery_1x2_27/COL_LINE1 OffBn openDVS_pixel2x2_top_194/vpd[2]
+ openDVS_pixel2x2_top_194/vpd[3] openDVS_pixel2x2_top_194/vpd[1] openDVS_pixel2x2_top_194/vpd[0]
+ rowReadON<41> rowReadOFF<40> openDVS_pixel2x2_top_535/GndD DiffBn GndA OnBn VddA18
+ openDVS_pixel2x2_top
XopenDVS_pixel2x2_top_161 rowReadOFF<35> rowReadON<34> RefrBp PrBp PrSFBp col_periphery_1x2_21/COL_LINE0
+ pixRst<42> pixRst<43> col_periphery_1x2_21/COL_LINE1 OffBn openDVS_pixel2x2_top_161/vpd[2]
+ openDVS_pixel2x2_top_161/vpd[3] openDVS_pixel2x2_top_161/vpd[1] openDVS_pixel2x2_top_161/vpd[0]
+ rowReadON<35> rowReadOFF<34> openDVS_pixel2x2_top_995/GndD DiffBn GndA OnBn VddA18
+ openDVS_pixel2x2_top
XopenDVS_pixel2x2_top_150 rowReadOFF<33> rowReadON<32> RefrBp PrBp PrSFBp col_periphery_1x2_19/COL_LINE0
+ pixRst<38> pixRst<39> col_periphery_1x2_19/COL_LINE1 OffBn openDVS_pixel2x2_top_150/vpd[2]
+ openDVS_pixel2x2_top_150/vpd[3] openDVS_pixel2x2_top_150/vpd[1] openDVS_pixel2x2_top_150/vpd[0]
+ rowReadON<33> rowReadOFF<32> openDVS_pixel2x2_top_993/GndD DiffBn GndA OnBn VddA18
+ openDVS_pixel2x2_top
Xcol_periphery_1x2_3 pixRst<3> col_periphery_1x2_3/COL_LINE0 col_periphery_1x2_3/COL_LINE1
+ nDETECT DETECT col_periphery_1x2_9/VDD VTHRESH pixRst<2> voutn<2> GndA voutn<3>
+ NCHARGE col_periphery_1x2
XopenDVS_pixel2x2_top_89 rowReadOFF<57> rowReadON<56> RefrBp PrBp PrSFBp col_periphery_1x2_21/COL_LINE0
+ pixRst<42> pixRst<43> col_periphery_1x2_21/COL_LINE1 OffBn openDVS_pixel2x2_top_89/vpd[2]
+ openDVS_pixel2x2_top_89/vpd[3] openDVS_pixel2x2_top_89/vpd[1] openDVS_pixel2x2_top_89/vpd[0]
+ rowReadON<57> rowReadOFF<56> openDVS_pixel2x2_top_9/GndD DiffBn GndA OnBn VddA18
+ openDVS_pixel2x2_top
XopenDVS_pixel2x2_top_67 rowReadOFF<55> rowReadON<54> RefrBp PrBp PrSFBp col_periphery_1x2_22/COL_LINE0
+ pixRst<44> pixRst<45> col_periphery_1x2_22/COL_LINE1 OffBn openDVS_pixel2x2_top_67/vpd[2]
+ openDVS_pixel2x2_top_67/vpd[3] openDVS_pixel2x2_top_67/vpd[1] openDVS_pixel2x2_top_67/vpd[0]
+ rowReadON<55> rowReadOFF<54> openDVS_pixel2x2_top_67/GndD DiffBn GndA OnBn VddA18
+ openDVS_pixel2x2_top
XopenDVS_pixel2x2_top_34 rowReadOFF<61> rowReadON<60> RefrBp PrBp PrSFBp col_periphery_1x2_27/COL_LINE0
+ pixRst<56> pixRst<57> col_periphery_1x2_27/COL_LINE1 OffBn openDVS_pixel2x2_top_34/vpd[2]
+ openDVS_pixel2x2_top_34/vpd[3] openDVS_pixel2x2_top_34/vpd[1] openDVS_pixel2x2_top_34/vpd[0]
+ rowReadON<61> rowReadOFF<60> openDVS_pixel2x2_top_96/GndD DiffBn GndA OnBn VddA18
+ openDVS_pixel2x2_top
XopenDVS_pixel2x2_top_45 rowReadOFF<63> rowReadON<62> RefrBp PrBp PrSFBp col_periphery_1x2_29/COL_LINE0
+ pixRst<60> pixRst<61> col_periphery_1x2_29/COL_LINE1 OffBn openDVS_pixel2x2_top_45/vpd[2]
+ openDVS_pixel2x2_top_45/vpd[3] openDVS_pixel2x2_top_45/vpd[1] openDVS_pixel2x2_top_45/vpd[0]
+ rowReadON<63> rowReadOFF<62> openDVS_pixel2x2_top_82/GndD DiffBn GndA OnBn VddA18
+ openDVS_pixel2x2_top
XopenDVS_pixel2x2_top_23 rowReadOFF<53> rowReadON<52> RefrBp PrBp PrSFBp col_periphery_1x2_30/COL_LINE0
+ pixRst<62> pixRst<63> col_periphery_1x2_30/COL_LINE1 OffBn openDVS_pixel2x2_top_23/vpd[2]
+ openDVS_pixel2x2_top_23/vpd[3] openDVS_pixel2x2_top_23/vpd[1] openDVS_pixel2x2_top_23/vpd[0]
+ rowReadON<53> rowReadOFF<52> openDVS_pixel2x2_top_99/GndD DiffBn GndA OnBn VddA18
+ openDVS_pixel2x2_top
XopenDVS_pixel2x2_top_78 rowReadOFF<47> rowReadON<46> RefrBp PrBp PrSFBp col_periphery_1x2_22/COL_LINE0
+ pixRst<44> pixRst<45> col_periphery_1x2_22/COL_LINE1 OffBn openDVS_pixel2x2_top_78/vpd[2]
+ openDVS_pixel2x2_top_78/vpd[3] openDVS_pixel2x2_top_78/vpd[1] openDVS_pixel2x2_top_78/vpd[0]
+ rowReadON<47> rowReadOFF<46> openDVS_pixel2x2_top_78/GndD DiffBn GndA OnBn VddA18
+ openDVS_pixel2x2_top
XopenDVS_pixel2x2_top_56 rowReadOFF<47> rowReadON<46> RefrBp PrBp PrSFBp col_periphery_1x2_25/COL_LINE0
+ pixRst<52> pixRst<53> col_periphery_1x2_25/COL_LINE1 OffBn openDVS_pixel2x2_top_56/vpd[2]
+ openDVS_pixel2x2_top_56/vpd[3] openDVS_pixel2x2_top_56/vpd[1] openDVS_pixel2x2_top_56/vpd[0]
+ rowReadON<47> rowReadOFF<46> openDVS_pixel2x2_top_78/GndD DiffBn GndA OnBn VddA18
+ openDVS_pixel2x2_top
XopenDVS_pixel2x2_top_12 rowReadOFF<47> rowReadON<46> RefrBp PrBp PrSFBp col_periphery_1x2_28/COL_LINE0
+ pixRst<58> pixRst<59> col_periphery_1x2_28/COL_LINE1 OffBn openDVS_pixel2x2_top_12/vpd[2]
+ openDVS_pixel2x2_top_12/vpd[3] openDVS_pixel2x2_top_12/vpd[1] openDVS_pixel2x2_top_12/vpd[0]
+ rowReadON<47> rowReadOFF<46> openDVS_pixel2x2_top_78/GndD DiffBn GndA OnBn VddA18
+ openDVS_pixel2x2_top
XopenDVS_pixel2x2_top_908 rowReadOFF<9> rowReadON<8> RefrBp PrBp PrSFBp col_periphery_1x2_31/COL_LINE0
+ pixRst<48> pixRst<49> col_periphery_1x2_31/COL_LINE1 OffBn openDVS_pixel2x2_top_908/vpd[2]
+ openDVS_pixel2x2_top_908/vpd[3] openDVS_pixel2x2_top_908/vpd[1] openDVS_pixel2x2_top_908/vpd[0]
+ rowReadON<9> rowReadOFF<8> openDVS_pixel2x2_top_939/GndD DiffBn GndA OnBn VddA18
+ openDVS_pixel2x2_top
XopenDVS_pixel2x2_top_919 rowReadOFF<13> rowReadON<12> RefrBp PrBp PrSFBp col_periphery_1x2_31/COL_LINE0
+ pixRst<48> pixRst<49> col_periphery_1x2_31/COL_LINE1 OffBn openDVS_pixel2x2_top_919/vpd[2]
+ openDVS_pixel2x2_top_919/vpd[3] openDVS_pixel2x2_top_919/vpd[1] openDVS_pixel2x2_top_919/vpd[0]
+ rowReadON<13> rowReadOFF<12> openDVS_pixel2x2_top_943/GndD DiffBn GndA OnBn VddA18
+ openDVS_pixel2x2_top
XopenDVS_pixel2x2_top_716 rowReadOFF<9> rowReadON<8> RefrBp PrBp PrSFBp col_periphery_1x2_13/COL_LINE0
+ pixRst<28> pixRst<29> col_periphery_1x2_13/COL_LINE1 OffBn openDVS_pixel2x2_top_716/vpd[2]
+ openDVS_pixel2x2_top_716/vpd[3] openDVS_pixel2x2_top_716/vpd[1] openDVS_pixel2x2_top_716/vpd[0]
+ rowReadON<9> rowReadOFF<8> openDVS_pixel2x2_top_939/GndD DiffBn GndA OnBn VddA18
+ openDVS_pixel2x2_top
XopenDVS_pixel2x2_top_705 rowReadOFF<9> rowReadON<8> RefrBp PrBp PrSFBp col_periphery_1x2_5/COL_LINE0
+ pixRst<6> pixRst<7> col_periphery_1x2_5/COL_LINE1 OffBn openDVS_pixel2x2_top_705/vpd[2]
+ openDVS_pixel2x2_top_705/vpd[3] openDVS_pixel2x2_top_705/vpd[1] openDVS_pixel2x2_top_705/vpd[0]
+ rowReadON<9> rowReadOFF<8> openDVS_pixel2x2_top_939/GndD DiffBn GndA OnBn VddA18
+ openDVS_pixel2x2_top
XopenDVS_pixel2x2_top_749 rowReadOFF<13> rowReadON<12> RefrBp PrBp PrSFBp col_periphery_1x2_30/COL_LINE0
+ pixRst<62> pixRst<63> col_periphery_1x2_30/COL_LINE1 OffBn openDVS_pixel2x2_top_749/vpd[2]
+ openDVS_pixel2x2_top_749/vpd[3] openDVS_pixel2x2_top_749/vpd[1] openDVS_pixel2x2_top_749/vpd[0]
+ rowReadON<13> rowReadOFF<12> openDVS_pixel2x2_top_943/GndD DiffBn GndA OnBn VddA18
+ openDVS_pixel2x2_top
XopenDVS_pixel2x2_top_738 rowReadOFF<17> rowReadON<16> RefrBp PrBp PrSFBp col_periphery_1x2_27/COL_LINE0
+ pixRst<56> pixRst<57> col_periphery_1x2_27/COL_LINE1 OffBn openDVS_pixel2x2_top_738/vpd[2]
+ openDVS_pixel2x2_top_738/vpd[3] openDVS_pixel2x2_top_738/vpd[1] openDVS_pixel2x2_top_738/vpd[0]
+ rowReadON<17> rowReadOFF<16> openDVS_pixel2x2_top_947/GndD DiffBn GndA OnBn VddA18
+ openDVS_pixel2x2_top
XopenDVS_pixel2x2_top_727 rowReadOFF<13> rowReadON<12> RefrBp PrBp PrSFBp col_periphery_1x2_15/COL_LINE0
+ pixRst<14> pixRst<15> col_periphery_1x2_15/COL_LINE1 OffBn openDVS_pixel2x2_top_727/vpd[2]
+ openDVS_pixel2x2_top_727/vpd[3] openDVS_pixel2x2_top_727/vpd[1] openDVS_pixel2x2_top_727/vpd[0]
+ rowReadON<13> rowReadOFF<12> openDVS_pixel2x2_top_943/GndD DiffBn GndA OnBn VddA18
+ openDVS_pixel2x2_top
XopenDVS_pixel2x2_top_546 rowReadOFF<13> rowReadON<12> RefrBp PrBp PrSFBp col_periphery_1x2_13/COL_LINE0
+ pixRst<28> pixRst<29> col_periphery_1x2_13/COL_LINE1 OffBn openDVS_pixel2x2_top_546/vpd[2]
+ openDVS_pixel2x2_top_546/vpd[3] openDVS_pixel2x2_top_546/vpd[1] openDVS_pixel2x2_top_546/vpd[0]
+ rowReadON<13> rowReadOFF<12> openDVS_pixel2x2_top_943/GndD DiffBn GndA OnBn VddA18
+ openDVS_pixel2x2_top
XopenDVS_pixel2x2_top_535 rowReadOFF<41> rowReadON<40> RefrBp PrBp PrSFBp col_periphery_1x2_7/COL_LINE0
+ pixRst<16> pixRst<17> col_periphery_1x2_7/COL_LINE1 OffBn openDVS_pixel2x2_top_535/vpd[2]
+ openDVS_pixel2x2_top_535/vpd[3] openDVS_pixel2x2_top_535/vpd[1] openDVS_pixel2x2_top_535/vpd[0]
+ rowReadON<41> rowReadOFF<40> openDVS_pixel2x2_top_535/GndD DiffBn GndA OnBn VddA18
+ openDVS_pixel2x2_top
XopenDVS_pixel2x2_top_524 rowReadOFF<33> rowReadON<32> RefrBp PrBp PrSFBp col_periphery_1x2_15/COL_LINE0
+ pixRst<14> pixRst<15> col_periphery_1x2_15/COL_LINE1 OffBn openDVS_pixel2x2_top_524/vpd[2]
+ openDVS_pixel2x2_top_524/vpd[3] openDVS_pixel2x2_top_524/vpd[1] openDVS_pixel2x2_top_524/vpd[0]
+ rowReadON<33> rowReadOFF<32> openDVS_pixel2x2_top_993/GndD DiffBn GndA OnBn VddA18
+ openDVS_pixel2x2_top
XopenDVS_pixel2x2_top_513 rowReadOFF<55> rowReadON<54> RefrBp PrBp PrSFBp col_periphery_1x2_7/COL_LINE0
+ pixRst<16> pixRst<17> col_periphery_1x2_7/COL_LINE1 OffBn openDVS_pixel2x2_top_513/vpd[2]
+ openDVS_pixel2x2_top_513/vpd[3] openDVS_pixel2x2_top_513/vpd[1] openDVS_pixel2x2_top_513/vpd[0]
+ rowReadON<55> rowReadOFF<54> openDVS_pixel2x2_top_67/GndD DiffBn GndA OnBn VddA18
+ openDVS_pixel2x2_top
XopenDVS_pixel2x2_top_502 rowReadOFF<45> rowReadON<44> RefrBp PrBp PrSFBp col_periphery_1x2_12/COL_LINE0
+ pixRst<26> pixRst<27> col_periphery_1x2_12/COL_LINE1 OffBn openDVS_pixel2x2_top_502/vpd[2]
+ openDVS_pixel2x2_top_502/vpd[3] openDVS_pixel2x2_top_502/vpd[1] openDVS_pixel2x2_top_502/vpd[0]
+ rowReadON<45> rowReadOFF<44> openDVS_pixel2x2_top_539/GndD DiffBn GndA OnBn VddA18
+ openDVS_pixel2x2_top
XopenDVS_pixel2x2_top_557 rowReadOFF<11> rowReadON<10> RefrBp PrBp PrSFBp col_periphery_1x2_13/COL_LINE0
+ pixRst<28> pixRst<29> col_periphery_1x2_13/COL_LINE1 OffBn openDVS_pixel2x2_top_557/vpd[2]
+ openDVS_pixel2x2_top_557/vpd[3] openDVS_pixel2x2_top_557/vpd[1] openDVS_pixel2x2_top_557/vpd[0]
+ rowReadON<11> rowReadOFF<10> openDVS_pixel2x2_top_941/GndD DiffBn GndA OnBn VddA18
+ openDVS_pixel2x2_top
XopenDVS_pixel2x2_top_568 rowReadOFF<17> rowReadON<16> RefrBp PrBp PrSFBp col_periphery_1x2_12/COL_LINE0
+ pixRst<26> pixRst<27> col_periphery_1x2_12/COL_LINE1 OffBn openDVS_pixel2x2_top_568/vpd[2]
+ openDVS_pixel2x2_top_568/vpd[3] openDVS_pixel2x2_top_568/vpd[1] openDVS_pixel2x2_top_568/vpd[0]
+ rowReadON<17> rowReadOFF<16> openDVS_pixel2x2_top_947/GndD DiffBn GndA OnBn VddA18
+ openDVS_pixel2x2_top
XopenDVS_pixel2x2_top_579 rowReadOFF<25> rowReadON<24> RefrBp PrBp PrSFBp col_periphery_1x2_13/COL_LINE0
+ pixRst<28> pixRst<29> col_periphery_1x2_13/COL_LINE1 OffBn openDVS_pixel2x2_top_579/vpd[2]
+ openDVS_pixel2x2_top_579/vpd[3] openDVS_pixel2x2_top_579/vpd[1] openDVS_pixel2x2_top_579/vpd[0]
+ rowReadON<25> rowReadOFF<24> openDVS_pixel2x2_top_955/GndD DiffBn GndA OnBn VddA18
+ openDVS_pixel2x2_top
XopenDVS_pixel2x2_top_321 rowReadOFF<59> rowReadON<58> RefrBp PrBp PrSFBp col_periphery_1x2_12/COL_LINE0
+ pixRst<26> pixRst<27> col_periphery_1x2_12/COL_LINE1 OffBn openDVS_pixel2x2_top_321/vpd[2]
+ openDVS_pixel2x2_top_321/vpd[3] openDVS_pixel2x2_top_321/vpd[1] openDVS_pixel2x2_top_321/vpd[0]
+ rowReadON<59> rowReadOFF<58> openDVS_pixel2x2_top_74/GndD DiffBn GndA OnBn VddA18
+ openDVS_pixel2x2_top
XopenDVS_pixel2x2_top_310 rowReadOFF<57> rowReadON<56> RefrBp PrBp PrSFBp col_periphery_1x2_11/COL_LINE0
+ pixRst<24> pixRst<25> col_periphery_1x2_11/COL_LINE1 OffBn openDVS_pixel2x2_top_310/vpd[2]
+ openDVS_pixel2x2_top_310/vpd[3] openDVS_pixel2x2_top_310/vpd[1] openDVS_pixel2x2_top_310/vpd[0]
+ rowReadON<57> rowReadOFF<56> openDVS_pixel2x2_top_9/GndD DiffBn GndA OnBn VddA18
+ openDVS_pixel2x2_top
XopenDVS_pixel2x2_top_376 rowReadOFF<59> rowReadON<58> RefrBp PrBp PrSFBp col_periphery_1x2_1/COL_LINE0
+ pixRst<12> pixRst<13> col_periphery_1x2_1/COL_LINE1 OffBn openDVS_pixel2x2_top_376/vpd[2]
+ openDVS_pixel2x2_top_376/vpd[3] openDVS_pixel2x2_top_376/vpd[1] openDVS_pixel2x2_top_376/vpd[0]
+ rowReadON<59> rowReadOFF<58> openDVS_pixel2x2_top_74/GndD DiffBn GndA OnBn VddA18
+ openDVS_pixel2x2_top
XopenDVS_pixel2x2_top_332 rowReadOFF<57> rowReadON<56> RefrBp PrBp PrSFBp col_periphery_1x2_6/COL_LINE0
+ pixRst<8> pixRst<9> col_periphery_1x2_6/COL_LINE1 OffBn openDVS_pixel2x2_top_332/vpd[2]
+ openDVS_pixel2x2_top_332/vpd[3] openDVS_pixel2x2_top_332/vpd[1] openDVS_pixel2x2_top_332/vpd[0]
+ rowReadON<57> rowReadOFF<56> openDVS_pixel2x2_top_9/GndD DiffBn GndA OnBn VddA18
+ openDVS_pixel2x2_top
XopenDVS_pixel2x2_top_365 rowReadOFF<59> rowReadON<58> RefrBp PrBp PrSFBp col_periphery_1x2_6/COL_LINE0
+ pixRst<8> pixRst<9> col_periphery_1x2_6/COL_LINE1 OffBn openDVS_pixel2x2_top_365/vpd[2]
+ openDVS_pixel2x2_top_365/vpd[3] openDVS_pixel2x2_top_365/vpd[1] openDVS_pixel2x2_top_365/vpd[0]
+ rowReadON<59> rowReadOFF<58> openDVS_pixel2x2_top_74/GndD DiffBn GndA OnBn VddA18
+ openDVS_pixel2x2_top
XopenDVS_pixel2x2_top_354 rowReadOFF<59> rowReadON<58> RefrBp PrBp PrSFBp col_periphery_1x2_4/COL_LINE0
+ pixRst<4> pixRst<5> col_periphery_1x2_4/COL_LINE1 OffBn openDVS_pixel2x2_top_354/vpd[2]
+ openDVS_pixel2x2_top_354/vpd[3] openDVS_pixel2x2_top_354/vpd[1] openDVS_pixel2x2_top_354/vpd[0]
+ rowReadON<59> rowReadOFF<58> openDVS_pixel2x2_top_74/GndD DiffBn GndA OnBn VddA18
+ openDVS_pixel2x2_top
XopenDVS_pixel2x2_top_387 rowReadOFF<43> rowReadON<42> RefrBp PrBp PrSFBp col_periphery_1x2_6/COL_LINE0
+ pixRst<8> pixRst<9> col_periphery_1x2_6/COL_LINE1 OffBn openDVS_pixel2x2_top_387/vpd[2]
+ openDVS_pixel2x2_top_387/vpd[3] openDVS_pixel2x2_top_387/vpd[1] openDVS_pixel2x2_top_387/vpd[0]
+ rowReadON<43> rowReadOFF<42> openDVS_pixel2x2_top_537/GndD DiffBn GndA OnBn VddA18
+ openDVS_pixel2x2_top
XopenDVS_pixel2x2_top_343 rowReadOFF<47> rowReadON<46> RefrBp PrBp PrSFBp col_periphery_1x2_1/COL_LINE0
+ pixRst<12> pixRst<13> col_periphery_1x2_1/COL_LINE1 OffBn openDVS_pixel2x2_top_343/vpd[2]
+ openDVS_pixel2x2_top_343/vpd[3] openDVS_pixel2x2_top_343/vpd[1] openDVS_pixel2x2_top_343/vpd[0]
+ rowReadON<47> rowReadOFF<46> openDVS_pixel2x2_top_78/GndD DiffBn GndA OnBn VddA18
+ openDVS_pixel2x2_top
XopenDVS_pixel2x2_top_398 rowReadOFF<41> rowReadON<40> RefrBp PrBp PrSFBp col_periphery_1x2_4/COL_LINE0
+ pixRst<4> pixRst<5> col_periphery_1x2_4/COL_LINE1 OffBn openDVS_pixel2x2_top_398/vpd[2]
+ openDVS_pixel2x2_top_398/vpd[3] openDVS_pixel2x2_top_398/vpd[1] openDVS_pixel2x2_top_398/vpd[0]
+ rowReadON<41> rowReadOFF<40> openDVS_pixel2x2_top_535/GndD DiffBn GndA OnBn VddA18
+ openDVS_pixel2x2_top
XopenDVS_pixel2x2_top_173 rowReadOFF<37> rowReadON<36> RefrBp PrBp PrSFBp col_periphery_1x2_30/COL_LINE0
+ pixRst<62> pixRst<63> col_periphery_1x2_30/COL_LINE1 OffBn openDVS_pixel2x2_top_173/vpd[2]
+ openDVS_pixel2x2_top_173/vpd[3] openDVS_pixel2x2_top_173/vpd[1] openDVS_pixel2x2_top_173/vpd[0]
+ rowReadON<37> rowReadOFF<36> openDVS_pixel2x2_top_997/GndD DiffBn GndA OnBn VddA18
+ openDVS_pixel2x2_top
XopenDVS_pixel2x2_top_184 rowReadOFF<39> rowReadON<38> RefrBp PrBp PrSFBp col_periphery_1x2_28/COL_LINE0
+ pixRst<58> pixRst<59> col_periphery_1x2_28/COL_LINE1 OffBn openDVS_pixel2x2_top_184/vpd[2]
+ openDVS_pixel2x2_top_184/vpd[3] openDVS_pixel2x2_top_184/vpd[1] openDVS_pixel2x2_top_184/vpd[0]
+ rowReadON<39> rowReadOFF<38> openDVS_pixel2x2_top_999/GndD DiffBn GndA OnBn VddA18
+ openDVS_pixel2x2_top
XopenDVS_pixel2x2_top_195 rowReadOFF<41> rowReadON<40> RefrBp PrBp PrSFBp col_periphery_1x2_28/COL_LINE0
+ pixRst<58> pixRst<59> col_periphery_1x2_28/COL_LINE1 OffBn openDVS_pixel2x2_top_195/vpd[2]
+ openDVS_pixel2x2_top_195/vpd[3] openDVS_pixel2x2_top_195/vpd[1] openDVS_pixel2x2_top_195/vpd[0]
+ rowReadON<41> rowReadOFF<40> openDVS_pixel2x2_top_535/GndD DiffBn GndA OnBn VddA18
+ openDVS_pixel2x2_top
XopenDVS_pixel2x2_top_162 rowReadOFF<35> rowReadON<34> RefrBp PrBp PrSFBp col_periphery_1x2_22/COL_LINE0
+ pixRst<44> pixRst<45> col_periphery_1x2_22/COL_LINE1 OffBn openDVS_pixel2x2_top_162/vpd[2]
+ openDVS_pixel2x2_top_162/vpd[3] openDVS_pixel2x2_top_162/vpd[1] openDVS_pixel2x2_top_162/vpd[0]
+ rowReadON<35> rowReadOFF<34> openDVS_pixel2x2_top_995/GndD DiffBn GndA OnBn VddA18
+ openDVS_pixel2x2_top
XopenDVS_pixel2x2_top_140 rowReadOFF<39> rowReadON<38> RefrBp PrBp PrSFBp col_periphery_1x2_21/COL_LINE0
+ pixRst<42> pixRst<43> col_periphery_1x2_21/COL_LINE1 OffBn openDVS_pixel2x2_top_140/vpd[2]
+ openDVS_pixel2x2_top_140/vpd[3] openDVS_pixel2x2_top_140/vpd[1] openDVS_pixel2x2_top_140/vpd[0]
+ rowReadON<39> rowReadOFF<38> openDVS_pixel2x2_top_999/GndD DiffBn GndA OnBn VddA18
+ openDVS_pixel2x2_top
XopenDVS_pixel2x2_top_151 rowReadOFF<33> rowReadON<32> RefrBp PrBp PrSFBp col_periphery_1x2_20/COL_LINE0
+ pixRst<40> pixRst<41> col_periphery_1x2_20/COL_LINE1 OffBn openDVS_pixel2x2_top_151/vpd[2]
+ openDVS_pixel2x2_top_151/vpd[3] openDVS_pixel2x2_top_151/vpd[1] openDVS_pixel2x2_top_151/vpd[0]
+ rowReadON<33> rowReadOFF<32> openDVS_pixel2x2_top_993/GndD DiffBn GndA OnBn VddA18
+ openDVS_pixel2x2_top
Xcol_periphery_1x2_4 pixRst<5> col_periphery_1x2_4/COL_LINE0 col_periphery_1x2_4/COL_LINE1
+ nDETECT DETECT col_periphery_1x2_9/VDD VTHRESH pixRst<4> voutn<4> GndA voutn<5>
+ NCHARGE col_periphery_1x2
XopenDVS_pixel2x2_top_68 rowReadOFF<63> rowReadON<62> RefrBp PrBp PrSFBp col_periphery_1x2_17/COL_LINE0
+ pixRst<34> pixRst<35> col_periphery_1x2_17/COL_LINE1 OffBn openDVS_pixel2x2_top_68/vpd[2]
+ openDVS_pixel2x2_top_68/vpd[3] openDVS_pixel2x2_top_68/vpd[1] openDVS_pixel2x2_top_68/vpd[0]
+ rowReadON<63> rowReadOFF<62> openDVS_pixel2x2_top_82/GndD DiffBn GndA OnBn VddA18
+ openDVS_pixel2x2_top
XopenDVS_pixel2x2_top_35 rowReadOFF<57> rowReadON<56> RefrBp PrBp PrSFBp col_periphery_1x2_24/COL_LINE0
+ pixRst<50> pixRst<51> col_periphery_1x2_24/COL_LINE1 OffBn openDVS_pixel2x2_top_35/vpd[2]
+ openDVS_pixel2x2_top_35/vpd[3] openDVS_pixel2x2_top_35/vpd[1] openDVS_pixel2x2_top_35/vpd[0]
+ rowReadON<57> rowReadOFF<56> openDVS_pixel2x2_top_9/GndD DiffBn GndA OnBn VddA18
+ openDVS_pixel2x2_top
XopenDVS_pixel2x2_top_24 rowReadOFF<55> rowReadON<54> RefrBp PrBp PrSFBp col_periphery_1x2_28/COL_LINE0
+ pixRst<58> pixRst<59> col_periphery_1x2_28/COL_LINE1 OffBn openDVS_pixel2x2_top_24/vpd[2]
+ openDVS_pixel2x2_top_24/vpd[3] openDVS_pixel2x2_top_24/vpd[1] openDVS_pixel2x2_top_24/vpd[0]
+ rowReadON<55> rowReadOFF<54> openDVS_pixel2x2_top_67/GndD DiffBn GndA OnBn VddA18
+ openDVS_pixel2x2_top
XopenDVS_pixel2x2_top_46 rowReadOFF<63> rowReadON<62> RefrBp PrBp PrSFBp col_periphery_1x2_30/COL_LINE0
+ pixRst<62> pixRst<63> col_periphery_1x2_30/COL_LINE1 OffBn openDVS_pixel2x2_top_46/vpd[2]
+ openDVS_pixel2x2_top_46/vpd[3] openDVS_pixel2x2_top_46/vpd[1] openDVS_pixel2x2_top_46/vpd[0]
+ rowReadON<63> rowReadOFF<62> openDVS_pixel2x2_top_82/GndD DiffBn GndA OnBn VddA18
+ openDVS_pixel2x2_top
XopenDVS_pixel2x2_top_79 rowReadOFF<49> rowReadON<48> RefrBp PrBp PrSFBp col_periphery_1x2_19/COL_LINE0
+ pixRst<38> pixRst<39> col_periphery_1x2_19/COL_LINE1 OffBn openDVS_pixel2x2_top_79/vpd[2]
+ openDVS_pixel2x2_top_79/vpd[3] openDVS_pixel2x2_top_79/vpd[1] openDVS_pixel2x2_top_79/vpd[0]
+ rowReadON<49> rowReadOFF<48> openDVS_pixel2x2_top_3/GndD DiffBn GndA OnBn VddA18
+ openDVS_pixel2x2_top
XopenDVS_pixel2x2_top_57 rowReadOFF<47> rowReadON<46> RefrBp PrBp PrSFBp col_periphery_1x2_26/COL_LINE0
+ pixRst<54> pixRst<55> col_periphery_1x2_26/COL_LINE1 OffBn openDVS_pixel2x2_top_57/vpd[2]
+ openDVS_pixel2x2_top_57/vpd[3] openDVS_pixel2x2_top_57/vpd[1] openDVS_pixel2x2_top_57/vpd[0]
+ rowReadON<47> rowReadOFF<46> openDVS_pixel2x2_top_78/GndD DiffBn GndA OnBn VddA18
+ openDVS_pixel2x2_top
XopenDVS_pixel2x2_top_13 rowReadOFF<47> rowReadON<46> RefrBp PrBp PrSFBp col_periphery_1x2_29/COL_LINE0
+ pixRst<60> pixRst<61> col_periphery_1x2_29/COL_LINE1 OffBn openDVS_pixel2x2_top_13/vpd[2]
+ openDVS_pixel2x2_top_13/vpd[3] openDVS_pixel2x2_top_13/vpd[1] openDVS_pixel2x2_top_13/vpd[0]
+ rowReadON<47> rowReadOFF<46> openDVS_pixel2x2_top_78/GndD DiffBn GndA OnBn VddA18
+ openDVS_pixel2x2_top
XopenDVS_pixel2x2_top_909 rowReadOFF<9> rowReadON<8> RefrBp PrBp PrSFBp col_periphery_1x2_24/COL_LINE0
+ pixRst<50> pixRst<51> col_periphery_1x2_24/COL_LINE1 OffBn openDVS_pixel2x2_top_909/vpd[2]
+ openDVS_pixel2x2_top_909/vpd[3] openDVS_pixel2x2_top_909/vpd[1] openDVS_pixel2x2_top_909/vpd[0]
+ rowReadON<9> rowReadOFF<8> openDVS_pixel2x2_top_939/GndD DiffBn GndA OnBn VddA18
+ openDVS_pixel2x2_top
XopenDVS_pixel2x2_top_706 rowReadOFF<9> rowReadON<8> RefrBp PrBp PrSFBp col_periphery_1x2_6/COL_LINE0
+ pixRst<8> pixRst<9> col_periphery_1x2_6/COL_LINE1 OffBn openDVS_pixel2x2_top_706/vpd[2]
+ openDVS_pixel2x2_top_706/vpd[3] openDVS_pixel2x2_top_706/vpd[1] openDVS_pixel2x2_top_706/vpd[0]
+ rowReadON<9> rowReadOFF<8> openDVS_pixel2x2_top_939/GndD DiffBn GndA OnBn VddA18
+ openDVS_pixel2x2_top
XopenDVS_pixel2x2_top_739 rowReadOFF<17> rowReadON<16> RefrBp PrBp PrSFBp col_periphery_1x2_28/COL_LINE0
+ pixRst<58> pixRst<59> col_periphery_1x2_28/COL_LINE1 OffBn openDVS_pixel2x2_top_739/vpd[2]
+ openDVS_pixel2x2_top_739/vpd[3] openDVS_pixel2x2_top_739/vpd[1] openDVS_pixel2x2_top_739/vpd[0]
+ rowReadON<17> rowReadOFF<16> openDVS_pixel2x2_top_947/GndD DiffBn GndA OnBn VddA18
+ openDVS_pixel2x2_top
XopenDVS_pixel2x2_top_728 rowReadOFF<13> rowReadON<12> RefrBp PrBp PrSFBp col_periphery_1x2_7/COL_LINE0
+ pixRst<16> pixRst<17> col_periphery_1x2_7/COL_LINE1 OffBn openDVS_pixel2x2_top_728/vpd[2]
+ openDVS_pixel2x2_top_728/vpd[3] openDVS_pixel2x2_top_728/vpd[1] openDVS_pixel2x2_top_728/vpd[0]
+ rowReadON<13> rowReadOFF<12> openDVS_pixel2x2_top_943/GndD DiffBn GndA OnBn VddA18
+ openDVS_pixel2x2_top
XopenDVS_pixel2x2_top_717 rowReadOFF<17> rowReadON<16> RefrBp PrBp PrSFBp col_periphery_1x2_15/COL_LINE0
+ pixRst<14> pixRst<15> col_periphery_1x2_15/COL_LINE1 OffBn openDVS_pixel2x2_top_717/vpd[2]
+ openDVS_pixel2x2_top_717/vpd[3] openDVS_pixel2x2_top_717/vpd[1] openDVS_pixel2x2_top_717/vpd[0]
+ rowReadON<17> rowReadOFF<16> openDVS_pixel2x2_top_947/GndD DiffBn GndA OnBn VddA18
+ openDVS_pixel2x2_top
XopenDVS_pixel2x2_top_569 rowReadOFF<17> rowReadON<16> RefrBp PrBp PrSFBp col_periphery_1x2_13/COL_LINE0
+ pixRst<28> pixRst<29> col_periphery_1x2_13/COL_LINE1 OffBn openDVS_pixel2x2_top_569/vpd[2]
+ openDVS_pixel2x2_top_569/vpd[3] openDVS_pixel2x2_top_569/vpd[1] openDVS_pixel2x2_top_569/vpd[0]
+ rowReadON<17> rowReadOFF<16> openDVS_pixel2x2_top_947/GndD DiffBn GndA OnBn VddA18
+ openDVS_pixel2x2_top
XopenDVS_pixel2x2_top_558 rowReadOFF<19> rowReadON<18> RefrBp PrBp PrSFBp col_periphery_1x2_9/COL_LINE0
+ pixRst<20> pixRst<21> col_periphery_1x2_9/COL_LINE1 OffBn openDVS_pixel2x2_top_558/vpd[2]
+ openDVS_pixel2x2_top_558/vpd[3] openDVS_pixel2x2_top_558/vpd[1] openDVS_pixel2x2_top_558/vpd[0]
+ rowReadON<19> rowReadOFF<18> openDVS_pixel2x2_top_949/GndD DiffBn GndA OnBn VddA18
+ openDVS_pixel2x2_top
XopenDVS_pixel2x2_top_547 rowReadOFF<19> rowReadON<18> RefrBp PrBp PrSFBp col_periphery_1x2_8/COL_LINE0
+ pixRst<18> pixRst<19> col_periphery_1x2_8/COL_LINE1 OffBn openDVS_pixel2x2_top_547/vpd[2]
+ openDVS_pixel2x2_top_547/vpd[3] openDVS_pixel2x2_top_547/vpd[1] openDVS_pixel2x2_top_547/vpd[0]
+ rowReadON<19> rowReadOFF<18> openDVS_pixel2x2_top_949/GndD DiffBn GndA OnBn VddA18
+ openDVS_pixel2x2_top
XopenDVS_pixel2x2_top_525 rowReadOFF<33> rowReadON<32> RefrBp PrBp PrSFBp col_periphery_1x2_7/COL_LINE0
+ pixRst<16> pixRst<17> col_periphery_1x2_7/COL_LINE1 OffBn openDVS_pixel2x2_top_525/vpd[2]
+ openDVS_pixel2x2_top_525/vpd[3] openDVS_pixel2x2_top_525/vpd[1] openDVS_pixel2x2_top_525/vpd[0]
+ rowReadON<33> rowReadOFF<32> openDVS_pixel2x2_top_993/GndD DiffBn GndA OnBn VddA18
+ openDVS_pixel2x2_top
XopenDVS_pixel2x2_top_514 rowReadOFF<63> rowReadON<62> RefrBp PrBp PrSFBp col_periphery_1x2_15/COL_LINE0
+ pixRst<14> pixRst<15> col_periphery_1x2_15/COL_LINE1 OffBn openDVS_pixel2x2_top_514/vpd[2]
+ openDVS_pixel2x2_top_514/vpd[3] openDVS_pixel2x2_top_514/vpd[1] openDVS_pixel2x2_top_514/vpd[0]
+ rowReadON<63> rowReadOFF<62> openDVS_pixel2x2_top_82/GndD DiffBn GndA OnBn VddA18
+ openDVS_pixel2x2_top
XopenDVS_pixel2x2_top_536 rowReadOFF<43> rowReadON<42> RefrBp PrBp PrSFBp col_periphery_1x2_15/COL_LINE0
+ pixRst<14> pixRst<15> col_periphery_1x2_15/COL_LINE1 OffBn openDVS_pixel2x2_top_536/vpd[2]
+ openDVS_pixel2x2_top_536/vpd[3] openDVS_pixel2x2_top_536/vpd[1] openDVS_pixel2x2_top_536/vpd[0]
+ rowReadON<43> rowReadOFF<42> openDVS_pixel2x2_top_537/GndD DiffBn GndA OnBn VddA18
+ openDVS_pixel2x2_top
XopenDVS_pixel2x2_top_503 rowReadOFF<45> rowReadON<44> RefrBp PrBp PrSFBp col_periphery_1x2_13/COL_LINE0
+ pixRst<28> pixRst<29> col_periphery_1x2_13/COL_LINE1 OffBn openDVS_pixel2x2_top_503/vpd[2]
+ openDVS_pixel2x2_top_503/vpd[3] openDVS_pixel2x2_top_503/vpd[1] openDVS_pixel2x2_top_503/vpd[0]
+ rowReadON<45> rowReadOFF<44> openDVS_pixel2x2_top_539/GndD DiffBn GndA OnBn VddA18
+ openDVS_pixel2x2_top
XopenDVS_pixel2x2_top_300 rowReadOFF<63> rowReadON<62> RefrBp PrBp PrSFBp col_periphery_1x2_13/COL_LINE0
+ pixRst<28> pixRst<29> col_periphery_1x2_13/COL_LINE1 OffBn openDVS_pixel2x2_top_300/vpd[2]
+ openDVS_pixel2x2_top_300/vpd[3] openDVS_pixel2x2_top_300/vpd[1] openDVS_pixel2x2_top_300/vpd[0]
+ rowReadON<63> rowReadOFF<62> openDVS_pixel2x2_top_82/GndD DiffBn GndA OnBn VddA18
+ openDVS_pixel2x2_top
XopenDVS_pixel2x2_top_322 rowReadOFF<59> rowReadON<58> RefrBp PrBp PrSFBp col_periphery_1x2_13/COL_LINE0
+ pixRst<28> pixRst<29> col_periphery_1x2_13/COL_LINE1 OffBn openDVS_pixel2x2_top_322/vpd[2]
+ openDVS_pixel2x2_top_322/vpd[3] openDVS_pixel2x2_top_322/vpd[1] openDVS_pixel2x2_top_322/vpd[0]
+ rowReadON<59> rowReadOFF<58> openDVS_pixel2x2_top_74/GndD DiffBn GndA OnBn VddA18
+ openDVS_pixel2x2_top
XopenDVS_pixel2x2_top_333 rowReadOFF<57> rowReadON<56> RefrBp PrBp PrSFBp col_periphery_1x2_0/COL_LINE0
+ pixRst<10> pixRst<11> col_periphery_1x2_0/COL_LINE1 OffBn openDVS_pixel2x2_top_333/vpd[2]
+ openDVS_pixel2x2_top_333/vpd[3] openDVS_pixel2x2_top_333/vpd[1] openDVS_pixel2x2_top_333/vpd[0]
+ rowReadON<57> rowReadOFF<56> openDVS_pixel2x2_top_9/GndD DiffBn GndA OnBn VddA18
+ openDVS_pixel2x2_top
XopenDVS_pixel2x2_top_366 rowReadOFF<59> rowReadON<58> RefrBp PrBp PrSFBp col_periphery_1x2_0/COL_LINE0
+ pixRst<10> pixRst<11> col_periphery_1x2_0/COL_LINE1 OffBn openDVS_pixel2x2_top_366/vpd[2]
+ openDVS_pixel2x2_top_366/vpd[3] openDVS_pixel2x2_top_366/vpd[1] openDVS_pixel2x2_top_366/vpd[0]
+ rowReadON<59> rowReadOFF<58> openDVS_pixel2x2_top_74/GndD DiffBn GndA OnBn VddA18
+ openDVS_pixel2x2_top
XopenDVS_pixel2x2_top_355 rowReadOFF<59> rowReadON<58> RefrBp PrBp PrSFBp col_periphery_1x2_5/COL_LINE0
+ pixRst<6> pixRst<7> col_periphery_1x2_5/COL_LINE1 OffBn openDVS_pixel2x2_top_355/vpd[2]
+ openDVS_pixel2x2_top_355/vpd[3] openDVS_pixel2x2_top_355/vpd[1] openDVS_pixel2x2_top_355/vpd[0]
+ rowReadON<59> rowReadOFF<58> openDVS_pixel2x2_top_74/GndD DiffBn GndA OnBn VddA18
+ openDVS_pixel2x2_top
XopenDVS_pixel2x2_top_377 rowReadOFF<61> rowReadON<60> RefrBp PrBp PrSFBp col_periphery_1x2_5/COL_LINE0
+ pixRst<6> pixRst<7> col_periphery_1x2_5/COL_LINE1 OffBn openDVS_pixel2x2_top_377/vpd[2]
+ openDVS_pixel2x2_top_377/vpd[3] openDVS_pixel2x2_top_377/vpd[1] openDVS_pixel2x2_top_377/vpd[0]
+ rowReadON<61> rowReadOFF<60> openDVS_pixel2x2_top_96/GndD DiffBn GndA OnBn VddA18
+ openDVS_pixel2x2_top
XopenDVS_pixel2x2_top_344 rowReadOFF<59> rowReadON<58> RefrBp PrBp PrSFBp col_periphery_1x2_2/COL_LINE0
+ pixRst<0> pixRst<1> col_periphery_1x2_2/COL_LINE1 OffBn openDVS_pixel2x2_top_344/vpd[2]
+ openDVS_pixel2x2_top_344/vpd[3] openDVS_pixel2x2_top_344/vpd[1] openDVS_pixel2x2_top_344/vpd[0]
+ rowReadON<59> rowReadOFF<58> openDVS_pixel2x2_top_74/GndD DiffBn GndA OnBn VddA18
+ openDVS_pixel2x2_top
XopenDVS_pixel2x2_top_388 rowReadOFF<43> rowReadON<42> RefrBp PrBp PrSFBp col_periphery_1x2_0/COL_LINE0
+ pixRst<10> pixRst<11> col_periphery_1x2_0/COL_LINE1 OffBn openDVS_pixel2x2_top_388/vpd[2]
+ openDVS_pixel2x2_top_388/vpd[3] openDVS_pixel2x2_top_388/vpd[1] openDVS_pixel2x2_top_388/vpd[0]
+ rowReadON<43> rowReadOFF<42> openDVS_pixel2x2_top_537/GndD DiffBn GndA OnBn VddA18
+ openDVS_pixel2x2_top
XopenDVS_pixel2x2_top_311 rowReadOFF<49> rowReadON<48> RefrBp PrBp PrSFBp col_periphery_1x2_8/COL_LINE0
+ pixRst<18> pixRst<19> col_periphery_1x2_8/COL_LINE1 OffBn openDVS_pixel2x2_top_311/vpd[2]
+ openDVS_pixel2x2_top_311/vpd[3] openDVS_pixel2x2_top_311/vpd[1] openDVS_pixel2x2_top_311/vpd[0]
+ rowReadON<49> rowReadOFF<48> openDVS_pixel2x2_top_3/GndD DiffBn GndA OnBn VddA18
+ openDVS_pixel2x2_top
XopenDVS_pixel2x2_top_399 rowReadOFF<41> rowReadON<40> RefrBp PrBp PrSFBp col_periphery_1x2_5/COL_LINE0
+ pixRst<6> pixRst<7> col_periphery_1x2_5/COL_LINE1 OffBn openDVS_pixel2x2_top_399/vpd[2]
+ openDVS_pixel2x2_top_399/vpd[3] openDVS_pixel2x2_top_399/vpd[1] openDVS_pixel2x2_top_399/vpd[0]
+ rowReadON<41> rowReadOFF<40> openDVS_pixel2x2_top_535/GndD DiffBn GndA OnBn VddA18
+ openDVS_pixel2x2_top
XopenDVS_pixel2x2_top_185 rowReadOFF<39> rowReadON<38> RefrBp PrBp PrSFBp col_periphery_1x2_29/COL_LINE0
+ pixRst<60> pixRst<61> col_periphery_1x2_29/COL_LINE1 OffBn openDVS_pixel2x2_top_185/vpd[2]
+ openDVS_pixel2x2_top_185/vpd[3] openDVS_pixel2x2_top_185/vpd[1] openDVS_pixel2x2_top_185/vpd[0]
+ rowReadON<39> rowReadOFF<38> openDVS_pixel2x2_top_999/GndD DiffBn GndA OnBn VddA18
+ openDVS_pixel2x2_top
XopenDVS_pixel2x2_top_196 rowReadOFF<41> rowReadON<40> RefrBp PrBp PrSFBp col_periphery_1x2_29/COL_LINE0
+ pixRst<60> pixRst<61> col_periphery_1x2_29/COL_LINE1 OffBn openDVS_pixel2x2_top_196/vpd[2]
+ openDVS_pixel2x2_top_196/vpd[3] openDVS_pixel2x2_top_196/vpd[1] openDVS_pixel2x2_top_196/vpd[0]
+ rowReadON<41> rowReadOFF<40> openDVS_pixel2x2_top_535/GndD DiffBn GndA OnBn VddA18
+ openDVS_pixel2x2_top
XopenDVS_pixel2x2_top_174 rowReadOFF<35> rowReadON<34> RefrBp PrBp PrSFBp col_periphery_1x2_28/COL_LINE0
+ pixRst<58> pixRst<59> col_periphery_1x2_28/COL_LINE1 OffBn openDVS_pixel2x2_top_174/vpd[2]
+ openDVS_pixel2x2_top_174/vpd[3] openDVS_pixel2x2_top_174/vpd[1] openDVS_pixel2x2_top_174/vpd[0]
+ rowReadON<35> rowReadOFF<34> openDVS_pixel2x2_top_995/GndD DiffBn GndA OnBn VddA18
+ openDVS_pixel2x2_top
XopenDVS_pixel2x2_top_152 rowReadOFF<33> rowReadON<32> RefrBp PrBp PrSFBp col_periphery_1x2_21/COL_LINE0
+ pixRst<42> pixRst<43> col_periphery_1x2_21/COL_LINE1 OffBn openDVS_pixel2x2_top_152/vpd[2]
+ openDVS_pixel2x2_top_152/vpd[3] openDVS_pixel2x2_top_152/vpd[1] openDVS_pixel2x2_top_152/vpd[0]
+ rowReadON<33> rowReadOFF<32> openDVS_pixel2x2_top_993/GndD DiffBn GndA OnBn VddA18
+ openDVS_pixel2x2_top
XopenDVS_pixel2x2_top_141 rowReadOFF<39> rowReadON<38> RefrBp PrBp PrSFBp col_periphery_1x2_22/COL_LINE0
+ pixRst<44> pixRst<45> col_periphery_1x2_22/COL_LINE1 OffBn openDVS_pixel2x2_top_141/vpd[2]
+ openDVS_pixel2x2_top_141/vpd[3] openDVS_pixel2x2_top_141/vpd[1] openDVS_pixel2x2_top_141/vpd[0]
+ rowReadON<39> rowReadOFF<38> openDVS_pixel2x2_top_999/GndD DiffBn GndA OnBn VddA18
+ openDVS_pixel2x2_top
XopenDVS_pixel2x2_top_163 rowReadOFF<35> rowReadON<34> RefrBp PrBp PrSFBp col_periphery_1x2_17/COL_LINE0
+ pixRst<34> pixRst<35> col_periphery_1x2_17/COL_LINE1 OffBn openDVS_pixel2x2_top_163/vpd[2]
+ openDVS_pixel2x2_top_163/vpd[3] openDVS_pixel2x2_top_163/vpd[1] openDVS_pixel2x2_top_163/vpd[0]
+ rowReadON<35> rowReadOFF<34> openDVS_pixel2x2_top_995/GndD DiffBn GndA OnBn VddA18
+ openDVS_pixel2x2_top
XopenDVS_pixel2x2_top_130 rowReadOFF<43> rowReadON<42> RefrBp PrBp PrSFBp col_periphery_1x2_20/COL_LINE0
+ pixRst<40> pixRst<41> col_periphery_1x2_20/COL_LINE1 OffBn openDVS_pixel2x2_top_130/vpd[2]
+ openDVS_pixel2x2_top_130/vpd[3] openDVS_pixel2x2_top_130/vpd[1] openDVS_pixel2x2_top_130/vpd[0]
+ rowReadON<43> rowReadOFF<42> openDVS_pixel2x2_top_537/GndD DiffBn GndA OnBn VddA18
+ openDVS_pixel2x2_top
XopenDVS_pixel2x2_top_1020 rowReadOFF<61> rowReadON<60> RefrBp PrBp PrSFBp col_periphery_1x2_14/COL_LINE0
+ pixRst<30> pixRst<31> col_periphery_1x2_14/COL_LINE1 OffBn openDVS_pixel2x2_top_1020/vpd[2]
+ openDVS_pixel2x2_top_1020/vpd[3] openDVS_pixel2x2_top_1020/vpd[1] openDVS_pixel2x2_top_1020/vpd[0]
+ rowReadON<61> rowReadOFF<60> openDVS_pixel2x2_top_96/GndD DiffBn GndA OnBn VddA18
+ openDVS_pixel2x2_top
XopenDVS_pixel2x2_top_47 rowReadOFF<59> rowReadON<58> RefrBp PrBp PrSFBp col_periphery_1x2_24/COL_LINE0
+ pixRst<50> pixRst<51> col_periphery_1x2_24/COL_LINE1 OffBn openDVS_pixel2x2_top_47/vpd[2]
+ openDVS_pixel2x2_top_47/vpd[3] openDVS_pixel2x2_top_47/vpd[1] openDVS_pixel2x2_top_47/vpd[0]
+ rowReadON<59> rowReadOFF<58> openDVS_pixel2x2_top_74/GndD DiffBn GndA OnBn VddA18
+ openDVS_pixel2x2_top
XopenDVS_pixel2x2_top_25 rowReadOFF<61> rowReadON<60> RefrBp PrBp PrSFBp col_periphery_1x2_24/COL_LINE0
+ pixRst<50> pixRst<51> col_periphery_1x2_24/COL_LINE1 OffBn openDVS_pixel2x2_top_25/vpd[2]
+ openDVS_pixel2x2_top_25/vpd[3] openDVS_pixel2x2_top_25/vpd[1] openDVS_pixel2x2_top_25/vpd[0]
+ rowReadON<61> rowReadOFF<60> openDVS_pixel2x2_top_96/GndD DiffBn GndA OnBn VddA18
+ openDVS_pixel2x2_top
XopenDVS_pixel2x2_top_36 rowReadOFF<61> rowReadON<60> RefrBp PrBp PrSFBp col_periphery_1x2_28/COL_LINE0
+ pixRst<58> pixRst<59> col_periphery_1x2_28/COL_LINE1 OffBn openDVS_pixel2x2_top_36/vpd[2]
+ openDVS_pixel2x2_top_36/vpd[3] openDVS_pixel2x2_top_36/vpd[1] openDVS_pixel2x2_top_36/vpd[0]
+ rowReadON<61> rowReadOFF<60> openDVS_pixel2x2_top_96/GndD DiffBn GndA OnBn VddA18
+ openDVS_pixel2x2_top
XopenDVS_pixel2x2_top_69 rowReadOFF<49> rowReadON<48> RefrBp PrBp PrSFBp col_periphery_1x2_17/COL_LINE0
+ pixRst<34> pixRst<35> col_periphery_1x2_17/COL_LINE1 OffBn openDVS_pixel2x2_top_69/vpd[2]
+ openDVS_pixel2x2_top_69/vpd[3] openDVS_pixel2x2_top_69/vpd[1] openDVS_pixel2x2_top_69/vpd[0]
+ rowReadON<49> rowReadOFF<48> openDVS_pixel2x2_top_3/GndD DiffBn GndA OnBn VddA18
+ openDVS_pixel2x2_top
XopenDVS_pixel2x2_top_58 rowReadOFF<47> rowReadON<46> RefrBp PrBp PrSFBp col_periphery_1x2_27/COL_LINE0
+ pixRst<56> pixRst<57> col_periphery_1x2_27/COL_LINE1 OffBn openDVS_pixel2x2_top_58/vpd[2]
+ openDVS_pixel2x2_top_58/vpd[3] openDVS_pixel2x2_top_58/vpd[1] openDVS_pixel2x2_top_58/vpd[0]
+ rowReadON<47> rowReadOFF<46> openDVS_pixel2x2_top_78/GndD DiffBn GndA OnBn VddA18
+ openDVS_pixel2x2_top
XopenDVS_pixel2x2_top_14 rowReadOFF<47> rowReadON<46> RefrBp PrBp PrSFBp col_periphery_1x2_30/COL_LINE0
+ pixRst<62> pixRst<63> col_periphery_1x2_30/COL_LINE1 OffBn openDVS_pixel2x2_top_14/vpd[2]
+ openDVS_pixel2x2_top_14/vpd[3] openDVS_pixel2x2_top_14/vpd[1] openDVS_pixel2x2_top_14/vpd[0]
+ rowReadON<47> rowReadOFF<46> openDVS_pixel2x2_top_78/GndD DiffBn GndA OnBn VddA18
+ openDVS_pixel2x2_top
Xcol_periphery_1x2_5 pixRst<7> col_periphery_1x2_5/COL_LINE0 col_periphery_1x2_5/COL_LINE1
+ nDETECT DETECT col_periphery_1x2_9/VDD VTHRESH pixRst<6> voutn<6> GndA voutn<7>
+ NCHARGE col_periphery_1x2
XopenDVS_pixel2x2_top_729 rowReadOFF<3> rowReadON<2> RefrBp PrBp PrSFBp col_periphery_1x2_15/COL_LINE0
+ pixRst<14> pixRst<15> col_periphery_1x2_15/COL_LINE1 OffBn openDVS_pixel2x2_top_729/vpd[2]
+ openDVS_pixel2x2_top_729/vpd[3] openDVS_pixel2x2_top_729/vpd[1] openDVS_pixel2x2_top_729/vpd[0]
+ rowReadON<3> rowReadOFF<2> openDVS_pixel2x2_top_933/GndD DiffBn GndA OnBn VddA18
+ openDVS_pixel2x2_top
XopenDVS_pixel2x2_top_707 rowReadOFF<9> rowReadON<8> RefrBp PrBp PrSFBp col_periphery_1x2_0/COL_LINE0
+ pixRst<10> pixRst<11> col_periphery_1x2_0/COL_LINE1 OffBn openDVS_pixel2x2_top_707/vpd[2]
+ openDVS_pixel2x2_top_707/vpd[3] openDVS_pixel2x2_top_707/vpd[1] openDVS_pixel2x2_top_707/vpd[0]
+ rowReadON<9> rowReadOFF<8> openDVS_pixel2x2_top_939/GndD DiffBn GndA OnBn VddA18
+ openDVS_pixel2x2_top
XopenDVS_pixel2x2_top_718 rowReadOFF<17> rowReadON<16> RefrBp PrBp PrSFBp col_periphery_1x2_7/COL_LINE0
+ pixRst<16> pixRst<17> col_periphery_1x2_7/COL_LINE1 OffBn openDVS_pixel2x2_top_718/vpd[2]
+ openDVS_pixel2x2_top_718/vpd[3] openDVS_pixel2x2_top_718/vpd[1] openDVS_pixel2x2_top_718/vpd[0]
+ rowReadON<17> rowReadOFF<16> openDVS_pixel2x2_top_947/GndD DiffBn GndA OnBn VddA18
+ openDVS_pixel2x2_top
XopenDVS_pixel2x2_top_559 rowReadOFF<19> rowReadON<18> RefrBp PrBp PrSFBp col_periphery_1x2_10/COL_LINE0
+ pixRst<22> pixRst<23> col_periphery_1x2_10/COL_LINE1 OffBn openDVS_pixel2x2_top_559/vpd[2]
+ openDVS_pixel2x2_top_559/vpd[3] openDVS_pixel2x2_top_559/vpd[1] openDVS_pixel2x2_top_559/vpd[0]
+ rowReadON<19> rowReadOFF<18> openDVS_pixel2x2_top_949/GndD DiffBn GndA OnBn VddA18
+ openDVS_pixel2x2_top
XopenDVS_pixel2x2_top_548 rowReadOFF<23> rowReadON<22> RefrBp PrBp PrSFBp col_periphery_1x2_8/COL_LINE0
+ pixRst<18> pixRst<19> col_periphery_1x2_8/COL_LINE1 OffBn openDVS_pixel2x2_top_548/vpd[2]
+ openDVS_pixel2x2_top_548/vpd[3] openDVS_pixel2x2_top_548/vpd[1] openDVS_pixel2x2_top_548/vpd[0]
+ rowReadON<23> rowReadOFF<22> openDVS_pixel2x2_top_953/GndD DiffBn GndA OnBn VddA18
+ openDVS_pixel2x2_top
XopenDVS_pixel2x2_top_526 rowReadOFF<35> rowReadON<34> RefrBp PrBp PrSFBp col_periphery_1x2_15/COL_LINE0
+ pixRst<14> pixRst<15> col_periphery_1x2_15/COL_LINE1 OffBn openDVS_pixel2x2_top_526/vpd[2]
+ openDVS_pixel2x2_top_526/vpd[3] openDVS_pixel2x2_top_526/vpd[1] openDVS_pixel2x2_top_526/vpd[0]
+ rowReadON<35> rowReadOFF<34> openDVS_pixel2x2_top_995/GndD DiffBn GndA OnBn VddA18
+ openDVS_pixel2x2_top
XopenDVS_pixel2x2_top_515 rowReadOFF<63> rowReadON<62> RefrBp PrBp PrSFBp col_periphery_1x2_7/COL_LINE0
+ pixRst<16> pixRst<17> col_periphery_1x2_7/COL_LINE1 OffBn openDVS_pixel2x2_top_515/vpd[2]
+ openDVS_pixel2x2_top_515/vpd[3] openDVS_pixel2x2_top_515/vpd[1] openDVS_pixel2x2_top_515/vpd[0]
+ rowReadON<63> rowReadOFF<62> openDVS_pixel2x2_top_82/GndD DiffBn GndA OnBn VddA18
+ openDVS_pixel2x2_top
XopenDVS_pixel2x2_top_504 rowReadOFF<47> rowReadON<46> RefrBp PrBp PrSFBp col_periphery_1x2_15/COL_LINE0
+ pixRst<14> pixRst<15> col_periphery_1x2_15/COL_LINE1 OffBn openDVS_pixel2x2_top_504/vpd[2]
+ openDVS_pixel2x2_top_504/vpd[3] openDVS_pixel2x2_top_504/vpd[1] openDVS_pixel2x2_top_504/vpd[0]
+ rowReadON<47> rowReadOFF<46> openDVS_pixel2x2_top_78/GndD DiffBn GndA OnBn VddA18
+ openDVS_pixel2x2_top
XopenDVS_pixel2x2_top_537 rowReadOFF<43> rowReadON<42> RefrBp PrBp PrSFBp col_periphery_1x2_7/COL_LINE0
+ pixRst<16> pixRst<17> col_periphery_1x2_7/COL_LINE1 OffBn openDVS_pixel2x2_top_537/vpd[2]
+ openDVS_pixel2x2_top_537/vpd[3] openDVS_pixel2x2_top_537/vpd[1] openDVS_pixel2x2_top_537/vpd[0]
+ rowReadON<43> rowReadOFF<42> openDVS_pixel2x2_top_537/GndD DiffBn GndA OnBn VddA18
+ openDVS_pixel2x2_top
XopenDVS_pixel2x2_top_301 rowReadOFF<53> rowReadON<52> RefrBp PrBp PrSFBp col_periphery_1x2_9/COL_LINE0
+ pixRst<20> pixRst<21> col_periphery_1x2_9/COL_LINE1 OffBn openDVS_pixel2x2_top_301/vpd[2]
+ openDVS_pixel2x2_top_301/vpd[3] openDVS_pixel2x2_top_301/vpd[1] openDVS_pixel2x2_top_301/vpd[0]
+ rowReadON<53> rowReadOFF<52> openDVS_pixel2x2_top_99/GndD DiffBn GndA OnBn VddA18
+ openDVS_pixel2x2_top
XopenDVS_pixel2x2_top_312 rowReadOFF<49> rowReadON<48> RefrBp PrBp PrSFBp col_periphery_1x2_9/COL_LINE0
+ pixRst<20> pixRst<21> col_periphery_1x2_9/COL_LINE1 OffBn openDVS_pixel2x2_top_312/vpd[2]
+ openDVS_pixel2x2_top_312/vpd[3] openDVS_pixel2x2_top_312/vpd[1] openDVS_pixel2x2_top_312/vpd[0]
+ rowReadON<49> rowReadOFF<48> openDVS_pixel2x2_top_3/GndD DiffBn GndA OnBn VddA18
+ openDVS_pixel2x2_top
XopenDVS_pixel2x2_top_323 rowReadOFF<55> rowReadON<54> RefrBp PrBp PrSFBp col_periphery_1x2_8/COL_LINE0
+ pixRst<18> pixRst<19> col_periphery_1x2_8/COL_LINE1 OffBn openDVS_pixel2x2_top_323/vpd[2]
+ openDVS_pixel2x2_top_323/vpd[3] openDVS_pixel2x2_top_323/vpd[1] openDVS_pixel2x2_top_323/vpd[0]
+ rowReadON<55> rowReadOFF<54> openDVS_pixel2x2_top_67/GndD DiffBn GndA OnBn VddA18
+ openDVS_pixel2x2_top
XopenDVS_pixel2x2_top_334 rowReadOFF<57> rowReadON<56> RefrBp PrBp PrSFBp col_periphery_1x2_1/COL_LINE0
+ pixRst<12> pixRst<13> col_periphery_1x2_1/COL_LINE1 OffBn openDVS_pixel2x2_top_334/vpd[2]
+ openDVS_pixel2x2_top_334/vpd[3] openDVS_pixel2x2_top_334/vpd[1] openDVS_pixel2x2_top_334/vpd[0]
+ rowReadON<57> rowReadOFF<56> openDVS_pixel2x2_top_9/GndD DiffBn GndA OnBn VddA18
+ openDVS_pixel2x2_top
XopenDVS_pixel2x2_top_378 rowReadOFF<63> rowReadON<62> RefrBp PrBp PrSFBp col_periphery_1x2_0/COL_LINE0
+ pixRst<10> pixRst<11> col_periphery_1x2_0/COL_LINE1 OffBn openDVS_pixel2x2_top_378/vpd[2]
+ openDVS_pixel2x2_top_378/vpd[3] openDVS_pixel2x2_top_378/vpd[1] openDVS_pixel2x2_top_378/vpd[0]
+ rowReadON<63> rowReadOFF<62> openDVS_pixel2x2_top_82/GndD DiffBn GndA OnBn VddA18
+ openDVS_pixel2x2_top
XopenDVS_pixel2x2_top_367 rowReadOFF<63> rowReadON<62> RefrBp PrBp PrSFBp col_periphery_1x2_5/COL_LINE0
+ pixRst<6> pixRst<7> col_periphery_1x2_5/COL_LINE1 OffBn openDVS_pixel2x2_top_367/vpd[2]
+ openDVS_pixel2x2_top_367/vpd[3] openDVS_pixel2x2_top_367/vpd[1] openDVS_pixel2x2_top_367/vpd[0]
+ rowReadON<63> rowReadOFF<62> openDVS_pixel2x2_top_82/GndD DiffBn GndA OnBn VddA18
+ openDVS_pixel2x2_top
XopenDVS_pixel2x2_top_345 rowReadOFF<59> rowReadON<58> RefrBp PrBp PrSFBp col_periphery_1x2_3/COL_LINE0
+ pixRst<2> pixRst<3> col_periphery_1x2_3/COL_LINE1 OffBn openDVS_pixel2x2_top_345/vpd[2]
+ openDVS_pixel2x2_top_345/vpd[3] openDVS_pixel2x2_top_345/vpd[1] openDVS_pixel2x2_top_345/vpd[0]
+ rowReadON<59> rowReadOFF<58> openDVS_pixel2x2_top_74/GndD DiffBn GndA OnBn VddA18
+ openDVS_pixel2x2_top
XopenDVS_pixel2x2_top_356 rowReadOFF<63> rowReadON<62> RefrBp PrBp PrSFBp col_periphery_1x2_3/COL_LINE0
+ pixRst<2> pixRst<3> col_periphery_1x2_3/COL_LINE1 OffBn openDVS_pixel2x2_top_356/vpd[2]
+ openDVS_pixel2x2_top_356/vpd[3] openDVS_pixel2x2_top_356/vpd[1] openDVS_pixel2x2_top_356/vpd[0]
+ rowReadON<63> rowReadOFF<62> openDVS_pixel2x2_top_82/GndD DiffBn GndA OnBn VddA18
+ openDVS_pixel2x2_top
XopenDVS_pixel2x2_top_389 rowReadOFF<41> rowReadON<40> RefrBp PrBp PrSFBp col_periphery_1x2_2/COL_LINE0
+ pixRst<0> pixRst<1> col_periphery_1x2_2/COL_LINE1 OffBn openDVS_pixel2x2_top_389/vpd[2]
+ openDVS_pixel2x2_top_389/vpd[3] openDVS_pixel2x2_top_389/vpd[1] openDVS_pixel2x2_top_389/vpd[0]
+ rowReadON<41> rowReadOFF<40> openDVS_pixel2x2_top_535/GndD DiffBn GndA OnBn VddA18
+ openDVS_pixel2x2_top
XopenDVS_pixel2x2_top_890 rowReadOFF<7> rowReadON<6> RefrBp PrBp PrSFBp col_periphery_1x2_28/COL_LINE0
+ pixRst<58> pixRst<59> col_periphery_1x2_28/COL_LINE1 OffBn openDVS_pixel2x2_top_890/vpd[2]
+ openDVS_pixel2x2_top_890/vpd[3] openDVS_pixel2x2_top_890/vpd[1] openDVS_pixel2x2_top_890/vpd[0]
+ rowReadON<7> rowReadOFF<6> openDVS_pixel2x2_top_937/GndD DiffBn GndA OnBn VddA18
+ openDVS_pixel2x2_top
XopenDVS_pixel2x2_top_142 rowReadOFF<29> rowReadON<28> RefrBp PrBp PrSFBp col_periphery_1x2_18/COL_LINE0
+ pixRst<36> pixRst<37> col_periphery_1x2_18/COL_LINE1 OffBn openDVS_pixel2x2_top_142/vpd[2]
+ openDVS_pixel2x2_top_142/vpd[3] openDVS_pixel2x2_top_142/vpd[1] openDVS_pixel2x2_top_142/vpd[0]
+ rowReadON<29> rowReadOFF<28> openDVS_pixel2x2_top_989/GndD DiffBn GndA OnBn VddA18
+ openDVS_pixel2x2_top
XopenDVS_pixel2x2_top_186 rowReadOFF<39> rowReadON<38> RefrBp PrBp PrSFBp col_periphery_1x2_30/COL_LINE0
+ pixRst<62> pixRst<63> col_periphery_1x2_30/COL_LINE1 OffBn openDVS_pixel2x2_top_186/vpd[2]
+ openDVS_pixel2x2_top_186/vpd[3] openDVS_pixel2x2_top_186/vpd[1] openDVS_pixel2x2_top_186/vpd[0]
+ rowReadON<39> rowReadOFF<38> openDVS_pixel2x2_top_999/GndD DiffBn GndA OnBn VddA18
+ openDVS_pixel2x2_top
XopenDVS_pixel2x2_top_197 rowReadOFF<41> rowReadON<40> RefrBp PrBp PrSFBp col_periphery_1x2_30/COL_LINE0
+ pixRst<62> pixRst<63> col_periphery_1x2_30/COL_LINE1 OffBn openDVS_pixel2x2_top_197/vpd[2]
+ openDVS_pixel2x2_top_197/vpd[3] openDVS_pixel2x2_top_197/vpd[1] openDVS_pixel2x2_top_197/vpd[0]
+ rowReadON<41> rowReadOFF<40> openDVS_pixel2x2_top_535/GndD DiffBn GndA OnBn VddA18
+ openDVS_pixel2x2_top
XopenDVS_pixel2x2_top_175 rowReadOFF<33> rowReadON<32> RefrBp PrBp PrSFBp col_periphery_1x2_24/COL_LINE0
+ pixRst<50> pixRst<51> col_periphery_1x2_24/COL_LINE1 OffBn openDVS_pixel2x2_top_175/vpd[2]
+ openDVS_pixel2x2_top_175/vpd[3] openDVS_pixel2x2_top_175/vpd[1] openDVS_pixel2x2_top_175/vpd[0]
+ rowReadON<33> rowReadOFF<32> openDVS_pixel2x2_top_993/GndD DiffBn GndA OnBn VddA18
+ openDVS_pixel2x2_top
XopenDVS_pixel2x2_top_120 rowReadOFF<37> rowReadON<36> RefrBp PrBp PrSFBp col_periphery_1x2_20/COL_LINE0
+ pixRst<40> pixRst<41> col_periphery_1x2_20/COL_LINE1 OffBn openDVS_pixel2x2_top_120/vpd[2]
+ openDVS_pixel2x2_top_120/vpd[3] openDVS_pixel2x2_top_120/vpd[1] openDVS_pixel2x2_top_120/vpd[0]
+ rowReadON<37> rowReadOFF<36> openDVS_pixel2x2_top_997/GndD DiffBn GndA OnBn VddA18
+ openDVS_pixel2x2_top
XopenDVS_pixel2x2_top_164 rowReadOFF<35> rowReadON<34> RefrBp PrBp PrSFBp col_periphery_1x2_18/COL_LINE0
+ pixRst<36> pixRst<37> col_periphery_1x2_18/COL_LINE1 OffBn openDVS_pixel2x2_top_164/vpd[2]
+ openDVS_pixel2x2_top_164/vpd[3] openDVS_pixel2x2_top_164/vpd[1] openDVS_pixel2x2_top_164/vpd[0]
+ rowReadON<35> rowReadOFF<34> openDVS_pixel2x2_top_995/GndD DiffBn GndA OnBn VddA18
+ openDVS_pixel2x2_top
XopenDVS_pixel2x2_top_153 rowReadOFF<41> rowReadON<40> RefrBp PrBp PrSFBp col_periphery_1x2_17/COL_LINE0
+ pixRst<34> pixRst<35> col_periphery_1x2_17/COL_LINE1 OffBn openDVS_pixel2x2_top_153/vpd[2]
+ openDVS_pixel2x2_top_153/vpd[3] openDVS_pixel2x2_top_153/vpd[1] openDVS_pixel2x2_top_153/vpd[0]
+ rowReadON<41> rowReadOFF<40> openDVS_pixel2x2_top_535/GndD DiffBn GndA OnBn VddA18
+ openDVS_pixel2x2_top
XopenDVS_pixel2x2_top_131 rowReadOFF<43> rowReadON<42> RefrBp PrBp PrSFBp col_periphery_1x2_21/COL_LINE0
+ pixRst<42> pixRst<43> col_periphery_1x2_21/COL_LINE1 OffBn openDVS_pixel2x2_top_131/vpd[2]
+ openDVS_pixel2x2_top_131/vpd[3] openDVS_pixel2x2_top_131/vpd[1] openDVS_pixel2x2_top_131/vpd[0]
+ rowReadON<43> rowReadOFF<42> openDVS_pixel2x2_top_537/GndD DiffBn GndA OnBn VddA18
+ openDVS_pixel2x2_top
Xcol_periphery_1x2_6 pixRst<9> col_periphery_1x2_6/COL_LINE0 col_periphery_1x2_6/COL_LINE1
+ nDETECT DETECT col_periphery_1x2_9/VDD VTHRESH pixRst<8> voutn<8> GndA voutn<9>
+ NCHARGE col_periphery_1x2
XopenDVS_pixel2x2_top_1021 rowReadOFF<61> rowReadON<60> RefrBp PrBp PrSFBp col_periphery_1x2_16/COL_LINE0
+ pixRst<32> pixRst<33> col_periphery_1x2_16/COL_LINE1 OffBn openDVS_pixel2x2_top_1021/vpd[2]
+ openDVS_pixel2x2_top_1021/vpd[3] openDVS_pixel2x2_top_1021/vpd[1] openDVS_pixel2x2_top_1021/vpd[0]
+ rowReadON<61> rowReadOFF<60> openDVS_pixel2x2_top_96/GndD DiffBn GndA OnBn VddA18
+ openDVS_pixel2x2_top
XopenDVS_pixel2x2_top_26 rowReadOFF<63> rowReadON<62> RefrBp PrBp PrSFBp col_periphery_1x2_24/COL_LINE0
+ pixRst<50> pixRst<51> col_periphery_1x2_24/COL_LINE1 OffBn openDVS_pixel2x2_top_26/vpd[2]
+ openDVS_pixel2x2_top_26/vpd[3] openDVS_pixel2x2_top_26/vpd[1] openDVS_pixel2x2_top_26/vpd[0]
+ rowReadON<63> rowReadOFF<62> openDVS_pixel2x2_top_82/GndD DiffBn GndA OnBn VddA18
+ openDVS_pixel2x2_top
XopenDVS_pixel2x2_top_48 rowReadOFF<59> rowReadON<58> RefrBp PrBp PrSFBp col_periphery_1x2_25/COL_LINE0
+ pixRst<52> pixRst<53> col_periphery_1x2_25/COL_LINE1 OffBn openDVS_pixel2x2_top_48/vpd[2]
+ openDVS_pixel2x2_top_48/vpd[3] openDVS_pixel2x2_top_48/vpd[1] openDVS_pixel2x2_top_48/vpd[0]
+ rowReadON<59> rowReadOFF<58> openDVS_pixel2x2_top_74/GndD DiffBn GndA OnBn VddA18
+ openDVS_pixel2x2_top
XopenDVS_pixel2x2_top_15 rowReadOFF<55> rowReadON<54> RefrBp PrBp PrSFBp col_periphery_1x2_26/COL_LINE0
+ pixRst<54> pixRst<55> col_periphery_1x2_26/COL_LINE1 OffBn openDVS_pixel2x2_top_15/vpd[2]
+ openDVS_pixel2x2_top_15/vpd[3] openDVS_pixel2x2_top_15/vpd[1] openDVS_pixel2x2_top_15/vpd[0]
+ rowReadON<55> rowReadOFF<54> openDVS_pixel2x2_top_67/GndD DiffBn GndA OnBn VddA18
+ openDVS_pixel2x2_top
XopenDVS_pixel2x2_top_37 rowReadOFF<55> rowReadON<54> RefrBp PrBp PrSFBp col_periphery_1x2_29/COL_LINE0
+ pixRst<60> pixRst<61> col_periphery_1x2_29/COL_LINE1 OffBn openDVS_pixel2x2_top_37/vpd[2]
+ openDVS_pixel2x2_top_37/vpd[3] openDVS_pixel2x2_top_37/vpd[1] openDVS_pixel2x2_top_37/vpd[0]
+ rowReadON<55> rowReadOFF<54> openDVS_pixel2x2_top_67/GndD DiffBn GndA OnBn VddA18
+ openDVS_pixel2x2_top
XopenDVS_pixel2x2_top_1010 rowReadOFF<51> rowReadON<50> RefrBp PrBp PrSFBp col_periphery_1x2_14/COL_LINE0
+ pixRst<30> pixRst<31> col_periphery_1x2_14/COL_LINE1 OffBn openDVS_pixel2x2_top_1010/vpd[2]
+ openDVS_pixel2x2_top_1010/vpd[3] openDVS_pixel2x2_top_1010/vpd[1] openDVS_pixel2x2_top_1010/vpd[0]
+ rowReadON<51> rowReadOFF<50> openDVS_pixel2x2_top_6/GndD DiffBn GndA OnBn VddA18
+ openDVS_pixel2x2_top
XopenDVS_pixel2x2_top_59 rowReadOFF<51> rowReadON<50> RefrBp PrBp PrSFBp col_periphery_1x2_24/COL_LINE0
+ pixRst<50> pixRst<51> col_periphery_1x2_24/COL_LINE1 OffBn openDVS_pixel2x2_top_59/vpd[2]
+ openDVS_pixel2x2_top_59/vpd[3] openDVS_pixel2x2_top_59/vpd[1] openDVS_pixel2x2_top_59/vpd[0]
+ rowReadON<51> rowReadOFF<50> openDVS_pixel2x2_top_6/GndD DiffBn GndA OnBn VddA18
+ openDVS_pixel2x2_top
XopenDVS_pixel2x2_top_708 rowReadOFF<9> rowReadON<8> RefrBp PrBp PrSFBp col_periphery_1x2_1/COL_LINE0
+ pixRst<12> pixRst<13> col_periphery_1x2_1/COL_LINE1 OffBn openDVS_pixel2x2_top_708/vpd[2]
+ openDVS_pixel2x2_top_708/vpd[3] openDVS_pixel2x2_top_708/vpd[1] openDVS_pixel2x2_top_708/vpd[0]
+ rowReadON<9> rowReadOFF<8> openDVS_pixel2x2_top_939/GndD DiffBn GndA OnBn VddA18
+ openDVS_pixel2x2_top
XopenDVS_pixel2x2_top_719 rowReadOFF<11> rowReadON<10> RefrBp PrBp PrSFBp col_periphery_1x2_15/COL_LINE0
+ pixRst<14> pixRst<15> col_periphery_1x2_15/COL_LINE1 OffBn openDVS_pixel2x2_top_719/vpd[2]
+ openDVS_pixel2x2_top_719/vpd[3] openDVS_pixel2x2_top_719/vpd[1] openDVS_pixel2x2_top_719/vpd[0]
+ rowReadON<11> rowReadOFF<10> openDVS_pixel2x2_top_941/GndD DiffBn GndA OnBn VddA18
+ openDVS_pixel2x2_top
XopenDVS_pixel2x2_top_549 rowReadOFF<23> rowReadON<22> RefrBp PrBp PrSFBp col_periphery_1x2_9/COL_LINE0
+ pixRst<20> pixRst<21> col_periphery_1x2_9/COL_LINE1 OffBn openDVS_pixel2x2_top_549/vpd[2]
+ openDVS_pixel2x2_top_549/vpd[3] openDVS_pixel2x2_top_549/vpd[1] openDVS_pixel2x2_top_549/vpd[0]
+ rowReadON<23> rowReadOFF<22> openDVS_pixel2x2_top_953/GndD DiffBn GndA OnBn VddA18
+ openDVS_pixel2x2_top
XopenDVS_pixel2x2_top_527 rowReadOFF<35> rowReadON<34> RefrBp PrBp PrSFBp col_periphery_1x2_7/COL_LINE0
+ pixRst<16> pixRst<17> col_periphery_1x2_7/COL_LINE1 OffBn openDVS_pixel2x2_top_527/vpd[2]
+ openDVS_pixel2x2_top_527/vpd[3] openDVS_pixel2x2_top_527/vpd[1] openDVS_pixel2x2_top_527/vpd[0]
+ rowReadON<35> rowReadOFF<34> openDVS_pixel2x2_top_995/GndD DiffBn GndA OnBn VddA18
+ openDVS_pixel2x2_top
XopenDVS_pixel2x2_top_516 rowReadOFF<57> rowReadON<56> RefrBp PrBp PrSFBp col_periphery_1x2_15/COL_LINE0
+ pixRst<14> pixRst<15> col_periphery_1x2_15/COL_LINE1 OffBn openDVS_pixel2x2_top_516/vpd[2]
+ openDVS_pixel2x2_top_516/vpd[3] openDVS_pixel2x2_top_516/vpd[1] openDVS_pixel2x2_top_516/vpd[0]
+ rowReadON<57> rowReadOFF<56> openDVS_pixel2x2_top_9/GndD DiffBn GndA OnBn VddA18
+ openDVS_pixel2x2_top
XopenDVS_pixel2x2_top_538 rowReadOFF<45> rowReadON<44> RefrBp PrBp PrSFBp col_periphery_1x2_2/COL_LINE0
+ pixRst<0> pixRst<1> col_periphery_1x2_2/COL_LINE1 OffBn openDVS_pixel2x2_top_538/vpd[2]
+ openDVS_pixel2x2_top_538/vpd[3] openDVS_pixel2x2_top_538/vpd[1] openDVS_pixel2x2_top_538/vpd[0]
+ rowReadON<45> rowReadOFF<44> openDVS_pixel2x2_top_539/GndD DiffBn GndA OnBn VddA18
+ openDVS_pixel2x2_top
XopenDVS_pixel2x2_top_505 rowReadOFF<47> rowReadON<46> RefrBp PrBp PrSFBp col_periphery_1x2_7/COL_LINE0
+ pixRst<16> pixRst<17> col_periphery_1x2_7/COL_LINE1 OffBn openDVS_pixel2x2_top_505/vpd[2]
+ openDVS_pixel2x2_top_505/vpd[3] openDVS_pixel2x2_top_505/vpd[1] openDVS_pixel2x2_top_505/vpd[0]
+ rowReadON<47> rowReadOFF<46> openDVS_pixel2x2_top_78/GndD DiffBn GndA OnBn VddA18
+ openDVS_pixel2x2_top
XopenDVS_pixel2x2_top_302 rowReadOFF<53> rowReadON<52> RefrBp PrBp PrSFBp col_periphery_1x2_10/COL_LINE0
+ pixRst<22> pixRst<23> col_periphery_1x2_10/COL_LINE1 OffBn openDVS_pixel2x2_top_302/vpd[2]
+ openDVS_pixel2x2_top_302/vpd[3] openDVS_pixel2x2_top_302/vpd[1] openDVS_pixel2x2_top_302/vpd[0]
+ rowReadON<53> rowReadOFF<52> openDVS_pixel2x2_top_99/GndD DiffBn GndA OnBn VddA18
+ openDVS_pixel2x2_top
XopenDVS_pixel2x2_top_379 rowReadOFF<63> rowReadON<62> RefrBp PrBp PrSFBp col_periphery_1x2_1/COL_LINE0
+ pixRst<12> pixRst<13> col_periphery_1x2_1/COL_LINE1 OffBn openDVS_pixel2x2_top_379/vpd[2]
+ openDVS_pixel2x2_top_379/vpd[3] openDVS_pixel2x2_top_379/vpd[1] openDVS_pixel2x2_top_379/vpd[0]
+ rowReadON<63> rowReadOFF<62> openDVS_pixel2x2_top_82/GndD DiffBn GndA OnBn VddA18
+ openDVS_pixel2x2_top
XopenDVS_pixel2x2_top_324 rowReadOFF<61> rowReadON<60> RefrBp PrBp PrSFBp col_periphery_1x2_6/COL_LINE0
+ pixRst<8> pixRst<9> col_periphery_1x2_6/COL_LINE1 OffBn openDVS_pixel2x2_top_324/vpd[2]
+ openDVS_pixel2x2_top_324/vpd[3] openDVS_pixel2x2_top_324/vpd[1] openDVS_pixel2x2_top_324/vpd[0]
+ rowReadON<61> rowReadOFF<60> openDVS_pixel2x2_top_96/GndD DiffBn GndA OnBn VddA18
+ openDVS_pixel2x2_top
XopenDVS_pixel2x2_top_368 rowReadOFF<63> rowReadON<62> RefrBp PrBp PrSFBp col_periphery_1x2_6/COL_LINE0
+ pixRst<8> pixRst<9> col_periphery_1x2_6/COL_LINE1 OffBn openDVS_pixel2x2_top_368/vpd[2]
+ openDVS_pixel2x2_top_368/vpd[3] openDVS_pixel2x2_top_368/vpd[1] openDVS_pixel2x2_top_368/vpd[0]
+ rowReadON<63> rowReadOFF<62> openDVS_pixel2x2_top_82/GndD DiffBn GndA OnBn VddA18
+ openDVS_pixel2x2_top
XopenDVS_pixel2x2_top_357 rowReadOFF<63> rowReadON<62> RefrBp PrBp PrSFBp col_periphery_1x2_4/COL_LINE0
+ pixRst<4> pixRst<5> col_periphery_1x2_4/COL_LINE1 OffBn openDVS_pixel2x2_top_357/vpd[2]
+ openDVS_pixel2x2_top_357/vpd[3] openDVS_pixel2x2_top_357/vpd[1] openDVS_pixel2x2_top_357/vpd[0]
+ rowReadON<63> rowReadOFF<62> openDVS_pixel2x2_top_82/GndD DiffBn GndA OnBn VddA18
+ openDVS_pixel2x2_top
XopenDVS_pixel2x2_top_335 rowReadOFF<61> rowReadON<60> RefrBp PrBp PrSFBp col_periphery_1x2_3/COL_LINE0
+ pixRst<2> pixRst<3> col_periphery_1x2_3/COL_LINE1 OffBn openDVS_pixel2x2_top_335/vpd[2]
+ openDVS_pixel2x2_top_335/vpd[3] openDVS_pixel2x2_top_335/vpd[1] openDVS_pixel2x2_top_335/vpd[0]
+ rowReadON<61> rowReadOFF<60> openDVS_pixel2x2_top_96/GndD DiffBn GndA OnBn VddA18
+ openDVS_pixel2x2_top
XopenDVS_pixel2x2_top_346 rowReadOFF<63> rowReadON<62> RefrBp PrBp PrSFBp col_periphery_1x2_2/COL_LINE0
+ pixRst<0> pixRst<1> col_periphery_1x2_2/COL_LINE1 OffBn openDVS_pixel2x2_top_346/vpd[2]
+ openDVS_pixel2x2_top_346/vpd[3] openDVS_pixel2x2_top_346/vpd[1] openDVS_pixel2x2_top_346/vpd[0]
+ rowReadON<63> rowReadOFF<62> openDVS_pixel2x2_top_82/GndD DiffBn GndA OnBn VddA18
+ openDVS_pixel2x2_top
XopenDVS_pixel2x2_top_313 rowReadOFF<49> rowReadON<48> RefrBp PrBp PrSFBp col_periphery_1x2_10/COL_LINE0
+ pixRst<22> pixRst<23> col_periphery_1x2_10/COL_LINE1 OffBn openDVS_pixel2x2_top_313/vpd[2]
+ openDVS_pixel2x2_top_313/vpd[3] openDVS_pixel2x2_top_313/vpd[1] openDVS_pixel2x2_top_313/vpd[0]
+ rowReadON<49> rowReadOFF<48> openDVS_pixel2x2_top_3/GndD DiffBn GndA OnBn VddA18
+ openDVS_pixel2x2_top
XopenDVS_pixel2x2_top_880 rowReadOFF<7> rowReadON<6> RefrBp PrBp PrSFBp col_periphery_1x2_22/COL_LINE0
+ pixRst<44> pixRst<45> col_periphery_1x2_22/COL_LINE1 OffBn openDVS_pixel2x2_top_880/vpd[2]
+ openDVS_pixel2x2_top_880/vpd[3] openDVS_pixel2x2_top_880/vpd[1] openDVS_pixel2x2_top_880/vpd[0]
+ rowReadON<7> rowReadOFF<6> openDVS_pixel2x2_top_937/GndD DiffBn GndA OnBn VddA18
+ openDVS_pixel2x2_top
XopenDVS_pixel2x2_top_891 rowReadOFF<23> rowReadON<22> RefrBp PrBp PrSFBp col_periphery_1x2_23/COL_LINE0
+ pixRst<46> pixRst<47> col_periphery_1x2_23/COL_LINE1 OffBn openDVS_pixel2x2_top_891/vpd[2]
+ openDVS_pixel2x2_top_891/vpd[3] openDVS_pixel2x2_top_891/vpd[1] openDVS_pixel2x2_top_891/vpd[0]
+ rowReadON<23> rowReadOFF<22> openDVS_pixel2x2_top_953/GndD DiffBn GndA OnBn VddA18
+ openDVS_pixel2x2_top
XopenDVS_pixel2x2_top_187 rowReadOFF<29> rowReadON<28> RefrBp PrBp PrSFBp col_periphery_1x2_26/COL_LINE0
+ pixRst<54> pixRst<55> col_periphery_1x2_26/COL_LINE1 OffBn openDVS_pixel2x2_top_187/vpd[2]
+ openDVS_pixel2x2_top_187/vpd[3] openDVS_pixel2x2_top_187/vpd[1] openDVS_pixel2x2_top_187/vpd[0]
+ rowReadON<29> rowReadOFF<28> openDVS_pixel2x2_top_989/GndD DiffBn GndA OnBn VddA18
+ openDVS_pixel2x2_top
XopenDVS_pixel2x2_top_143 rowReadOFF<29> rowReadON<28> RefrBp PrBp PrSFBp col_periphery_1x2_19/COL_LINE0
+ pixRst<38> pixRst<39> col_periphery_1x2_19/COL_LINE1 OffBn openDVS_pixel2x2_top_143/vpd[2]
+ openDVS_pixel2x2_top_143/vpd[3] openDVS_pixel2x2_top_143/vpd[1] openDVS_pixel2x2_top_143/vpd[0]
+ rowReadON<29> rowReadOFF<28> openDVS_pixel2x2_top_989/GndD DiffBn GndA OnBn VddA18
+ openDVS_pixel2x2_top
XopenDVS_pixel2x2_top_165 rowReadOFF<35> rowReadON<34> RefrBp PrBp PrSFBp col_periphery_1x2_26/COL_LINE0
+ pixRst<54> pixRst<55> col_periphery_1x2_26/COL_LINE1 OffBn openDVS_pixel2x2_top_165/vpd[2]
+ openDVS_pixel2x2_top_165/vpd[3] openDVS_pixel2x2_top_165/vpd[1] openDVS_pixel2x2_top_165/vpd[0]
+ rowReadON<35> rowReadOFF<34> openDVS_pixel2x2_top_995/GndD DiffBn GndA OnBn VddA18
+ openDVS_pixel2x2_top
XopenDVS_pixel2x2_top_176 rowReadOFF<33> rowReadON<32> RefrBp PrBp PrSFBp col_periphery_1x2_25/COL_LINE0
+ pixRst<52> pixRst<53> col_periphery_1x2_25/COL_LINE1 OffBn openDVS_pixel2x2_top_176/vpd[2]
+ openDVS_pixel2x2_top_176/vpd[3] openDVS_pixel2x2_top_176/vpd[1] openDVS_pixel2x2_top_176/vpd[0]
+ rowReadON<33> rowReadOFF<32> openDVS_pixel2x2_top_993/GndD DiffBn GndA OnBn VddA18
+ openDVS_pixel2x2_top
XopenDVS_pixel2x2_top_121 rowReadOFF<37> rowReadON<36> RefrBp PrBp PrSFBp col_periphery_1x2_21/COL_LINE0
+ pixRst<42> pixRst<43> col_periphery_1x2_21/COL_LINE1 OffBn openDVS_pixel2x2_top_121/vpd[2]
+ openDVS_pixel2x2_top_121/vpd[3] openDVS_pixel2x2_top_121/vpd[1] openDVS_pixel2x2_top_121/vpd[0]
+ rowReadON<37> rowReadOFF<36> openDVS_pixel2x2_top_997/GndD DiffBn GndA OnBn VddA18
+ openDVS_pixel2x2_top
XopenDVS_pixel2x2_top_154 rowReadOFF<41> rowReadON<40> RefrBp PrBp PrSFBp col_periphery_1x2_18/COL_LINE0
+ pixRst<36> pixRst<37> col_periphery_1x2_18/COL_LINE1 OffBn openDVS_pixel2x2_top_154/vpd[2]
+ openDVS_pixel2x2_top_154/vpd[3] openDVS_pixel2x2_top_154/vpd[1] openDVS_pixel2x2_top_154/vpd[0]
+ rowReadON<41> rowReadOFF<40> openDVS_pixel2x2_top_535/GndD DiffBn GndA OnBn VddA18
+ openDVS_pixel2x2_top
XopenDVS_pixel2x2_top_110 rowReadOFF<55> rowReadON<54> RefrBp PrBp PrSFBp col_periphery_1x2_17/COL_LINE0
+ pixRst<34> pixRst<35> col_periphery_1x2_17/COL_LINE1 OffBn openDVS_pixel2x2_top_110/vpd[2]
+ openDVS_pixel2x2_top_110/vpd[3] openDVS_pixel2x2_top_110/vpd[1] openDVS_pixel2x2_top_110/vpd[0]
+ rowReadON<55> rowReadOFF<54> openDVS_pixel2x2_top_67/GndD DiffBn GndA OnBn VddA18
+ openDVS_pixel2x2_top
XopenDVS_pixel2x2_top_132 rowReadOFF<43> rowReadON<42> RefrBp PrBp PrSFBp col_periphery_1x2_22/COL_LINE0
+ pixRst<44> pixRst<45> col_periphery_1x2_22/COL_LINE1 OffBn openDVS_pixel2x2_top_132/vpd[2]
+ openDVS_pixel2x2_top_132/vpd[3] openDVS_pixel2x2_top_132/vpd[1] openDVS_pixel2x2_top_132/vpd[0]
+ rowReadON<43> rowReadOFF<42> openDVS_pixel2x2_top_537/GndD DiffBn GndA OnBn VddA18
+ openDVS_pixel2x2_top
XopenDVS_pixel2x2_top_198 rowReadOFF<29> rowReadON<28> RefrBp PrBp PrSFBp col_periphery_1x2_30/COL_LINE0
+ pixRst<62> pixRst<63> col_periphery_1x2_30/COL_LINE1 OffBn openDVS_pixel2x2_top_198/vpd[2]
+ openDVS_pixel2x2_top_198/vpd[3] openDVS_pixel2x2_top_198/vpd[1] openDVS_pixel2x2_top_198/vpd[0]
+ rowReadON<29> rowReadOFF<28> openDVS_pixel2x2_top_989/GndD DiffBn GndA OnBn VddA18
+ openDVS_pixel2x2_top
Xcol_periphery_1x2_7 pixRst<17> col_periphery_1x2_7/COL_LINE0 col_periphery_1x2_7/COL_LINE1
+ nDETECT DETECT col_periphery_1x2_9/VDD VTHRESH pixRst<16> voutn<16> GndA voutn<17>
+ NCHARGE col_periphery_1x2
XopenDVS_pixel2x2_top_1000 rowReadOFF<41> rowReadON<40> RefrBp PrBp PrSFBp col_periphery_1x2_14/COL_LINE0
+ pixRst<30> pixRst<31> col_periphery_1x2_14/COL_LINE1 OffBn openDVS_pixel2x2_top_1000/vpd[2]
+ openDVS_pixel2x2_top_1000/vpd[3] openDVS_pixel2x2_top_1000/vpd[1] openDVS_pixel2x2_top_1000/vpd[0]
+ rowReadON<41> rowReadOFF<40> openDVS_pixel2x2_top_535/GndD DiffBn GndA OnBn VddA18
+ openDVS_pixel2x2_top
XopenDVS_pixel2x2_top_1022 rowReadOFF<63> rowReadON<62> RefrBp PrBp PrSFBp col_periphery_1x2_14/COL_LINE0
+ pixRst<30> pixRst<31> col_periphery_1x2_14/COL_LINE1 OffBn openDVS_pixel2x2_top_1022/vpd[2]
+ openDVS_pixel2x2_top_1022/vpd[3] openDVS_pixel2x2_top_1022/vpd[1] openDVS_pixel2x2_top_1022/vpd[0]
+ rowReadON<63> rowReadOFF<62> openDVS_pixel2x2_top_82/GndD DiffBn GndA OnBn VddA18
+ openDVS_pixel2x2_top
XopenDVS_pixel2x2_top_27 rowReadOFF<61> rowReadON<60> RefrBp PrBp PrSFBp col_periphery_1x2_25/COL_LINE0
+ pixRst<52> pixRst<53> col_periphery_1x2_25/COL_LINE1 OffBn openDVS_pixel2x2_top_27/vpd[2]
+ openDVS_pixel2x2_top_27/vpd[3] openDVS_pixel2x2_top_27/vpd[1] openDVS_pixel2x2_top_27/vpd[0]
+ rowReadON<61> rowReadOFF<60> openDVS_pixel2x2_top_96/GndD DiffBn GndA OnBn VddA18
+ openDVS_pixel2x2_top
XopenDVS_pixel2x2_top_49 rowReadOFF<59> rowReadON<58> RefrBp PrBp PrSFBp col_periphery_1x2_26/COL_LINE0
+ pixRst<54> pixRst<55> col_periphery_1x2_26/COL_LINE1 OffBn openDVS_pixel2x2_top_49/vpd[2]
+ openDVS_pixel2x2_top_49/vpd[3] openDVS_pixel2x2_top_49/vpd[1] openDVS_pixel2x2_top_49/vpd[0]
+ rowReadON<59> rowReadOFF<58> openDVS_pixel2x2_top_74/GndD DiffBn GndA OnBn VddA18
+ openDVS_pixel2x2_top
XopenDVS_pixel2x2_top_16 rowReadOFF<55> rowReadON<54> RefrBp PrBp PrSFBp col_periphery_1x2_27/COL_LINE0
+ pixRst<56> pixRst<57> col_periphery_1x2_27/COL_LINE1 OffBn openDVS_pixel2x2_top_16/vpd[2]
+ openDVS_pixel2x2_top_16/vpd[3] openDVS_pixel2x2_top_16/vpd[1] openDVS_pixel2x2_top_16/vpd[0]
+ rowReadON<55> rowReadOFF<54> openDVS_pixel2x2_top_67/GndD DiffBn GndA OnBn VddA18
+ openDVS_pixel2x2_top
XopenDVS_pixel2x2_top_38 rowReadOFF<55> rowReadON<54> RefrBp PrBp PrSFBp col_periphery_1x2_30/COL_LINE0
+ pixRst<62> pixRst<63> col_periphery_1x2_30/COL_LINE1 OffBn openDVS_pixel2x2_top_38/vpd[2]
+ openDVS_pixel2x2_top_38/vpd[3] openDVS_pixel2x2_top_38/vpd[1] openDVS_pixel2x2_top_38/vpd[0]
+ rowReadON<55> rowReadOFF<54> openDVS_pixel2x2_top_67/GndD DiffBn GndA OnBn VddA18
+ openDVS_pixel2x2_top
XopenDVS_pixel2x2_top_1011 rowReadOFF<51> rowReadON<50> RefrBp PrBp PrSFBp col_periphery_1x2_16/COL_LINE0
+ pixRst<32> pixRst<33> col_periphery_1x2_16/COL_LINE1 OffBn openDVS_pixel2x2_top_1011/vpd[2]
+ openDVS_pixel2x2_top_1011/vpd[3] openDVS_pixel2x2_top_1011/vpd[1] openDVS_pixel2x2_top_1011/vpd[0]
+ rowReadON<51> rowReadOFF<50> openDVS_pixel2x2_top_6/GndD DiffBn GndA OnBn VddA18
+ openDVS_pixel2x2_top
XopenDVS_pixel2x2_top_709 rowReadOFF<9> rowReadON<8> RefrBp PrBp PrSFBp col_periphery_1x2_15/COL_LINE0
+ pixRst<14> pixRst<15> col_periphery_1x2_15/COL_LINE1 OffBn openDVS_pixel2x2_top_709/vpd[2]
+ openDVS_pixel2x2_top_709/vpd[3] openDVS_pixel2x2_top_709/vpd[1] openDVS_pixel2x2_top_709/vpd[0]
+ rowReadON<9> rowReadOFF<8> openDVS_pixel2x2_top_939/GndD DiffBn GndA OnBn VddA18
+ openDVS_pixel2x2_top
XopenDVS_pixel2x2_top_528 rowReadOFF<37> rowReadON<36> RefrBp PrBp PrSFBp col_periphery_1x2_15/COL_LINE0
+ pixRst<14> pixRst<15> col_periphery_1x2_15/COL_LINE1 OffBn openDVS_pixel2x2_top_528/vpd[2]
+ openDVS_pixel2x2_top_528/vpd[3] openDVS_pixel2x2_top_528/vpd[1] openDVS_pixel2x2_top_528/vpd[0]
+ rowReadON<37> rowReadOFF<36> openDVS_pixel2x2_top_997/GndD DiffBn GndA OnBn VddA18
+ openDVS_pixel2x2_top
XopenDVS_pixel2x2_top_517 rowReadOFF<57> rowReadON<56> RefrBp PrBp PrSFBp col_periphery_1x2_7/COL_LINE0
+ pixRst<16> pixRst<17> col_periphery_1x2_7/COL_LINE1 OffBn openDVS_pixel2x2_top_517/vpd[2]
+ openDVS_pixel2x2_top_517/vpd[3] openDVS_pixel2x2_top_517/vpd[1] openDVS_pixel2x2_top_517/vpd[0]
+ rowReadON<57> rowReadOFF<56> openDVS_pixel2x2_top_9/GndD DiffBn GndA OnBn VddA18
+ openDVS_pixel2x2_top
XopenDVS_pixel2x2_top_539 rowReadOFF<45> rowReadON<44> RefrBp PrBp PrSFBp col_periphery_1x2_3/COL_LINE0
+ pixRst<2> pixRst<3> col_periphery_1x2_3/COL_LINE1 OffBn openDVS_pixel2x2_top_539/vpd[2]
+ openDVS_pixel2x2_top_539/vpd[3] openDVS_pixel2x2_top_539/vpd[1] openDVS_pixel2x2_top_539/vpd[0]
+ rowReadON<45> rowReadOFF<44> openDVS_pixel2x2_top_539/GndD DiffBn GndA OnBn VddA18
+ openDVS_pixel2x2_top
XopenDVS_pixel2x2_top_506 rowReadOFF<49> rowReadON<48> RefrBp PrBp PrSFBp col_periphery_1x2_15/COL_LINE0
+ pixRst<14> pixRst<15> col_periphery_1x2_15/COL_LINE1 OffBn openDVS_pixel2x2_top_506/vpd[2]
+ openDVS_pixel2x2_top_506/vpd[3] openDVS_pixel2x2_top_506/vpd[1] openDVS_pixel2x2_top_506/vpd[0]
+ rowReadON<49> rowReadOFF<48> openDVS_pixel2x2_top_3/GndD DiffBn GndA OnBn VddA18
+ openDVS_pixel2x2_top
XopenDVS_pixel2x2_top_303 rowReadOFF<53> rowReadON<52> RefrBp PrBp PrSFBp col_periphery_1x2_11/COL_LINE0
+ pixRst<24> pixRst<25> col_periphery_1x2_11/COL_LINE1 OffBn openDVS_pixel2x2_top_303/vpd[2]
+ openDVS_pixel2x2_top_303/vpd[3] openDVS_pixel2x2_top_303/vpd[1] openDVS_pixel2x2_top_303/vpd[0]
+ rowReadON<53> rowReadOFF<52> openDVS_pixel2x2_top_99/GndD DiffBn GndA OnBn VddA18
+ openDVS_pixel2x2_top
XopenDVS_pixel2x2_top_325 rowReadOFF<61> rowReadON<60> RefrBp PrBp PrSFBp col_periphery_1x2_0/COL_LINE0
+ pixRst<10> pixRst<11> col_periphery_1x2_0/COL_LINE1 OffBn openDVS_pixel2x2_top_325/vpd[2]
+ openDVS_pixel2x2_top_325/vpd[3] openDVS_pixel2x2_top_325/vpd[1] openDVS_pixel2x2_top_325/vpd[0]
+ rowReadON<61> rowReadOFF<60> openDVS_pixel2x2_top_96/GndD DiffBn GndA OnBn VddA18
+ openDVS_pixel2x2_top
XopenDVS_pixel2x2_top_336 rowReadOFF<61> rowReadON<60> RefrBp PrBp PrSFBp col_periphery_1x2_4/COL_LINE0
+ pixRst<4> pixRst<5> col_periphery_1x2_4/COL_LINE1 OffBn openDVS_pixel2x2_top_336/vpd[2]
+ openDVS_pixel2x2_top_336/vpd[3] openDVS_pixel2x2_top_336/vpd[1] openDVS_pixel2x2_top_336/vpd[0]
+ rowReadON<61> rowReadOFF<60> openDVS_pixel2x2_top_96/GndD DiffBn GndA OnBn VddA18
+ openDVS_pixel2x2_top
XopenDVS_pixel2x2_top_369 rowReadOFF<53> rowReadON<52> RefrBp PrBp PrSFBp col_periphery_1x2_2/COL_LINE0
+ pixRst<0> pixRst<1> col_periphery_1x2_2/COL_LINE1 OffBn openDVS_pixel2x2_top_369/vpd[2]
+ openDVS_pixel2x2_top_369/vpd[3] openDVS_pixel2x2_top_369/vpd[1] openDVS_pixel2x2_top_369/vpd[0]
+ rowReadON<53> rowReadOFF<52> openDVS_pixel2x2_top_99/GndD DiffBn GndA OnBn VddA18
+ openDVS_pixel2x2_top
XopenDVS_pixel2x2_top_358 rowReadOFF<51> rowReadON<50> RefrBp PrBp PrSFBp col_periphery_1x2_2/COL_LINE0
+ pixRst<0> pixRst<1> col_periphery_1x2_2/COL_LINE1 OffBn openDVS_pixel2x2_top_358/vpd[2]
+ openDVS_pixel2x2_top_358/vpd[3] openDVS_pixel2x2_top_358/vpd[1] openDVS_pixel2x2_top_358/vpd[0]
+ rowReadON<51> rowReadOFF<50> openDVS_pixel2x2_top_6/GndD DiffBn GndA OnBn VddA18
+ openDVS_pixel2x2_top
XopenDVS_pixel2x2_top_347 rowReadOFF<49> rowReadON<48> RefrBp PrBp PrSFBp col_periphery_1x2_2/COL_LINE0
+ pixRst<0> pixRst<1> col_periphery_1x2_2/COL_LINE1 OffBn openDVS_pixel2x2_top_347/vpd[2]
+ openDVS_pixel2x2_top_347/vpd[3] openDVS_pixel2x2_top_347/vpd[1] openDVS_pixel2x2_top_347/vpd[0]
+ rowReadON<49> rowReadOFF<48> openDVS_pixel2x2_top_3/GndD DiffBn GndA OnBn VddA18
+ openDVS_pixel2x2_top
XopenDVS_pixel2x2_top_314 rowReadOFF<49> rowReadON<48> RefrBp PrBp PrSFBp col_periphery_1x2_11/COL_LINE0
+ pixRst<24> pixRst<25> col_periphery_1x2_11/COL_LINE1 OffBn openDVS_pixel2x2_top_314/vpd[2]
+ openDVS_pixel2x2_top_314/vpd[3] openDVS_pixel2x2_top_314/vpd[1] openDVS_pixel2x2_top_314/vpd[0]
+ rowReadON<49> rowReadOFF<48> openDVS_pixel2x2_top_3/GndD DiffBn GndA OnBn VddA18
+ openDVS_pixel2x2_top
XopenDVS_pixel2x2_top_870 rowReadOFF<1> rowReadON<0> RefrBp PrBp PrSFBp col_periphery_1x2_26/COL_LINE0
+ pixRst<54> pixRst<55> col_periphery_1x2_26/COL_LINE1 OffBn openDVS_pixel2x2_top_870/vpd[2]
+ openDVS_pixel2x2_top_870/vpd[3] openDVS_pixel2x2_top_870/vpd[1] openDVS_pixel2x2_top_870/vpd[0]
+ rowReadON<1> rowReadOFF<0> openDVS_pixel2x2_top_931/GndD DiffBn GndA OnBn VddA18
+ openDVS_pixel2x2_top
XopenDVS_pixel2x2_top_881 rowReadOFF<7> rowReadON<6> RefrBp PrBp PrSFBp col_periphery_1x2_17/COL_LINE0
+ pixRst<34> pixRst<35> col_periphery_1x2_17/COL_LINE1 OffBn openDVS_pixel2x2_top_881/vpd[2]
+ openDVS_pixel2x2_top_881/vpd[3] openDVS_pixel2x2_top_881/vpd[1] openDVS_pixel2x2_top_881/vpd[0]
+ rowReadON<7> rowReadOFF<6> openDVS_pixel2x2_top_937/GndD DiffBn GndA OnBn VddA18
+ openDVS_pixel2x2_top
XopenDVS_pixel2x2_top_892 rowReadOFF<23> rowReadON<22> RefrBp PrBp PrSFBp col_periphery_1x2_31/COL_LINE0
+ pixRst<48> pixRst<49> col_periphery_1x2_31/COL_LINE1 OffBn openDVS_pixel2x2_top_892/vpd[2]
+ openDVS_pixel2x2_top_892/vpd[3] openDVS_pixel2x2_top_892/vpd[1] openDVS_pixel2x2_top_892/vpd[0]
+ rowReadON<23> rowReadOFF<22> openDVS_pixel2x2_top_953/GndD DiffBn GndA OnBn VddA18
+ openDVS_pixel2x2_top
XopenDVS_pixel2x2_top_188 rowReadOFF<29> rowReadON<28> RefrBp PrBp PrSFBp col_periphery_1x2_27/COL_LINE0
+ pixRst<56> pixRst<57> col_periphery_1x2_27/COL_LINE1 OffBn openDVS_pixel2x2_top_188/vpd[2]
+ openDVS_pixel2x2_top_188/vpd[3] openDVS_pixel2x2_top_188/vpd[1] openDVS_pixel2x2_top_188/vpd[0]
+ rowReadON<29> rowReadOFF<28> openDVS_pixel2x2_top_989/GndD DiffBn GndA OnBn VddA18
+ openDVS_pixel2x2_top
XopenDVS_pixel2x2_top_133 rowReadOFF<31> rowReadON<30> RefrBp PrBp PrSFBp col_periphery_1x2_21/COL_LINE0
+ pixRst<42> pixRst<43> col_periphery_1x2_21/COL_LINE1 OffBn openDVS_pixel2x2_top_133/vpd[2]
+ openDVS_pixel2x2_top_133/vpd[3] openDVS_pixel2x2_top_133/vpd[1] openDVS_pixel2x2_top_133/vpd[0]
+ rowReadON<31> rowReadOFF<30> openDVS_pixel2x2_top_991/GndD DiffBn GndA OnBn VddA18
+ openDVS_pixel2x2_top
XopenDVS_pixel2x2_top_144 rowReadOFF<29> rowReadON<28> RefrBp PrBp PrSFBp col_periphery_1x2_20/COL_LINE0
+ pixRst<40> pixRst<41> col_periphery_1x2_20/COL_LINE1 OffBn openDVS_pixel2x2_top_144/vpd[2]
+ openDVS_pixel2x2_top_144/vpd[3] openDVS_pixel2x2_top_144/vpd[1] openDVS_pixel2x2_top_144/vpd[0]
+ rowReadON<29> rowReadOFF<28> openDVS_pixel2x2_top_989/GndD DiffBn GndA OnBn VddA18
+ openDVS_pixel2x2_top
XopenDVS_pixel2x2_top_177 rowReadOFF<33> rowReadON<32> RefrBp PrBp PrSFBp col_periphery_1x2_26/COL_LINE0
+ pixRst<54> pixRst<55> col_periphery_1x2_26/COL_LINE1 OffBn openDVS_pixel2x2_top_177/vpd[2]
+ openDVS_pixel2x2_top_177/vpd[3] openDVS_pixel2x2_top_177/vpd[1] openDVS_pixel2x2_top_177/vpd[0]
+ rowReadON<33> rowReadOFF<32> openDVS_pixel2x2_top_993/GndD DiffBn GndA OnBn VddA18
+ openDVS_pixel2x2_top
XopenDVS_pixel2x2_top_199 rowReadOFF<33> rowReadON<32> RefrBp PrBp PrSFBp col_periphery_1x2_27/COL_LINE0
+ pixRst<56> pixRst<57> col_periphery_1x2_27/COL_LINE1 OffBn openDVS_pixel2x2_top_199/vpd[2]
+ openDVS_pixel2x2_top_199/vpd[3] openDVS_pixel2x2_top_199/vpd[1] openDVS_pixel2x2_top_199/vpd[0]
+ rowReadON<33> rowReadOFF<32> openDVS_pixel2x2_top_993/GndD DiffBn GndA OnBn VddA18
+ openDVS_pixel2x2_top
XopenDVS_pixel2x2_top_166 rowReadOFF<35> rowReadON<34> RefrBp PrBp PrSFBp col_periphery_1x2_27/COL_LINE0
+ pixRst<56> pixRst<57> col_periphery_1x2_27/COL_LINE1 OffBn openDVS_pixel2x2_top_166/vpd[2]
+ openDVS_pixel2x2_top_166/vpd[3] openDVS_pixel2x2_top_166/vpd[1] openDVS_pixel2x2_top_166/vpd[0]
+ rowReadON<35> rowReadOFF<34> openDVS_pixel2x2_top_995/GndD DiffBn GndA OnBn VddA18
+ openDVS_pixel2x2_top
XopenDVS_pixel2x2_top_122 rowReadOFF<37> rowReadON<36> RefrBp PrBp PrSFBp col_periphery_1x2_22/COL_LINE0
+ pixRst<44> pixRst<45> col_periphery_1x2_22/COL_LINE1 OffBn openDVS_pixel2x2_top_122/vpd[2]
+ openDVS_pixel2x2_top_122/vpd[3] openDVS_pixel2x2_top_122/vpd[1] openDVS_pixel2x2_top_122/vpd[0]
+ rowReadON<37> rowReadOFF<36> openDVS_pixel2x2_top_997/GndD DiffBn GndA OnBn VddA18
+ openDVS_pixel2x2_top
XopenDVS_pixel2x2_top_155 rowReadOFF<41> rowReadON<40> RefrBp PrBp PrSFBp col_periphery_1x2_19/COL_LINE0
+ pixRst<38> pixRst<39> col_periphery_1x2_19/COL_LINE1 OffBn openDVS_pixel2x2_top_155/vpd[2]
+ openDVS_pixel2x2_top_155/vpd[3] openDVS_pixel2x2_top_155/vpd[1] openDVS_pixel2x2_top_155/vpd[0]
+ rowReadON<41> rowReadOFF<40> openDVS_pixel2x2_top_535/GndD DiffBn GndA OnBn VddA18
+ openDVS_pixel2x2_top
XopenDVS_pixel2x2_top_100 rowReadOFF<53> rowReadON<52> RefrBp PrBp PrSFBp col_periphery_1x2_19/COL_LINE0
+ pixRst<38> pixRst<39> col_periphery_1x2_19/COL_LINE1 OffBn openDVS_pixel2x2_top_100/vpd[2]
+ openDVS_pixel2x2_top_100/vpd[3] openDVS_pixel2x2_top_100/vpd[1] openDVS_pixel2x2_top_100/vpd[0]
+ rowReadON<53> rowReadOFF<52> openDVS_pixel2x2_top_99/GndD DiffBn GndA OnBn VddA18
+ openDVS_pixel2x2_top
XopenDVS_pixel2x2_top_111 rowReadOFF<51> rowReadON<50> RefrBp PrBp PrSFBp col_periphery_1x2_20/COL_LINE0
+ pixRst<40> pixRst<41> col_periphery_1x2_20/COL_LINE1 OffBn openDVS_pixel2x2_top_111/vpd[2]
+ openDVS_pixel2x2_top_111/vpd[3] openDVS_pixel2x2_top_111/vpd[1] openDVS_pixel2x2_top_111/vpd[0]
+ rowReadON<51> rowReadOFF<50> openDVS_pixel2x2_top_6/GndD DiffBn GndA OnBn VddA18
+ openDVS_pixel2x2_top
Xcol_periphery_1x2_8 pixRst<19> col_periphery_1x2_8/COL_LINE0 col_periphery_1x2_8/COL_LINE1
+ nDETECT DETECT col_periphery_1x2_9/VDD VTHRESH pixRst<18> voutn<18> GndA voutn<19>
+ NCHARGE col_periphery_1x2
XopenDVS_pixel2x2_top_1001 rowReadOFF<41> rowReadON<40> RefrBp PrBp PrSFBp col_periphery_1x2_16/COL_LINE0
+ pixRst<32> pixRst<33> col_periphery_1x2_16/COL_LINE1 OffBn openDVS_pixel2x2_top_1001/vpd[2]
+ openDVS_pixel2x2_top_1001/vpd[3] openDVS_pixel2x2_top_1001/vpd[1] openDVS_pixel2x2_top_1001/vpd[0]
+ rowReadON<41> rowReadOFF<40> openDVS_pixel2x2_top_535/GndD DiffBn GndA OnBn VddA18
+ openDVS_pixel2x2_top
XopenDVS_pixel2x2_top_1012 rowReadOFF<53> rowReadON<52> RefrBp PrBp PrSFBp col_periphery_1x2_14/COL_LINE0
+ pixRst<30> pixRst<31> col_periphery_1x2_14/COL_LINE1 OffBn openDVS_pixel2x2_top_1012/vpd[2]
+ openDVS_pixel2x2_top_1012/vpd[3] openDVS_pixel2x2_top_1012/vpd[1] openDVS_pixel2x2_top_1012/vpd[0]
+ rowReadON<53> rowReadOFF<52> openDVS_pixel2x2_top_99/GndD DiffBn GndA OnBn VddA18
+ openDVS_pixel2x2_top
XopenDVS_pixel2x2_top_1023 rowReadOFF<63> rowReadON<62> RefrBp PrBp PrSFBp col_periphery_1x2_16/COL_LINE0
+ pixRst<32> pixRst<33> col_periphery_1x2_16/COL_LINE1 OffBn openDVS_pixel2x2_top_1023/vpd[2]
+ openDVS_pixel2x2_top_1023/vpd[3] openDVS_pixel2x2_top_1023/vpd[1] openDVS_pixel2x2_top_1023/vpd[0]
+ rowReadON<63> rowReadOFF<62> openDVS_pixel2x2_top_82/GndD DiffBn GndA OnBn VddA18
+ openDVS_pixel2x2_top
XopenDVS_pixel2x2_top_17 rowReadOFF<53> rowReadON<52> RefrBp PrBp PrSFBp col_periphery_1x2_24/COL_LINE0
+ pixRst<50> pixRst<51> col_periphery_1x2_24/COL_LINE1 OffBn openDVS_pixel2x2_top_17/vpd[2]
+ openDVS_pixel2x2_top_17/vpd[3] openDVS_pixel2x2_top_17/vpd[1] openDVS_pixel2x2_top_17/vpd[0]
+ rowReadON<53> rowReadOFF<52> openDVS_pixel2x2_top_99/GndD DiffBn GndA OnBn VddA18
+ openDVS_pixel2x2_top
XopenDVS_pixel2x2_top_39 rowReadOFF<59> rowReadON<58> RefrBp PrBp PrSFBp col_periphery_1x2_27/COL_LINE0
+ pixRst<56> pixRst<57> col_periphery_1x2_27/COL_LINE1 OffBn openDVS_pixel2x2_top_39/vpd[2]
+ openDVS_pixel2x2_top_39/vpd[3] openDVS_pixel2x2_top_39/vpd[1] openDVS_pixel2x2_top_39/vpd[0]
+ rowReadON<59> rowReadOFF<58> openDVS_pixel2x2_top_74/GndD DiffBn GndA OnBn VddA18
+ openDVS_pixel2x2_top
XopenDVS_pixel2x2_top_28 rowReadOFF<57> rowReadON<56> RefrBp PrBp PrSFBp col_periphery_1x2_30/COL_LINE0
+ pixRst<62> pixRst<63> col_periphery_1x2_30/COL_LINE1 OffBn openDVS_pixel2x2_top_28/vpd[2]
+ openDVS_pixel2x2_top_28/vpd[3] openDVS_pixel2x2_top_28/vpd[1] openDVS_pixel2x2_top_28/vpd[0]
+ rowReadON<57> rowReadOFF<56> openDVS_pixel2x2_top_9/GndD DiffBn GndA OnBn VddA18
+ openDVS_pixel2x2_top
XopenDVS_pixel2x2_top_529 rowReadOFF<37> rowReadON<36> RefrBp PrBp PrSFBp col_periphery_1x2_7/COL_LINE0
+ pixRst<16> pixRst<17> col_periphery_1x2_7/COL_LINE1 OffBn openDVS_pixel2x2_top_529/vpd[2]
+ openDVS_pixel2x2_top_529/vpd[3] openDVS_pixel2x2_top_529/vpd[1] openDVS_pixel2x2_top_529/vpd[0]
+ rowReadON<37> rowReadOFF<36> openDVS_pixel2x2_top_997/GndD DiffBn GndA OnBn VddA18
+ openDVS_pixel2x2_top
XopenDVS_pixel2x2_top_518 rowReadOFF<59> rowReadON<58> RefrBp PrBp PrSFBp col_periphery_1x2_15/COL_LINE0
+ pixRst<14> pixRst<15> col_periphery_1x2_15/COL_LINE1 OffBn openDVS_pixel2x2_top_518/vpd[2]
+ openDVS_pixel2x2_top_518/vpd[3] openDVS_pixel2x2_top_518/vpd[1] openDVS_pixel2x2_top_518/vpd[0]
+ rowReadON<59> rowReadOFF<58> openDVS_pixel2x2_top_74/GndD DiffBn GndA OnBn VddA18
+ openDVS_pixel2x2_top
XopenDVS_pixel2x2_top_507 rowReadOFF<49> rowReadON<48> RefrBp PrBp PrSFBp col_periphery_1x2_7/COL_LINE0
+ pixRst<16> pixRst<17> col_periphery_1x2_7/COL_LINE1 OffBn openDVS_pixel2x2_top_507/vpd[2]
+ openDVS_pixel2x2_top_507/vpd[3] openDVS_pixel2x2_top_507/vpd[1] openDVS_pixel2x2_top_507/vpd[0]
+ rowReadON<49> rowReadOFF<48> openDVS_pixel2x2_top_3/GndD DiffBn GndA OnBn VddA18
+ openDVS_pixel2x2_top
XopenDVS_pixel2x2_top_304 rowReadOFF<53> rowReadON<52> RefrBp PrBp PrSFBp col_periphery_1x2_12/COL_LINE0
+ pixRst<26> pixRst<27> col_periphery_1x2_12/COL_LINE1 OffBn openDVS_pixel2x2_top_304/vpd[2]
+ openDVS_pixel2x2_top_304/vpd[3] openDVS_pixel2x2_top_304/vpd[1] openDVS_pixel2x2_top_304/vpd[0]
+ rowReadON<53> rowReadOFF<52> openDVS_pixel2x2_top_99/GndD DiffBn GndA OnBn VddA18
+ openDVS_pixel2x2_top
XopenDVS_pixel2x2_top_326 rowReadOFF<61> rowReadON<60> RefrBp PrBp PrSFBp col_periphery_1x2_1/COL_LINE0
+ pixRst<12> pixRst<13> col_periphery_1x2_1/COL_LINE1 OffBn openDVS_pixel2x2_top_326/vpd[2]
+ openDVS_pixel2x2_top_326/vpd[3] openDVS_pixel2x2_top_326/vpd[1] openDVS_pixel2x2_top_326/vpd[0]
+ rowReadON<61> rowReadOFF<60> openDVS_pixel2x2_top_96/GndD DiffBn GndA OnBn VddA18
+ openDVS_pixel2x2_top
XopenDVS_pixel2x2_top_359 rowReadOFF<51> rowReadON<50> RefrBp PrBp PrSFBp col_periphery_1x2_3/COL_LINE0
+ pixRst<2> pixRst<3> col_periphery_1x2_3/COL_LINE1 OffBn openDVS_pixel2x2_top_359/vpd[2]
+ openDVS_pixel2x2_top_359/vpd[3] openDVS_pixel2x2_top_359/vpd[1] openDVS_pixel2x2_top_359/vpd[0]
+ rowReadON<51> rowReadOFF<50> openDVS_pixel2x2_top_6/GndD DiffBn GndA OnBn VddA18
+ openDVS_pixel2x2_top
XopenDVS_pixel2x2_top_348 rowReadOFF<49> rowReadON<48> RefrBp PrBp PrSFBp col_periphery_1x2_3/COL_LINE0
+ pixRst<2> pixRst<3> col_periphery_1x2_3/COL_LINE1 OffBn openDVS_pixel2x2_top_348/vpd[2]
+ openDVS_pixel2x2_top_348/vpd[3] openDVS_pixel2x2_top_348/vpd[1] openDVS_pixel2x2_top_348/vpd[0]
+ rowReadON<49> rowReadOFF<48> openDVS_pixel2x2_top_3/GndD DiffBn GndA OnBn VddA18
+ openDVS_pixel2x2_top
XopenDVS_pixel2x2_top_337 rowReadOFF<47> rowReadON<46> RefrBp PrBp PrSFBp col_periphery_1x2_2/COL_LINE0
+ pixRst<0> pixRst<1> col_periphery_1x2_2/COL_LINE1 OffBn openDVS_pixel2x2_top_337/vpd[2]
+ openDVS_pixel2x2_top_337/vpd[3] openDVS_pixel2x2_top_337/vpd[1] openDVS_pixel2x2_top_337/vpd[0]
+ rowReadON<47> rowReadOFF<46> openDVS_pixel2x2_top_78/GndD DiffBn GndA OnBn VddA18
+ openDVS_pixel2x2_top
XopenDVS_pixel2x2_top_315 rowReadOFF<49> rowReadON<48> RefrBp PrBp PrSFBp col_periphery_1x2_12/COL_LINE0
+ pixRst<26> pixRst<27> col_periphery_1x2_12/COL_LINE1 OffBn openDVS_pixel2x2_top_315/vpd[2]
+ openDVS_pixel2x2_top_315/vpd[3] openDVS_pixel2x2_top_315/vpd[1] openDVS_pixel2x2_top_315/vpd[0]
+ rowReadON<49> rowReadOFF<48> openDVS_pixel2x2_top_3/GndD DiffBn GndA OnBn VddA18
+ openDVS_pixel2x2_top
XopenDVS_pixel2x2_top_860 rowReadOFF<3> rowReadON<2> RefrBp PrBp PrSFBp col_periphery_1x2_28/COL_LINE0
+ pixRst<58> pixRst<59> col_periphery_1x2_28/COL_LINE1 OffBn openDVS_pixel2x2_top_860/vpd[2]
+ openDVS_pixel2x2_top_860/vpd[3] openDVS_pixel2x2_top_860/vpd[1] openDVS_pixel2x2_top_860/vpd[0]
+ rowReadON<3> rowReadOFF<2> openDVS_pixel2x2_top_933/GndD DiffBn GndA OnBn VddA18
+ openDVS_pixel2x2_top
XopenDVS_pixel2x2_top_871 rowReadOFF<1> rowReadON<0> RefrBp PrBp PrSFBp col_periphery_1x2_27/COL_LINE0
+ pixRst<56> pixRst<57> col_periphery_1x2_27/COL_LINE1 OffBn openDVS_pixel2x2_top_871/vpd[2]
+ openDVS_pixel2x2_top_871/vpd[3] openDVS_pixel2x2_top_871/vpd[1] openDVS_pixel2x2_top_871/vpd[0]
+ rowReadON<1> rowReadOFF<0> openDVS_pixel2x2_top_931/GndD DiffBn GndA OnBn VddA18
+ openDVS_pixel2x2_top
XopenDVS_pixel2x2_top_893 rowReadOFF<1> rowReadON<0> RefrBp PrBp PrSFBp col_periphery_1x2_23/COL_LINE0
+ pixRst<46> pixRst<47> col_periphery_1x2_23/COL_LINE1 OffBn openDVS_pixel2x2_top_893/vpd[2]
+ openDVS_pixel2x2_top_893/vpd[3] openDVS_pixel2x2_top_893/vpd[1] openDVS_pixel2x2_top_893/vpd[0]
+ rowReadON<1> rowReadOFF<0> openDVS_pixel2x2_top_931/GndD DiffBn GndA OnBn VddA18
+ openDVS_pixel2x2_top
XopenDVS_pixel2x2_top_882 rowReadOFF<7> rowReadON<6> RefrBp PrBp PrSFBp col_periphery_1x2_18/COL_LINE0
+ pixRst<36> pixRst<37> col_periphery_1x2_18/COL_LINE1 OffBn openDVS_pixel2x2_top_882/vpd[2]
+ openDVS_pixel2x2_top_882/vpd[3] openDVS_pixel2x2_top_882/vpd[1] openDVS_pixel2x2_top_882/vpd[0]
+ rowReadON<7> rowReadOFF<6> openDVS_pixel2x2_top_937/GndD DiffBn GndA OnBn VddA18
+ openDVS_pixel2x2_top
XopenDVS_pixel2x2_top_189 rowReadOFF<29> rowReadON<28> RefrBp PrBp PrSFBp col_periphery_1x2_28/COL_LINE0
+ pixRst<58> pixRst<59> col_periphery_1x2_28/COL_LINE1 OffBn openDVS_pixel2x2_top_189/vpd[2]
+ openDVS_pixel2x2_top_189/vpd[3] openDVS_pixel2x2_top_189/vpd[1] openDVS_pixel2x2_top_189/vpd[0]
+ rowReadON<29> rowReadOFF<28> openDVS_pixel2x2_top_989/GndD DiffBn GndA OnBn VddA18
+ openDVS_pixel2x2_top
XopenDVS_pixel2x2_top_178 rowReadOFF<29> rowReadON<28> RefrBp PrBp PrSFBp col_periphery_1x2_24/COL_LINE0
+ pixRst<50> pixRst<51> col_periphery_1x2_24/COL_LINE1 OffBn openDVS_pixel2x2_top_178/vpd[2]
+ openDVS_pixel2x2_top_178/vpd[3] openDVS_pixel2x2_top_178/vpd[1] openDVS_pixel2x2_top_178/vpd[0]
+ rowReadON<29> rowReadOFF<28> openDVS_pixel2x2_top_989/GndD DiffBn GndA OnBn VddA18
+ openDVS_pixel2x2_top
XopenDVS_pixel2x2_top_134 rowReadOFF<31> rowReadON<30> RefrBp PrBp PrSFBp col_periphery_1x2_22/COL_LINE0
+ pixRst<44> pixRst<45> col_periphery_1x2_22/COL_LINE1 OffBn openDVS_pixel2x2_top_134/vpd[2]
+ openDVS_pixel2x2_top_134/vpd[3] openDVS_pixel2x2_top_134/vpd[1] openDVS_pixel2x2_top_134/vpd[0]
+ rowReadON<31> rowReadOFF<30> openDVS_pixel2x2_top_991/GndD DiffBn GndA OnBn VddA18
+ openDVS_pixel2x2_top
XopenDVS_pixel2x2_top_145 rowReadOFF<29> rowReadON<28> RefrBp PrBp PrSFBp col_periphery_1x2_21/COL_LINE0
+ pixRst<42> pixRst<43> col_periphery_1x2_21/COL_LINE1 OffBn openDVS_pixel2x2_top_145/vpd[2]
+ openDVS_pixel2x2_top_145/vpd[3] openDVS_pixel2x2_top_145/vpd[1] openDVS_pixel2x2_top_145/vpd[0]
+ rowReadON<29> rowReadOFF<28> openDVS_pixel2x2_top_989/GndD DiffBn GndA OnBn VddA18
+ openDVS_pixel2x2_top
XopenDVS_pixel2x2_top_123 rowReadOFF<31> rowReadON<30> RefrBp PrBp PrSFBp col_periphery_1x2_17/COL_LINE0
+ pixRst<34> pixRst<35> col_periphery_1x2_17/COL_LINE1 OffBn openDVS_pixel2x2_top_123/vpd[2]
+ openDVS_pixel2x2_top_123/vpd[3] openDVS_pixel2x2_top_123/vpd[1] openDVS_pixel2x2_top_123/vpd[0]
+ rowReadON<31> rowReadOFF<30> openDVS_pixel2x2_top_991/GndD DiffBn GndA OnBn VddA18
+ openDVS_pixel2x2_top
XopenDVS_pixel2x2_top_167 rowReadOFF<37> rowReadON<36> RefrBp PrBp PrSFBp col_periphery_1x2_24/COL_LINE0
+ pixRst<50> pixRst<51> col_periphery_1x2_24/COL_LINE1 OffBn openDVS_pixel2x2_top_167/vpd[2]
+ openDVS_pixel2x2_top_167/vpd[3] openDVS_pixel2x2_top_167/vpd[1] openDVS_pixel2x2_top_167/vpd[0]
+ rowReadON<37> rowReadOFF<36> openDVS_pixel2x2_top_997/GndD DiffBn GndA OnBn VddA18
+ openDVS_pixel2x2_top
XopenDVS_pixel2x2_top_156 rowReadOFF<41> rowReadON<40> RefrBp PrBp PrSFBp col_periphery_1x2_20/COL_LINE0
+ pixRst<40> pixRst<41> col_periphery_1x2_20/COL_LINE1 OffBn openDVS_pixel2x2_top_156/vpd[2]
+ openDVS_pixel2x2_top_156/vpd[3] openDVS_pixel2x2_top_156/vpd[1] openDVS_pixel2x2_top_156/vpd[0]
+ rowReadON<41> rowReadOFF<40> openDVS_pixel2x2_top_535/GndD DiffBn GndA OnBn VddA18
+ openDVS_pixel2x2_top
XopenDVS_pixel2x2_top_101 rowReadOFF<53> rowReadON<52> RefrBp PrBp PrSFBp col_periphery_1x2_20/COL_LINE0
+ pixRst<40> pixRst<41> col_periphery_1x2_20/COL_LINE1 OffBn openDVS_pixel2x2_top_101/vpd[2]
+ openDVS_pixel2x2_top_101/vpd[3] openDVS_pixel2x2_top_101/vpd[1] openDVS_pixel2x2_top_101/vpd[0]
+ rowReadON<53> rowReadOFF<52> openDVS_pixel2x2_top_99/GndD DiffBn GndA OnBn VddA18
+ openDVS_pixel2x2_top
XopenDVS_pixel2x2_top_112 rowReadOFF<51> rowReadON<50> RefrBp PrBp PrSFBp col_periphery_1x2_21/COL_LINE0
+ pixRst<42> pixRst<43> col_periphery_1x2_21/COL_LINE1 OffBn openDVS_pixel2x2_top_112/vpd[2]
+ openDVS_pixel2x2_top_112/vpd[3] openDVS_pixel2x2_top_112/vpd[1] openDVS_pixel2x2_top_112/vpd[0]
+ rowReadON<51> rowReadOFF<50> openDVS_pixel2x2_top_6/GndD DiffBn GndA OnBn VddA18
+ openDVS_pixel2x2_top
Xcol_periphery_1x2_9 pixRst<21> col_periphery_1x2_9/COL_LINE0 col_periphery_1x2_9/COL_LINE1
+ nDETECT DETECT col_periphery_1x2_9/VDD VTHRESH pixRst<20> voutn<20> GndA voutn<21>
+ NCHARGE col_periphery_1x2
XopenDVS_pixel2x2_top_690 rowReadOFF<7> rowReadON<6> RefrBp PrBp PrSFBp col_periphery_1x2_8/COL_LINE0
+ pixRst<18> pixRst<19> col_periphery_1x2_8/COL_LINE1 OffBn openDVS_pixel2x2_top_690/vpd[2]
+ openDVS_pixel2x2_top_690/vpd[3] openDVS_pixel2x2_top_690/vpd[1] openDVS_pixel2x2_top_690/vpd[0]
+ rowReadON<7> rowReadOFF<6> openDVS_pixel2x2_top_937/GndD DiffBn GndA OnBn VddA18
+ openDVS_pixel2x2_top
XopenDVS_pixel2x2_top_1013 rowReadOFF<53> rowReadON<52> RefrBp PrBp PrSFBp col_periphery_1x2_16/COL_LINE0
+ pixRst<32> pixRst<33> col_periphery_1x2_16/COL_LINE1 OffBn openDVS_pixel2x2_top_1013/vpd[2]
+ openDVS_pixel2x2_top_1013/vpd[3] openDVS_pixel2x2_top_1013/vpd[1] openDVS_pixel2x2_top_1013/vpd[0]
+ rowReadON<53> rowReadOFF<52> openDVS_pixel2x2_top_99/GndD DiffBn GndA OnBn VddA18
+ openDVS_pixel2x2_top
XopenDVS_pixel2x2_top_29 rowReadOFF<63> rowReadON<62> RefrBp PrBp PrSFBp col_periphery_1x2_25/COL_LINE0
+ pixRst<52> pixRst<53> col_periphery_1x2_25/COL_LINE1 OffBn openDVS_pixel2x2_top_29/vpd[2]
+ openDVS_pixel2x2_top_29/vpd[3] openDVS_pixel2x2_top_29/vpd[1] openDVS_pixel2x2_top_29/vpd[0]
+ rowReadON<63> rowReadOFF<62> openDVS_pixel2x2_top_82/GndD DiffBn GndA OnBn VddA18
+ openDVS_pixel2x2_top
XopenDVS_pixel2x2_top_18 rowReadOFF<53> rowReadON<52> RefrBp PrBp PrSFBp col_periphery_1x2_25/COL_LINE0
+ pixRst<52> pixRst<53> col_periphery_1x2_25/COL_LINE1 OffBn openDVS_pixel2x2_top_18/vpd[2]
+ openDVS_pixel2x2_top_18/vpd[3] openDVS_pixel2x2_top_18/vpd[1] openDVS_pixel2x2_top_18/vpd[0]
+ rowReadON<53> rowReadOFF<52> openDVS_pixel2x2_top_99/GndD DiffBn GndA OnBn VddA18
+ openDVS_pixel2x2_top
XopenDVS_pixel2x2_top_1002 rowReadOFF<43> rowReadON<42> RefrBp PrBp PrSFBp col_periphery_1x2_14/COL_LINE0
+ pixRst<30> pixRst<31> col_periphery_1x2_14/COL_LINE1 OffBn openDVS_pixel2x2_top_1002/vpd[2]
+ openDVS_pixel2x2_top_1002/vpd[3] openDVS_pixel2x2_top_1002/vpd[1] openDVS_pixel2x2_top_1002/vpd[0]
+ rowReadON<43> rowReadOFF<42> openDVS_pixel2x2_top_537/GndD DiffBn GndA OnBn VddA18
+ openDVS_pixel2x2_top
XopenDVS_pixel2x2_top_519 rowReadOFF<59> rowReadON<58> RefrBp PrBp PrSFBp col_periphery_1x2_7/COL_LINE0
+ pixRst<16> pixRst<17> col_periphery_1x2_7/COL_LINE1 OffBn openDVS_pixel2x2_top_519/vpd[2]
+ openDVS_pixel2x2_top_519/vpd[3] openDVS_pixel2x2_top_519/vpd[1] openDVS_pixel2x2_top_519/vpd[0]
+ rowReadON<59> rowReadOFF<58> openDVS_pixel2x2_top_74/GndD DiffBn GndA OnBn VddA18
+ openDVS_pixel2x2_top
XopenDVS_pixel2x2_top_508 rowReadOFF<51> rowReadON<50> RefrBp PrBp PrSFBp col_periphery_1x2_15/COL_LINE0
+ pixRst<14> pixRst<15> col_periphery_1x2_15/COL_LINE1 OffBn openDVS_pixel2x2_top_508/vpd[2]
+ openDVS_pixel2x2_top_508/vpd[3] openDVS_pixel2x2_top_508/vpd[1] openDVS_pixel2x2_top_508/vpd[0]
+ rowReadON<51> rowReadOFF<50> openDVS_pixel2x2_top_6/GndD DiffBn GndA OnBn VddA18
+ openDVS_pixel2x2_top
XopenDVS_pixel2x2_top_305 rowReadOFF<53> rowReadON<52> RefrBp PrBp PrSFBp col_periphery_1x2_13/COL_LINE0
+ pixRst<28> pixRst<29> col_periphery_1x2_13/COL_LINE1 OffBn openDVS_pixel2x2_top_305/vpd[2]
+ openDVS_pixel2x2_top_305/vpd[3] openDVS_pixel2x2_top_305/vpd[1] openDVS_pixel2x2_top_305/vpd[0]
+ rowReadON<53> rowReadOFF<52> openDVS_pixel2x2_top_99/GndD DiffBn GndA OnBn VddA18
+ openDVS_pixel2x2_top
XopenDVS_pixel2x2_top_327 rowReadOFF<61> rowReadON<60> RefrBp PrBp PrSFBp col_periphery_1x2_2/COL_LINE0
+ pixRst<0> pixRst<1> col_periphery_1x2_2/COL_LINE1 OffBn openDVS_pixel2x2_top_327/vpd[2]
+ openDVS_pixel2x2_top_327/vpd[3] openDVS_pixel2x2_top_327/vpd[1] openDVS_pixel2x2_top_327/vpd[0]
+ rowReadON<61> rowReadOFF<60> openDVS_pixel2x2_top_96/GndD DiffBn GndA OnBn VddA18
+ openDVS_pixel2x2_top
XopenDVS_pixel2x2_top_338 rowReadOFF<47> rowReadON<46> RefrBp PrBp PrSFBp col_periphery_1x2_3/COL_LINE0
+ pixRst<2> pixRst<3> col_periphery_1x2_3/COL_LINE1 OffBn openDVS_pixel2x2_top_338/vpd[2]
+ openDVS_pixel2x2_top_338/vpd[3] openDVS_pixel2x2_top_338/vpd[1] openDVS_pixel2x2_top_338/vpd[0]
+ rowReadON<47> rowReadOFF<46> openDVS_pixel2x2_top_78/GndD DiffBn GndA OnBn VddA18
+ openDVS_pixel2x2_top
XopenDVS_pixel2x2_top_349 rowReadOFF<49> rowReadON<48> RefrBp PrBp PrSFBp col_periphery_1x2_4/COL_LINE0
+ pixRst<4> pixRst<5> col_periphery_1x2_4/COL_LINE1 OffBn openDVS_pixel2x2_top_349/vpd[2]
+ openDVS_pixel2x2_top_349/vpd[3] openDVS_pixel2x2_top_349/vpd[1] openDVS_pixel2x2_top_349/vpd[0]
+ rowReadON<49> rowReadOFF<48> openDVS_pixel2x2_top_3/GndD DiffBn GndA OnBn VddA18
+ openDVS_pixel2x2_top
XopenDVS_pixel2x2_top_316 rowReadOFF<49> rowReadON<48> RefrBp PrBp PrSFBp col_periphery_1x2_13/COL_LINE0
+ pixRst<28> pixRst<29> col_periphery_1x2_13/COL_LINE1 OffBn openDVS_pixel2x2_top_316/vpd[2]
+ openDVS_pixel2x2_top_316/vpd[3] openDVS_pixel2x2_top_316/vpd[1] openDVS_pixel2x2_top_316/vpd[0]
+ rowReadON<49> rowReadOFF<48> openDVS_pixel2x2_top_3/GndD DiffBn GndA OnBn VddA18
+ openDVS_pixel2x2_top
XopenDVS_pixel2x2_top_861 rowReadOFF<3> rowReadON<2> RefrBp PrBp PrSFBp col_periphery_1x2_29/COL_LINE0
+ pixRst<60> pixRst<61> col_periphery_1x2_29/COL_LINE1 OffBn openDVS_pixel2x2_top_861/vpd[2]
+ openDVS_pixel2x2_top_861/vpd[3] openDVS_pixel2x2_top_861/vpd[1] openDVS_pixel2x2_top_861/vpd[0]
+ rowReadON<3> rowReadOFF<2> openDVS_pixel2x2_top_933/GndD DiffBn GndA OnBn VddA18
+ openDVS_pixel2x2_top
XopenDVS_pixel2x2_top_872 rowReadOFF<1> rowReadON<0> RefrBp PrBp PrSFBp col_periphery_1x2_28/COL_LINE0
+ pixRst<58> pixRst<59> col_periphery_1x2_28/COL_LINE1 OffBn openDVS_pixel2x2_top_872/vpd[2]
+ openDVS_pixel2x2_top_872/vpd[3] openDVS_pixel2x2_top_872/vpd[1] openDVS_pixel2x2_top_872/vpd[0]
+ rowReadON<1> rowReadOFF<0> openDVS_pixel2x2_top_931/GndD DiffBn GndA OnBn VddA18
+ openDVS_pixel2x2_top
XopenDVS_pixel2x2_top_894 rowReadOFF<1> rowReadON<0> RefrBp PrBp PrSFBp col_periphery_1x2_31/COL_LINE0
+ pixRst<48> pixRst<49> col_periphery_1x2_31/COL_LINE1 OffBn openDVS_pixel2x2_top_894/vpd[2]
+ openDVS_pixel2x2_top_894/vpd[3] openDVS_pixel2x2_top_894/vpd[1] openDVS_pixel2x2_top_894/vpd[0]
+ rowReadON<1> rowReadOFF<0> openDVS_pixel2x2_top_931/GndD DiffBn GndA OnBn VddA18
+ openDVS_pixel2x2_top
XopenDVS_pixel2x2_top_850 rowReadOFF<3> rowReadON<2> RefrBp PrBp PrSFBp col_periphery_1x2_21/COL_LINE0
+ pixRst<42> pixRst<43> col_periphery_1x2_21/COL_LINE1 OffBn openDVS_pixel2x2_top_850/vpd[2]
+ openDVS_pixel2x2_top_850/vpd[3] openDVS_pixel2x2_top_850/vpd[1] openDVS_pixel2x2_top_850/vpd[0]
+ rowReadON<3> rowReadOFF<2> openDVS_pixel2x2_top_933/GndD DiffBn GndA OnBn VddA18
+ openDVS_pixel2x2_top
XopenDVS_pixel2x2_top_883 rowReadOFF<7> rowReadON<6> RefrBp PrBp PrSFBp col_periphery_1x2_19/COL_LINE0
+ pixRst<38> pixRst<39> col_periphery_1x2_19/COL_LINE1 OffBn openDVS_pixel2x2_top_883/vpd[2]
+ openDVS_pixel2x2_top_883/vpd[3] openDVS_pixel2x2_top_883/vpd[1] openDVS_pixel2x2_top_883/vpd[0]
+ rowReadON<7> rowReadOFF<6> openDVS_pixel2x2_top_937/GndD DiffBn GndA OnBn VddA18
+ openDVS_pixel2x2_top
XopenDVS_pixel2x2_top_179 rowReadOFF<29> rowReadON<28> RefrBp PrBp PrSFBp col_periphery_1x2_25/COL_LINE0
+ pixRst<52> pixRst<53> col_periphery_1x2_25/COL_LINE1 OffBn openDVS_pixel2x2_top_179/vpd[2]
+ openDVS_pixel2x2_top_179/vpd[3] openDVS_pixel2x2_top_179/vpd[1] openDVS_pixel2x2_top_179/vpd[0]
+ rowReadON<29> rowReadOFF<28> openDVS_pixel2x2_top_989/GndD DiffBn GndA OnBn VddA18
+ openDVS_pixel2x2_top
XopenDVS_pixel2x2_top_146 rowReadOFF<29> rowReadON<28> RefrBp PrBp PrSFBp col_periphery_1x2_22/COL_LINE0
+ pixRst<44> pixRst<45> col_periphery_1x2_22/COL_LINE1 OffBn openDVS_pixel2x2_top_146/vpd[2]
+ openDVS_pixel2x2_top_146/vpd[3] openDVS_pixel2x2_top_146/vpd[1] openDVS_pixel2x2_top_146/vpd[0]
+ rowReadON<29> rowReadOFF<28> openDVS_pixel2x2_top_989/GndD DiffBn GndA OnBn VddA18
+ openDVS_pixel2x2_top
XopenDVS_pixel2x2_top_124 rowReadOFF<31> rowReadON<30> RefrBp PrBp PrSFBp col_periphery_1x2_18/COL_LINE0
+ pixRst<36> pixRst<37> col_periphery_1x2_18/COL_LINE1 OffBn openDVS_pixel2x2_top_124/vpd[2]
+ openDVS_pixel2x2_top_124/vpd[3] openDVS_pixel2x2_top_124/vpd[1] openDVS_pixel2x2_top_124/vpd[0]
+ rowReadON<31> rowReadOFF<30> openDVS_pixel2x2_top_991/GndD DiffBn GndA OnBn VddA18
+ openDVS_pixel2x2_top
XopenDVS_pixel2x2_top_135 rowReadOFF<29> rowReadON<28> RefrBp PrBp PrSFBp col_periphery_1x2_17/COL_LINE0
+ pixRst<34> pixRst<35> col_periphery_1x2_17/COL_LINE1 OffBn openDVS_pixel2x2_top_135/vpd[2]
+ openDVS_pixel2x2_top_135/vpd[3] openDVS_pixel2x2_top_135/vpd[1] openDVS_pixel2x2_top_135/vpd[0]
+ rowReadON<29> rowReadOFF<28> openDVS_pixel2x2_top_989/GndD DiffBn GndA OnBn VddA18
+ openDVS_pixel2x2_top
XopenDVS_pixel2x2_top_168 rowReadOFF<37> rowReadON<36> RefrBp PrBp PrSFBp col_periphery_1x2_25/COL_LINE0
+ pixRst<52> pixRst<53> col_periphery_1x2_25/COL_LINE1 OffBn openDVS_pixel2x2_top_168/vpd[2]
+ openDVS_pixel2x2_top_168/vpd[3] openDVS_pixel2x2_top_168/vpd[1] openDVS_pixel2x2_top_168/vpd[0]
+ rowReadON<37> rowReadOFF<36> openDVS_pixel2x2_top_997/GndD DiffBn GndA OnBn VddA18
+ openDVS_pixel2x2_top
XopenDVS_pixel2x2_top_157 rowReadOFF<41> rowReadON<40> RefrBp PrBp PrSFBp col_periphery_1x2_21/COL_LINE0
+ pixRst<42> pixRst<43> col_periphery_1x2_21/COL_LINE1 OffBn openDVS_pixel2x2_top_157/vpd[2]
+ openDVS_pixel2x2_top_157/vpd[3] openDVS_pixel2x2_top_157/vpd[1] openDVS_pixel2x2_top_157/vpd[0]
+ rowReadON<41> rowReadOFF<40> openDVS_pixel2x2_top_535/GndD DiffBn GndA OnBn VddA18
+ openDVS_pixel2x2_top
XopenDVS_pixel2x2_top_102 rowReadOFF<53> rowReadON<52> RefrBp PrBp PrSFBp col_periphery_1x2_21/COL_LINE0
+ pixRst<42> pixRst<43> col_periphery_1x2_21/COL_LINE1 OffBn openDVS_pixel2x2_top_102/vpd[2]
+ openDVS_pixel2x2_top_102/vpd[3] openDVS_pixel2x2_top_102/vpd[1] openDVS_pixel2x2_top_102/vpd[0]
+ rowReadON<53> rowReadOFF<52> openDVS_pixel2x2_top_99/GndD DiffBn GndA OnBn VddA18
+ openDVS_pixel2x2_top
XopenDVS_pixel2x2_top_113 rowReadOFF<51> rowReadON<50> RefrBp PrBp PrSFBp col_periphery_1x2_22/COL_LINE0
+ pixRst<44> pixRst<45> col_periphery_1x2_22/COL_LINE1 OffBn openDVS_pixel2x2_top_113/vpd[2]
+ openDVS_pixel2x2_top_113/vpd[3] openDVS_pixel2x2_top_113/vpd[1] openDVS_pixel2x2_top_113/vpd[0]
+ rowReadON<51> rowReadOFF<50> openDVS_pixel2x2_top_6/GndD DiffBn GndA OnBn VddA18
+ openDVS_pixel2x2_top
XopenDVS_pixel2x2_top_680 rowReadOFF<3> rowReadON<2> RefrBp PrBp PrSFBp col_periphery_1x2_12/COL_LINE0
+ pixRst<26> pixRst<27> col_periphery_1x2_12/COL_LINE1 OffBn openDVS_pixel2x2_top_680/vpd[2]
+ openDVS_pixel2x2_top_680/vpd[3] openDVS_pixel2x2_top_680/vpd[1] openDVS_pixel2x2_top_680/vpd[0]
+ rowReadON<3> rowReadOFF<2> openDVS_pixel2x2_top_933/GndD DiffBn GndA OnBn VddA18
+ openDVS_pixel2x2_top
XopenDVS_pixel2x2_top_691 rowReadOFF<7> rowReadON<6> RefrBp PrBp PrSFBp col_periphery_1x2_9/COL_LINE0
+ pixRst<20> pixRst<21> col_periphery_1x2_9/COL_LINE1 OffBn openDVS_pixel2x2_top_691/vpd[2]
+ openDVS_pixel2x2_top_691/vpd[3] openDVS_pixel2x2_top_691/vpd[1] openDVS_pixel2x2_top_691/vpd[0]
+ rowReadON<7> rowReadOFF<6> openDVS_pixel2x2_top_937/GndD DiffBn GndA OnBn VddA18
+ openDVS_pixel2x2_top
XopenDVS_pixel2x2_top_1014 rowReadOFF<55> rowReadON<54> RefrBp PrBp PrSFBp col_periphery_1x2_14/COL_LINE0
+ pixRst<30> pixRst<31> col_periphery_1x2_14/COL_LINE1 OffBn openDVS_pixel2x2_top_1014/vpd[2]
+ openDVS_pixel2x2_top_1014/vpd[3] openDVS_pixel2x2_top_1014/vpd[1] openDVS_pixel2x2_top_1014/vpd[0]
+ rowReadON<55> rowReadOFF<54> openDVS_pixel2x2_top_67/GndD DiffBn GndA OnBn VddA18
+ openDVS_pixel2x2_top
XopenDVS_pixel2x2_top_19 rowReadOFF<53> rowReadON<52> RefrBp PrBp PrSFBp col_periphery_1x2_26/COL_LINE0
+ pixRst<54> pixRst<55> col_periphery_1x2_26/COL_LINE1 OffBn openDVS_pixel2x2_top_19/vpd[2]
+ openDVS_pixel2x2_top_19/vpd[3] openDVS_pixel2x2_top_19/vpd[1] openDVS_pixel2x2_top_19/vpd[0]
+ rowReadON<53> rowReadOFF<52> openDVS_pixel2x2_top_99/GndD DiffBn GndA OnBn VddA18
+ openDVS_pixel2x2_top
XopenDVS_pixel2x2_top_1003 rowReadOFF<43> rowReadON<42> RefrBp PrBp PrSFBp col_periphery_1x2_16/COL_LINE0
+ pixRst<32> pixRst<33> col_periphery_1x2_16/COL_LINE1 OffBn openDVS_pixel2x2_top_1003/vpd[2]
+ openDVS_pixel2x2_top_1003/vpd[3] openDVS_pixel2x2_top_1003/vpd[1] openDVS_pixel2x2_top_1003/vpd[0]
+ rowReadON<43> rowReadOFF<42> openDVS_pixel2x2_top_537/GndD DiffBn GndA OnBn VddA18
+ openDVS_pixel2x2_top
XopenDVS_pixel2x2_top_509 rowReadOFF<51> rowReadON<50> RefrBp PrBp PrSFBp col_periphery_1x2_7/COL_LINE0
+ pixRst<16> pixRst<17> col_periphery_1x2_7/COL_LINE1 OffBn openDVS_pixel2x2_top_509/vpd[2]
+ openDVS_pixel2x2_top_509/vpd[3] openDVS_pixel2x2_top_509/vpd[1] openDVS_pixel2x2_top_509/vpd[0]
+ rowReadON<51> rowReadOFF<50> openDVS_pixel2x2_top_6/GndD DiffBn GndA OnBn VddA18
+ openDVS_pixel2x2_top
XopenDVS_pixel2x2_top_317 rowReadOFF<57> rowReadON<56> RefrBp PrBp PrSFBp col_periphery_1x2_12/COL_LINE0
+ pixRst<26> pixRst<27> col_periphery_1x2_12/COL_LINE1 OffBn openDVS_pixel2x2_top_317/vpd[2]
+ openDVS_pixel2x2_top_317/vpd[3] openDVS_pixel2x2_top_317/vpd[1] openDVS_pixel2x2_top_317/vpd[0]
+ rowReadON<57> rowReadOFF<56> openDVS_pixel2x2_top_9/GndD DiffBn GndA OnBn VddA18
+ openDVS_pixel2x2_top
XopenDVS_pixel2x2_top_306 rowReadOFF<59> rowReadON<58> RefrBp PrBp PrSFBp col_periphery_1x2_11/COL_LINE0
+ pixRst<24> pixRst<25> col_periphery_1x2_11/COL_LINE1 OffBn openDVS_pixel2x2_top_306/vpd[2]
+ openDVS_pixel2x2_top_306/vpd[3] openDVS_pixel2x2_top_306/vpd[1] openDVS_pixel2x2_top_306/vpd[0]
+ rowReadON<59> rowReadOFF<58> openDVS_pixel2x2_top_74/GndD DiffBn GndA OnBn VddA18
+ openDVS_pixel2x2_top
XopenDVS_pixel2x2_top_862 rowReadOFF<3> rowReadON<2> RefrBp PrBp PrSFBp col_periphery_1x2_30/COL_LINE0
+ pixRst<62> pixRst<63> col_periphery_1x2_30/COL_LINE1 OffBn openDVS_pixel2x2_top_862/vpd[2]
+ openDVS_pixel2x2_top_862/vpd[3] openDVS_pixel2x2_top_862/vpd[1] openDVS_pixel2x2_top_862/vpd[0]
+ rowReadON<3> rowReadOFF<2> openDVS_pixel2x2_top_933/GndD DiffBn GndA OnBn VddA18
+ openDVS_pixel2x2_top
XopenDVS_pixel2x2_top_873 rowReadOFF<1> rowReadON<0> RefrBp PrBp PrSFBp col_periphery_1x2_29/COL_LINE0
+ pixRst<60> pixRst<61> col_periphery_1x2_29/COL_LINE1 OffBn openDVS_pixel2x2_top_873/vpd[2]
+ openDVS_pixel2x2_top_873/vpd[3] openDVS_pixel2x2_top_873/vpd[1] openDVS_pixel2x2_top_873/vpd[0]
+ rowReadON<1> rowReadOFF<0> openDVS_pixel2x2_top_931/GndD DiffBn GndA OnBn VddA18
+ openDVS_pixel2x2_top
XopenDVS_pixel2x2_top_851 rowReadOFF<3> rowReadON<2> RefrBp PrBp PrSFBp col_periphery_1x2_22/COL_LINE0
+ pixRst<44> pixRst<45> col_periphery_1x2_22/COL_LINE1 OffBn openDVS_pixel2x2_top_851/vpd[2]
+ openDVS_pixel2x2_top_851/vpd[3] openDVS_pixel2x2_top_851/vpd[1] openDVS_pixel2x2_top_851/vpd[0]
+ rowReadON<3> rowReadOFF<2> openDVS_pixel2x2_top_933/GndD DiffBn GndA OnBn VddA18
+ openDVS_pixel2x2_top
XopenDVS_pixel2x2_top_840 rowReadOFF<5> rowReadON<4> RefrBp PrBp PrSFBp col_periphery_1x2_22/COL_LINE0
+ pixRst<44> pixRst<45> col_periphery_1x2_22/COL_LINE1 OffBn openDVS_pixel2x2_top_840/vpd[2]
+ openDVS_pixel2x2_top_840/vpd[3] openDVS_pixel2x2_top_840/vpd[1] openDVS_pixel2x2_top_840/vpd[0]
+ rowReadON<5> rowReadOFF<4> openDVS_pixel2x2_top_935/GndD DiffBn GndA OnBn VddA18
+ openDVS_pixel2x2_top
XopenDVS_pixel2x2_top_328 rowReadOFF<57> rowReadON<56> RefrBp PrBp PrSFBp col_periphery_1x2_2/COL_LINE0
+ pixRst<0> pixRst<1> col_periphery_1x2_2/COL_LINE1 OffBn openDVS_pixel2x2_top_328/vpd[2]
+ openDVS_pixel2x2_top_328/vpd[3] openDVS_pixel2x2_top_328/vpd[1] openDVS_pixel2x2_top_328/vpd[0]
+ rowReadON<57> rowReadOFF<56> openDVS_pixel2x2_top_9/GndD DiffBn GndA OnBn VddA18
+ openDVS_pixel2x2_top
XopenDVS_pixel2x2_top_339 rowReadOFF<47> rowReadON<46> RefrBp PrBp PrSFBp col_periphery_1x2_4/COL_LINE0
+ pixRst<4> pixRst<5> col_periphery_1x2_4/COL_LINE1 OffBn openDVS_pixel2x2_top_339/vpd[2]
+ openDVS_pixel2x2_top_339/vpd[3] openDVS_pixel2x2_top_339/vpd[1] openDVS_pixel2x2_top_339/vpd[0]
+ rowReadON<47> rowReadOFF<46> openDVS_pixel2x2_top_78/GndD DiffBn GndA OnBn VddA18
+ openDVS_pixel2x2_top
XopenDVS_pixel2x2_top_884 rowReadOFF<7> rowReadON<6> RefrBp PrBp PrSFBp col_periphery_1x2_29/COL_LINE0
+ pixRst<60> pixRst<61> col_periphery_1x2_29/COL_LINE1 OffBn openDVS_pixel2x2_top_884/vpd[2]
+ openDVS_pixel2x2_top_884/vpd[3] openDVS_pixel2x2_top_884/vpd[1] openDVS_pixel2x2_top_884/vpd[0]
+ rowReadON<7> rowReadOFF<6> openDVS_pixel2x2_top_937/GndD DiffBn GndA OnBn VddA18
+ openDVS_pixel2x2_top
XopenDVS_pixel2x2_top_895 rowReadOFF<3> rowReadON<2> RefrBp PrBp PrSFBp col_periphery_1x2_23/COL_LINE0
+ pixRst<46> pixRst<47> col_periphery_1x2_23/COL_LINE1 OffBn openDVS_pixel2x2_top_895/vpd[2]
+ openDVS_pixel2x2_top_895/vpd[3] openDVS_pixel2x2_top_895/vpd[1] openDVS_pixel2x2_top_895/vpd[0]
+ rowReadON<3> rowReadOFF<2> openDVS_pixel2x2_top_933/GndD DiffBn GndA OnBn VddA18
+ openDVS_pixel2x2_top
XopenDVS_pixel2x2_top_125 rowReadOFF<31> rowReadON<30> RefrBp PrBp PrSFBp col_periphery_1x2_19/COL_LINE0
+ pixRst<38> pixRst<39> col_periphery_1x2_19/COL_LINE1 OffBn openDVS_pixel2x2_top_125/vpd[2]
+ openDVS_pixel2x2_top_125/vpd[3] openDVS_pixel2x2_top_125/vpd[1] openDVS_pixel2x2_top_125/vpd[0]
+ rowReadON<31> rowReadOFF<30> openDVS_pixel2x2_top_991/GndD DiffBn GndA OnBn VddA18
+ openDVS_pixel2x2_top
XopenDVS_pixel2x2_top_169 rowReadOFF<37> rowReadON<36> RefrBp PrBp PrSFBp col_periphery_1x2_26/COL_LINE0
+ pixRst<54> pixRst<55> col_periphery_1x2_26/COL_LINE1 OffBn openDVS_pixel2x2_top_169/vpd[2]
+ openDVS_pixel2x2_top_169/vpd[3] openDVS_pixel2x2_top_169/vpd[1] openDVS_pixel2x2_top_169/vpd[0]
+ rowReadON<37> rowReadOFF<36> openDVS_pixel2x2_top_997/GndD DiffBn GndA OnBn VddA18
+ openDVS_pixel2x2_top
XopenDVS_pixel2x2_top_158 rowReadOFF<41> rowReadON<40> RefrBp PrBp PrSFBp col_periphery_1x2_22/COL_LINE0
+ pixRst<44> pixRst<45> col_periphery_1x2_22/COL_LINE1 OffBn openDVS_pixel2x2_top_158/vpd[2]
+ openDVS_pixel2x2_top_158/vpd[3] openDVS_pixel2x2_top_158/vpd[1] openDVS_pixel2x2_top_158/vpd[0]
+ rowReadON<41> rowReadOFF<40> openDVS_pixel2x2_top_535/GndD DiffBn GndA OnBn VddA18
+ openDVS_pixel2x2_top
XopenDVS_pixel2x2_top_147 rowReadOFF<35> rowReadON<34> RefrBp PrBp PrSFBp col_periphery_1x2_19/COL_LINE0
+ pixRst<38> pixRst<39> col_periphery_1x2_19/COL_LINE1 OffBn openDVS_pixel2x2_top_147/vpd[2]
+ openDVS_pixel2x2_top_147/vpd[3] openDVS_pixel2x2_top_147/vpd[1] openDVS_pixel2x2_top_147/vpd[0]
+ rowReadON<35> rowReadOFF<34> openDVS_pixel2x2_top_995/GndD DiffBn GndA OnBn VddA18
+ openDVS_pixel2x2_top
XopenDVS_pixel2x2_top_136 rowReadOFF<39> rowReadON<38> RefrBp PrBp PrSFBp col_periphery_1x2_17/COL_LINE0
+ pixRst<34> pixRst<35> col_periphery_1x2_17/COL_LINE1 OffBn openDVS_pixel2x2_top_136/vpd[2]
+ openDVS_pixel2x2_top_136/vpd[3] openDVS_pixel2x2_top_136/vpd[1] openDVS_pixel2x2_top_136/vpd[0]
+ rowReadON<39> rowReadOFF<38> openDVS_pixel2x2_top_999/GndD DiffBn GndA OnBn VddA18
+ openDVS_pixel2x2_top
XopenDVS_pixel2x2_top_114 rowReadOFF<55> rowReadON<54> RefrBp PrBp PrSFBp col_periphery_1x2_18/COL_LINE0
+ pixRst<36> pixRst<37> col_periphery_1x2_18/COL_LINE1 OffBn openDVS_pixel2x2_top_114/vpd[2]
+ openDVS_pixel2x2_top_114/vpd[3] openDVS_pixel2x2_top_114/vpd[1] openDVS_pixel2x2_top_114/vpd[0]
+ rowReadON<55> rowReadOFF<54> openDVS_pixel2x2_top_67/GndD DiffBn GndA OnBn VddA18
+ openDVS_pixel2x2_top
XopenDVS_pixel2x2_top_103 rowReadOFF<59> rowReadON<58> RefrBp PrBp PrSFBp col_periphery_1x2_18/COL_LINE0
+ pixRst<36> pixRst<37> col_periphery_1x2_18/COL_LINE1 OffBn openDVS_pixel2x2_top_103/vpd[2]
+ openDVS_pixel2x2_top_103/vpd[3] openDVS_pixel2x2_top_103/vpd[1] openDVS_pixel2x2_top_103/vpd[0]
+ rowReadON<59> rowReadOFF<58> openDVS_pixel2x2_top_74/GndD DiffBn GndA OnBn VddA18
+ openDVS_pixel2x2_top
XopenDVS_pixel2x2_top_681 rowReadOFF<3> rowReadON<2> RefrBp PrBp PrSFBp col_periphery_1x2_13/COL_LINE0
+ pixRst<28> pixRst<29> col_periphery_1x2_13/COL_LINE1 OffBn openDVS_pixel2x2_top_681/vpd[2]
+ openDVS_pixel2x2_top_681/vpd[3] openDVS_pixel2x2_top_681/vpd[1] openDVS_pixel2x2_top_681/vpd[0]
+ rowReadON<3> rowReadOFF<2> openDVS_pixel2x2_top_933/GndD DiffBn GndA OnBn VddA18
+ openDVS_pixel2x2_top
XopenDVS_pixel2x2_top_670 rowReadOFF<1> rowReadON<0> RefrBp PrBp PrSFBp col_periphery_1x2_12/COL_LINE0
+ pixRst<26> pixRst<27> col_periphery_1x2_12/COL_LINE1 OffBn openDVS_pixel2x2_top_670/vpd[2]
+ openDVS_pixel2x2_top_670/vpd[3] openDVS_pixel2x2_top_670/vpd[1] openDVS_pixel2x2_top_670/vpd[0]
+ rowReadON<1> rowReadOFF<0> openDVS_pixel2x2_top_931/GndD DiffBn GndA OnBn VddA18
+ openDVS_pixel2x2_top
XopenDVS_pixel2x2_top_692 rowReadOFF<7> rowReadON<6> RefrBp PrBp PrSFBp col_periphery_1x2_10/COL_LINE0
+ pixRst<22> pixRst<23> col_periphery_1x2_10/COL_LINE1 OffBn openDVS_pixel2x2_top_692/vpd[2]
+ openDVS_pixel2x2_top_692/vpd[3] openDVS_pixel2x2_top_692/vpd[1] openDVS_pixel2x2_top_692/vpd[0]
+ rowReadON<7> rowReadOFF<6> openDVS_pixel2x2_top_937/GndD DiffBn GndA OnBn VddA18
+ openDVS_pixel2x2_top
XopenDVS_pixel2x2_top_1015 rowReadOFF<55> rowReadON<54> RefrBp PrBp PrSFBp col_periphery_1x2_16/COL_LINE0
+ pixRst<32> pixRst<33> col_periphery_1x2_16/COL_LINE1 OffBn openDVS_pixel2x2_top_1015/vpd[2]
+ openDVS_pixel2x2_top_1015/vpd[3] openDVS_pixel2x2_top_1015/vpd[1] openDVS_pixel2x2_top_1015/vpd[0]
+ rowReadON<55> rowReadOFF<54> openDVS_pixel2x2_top_67/GndD DiffBn GndA OnBn VddA18
+ openDVS_pixel2x2_top
XopenDVS_pixel2x2_top_1004 rowReadOFF<45> rowReadON<44> RefrBp PrBp PrSFBp col_periphery_1x2_14/COL_LINE0
+ pixRst<30> pixRst<31> col_periphery_1x2_14/COL_LINE1 OffBn openDVS_pixel2x2_top_1004/vpd[2]
+ openDVS_pixel2x2_top_1004/vpd[3] openDVS_pixel2x2_top_1004/vpd[1] openDVS_pixel2x2_top_1004/vpd[0]
+ rowReadON<45> rowReadOFF<44> openDVS_pixel2x2_top_539/GndD DiffBn GndA OnBn VddA18
+ openDVS_pixel2x2_top
XopenDVS_pixel2x2_top_318 rowReadOFF<57> rowReadON<56> RefrBp PrBp PrSFBp col_periphery_1x2_13/COL_LINE0
+ pixRst<28> pixRst<29> col_periphery_1x2_13/COL_LINE1 OffBn openDVS_pixel2x2_top_318/vpd[2]
+ openDVS_pixel2x2_top_318/vpd[3] openDVS_pixel2x2_top_318/vpd[1] openDVS_pixel2x2_top_318/vpd[0]
+ rowReadON<57> rowReadOFF<56> openDVS_pixel2x2_top_9/GndD DiffBn GndA OnBn VddA18
+ openDVS_pixel2x2_top
XopenDVS_pixel2x2_top_307 rowReadOFF<57> rowReadON<56> RefrBp PrBp PrSFBp col_periphery_1x2_8/COL_LINE0
+ pixRst<18> pixRst<19> col_periphery_1x2_8/COL_LINE1 OffBn openDVS_pixel2x2_top_307/vpd[2]
+ openDVS_pixel2x2_top_307/vpd[3] openDVS_pixel2x2_top_307/vpd[1] openDVS_pixel2x2_top_307/vpd[0]
+ rowReadON<57> rowReadOFF<56> openDVS_pixel2x2_top_9/GndD DiffBn GndA OnBn VddA18
+ openDVS_pixel2x2_top
XopenDVS_pixel2x2_top_329 rowReadOFF<57> rowReadON<56> RefrBp PrBp PrSFBp col_periphery_1x2_3/COL_LINE0
+ pixRst<2> pixRst<3> col_periphery_1x2_3/COL_LINE1 OffBn openDVS_pixel2x2_top_329/vpd[2]
+ openDVS_pixel2x2_top_329/vpd[3] openDVS_pixel2x2_top_329/vpd[1] openDVS_pixel2x2_top_329/vpd[0]
+ rowReadON<57> rowReadOFF<56> openDVS_pixel2x2_top_9/GndD DiffBn GndA OnBn VddA18
+ openDVS_pixel2x2_top
XopenDVS_pixel2x2_top_874 rowReadOFF<1> rowReadON<0> RefrBp PrBp PrSFBp col_periphery_1x2_30/COL_LINE0
+ pixRst<62> pixRst<63> col_periphery_1x2_30/COL_LINE1 OffBn openDVS_pixel2x2_top_874/vpd[2]
+ openDVS_pixel2x2_top_874/vpd[3] openDVS_pixel2x2_top_874/vpd[1] openDVS_pixel2x2_top_874/vpd[0]
+ rowReadON<1> rowReadOFF<0> openDVS_pixel2x2_top_931/GndD DiffBn GndA OnBn VddA18
+ openDVS_pixel2x2_top
XopenDVS_pixel2x2_top_885 rowReadOFF<7> rowReadON<6> RefrBp PrBp PrSFBp col_periphery_1x2_30/COL_LINE0
+ pixRst<62> pixRst<63> col_periphery_1x2_30/COL_LINE1 OffBn openDVS_pixel2x2_top_885/vpd[2]
+ openDVS_pixel2x2_top_885/vpd[3] openDVS_pixel2x2_top_885/vpd[1] openDVS_pixel2x2_top_885/vpd[0]
+ rowReadON<7> rowReadOFF<6> openDVS_pixel2x2_top_937/GndD DiffBn GndA OnBn VddA18
+ openDVS_pixel2x2_top
XopenDVS_pixel2x2_top_863 rowReadOFF<5> rowReadON<4> RefrBp PrBp PrSFBp col_periphery_1x2_29/COL_LINE0
+ pixRst<60> pixRst<61> col_periphery_1x2_29/COL_LINE1 OffBn openDVS_pixel2x2_top_863/vpd[2]
+ openDVS_pixel2x2_top_863/vpd[3] openDVS_pixel2x2_top_863/vpd[1] openDVS_pixel2x2_top_863/vpd[0]
+ rowReadON<5> rowReadOFF<4> openDVS_pixel2x2_top_935/GndD DiffBn GndA OnBn VddA18
+ openDVS_pixel2x2_top
XopenDVS_pixel2x2_top_896 rowReadOFF<3> rowReadON<2> RefrBp PrBp PrSFBp col_periphery_1x2_31/COL_LINE0
+ pixRst<48> pixRst<49> col_periphery_1x2_31/COL_LINE1 OffBn openDVS_pixel2x2_top_896/vpd[2]
+ openDVS_pixel2x2_top_896/vpd[3] openDVS_pixel2x2_top_896/vpd[1] openDVS_pixel2x2_top_896/vpd[0]
+ rowReadON<3> rowReadOFF<2> openDVS_pixel2x2_top_933/GndD DiffBn GndA OnBn VddA18
+ openDVS_pixel2x2_top
XopenDVS_pixel2x2_top_852 rowReadOFF<5> rowReadON<4> RefrBp PrBp PrSFBp col_periphery_1x2_20/COL_LINE0
+ pixRst<40> pixRst<41> col_periphery_1x2_20/COL_LINE1 OffBn openDVS_pixel2x2_top_852/vpd[2]
+ openDVS_pixel2x2_top_852/vpd[3] openDVS_pixel2x2_top_852/vpd[1] openDVS_pixel2x2_top_852/vpd[0]
+ rowReadON<5> rowReadOFF<4> openDVS_pixel2x2_top_935/GndD DiffBn GndA OnBn VddA18
+ openDVS_pixel2x2_top
XopenDVS_pixel2x2_top_841 rowReadOFF<1> rowReadON<0> RefrBp PrBp PrSFBp col_periphery_1x2_17/COL_LINE0
+ pixRst<34> pixRst<35> col_periphery_1x2_17/COL_LINE1 OffBn openDVS_pixel2x2_top_841/vpd[2]
+ openDVS_pixel2x2_top_841/vpd[3] openDVS_pixel2x2_top_841/vpd[1] openDVS_pixel2x2_top_841/vpd[0]
+ rowReadON<1> rowReadOFF<0> openDVS_pixel2x2_top_931/GndD DiffBn GndA OnBn VddA18
+ openDVS_pixel2x2_top
XopenDVS_pixel2x2_top_830 rowReadOFF<19> rowReadON<18> RefrBp PrBp PrSFBp col_periphery_1x2_19/COL_LINE0
+ pixRst<38> pixRst<39> col_periphery_1x2_19/COL_LINE1 OffBn openDVS_pixel2x2_top_830/vpd[2]
+ openDVS_pixel2x2_top_830/vpd[3] openDVS_pixel2x2_top_830/vpd[1] openDVS_pixel2x2_top_830/vpd[0]
+ rowReadON<19> rowReadOFF<18> openDVS_pixel2x2_top_949/GndD DiffBn GndA OnBn VddA18
+ openDVS_pixel2x2_top
XopenDVS_pixel2x2_top_126 rowReadOFF<31> rowReadON<30> RefrBp PrBp PrSFBp col_periphery_1x2_20/COL_LINE0
+ pixRst<40> pixRst<41> col_periphery_1x2_20/COL_LINE1 OffBn openDVS_pixel2x2_top_126/vpd[2]
+ openDVS_pixel2x2_top_126/vpd[3] openDVS_pixel2x2_top_126/vpd[1] openDVS_pixel2x2_top_126/vpd[0]
+ rowReadON<31> rowReadOFF<30> openDVS_pixel2x2_top_991/GndD DiffBn GndA OnBn VddA18
+ openDVS_pixel2x2_top
XopenDVS_pixel2x2_top_159 rowReadOFF<33> rowReadON<32> RefrBp PrBp PrSFBp col_periphery_1x2_22/COL_LINE0
+ pixRst<44> pixRst<45> col_periphery_1x2_22/COL_LINE1 OffBn openDVS_pixel2x2_top_159/vpd[2]
+ openDVS_pixel2x2_top_159/vpd[3] openDVS_pixel2x2_top_159/vpd[1] openDVS_pixel2x2_top_159/vpd[0]
+ rowReadON<33> rowReadOFF<32> openDVS_pixel2x2_top_993/GndD DiffBn GndA OnBn VddA18
+ openDVS_pixel2x2_top
XopenDVS_pixel2x2_top_137 rowReadOFF<39> rowReadON<38> RefrBp PrBp PrSFBp col_periphery_1x2_18/COL_LINE0
+ pixRst<36> pixRst<37> col_periphery_1x2_18/COL_LINE1 OffBn openDVS_pixel2x2_top_137/vpd[2]
+ openDVS_pixel2x2_top_137/vpd[3] openDVS_pixel2x2_top_137/vpd[1] openDVS_pixel2x2_top_137/vpd[0]
+ rowReadON<39> rowReadOFF<38> openDVS_pixel2x2_top_999/GndD DiffBn GndA OnBn VddA18
+ openDVS_pixel2x2_top
XopenDVS_pixel2x2_top_148 rowReadOFF<33> rowReadON<32> RefrBp PrBp PrSFBp col_periphery_1x2_17/COL_LINE0
+ pixRst<34> pixRst<35> col_periphery_1x2_17/COL_LINE1 OffBn openDVS_pixel2x2_top_148/vpd[2]
+ openDVS_pixel2x2_top_148/vpd[3] openDVS_pixel2x2_top_148/vpd[1] openDVS_pixel2x2_top_148/vpd[0]
+ rowReadON<33> rowReadOFF<32> openDVS_pixel2x2_top_993/GndD DiffBn GndA OnBn VddA18
+ openDVS_pixel2x2_top
XopenDVS_pixel2x2_top_115 rowReadOFF<55> rowReadON<54> RefrBp PrBp PrSFBp col_periphery_1x2_19/COL_LINE0
+ pixRst<38> pixRst<39> col_periphery_1x2_19/COL_LINE1 OffBn openDVS_pixel2x2_top_115/vpd[2]
+ openDVS_pixel2x2_top_115/vpd[3] openDVS_pixel2x2_top_115/vpd[1] openDVS_pixel2x2_top_115/vpd[0]
+ rowReadON<55> rowReadOFF<54> openDVS_pixel2x2_top_67/GndD DiffBn GndA OnBn VddA18
+ openDVS_pixel2x2_top
XopenDVS_pixel2x2_top_104 rowReadOFF<59> rowReadON<58> RefrBp PrBp PrSFBp col_periphery_1x2_19/COL_LINE0
+ pixRst<38> pixRst<39> col_periphery_1x2_19/COL_LINE1 OffBn openDVS_pixel2x2_top_104/vpd[2]
+ openDVS_pixel2x2_top_104/vpd[3] openDVS_pixel2x2_top_104/vpd[1] openDVS_pixel2x2_top_104/vpd[0]
+ rowReadON<59> rowReadOFF<58> openDVS_pixel2x2_top_74/GndD DiffBn GndA OnBn VddA18
+ openDVS_pixel2x2_top
XopenDVS_pixel2x2_top_671 rowReadOFF<1> rowReadON<0> RefrBp PrBp PrSFBp col_periphery_1x2_13/COL_LINE0
+ pixRst<28> pixRst<29> col_periphery_1x2_13/COL_LINE1 OffBn openDVS_pixel2x2_top_671/vpd[2]
+ openDVS_pixel2x2_top_671/vpd[3] openDVS_pixel2x2_top_671/vpd[1] openDVS_pixel2x2_top_671/vpd[0]
+ rowReadON<1> rowReadOFF<0> openDVS_pixel2x2_top_931/GndD DiffBn GndA OnBn VddA18
+ openDVS_pixel2x2_top
XopenDVS_pixel2x2_top_682 rowReadOFF<5> rowReadON<4> RefrBp PrBp PrSFBp col_periphery_1x2_12/COL_LINE0
+ pixRst<26> pixRst<27> col_periphery_1x2_12/COL_LINE1 OffBn openDVS_pixel2x2_top_682/vpd[2]
+ openDVS_pixel2x2_top_682/vpd[3] openDVS_pixel2x2_top_682/vpd[1] openDVS_pixel2x2_top_682/vpd[0]
+ rowReadON<5> rowReadOFF<4> openDVS_pixel2x2_top_935/GndD DiffBn GndA OnBn VddA18
+ openDVS_pixel2x2_top
XopenDVS_pixel2x2_top_693 rowReadOFF<7> rowReadON<6> RefrBp PrBp PrSFBp col_periphery_1x2_11/COL_LINE0
+ pixRst<24> pixRst<25> col_periphery_1x2_11/COL_LINE1 OffBn openDVS_pixel2x2_top_693/vpd[2]
+ openDVS_pixel2x2_top_693/vpd[3] openDVS_pixel2x2_top_693/vpd[1] openDVS_pixel2x2_top_693/vpd[0]
+ rowReadON<7> rowReadOFF<6> openDVS_pixel2x2_top_937/GndD DiffBn GndA OnBn VddA18
+ openDVS_pixel2x2_top
XopenDVS_pixel2x2_top_660 rowReadOFF<3> rowReadON<2> RefrBp PrBp PrSFBp col_periphery_1x2_1/COL_LINE0
+ pixRst<12> pixRst<13> col_periphery_1x2_1/COL_LINE1 OffBn openDVS_pixel2x2_top_660/vpd[2]
+ openDVS_pixel2x2_top_660/vpd[3] openDVS_pixel2x2_top_660/vpd[1] openDVS_pixel2x2_top_660/vpd[0]
+ rowReadON<3> rowReadOFF<2> openDVS_pixel2x2_top_933/GndD DiffBn GndA OnBn VddA18
+ openDVS_pixel2x2_top
XopenDVS_pixel2x2_top_1016 rowReadOFF<57> rowReadON<56> RefrBp PrBp PrSFBp col_periphery_1x2_14/COL_LINE0
+ pixRst<30> pixRst<31> col_periphery_1x2_14/COL_LINE1 OffBn openDVS_pixel2x2_top_1016/vpd[2]
+ openDVS_pixel2x2_top_1016/vpd[3] openDVS_pixel2x2_top_1016/vpd[1] openDVS_pixel2x2_top_1016/vpd[0]
+ rowReadON<57> rowReadOFF<56> openDVS_pixel2x2_top_9/GndD DiffBn GndA OnBn VddA18
+ openDVS_pixel2x2_top
XopenDVS_pixel2x2_top_1005 rowReadOFF<45> rowReadON<44> RefrBp PrBp PrSFBp col_periphery_1x2_16/COL_LINE0
+ pixRst<32> pixRst<33> col_periphery_1x2_16/COL_LINE1 OffBn openDVS_pixel2x2_top_1005/vpd[2]
+ openDVS_pixel2x2_top_1005/vpd[3] openDVS_pixel2x2_top_1005/vpd[1] openDVS_pixel2x2_top_1005/vpd[0]
+ rowReadON<45> rowReadOFF<44> openDVS_pixel2x2_top_539/GndD DiffBn GndA OnBn VddA18
+ openDVS_pixel2x2_top
XopenDVS_pixel2x2_top_490 rowReadOFF<33> rowReadON<32> RefrBp PrBp PrSFBp col_periphery_1x2_8/COL_LINE0
+ pixRst<18> pixRst<19> col_periphery_1x2_8/COL_LINE1 OffBn openDVS_pixel2x2_top_490/vpd[2]
+ openDVS_pixel2x2_top_490/vpd[3] openDVS_pixel2x2_top_490/vpd[1] openDVS_pixel2x2_top_490/vpd[0]
+ rowReadON<33> rowReadOFF<32> openDVS_pixel2x2_top_993/GndD DiffBn GndA OnBn VddA18
+ openDVS_pixel2x2_top
XopenDVS_pixel2x2_top_308 rowReadOFF<57> rowReadON<56> RefrBp PrBp PrSFBp col_periphery_1x2_9/COL_LINE0
+ pixRst<20> pixRst<21> col_periphery_1x2_9/COL_LINE1 OffBn openDVS_pixel2x2_top_308/vpd[2]
+ openDVS_pixel2x2_top_308/vpd[3] openDVS_pixel2x2_top_308/vpd[1] openDVS_pixel2x2_top_308/vpd[0]
+ rowReadON<57> rowReadOFF<56> openDVS_pixel2x2_top_9/GndD DiffBn GndA OnBn VddA18
+ openDVS_pixel2x2_top
XopenDVS_pixel2x2_top_319 rowReadOFF<63> rowReadON<62> RefrBp PrBp PrSFBp col_periphery_1x2_8/COL_LINE0
+ pixRst<18> pixRst<19> col_periphery_1x2_8/COL_LINE1 OffBn openDVS_pixel2x2_top_319/vpd[2]
+ openDVS_pixel2x2_top_319/vpd[3] openDVS_pixel2x2_top_319/vpd[1] openDVS_pixel2x2_top_319/vpd[0]
+ rowReadON<63> rowReadOFF<62> openDVS_pixel2x2_top_82/GndD DiffBn GndA OnBn VddA18
+ openDVS_pixel2x2_top
XopenDVS_pixel2x2_top_864 rowReadOFF<5> rowReadON<4> RefrBp PrBp PrSFBp col_periphery_1x2_30/COL_LINE0
+ pixRst<62> pixRst<63> col_periphery_1x2_30/COL_LINE1 OffBn openDVS_pixel2x2_top_864/vpd[2]
+ openDVS_pixel2x2_top_864/vpd[3] openDVS_pixel2x2_top_864/vpd[1] openDVS_pixel2x2_top_864/vpd[0]
+ rowReadON<5> rowReadOFF<4> openDVS_pixel2x2_top_935/GndD DiffBn GndA OnBn VddA18
+ openDVS_pixel2x2_top
XopenDVS_pixel2x2_top_875 rowReadOFF<5> rowReadON<4> RefrBp PrBp PrSFBp col_periphery_1x2_25/COL_LINE0
+ pixRst<52> pixRst<53> col_periphery_1x2_25/COL_LINE1 OffBn openDVS_pixel2x2_top_875/vpd[2]
+ openDVS_pixel2x2_top_875/vpd[3] openDVS_pixel2x2_top_875/vpd[1] openDVS_pixel2x2_top_875/vpd[0]
+ rowReadON<5> rowReadOFF<4> openDVS_pixel2x2_top_935/GndD DiffBn GndA OnBn VddA18
+ openDVS_pixel2x2_top
XopenDVS_pixel2x2_top_886 rowReadOFF<7> rowReadON<6> RefrBp PrBp PrSFBp col_periphery_1x2_24/COL_LINE0
+ pixRst<50> pixRst<51> col_periphery_1x2_24/COL_LINE1 OffBn openDVS_pixel2x2_top_886/vpd[2]
+ openDVS_pixel2x2_top_886/vpd[3] openDVS_pixel2x2_top_886/vpd[1] openDVS_pixel2x2_top_886/vpd[0]
+ rowReadON<7> rowReadOFF<6> openDVS_pixel2x2_top_937/GndD DiffBn GndA OnBn VddA18
+ openDVS_pixel2x2_top
XopenDVS_pixel2x2_top_897 rowReadOFF<5> rowReadON<4> RefrBp PrBp PrSFBp col_periphery_1x2_23/COL_LINE0
+ pixRst<46> pixRst<47> col_periphery_1x2_23/COL_LINE1 OffBn openDVS_pixel2x2_top_897/vpd[2]
+ openDVS_pixel2x2_top_897/vpd[3] openDVS_pixel2x2_top_897/vpd[1] openDVS_pixel2x2_top_897/vpd[0]
+ rowReadON<5> rowReadOFF<4> openDVS_pixel2x2_top_935/GndD DiffBn GndA OnBn VddA18
+ openDVS_pixel2x2_top
XopenDVS_pixel2x2_top_842 rowReadOFF<1> rowReadON<0> RefrBp PrBp PrSFBp col_periphery_1x2_18/COL_LINE0
+ pixRst<36> pixRst<37> col_periphery_1x2_18/COL_LINE1 OffBn openDVS_pixel2x2_top_842/vpd[2]
+ openDVS_pixel2x2_top_842/vpd[3] openDVS_pixel2x2_top_842/vpd[1] openDVS_pixel2x2_top_842/vpd[0]
+ rowReadON<1> rowReadOFF<0> openDVS_pixel2x2_top_931/GndD DiffBn GndA OnBn VddA18
+ openDVS_pixel2x2_top
XopenDVS_pixel2x2_top_853 rowReadOFF<5> rowReadON<4> RefrBp PrBp PrSFBp col_periphery_1x2_17/COL_LINE0
+ pixRst<34> pixRst<35> col_periphery_1x2_17/COL_LINE1 OffBn openDVS_pixel2x2_top_853/vpd[2]
+ openDVS_pixel2x2_top_853/vpd[3] openDVS_pixel2x2_top_853/vpd[1] openDVS_pixel2x2_top_853/vpd[0]
+ rowReadON<5> rowReadOFF<4> openDVS_pixel2x2_top_935/GndD DiffBn GndA OnBn VddA18
+ openDVS_pixel2x2_top
XopenDVS_pixel2x2_top_831 rowReadOFF<19> rowReadON<18> RefrBp PrBp PrSFBp col_periphery_1x2_20/COL_LINE0
+ pixRst<40> pixRst<41> col_periphery_1x2_20/COL_LINE1 OffBn openDVS_pixel2x2_top_831/vpd[2]
+ openDVS_pixel2x2_top_831/vpd[3] openDVS_pixel2x2_top_831/vpd[1] openDVS_pixel2x2_top_831/vpd[0]
+ rowReadON<19> rowReadOFF<18> openDVS_pixel2x2_top_949/GndD DiffBn GndA OnBn VddA18
+ openDVS_pixel2x2_top
XopenDVS_pixel2x2_top_820 rowReadOFF<17> rowReadON<16> RefrBp PrBp PrSFBp col_periphery_1x2_18/COL_LINE0
+ pixRst<36> pixRst<37> col_periphery_1x2_18/COL_LINE1 OffBn openDVS_pixel2x2_top_820/vpd[2]
+ openDVS_pixel2x2_top_820/vpd[3] openDVS_pixel2x2_top_820/vpd[1] openDVS_pixel2x2_top_820/vpd[0]
+ rowReadON<17> rowReadOFF<16> openDVS_pixel2x2_top_947/GndD DiffBn GndA OnBn VddA18
+ openDVS_pixel2x2_top
XopenDVS_pixel2x2_top_138 rowReadOFF<39> rowReadON<38> RefrBp PrBp PrSFBp col_periphery_1x2_19/COL_LINE0
+ pixRst<38> pixRst<39> col_periphery_1x2_19/COL_LINE1 OffBn openDVS_pixel2x2_top_138/vpd[2]
+ openDVS_pixel2x2_top_138/vpd[3] openDVS_pixel2x2_top_138/vpd[1] openDVS_pixel2x2_top_138/vpd[0]
+ rowReadON<39> rowReadOFF<38> openDVS_pixel2x2_top_999/GndD DiffBn GndA OnBn VddA18
+ openDVS_pixel2x2_top
XopenDVS_pixel2x2_top_149 rowReadOFF<33> rowReadON<32> RefrBp PrBp PrSFBp col_periphery_1x2_18/COL_LINE0
+ pixRst<36> pixRst<37> col_periphery_1x2_18/COL_LINE1 OffBn openDVS_pixel2x2_top_149/vpd[2]
+ openDVS_pixel2x2_top_149/vpd[3] openDVS_pixel2x2_top_149/vpd[1] openDVS_pixel2x2_top_149/vpd[0]
+ rowReadON<33> rowReadOFF<32> openDVS_pixel2x2_top_993/GndD DiffBn GndA OnBn VddA18
+ openDVS_pixel2x2_top
XopenDVS_pixel2x2_top_116 rowReadOFF<55> rowReadON<54> RefrBp PrBp PrSFBp col_periphery_1x2_20/COL_LINE0
+ pixRst<40> pixRst<41> col_periphery_1x2_20/COL_LINE1 OffBn openDVS_pixel2x2_top_116/vpd[2]
+ openDVS_pixel2x2_top_116/vpd[3] openDVS_pixel2x2_top_116/vpd[1] openDVS_pixel2x2_top_116/vpd[0]
+ rowReadON<55> rowReadOFF<54> openDVS_pixel2x2_top_67/GndD DiffBn GndA OnBn VddA18
+ openDVS_pixel2x2_top
XopenDVS_pixel2x2_top_105 rowReadOFF<59> rowReadON<58> RefrBp PrBp PrSFBp col_periphery_1x2_20/COL_LINE0
+ pixRst<40> pixRst<41> col_periphery_1x2_20/COL_LINE1 OffBn openDVS_pixel2x2_top_105/vpd[2]
+ openDVS_pixel2x2_top_105/vpd[3] openDVS_pixel2x2_top_105/vpd[1] openDVS_pixel2x2_top_105/vpd[0]
+ rowReadON<59> rowReadOFF<58> openDVS_pixel2x2_top_74/GndD DiffBn GndA OnBn VddA18
+ openDVS_pixel2x2_top
XopenDVS_pixel2x2_top_127 rowReadOFF<43> rowReadON<42> RefrBp PrBp PrSFBp col_periphery_1x2_17/COL_LINE0
+ pixRst<34> pixRst<35> col_periphery_1x2_17/COL_LINE1 OffBn openDVS_pixel2x2_top_127/vpd[2]
+ openDVS_pixel2x2_top_127/vpd[3] openDVS_pixel2x2_top_127/vpd[1] openDVS_pixel2x2_top_127/vpd[0]
+ rowReadON<43> rowReadOFF<42> openDVS_pixel2x2_top_537/GndD DiffBn GndA OnBn VddA18
+ openDVS_pixel2x2_top
XopenDVS_pixel2x2_top_694 rowReadOFF<7> rowReadON<6> RefrBp PrBp PrSFBp col_periphery_1x2_12/COL_LINE0
+ pixRst<26> pixRst<27> col_periphery_1x2_12/COL_LINE1 OffBn openDVS_pixel2x2_top_694/vpd[2]
+ openDVS_pixel2x2_top_694/vpd[3] openDVS_pixel2x2_top_694/vpd[1] openDVS_pixel2x2_top_694/vpd[0]
+ rowReadON<7> rowReadOFF<6> openDVS_pixel2x2_top_937/GndD DiffBn GndA OnBn VddA18
+ openDVS_pixel2x2_top
XopenDVS_pixel2x2_top_672 rowReadOFF<5> rowReadON<4> RefrBp PrBp PrSFBp col_periphery_1x2_8/COL_LINE0
+ pixRst<18> pixRst<19> col_periphery_1x2_8/COL_LINE1 OffBn openDVS_pixel2x2_top_672/vpd[2]
+ openDVS_pixel2x2_top_672/vpd[3] openDVS_pixel2x2_top_672/vpd[1] openDVS_pixel2x2_top_672/vpd[0]
+ rowReadON<5> rowReadOFF<4> openDVS_pixel2x2_top_935/GndD DiffBn GndA OnBn VddA18
+ openDVS_pixel2x2_top
XopenDVS_pixel2x2_top_661 rowReadOFF<5> rowReadON<4> RefrBp PrBp PrSFBp col_periphery_1x2_1/COL_LINE0
+ pixRst<12> pixRst<13> col_periphery_1x2_1/COL_LINE1 OffBn openDVS_pixel2x2_top_661/vpd[2]
+ openDVS_pixel2x2_top_661/vpd[3] openDVS_pixel2x2_top_661/vpd[1] openDVS_pixel2x2_top_661/vpd[0]
+ rowReadON<5> rowReadOFF<4> openDVS_pixel2x2_top_935/GndD DiffBn GndA OnBn VddA18
+ openDVS_pixel2x2_top
XopenDVS_pixel2x2_top_650 rowReadOFF<3> rowReadON<2> RefrBp PrBp PrSFBp col_periphery_1x2_4/COL_LINE0
+ pixRst<4> pixRst<5> col_periphery_1x2_4/COL_LINE1 OffBn openDVS_pixel2x2_top_650/vpd[2]
+ openDVS_pixel2x2_top_650/vpd[3] openDVS_pixel2x2_top_650/vpd[1] openDVS_pixel2x2_top_650/vpd[0]
+ rowReadON<3> rowReadOFF<2> openDVS_pixel2x2_top_933/GndD DiffBn GndA OnBn VddA18
+ openDVS_pixel2x2_top
XopenDVS_pixel2x2_top_683 rowReadOFF<7> rowReadON<6> RefrBp PrBp PrSFBp col_periphery_1x2_2/COL_LINE0
+ pixRst<0> pixRst<1> col_periphery_1x2_2/COL_LINE1 OffBn openDVS_pixel2x2_top_683/vpd[2]
+ openDVS_pixel2x2_top_683/vpd[3] openDVS_pixel2x2_top_683/vpd[1] openDVS_pixel2x2_top_683/vpd[0]
+ rowReadON<7> rowReadOFF<6> openDVS_pixel2x2_top_937/GndD DiffBn GndA OnBn VddA18
+ openDVS_pixel2x2_top
XopenDVS_pixel2x2_top_1017 rowReadOFF<57> rowReadON<56> RefrBp PrBp PrSFBp col_periphery_1x2_16/COL_LINE0
+ pixRst<32> pixRst<33> col_periphery_1x2_16/COL_LINE1 OffBn openDVS_pixel2x2_top_1017/vpd[2]
+ openDVS_pixel2x2_top_1017/vpd[3] openDVS_pixel2x2_top_1017/vpd[1] openDVS_pixel2x2_top_1017/vpd[0]
+ rowReadON<57> rowReadOFF<56> openDVS_pixel2x2_top_9/GndD DiffBn GndA OnBn VddA18
+ openDVS_pixel2x2_top
XopenDVS_pixel2x2_top_1006 rowReadOFF<47> rowReadON<46> RefrBp PrBp PrSFBp col_periphery_1x2_14/COL_LINE0
+ pixRst<30> pixRst<31> col_periphery_1x2_14/COL_LINE1 OffBn openDVS_pixel2x2_top_1006/vpd[2]
+ openDVS_pixel2x2_top_1006/vpd[3] openDVS_pixel2x2_top_1006/vpd[1] openDVS_pixel2x2_top_1006/vpd[0]
+ rowReadON<47> rowReadOFF<46> openDVS_pixel2x2_top_78/GndD DiffBn GndA OnBn VddA18
+ openDVS_pixel2x2_top
XopenDVS_pixel2x2_top_491 rowReadOFF<45> rowReadON<44> RefrBp PrBp PrSFBp col_periphery_1x2_4/COL_LINE0
+ pixRst<4> pixRst<5> col_periphery_1x2_4/COL_LINE1 OffBn openDVS_pixel2x2_top_491/vpd[2]
+ openDVS_pixel2x2_top_491/vpd[3] openDVS_pixel2x2_top_491/vpd[1] openDVS_pixel2x2_top_491/vpd[0]
+ rowReadON<45> rowReadOFF<44> openDVS_pixel2x2_top_539/GndD DiffBn GndA OnBn VddA18
+ openDVS_pixel2x2_top
XopenDVS_pixel2x2_top_480 rowReadOFF<43> rowReadON<42> RefrBp PrBp PrSFBp col_periphery_1x2_10/COL_LINE0
+ pixRst<22> pixRst<23> col_periphery_1x2_10/COL_LINE1 OffBn openDVS_pixel2x2_top_480/vpd[2]
+ openDVS_pixel2x2_top_480/vpd[3] openDVS_pixel2x2_top_480/vpd[1] openDVS_pixel2x2_top_480/vpd[0]
+ rowReadON<43> rowReadOFF<42> openDVS_pixel2x2_top_537/GndD DiffBn GndA OnBn VddA18
+ openDVS_pixel2x2_top
.ends

.subckt pixel_4tile_layout array_col_top_right<1> array_col_top_right<5> col_event_rst_top_right<17>
+ array_col_top_right<28> col_event_rst_top_right<24> col_event_rst_top_right<16>
+ array_col_top_right<8> array_col_top_right<9> col_event_rst_top_right<23> col_event_rst_top_right<15>
+ col_event_rst_top_right<22> col_event_rst_top_right<14> array_col_top_right<3> col_event_rst_top_right<13>
+ col_event_rst_top_right<12> array_col_top_right<20> col_event_rst_top_right<11>
+ array_col_top_right<17> array_col_top_right<4> col_event_rst_top_right<10> array_col_top_right<2>
+ array_col_top_right<12> array_col_top_right<19> array_col_top_right<13> col_event_rst_top_right<9>
+ col_event_rst_top_right<21> array_col_top_right<18> array_col_top_right<16> col_event_rst_top_right<8>
+ array_col_top_right<15> array_col_top_right<11> col_event_rst_top_right<7> array_col_top_right<26>
+ array_col_top_right<10> col_event_rst_top_right<6> array_col_top_right<27> col_event_rst_top_right<5>
+ array_col_top_right<25> col_event_rst_top_right<4> col_event_rst_top_right<28> array_col_top_right<24>
+ col_event_rst_top_right<3> array_col_top_right<23> col_event_rst_top_right<2> col_event_rst_top_right<26>
+ col_event_rst_top_right<1> array_col_top_right<21> col_event_rst_top_right<0> array_col_top_right<14>
+ col_event_rst_top_right<20> array_col_top_right<0> col_event_rst_top_right<27> array_col_top_right<7>
+ col_event_rst_top_right<19> col_event_rst_top_right<25> col_event_rst_top_right<18>
+ array_col_top_right<6> array_col_top_right<22> array_col_top_right<29> array_col_top_right<31>
+ array_col_top_right<30> col_event_rst_top_right<31> col_event_rst_top_right<30>
+ col_event_rst_top_right<29> col_event_rst_top_right<63> col_event_rst_top_right<37>
+ array_col_top_right<59> col_event_rst_top_right<46> col_event_rst_top_right<36>
+ col_event_rst_top_right<35> col_event_rst_top_right<62> col_event_rst_top_right<34>
+ col_event_rst_top_right<33> col_event_rst_top_right<32> col_event_rst_top_right<45>
+ col_event_rst_top_right<44> col_event_rst_top_right<47> col_event_rst_top_right<43>
+ col_event_rst_top_right<48> col_event_rst_top_right<52> col_event_rst_top_right<56>
+ col_event_rst_top_right<59> array_col_top_right<38> col_event_rst_top_right<42>
+ col_event_rst_top_right<51> col_event_rst_top_right<60> col_event_rst_top_right<55>
+ col_event_rst_top_right<41> array_col_top_right<33> array_col_top_right<32> array_col_top_right<61>
+ array_col_top_right<60> col_event_rst_top_right<61> col_event_rst_top_right<57>
+ col_event_rst_top_right<54> array_col_top_right<37> array_col_top_right<56> array_col_top_right<58>
+ array_col_top_right<57> array_col_top_right<54> array_col_top_right<51> array_col_top_right<55>
+ array_col_top_right<50> array_col_top_right<49> array_col_top_right<48> array_col_top_right<45>
+ array_col_top_right<42> array_col_top_right<53> array_col_top_right<41> array_col_top_right<39>
+ col_event_rst_top_right<53> array_col_top_right<35> array_col_top_right<34> array_col_top_right<63>
+ array_col_top_right<62> col_event_rst_top_right<58> col_event_rst_top_right<40>
+ col_event_rst_top_right<50> col_event_rst_top_right<39> col_event_rst_top_right<38>
+ array_col_top_right<43> col_event_rst_top_right<49> array_col_top_right<52> array_col_top_right<47>
+ array_col_top_right<46> array_col_top_right<44> array_col_top_right<40> array_col_top_right<36>
+ array_col_top_left<10> array_col_top_left<26> array_col_top_left<8> col_event_rst_top_left<27>
+ col_event_rst_top_left<21> col_event_rst_top_left<15> col_event_rst_top_left<10>
+ col_event_rst_top_left<9> col_event_rst_top_left<20> array_col_top_left<14> col_event_rst_top_left<17>
+ array_col_top_left<20> array_col_top_left<2> col_event_rst_top_left<24> col_event_rst_top_left<2>
+ col_event_rst_top_left<14> array_col_top_left<21> array_col_top_left<0> col_event_rst_top_left<22>
+ col_event_rst_top_left<13> array_col_top_left<28> col_event_rst_top_left<29> col_event_rst_top_left<28>
+ col_event_rst_top_left<3> col_event_rst_top_left<7> array_col_top_left<24> array_col_top_left<15>
+ array_col_top_left<16> col_event_rst_top_left<19> array_col_top_left<31> array_col_top_left<12>
+ col_event_rst_top_left<16> col_event_rst_top_left<26> col_event_rst_top_left<25>
+ array_col_top_left<1> array_col_top_left<22> array_col_top_left<3> col_event_rst_top_left<0>
+ col_event_rst_top_left<4> col_event_rst_top_left<8> array_col_top_left<23> array_col_top_left<17>
+ col_event_rst_top_left<30> array_col_top_left<6> array_col_top_left<29> array_col_top_left<11>
+ array_col_top_left<9> array_col_top_left<27> array_col_top_left<5> array_col_top_left<4>
+ array_col_top_left<19> array_col_top_left<30> array_col_top_left<25> col_event_rst_top_left<12>
+ col_event_rst_top_left<5> col_event_rst_top_left<23> col_event_rst_top_left<6> col_event_rst_top_left<11>
+ array_col_top_left<7> col_event_rst_top_left<18> col_event_rst_top_left<1> col_event_rst_top_left<31>
+ array_col_top_left<18> array_col_top_left<13> array_col_top_left<32> col_event_rst_top_left<32>
+ array_col_top_left<34> col_event_rst_top_left<33> array_col_top_left<33> col_event_rst_top_left<34>
+ col_event_rst_top_left<36> col_event_rst_top_left<40> array_col_top_left<38> array_col_top_left<39>
+ array_col_top_left<40> array_col_top_left<41> array_col_top_left<63> array_col_top_left<42>
+ array_col_top_left<43> array_col_top_left<44> col_event_rst_top_left<43> array_col_top_left<45>
+ array_col_top_left<46> col_event_rst_top_left<44> col_event_rst_top_left<59> array_col_top_left<47>
+ col_event_rst_top_left<58> array_col_top_left<48> array_col_top_left<49> col_event_rst_top_left<63>
+ col_event_rst_top_left<62> col_event_rst_top_left<42> array_col_top_left<50> col_event_rst_top_left<37>
+ col_event_rst_top_left<35> array_col_top_left<37> col_event_rst_top_left<41> col_event_rst_top_left<38>
+ col_event_rst_top_left<54> col_event_rst_top_left<48> array_col_top_left<51> array_col_top_left<52>
+ array_col_top_left<53> array_col_top_left<54> array_col_top_left<55> array_col_top_left<56>
+ array_col_top_left<57> array_col_top_left<58> array_col_top_left<59> array_col_top_left<60>
+ array_col_top_left<61> array_col_top_left<62> col_event_rst_top_left<46> col_event_rst_top_left<57>
+ col_event_rst_top_left<51> col_event_rst_top_left<49> col_event_rst_top_left<53>
+ array_col_top_left<36> col_event_rst_top_left<52> col_event_rst_top_left<55> col_event_rst_top_left<60>
+ col_event_rst_top_left<56> col_event_rst_top_left<50> col_event_rst_top_left<45>
+ col_event_rst_top_left<47> col_event_rst_top_left<39> array_col_top_left<35> col_event_rst_top_left<61>
+ col_event_rst_bot_left<46> col_event_rst_bot_left<45> col_event_rst_bot_left<44>
+ col_event_rst_bot_left<43> col_event_rst_bot_left<42> col_event_rst_bot_left<41>
+ col_event_rst_bot_left<40> col_event_rst_bot_left<39> col_event_rst_bot_left<38>
+ col_event_rst_bot_left<37> col_event_rst_bot_left<36> col_event_rst_bot_left<35>
+ col_event_rst_bot_left<63> col_event_rst_bot_left<62> col_event_rst_bot_left<61>
+ col_event_rst_bot_left<60> array_col_bot_left<55> array_col_bot_left<42> array_col_bot_left<41>
+ array_col_bot_left<40> array_col_bot_left<43> array_col_bot_left<60> array_col_bot_left<45>
+ array_col_bot_left<44> array_col_bot_left<62> array_col_bot_left<58> array_col_bot_left<54>
+ array_col_bot_left<53> array_col_bot_left<50> array_col_bot_left<49> array_col_bot_left<37>
+ array_col_bot_left<36> array_col_bot_left<61> array_col_bot_left<57> array_col_bot_left<56>
+ array_col_bot_left<52> array_col_bot_left<51> array_col_bot_left<48> array_col_bot_left<47>
+ array_col_bot_left<46> array_col_bot_left<63> array_col_bot_left<39> array_col_bot_left<38>
+ array_col_bot_left<35> array_col_bot_left<59> col_event_rst_bot_left<59> col_event_rst_bot_left<58>
+ col_event_rst_bot_left<57> col_event_rst_bot_left<56> col_event_rst_bot_left<55>
+ col_event_rst_bot_left<54> col_event_rst_bot_left<53> col_event_rst_bot_left<52>
+ col_event_rst_bot_left<51> col_event_rst_bot_left<50> col_event_rst_bot_left<49>
+ col_event_rst_bot_left<48> col_event_rst_bot_left<47> array_col_bot_left<34> col_event_rst_bot_left<34>
+ col_event_rst_bot_left<33> col_event_rst_bot_left<32> array_col_bot_left<32> array_col_bot_left<33>
+ col_event_rst_bot_left<31> col_event_rst_bot_left<30> col_event_rst_bot_left<29>
+ col_event_rst_bot_left<28> col_event_rst_bot_left<27> col_event_rst_bot_left<26>
+ array_col_bot_left<20> array_col_bot_left<23> array_col_bot_left<31> col_event_rst_bot_left<25>
+ col_event_rst_bot_left<24> array_col_bot_left<21> array_col_bot_left<22> array_col_bot_left<16>
+ col_event_rst_bot_left<23> array_col_bot_left<1> array_col_bot_left<7> array_col_bot_left<0>
+ col_event_rst_bot_left<22> col_event_rst_bot_left<21> array_col_bot_left<15> array_col_bot_left<14>
+ array_col_bot_left<5> array_col_bot_left<4> array_col_bot_left<30> array_col_bot_left<12>
+ array_col_bot_left<26> col_event_rst_bot_left<20> array_col_bot_left<2> array_col_bot_left<3>
+ col_event_rst_bot_left<19> col_event_rst_bot_left<18> col_event_rst_bot_left<17>
+ col_event_rst_bot_left<16> array_col_bot_left<10> array_col_bot_left<11> array_col_bot_left<6>
+ col_event_rst_bot_left<15> col_event_rst_bot_left<14> array_col_bot_left<29> array_col_bot_left<28>
+ array_col_bot_left<24> array_col_bot_left<19> col_event_rst_bot_left<13> col_event_rst_bot_left<12>
+ col_event_rst_bot_left<11> col_event_rst_bot_left<10> col_event_rst_bot_left<9>
+ col_event_rst_bot_left<8> col_event_rst_bot_left<7> array_col_bot_left<17> array_col_bot_left<9>
+ col_event_rst_bot_left<0> array_col_bot_left<8> col_event_rst_bot_left<1> col_event_rst_bot_left<5>
+ array_col_bot_left<13> col_event_rst_bot_left<4> col_event_rst_bot_left<3> col_event_rst_bot_left<2>
+ col_event_rst_bot_left<6> array_col_bot_left<27> array_col_bot_left<25> array_col_bot_left<18>
+ col_event_rst_bot_right<40> col_event_rst_bot_right<39> array_col_bot_right<55>
+ array_col_bot_right<62> array_col_bot_right<59> array_col_bot_right<58> array_col_bot_right<54>
+ col_event_rst_bot_right<38> col_event_rst_bot_right<37> col_event_rst_bot_right<36>
+ col_event_rst_bot_right<35> col_event_rst_bot_right<34> array_col_bot_right<61>
+ col_event_rst_bot_right<33> col_event_rst_bot_right<32> array_col_bot_right<60>
+ array_col_bot_right<57> array_col_bot_right<56> array_col_bot_right<53> array_col_bot_right<52>
+ array_col_bot_right<49> array_col_bot_right<48> array_col_bot_right<45> array_col_bot_right<44>
+ array_col_bot_right<41> array_col_bot_right<40> array_col_bot_right<37> array_col_bot_right<36>
+ array_col_bot_right<33> array_col_bot_right<32> array_col_bot_right<51> array_col_bot_right<50>
+ array_col_bot_right<47> array_col_bot_right<46> array_col_bot_right<43> array_col_bot_right<42>
+ array_col_bot_right<39> array_col_bot_right<38> array_col_bot_right<35> array_col_bot_right<34>
+ col_event_rst_bot_right<62> col_event_rst_bot_right<61> col_event_rst_bot_right<60>
+ col_event_rst_bot_right<59> col_event_rst_bot_right<58> col_event_rst_bot_right<57>
+ col_event_rst_bot_right<56> array_col_bot_right<63> col_event_rst_bot_right<55>
+ col_event_rst_bot_right<54> col_event_rst_bot_right<63> col_event_rst_bot_right<53>
+ col_event_rst_bot_right<52> col_event_rst_bot_right<51> col_event_rst_bot_right<50>
+ col_event_rst_bot_right<49> col_event_rst_bot_right<48> col_event_rst_bot_right<47>
+ col_event_rst_bot_right<46> col_event_rst_bot_right<45> col_event_rst_bot_right<44>
+ col_event_rst_bot_right<43> col_event_rst_bot_right<42> col_event_rst_bot_right<41>
+ col_event_rst_bot_right<29> array_col_bot_right<29> array_col_bot_right<31> array_col_bot_right<30>
+ col_event_rst_bot_right<31> col_event_rst_bot_right<30> col_event_rst_bot_right<24>
+ col_event_rst_bot_right<23> array_col_bot_right<0> array_col_bot_right<3> array_col_bot_right<15>
+ array_col_bot_right<27> array_col_bot_right<26> array_col_bot_right<11> array_col_bot_right<17>
+ array_col_bot_right<2> array_col_bot_right<13> array_col_bot_right<18> array_col_bot_right<9>
+ col_event_rst_bot_right<22> col_event_rst_bot_right<21> col_event_rst_bot_right<20>
+ col_event_rst_bot_right<19> col_event_rst_bot_right<18> col_event_rst_bot_right<17>
+ col_event_rst_bot_right<16> col_event_rst_bot_right<15> col_event_rst_bot_right<14>
+ col_event_rst_bot_right<13> col_event_rst_bot_right<12> col_event_rst_bot_right<11>
+ col_event_rst_bot_right<10> col_event_rst_bot_right<9> col_event_rst_bot_right<8>
+ col_event_rst_bot_right<7> col_event_rst_bot_right<6> col_event_rst_bot_right<5>
+ array_col_bot_right<4> array_col_bot_right<6> array_col_bot_right<22> array_col_bot_right<14>
+ col_event_rst_bot_right<28> array_col_bot_right<10> array_col_bot_right<28> array_col_bot_right<25>
+ col_event_rst_bot_right<27> array_col_bot_right<8> array_col_bot_right<24> array_col_bot_right<21>
+ col_event_rst_bot_right<4> array_col_bot_right<20> array_col_bot_right<23> col_event_rst_bot_right<3>
+ array_col_bot_right<16> array_col_bot_right<19> array_col_bot_right<1> col_event_rst_bot_right<2>
+ col_event_rst_bot_right<1> col_event_rst_bot_right<0> array_col_bot_right<7> array_col_bot_right<5>
+ col_event_rst_bot_right<26> array_col_bot_right<12> col_event_rst_bot_right<25>
+ vssa1 vdda1 vssc1 dac_config_1 dac_config_4 dac_config_2 dac_config_3 dac_config_5
+ row_on_detect_top<26> pre_charge_global_top_left detect_pulse_global_top_left row_off_detect_top<10>
+ row_off_detect_top<9> row_on_detect_top<9> row_on_detect_top<8> row_off_detect_top<8>
+ row_off_detect_top<7> row_on_detect_top<7> row_on_detect_top<6> row_off_detect_top<6>
+ row_off_detect_top<5> row_on_detect_top<5> row_on_detect_top<4> row_off_detect_top<4>
+ row_off_detect_top<3> row_on_detect_top<3> row_on_detect_top<2> row_off_detect_top<2>
+ row_off_detect_top<1> row_on_detect_top<1> row_on_detect_top<0> row_off_detect_top<0>
+ ndetect_pulse_global_top_left row_off_detect_top<26> row_off_detect_top<25> row_on_detect_top<25>
+ row_on_detect_top<24> row_off_detect_top<24> row_off_detect_top<23> row_on_detect_top<23>
+ row_on_detect_top<22> row_off_detect_top<22> row_off_detect_top<21> row_on_detect_top<21>
+ row_on_detect_top<20> row_off_detect_top<20> row_off_detect_top<19> row_on_detect_top<19>
+ row_on_detect_top<18> row_off_detect_top<18> row_off_detect_top<17> row_on_detect_top<17>
+ row_on_detect_top<16> row_off_detect_top<16> row_off_detect_top<15> row_on_detect_top<15>
+ row_on_detect_top<14> row_off_detect_top<14> row_off_detect_top<13> row_on_detect_top<13>
+ row_on_detect_top<12> row_off_detect_top<12> row_off_detect_top<11> row_on_detect_top<11>
+ row_on_detect_top<10> row_off_detect_top<30> row_off_detect_top<29> row_on_detect_top<29>
+ row_on_detect_top<28> row_off_detect_top<28> row_off_detect_top<27> row_on_detect_top<27>
+ row_off_detect_top<31> row_on_detect_top<31> row_on_detect_top<30> row_off_detect_top<42>
+ row_off_detect_top<41> row_on_detect_top<41> row_on_detect_top<40> row_off_detect_top<40>
+ row_off_detect_top<39> row_on_detect_top<39> row_on_detect_top<38> row_off_detect_top<38>
+ row_off_detect_top<37> row_on_detect_top<37> row_on_detect_top<36> row_off_detect_top<36>
+ row_off_detect_top<35> row_on_detect_top<35> row_on_detect_top<34> row_off_detect_top<34>
+ row_off_detect_top<33> row_on_detect_top<33> row_on_detect_top<32> row_off_detect_top<32>
+ row_off_detect_top<63> row_on_detect_top<63> row_on_detect_top<62> row_off_detect_top<62>
+ row_off_detect_top<61> row_on_detect_top<61> row_on_detect_top<60> row_off_detect_top<60>
+ row_off_detect_top<59> row_on_detect_top<59> row_on_detect_top<58> row_off_detect_top<58>
+ row_off_detect_top<57> row_on_detect_top<57> row_on_detect_top<56> row_off_detect_top<56>
+ row_off_detect_top<55> row_on_detect_top<55> row_on_detect_top<54> row_off_detect_top<54>
+ row_off_detect_top<53> row_on_detect_top<53> row_on_detect_top<52> row_off_detect_top<52>
+ row_off_detect_top<51> row_on_detect_top<51> row_on_detect_top<50> row_off_detect_top<50>
+ row_off_detect_top<49> row_on_detect_top<49> row_on_detect_top<48> row_off_detect_top<48>
+ row_off_detect_top<47> row_on_detect_top<47> row_on_detect_top<46> row_off_detect_top<46>
+ row_off_detect_top<45> row_on_detect_top<45> row_on_detect_top<44> row_off_detect_top<44>
+ row_off_detect_top<43> row_on_detect_top<43> row_on_detect_top<42> row_on_detect_bot<37>
+ row_on_detect_bot<36> row_off_detect_bot<36> row_off_detect_bot<35> row_on_detect_bot<35>
+ row_on_detect_bot<34> row_off_detect_bot<34> row_off_detect_bot<33> row_on_detect_bot<33>
+ row_on_detect_bot<32> row_off_detect_bot<32> row_off_detect_bot<31> row_on_detect_bot<31>
+ row_on_detect_bot<30> row_off_detect_bot<30> row_off_detect_bot<29> row_on_detect_bot<29>
+ row_on_detect_bot<28> row_off_detect_bot<28> row_off_detect_bot<27> row_on_detect_bot<27>
+ row_on_detect_bot<26> row_off_detect_bot<26> row_off_detect_bot<25> row_on_detect_bot<25>
+ row_on_detect_bot<24> row_off_detect_bot<24> row_off_detect_bot<23> row_on_detect_bot<23>
+ row_on_detect_bot<22> row_off_detect_bot<22> row_off_detect_bot<21> row_on_detect_bot<21>
+ row_on_detect_bot<20> row_off_detect_bot<20> row_off_detect_bot<19> row_on_detect_bot<19>
+ row_on_detect_bot<18> row_off_detect_bot<18> row_off_detect_bot<17> row_on_detect_bot<17>
+ row_on_detect_bot<16> row_off_detect_bot<16> row_off_detect_bot<15> row_on_detect_bot<15>
+ row_on_detect_bot<14> row_off_detect_bot<14> row_off_detect_bot<13> row_on_detect_bot<13>
+ row_on_detect_bot<12> row_off_detect_bot<12> row_off_detect_bot<11> row_on_detect_bot<11>
+ row_on_detect_bot<10> row_off_detect_bot<10> row_off_detect_bot<9> row_on_detect_bot<9>
+ row_on_detect_bot<8> row_off_detect_bot<8> row_off_detect_bot<7> row_on_detect_bot<7>
+ row_on_detect_bot<6> row_off_detect_bot<6> row_off_detect_bot<5> row_on_detect_bot<5>
+ row_on_detect_bot<4> row_off_detect_bot<4> row_off_detect_bot<3> row_on_detect_bot<3>
+ row_on_detect_bot<2> row_off_detect_bot<2> row_off_detect_bot<1> row_on_detect_bot<1>
+ row_on_detect_bot<0> row_off_detect_bot<0> row_on_detect_bot<50> row_off_detect_bot<50>
+ row_off_detect_bot<49> row_on_detect_bot<49> row_on_detect_bot<48> row_off_detect_bot<48>
+ row_off_detect_bot<47> row_on_detect_bot<47> row_on_detect_bot<46> row_off_detect_bot<46>
+ row_off_detect_bot<45> row_on_detect_bot<45> row_on_detect_bot<44> row_off_detect_bot<44>
+ row_off_detect_bot<43> row_on_detect_bot<63> row_on_detect_bot<43> row_on_detect_bot<42>
+ row_off_detect_bot<42> row_on_detect_bot<62> row_off_detect_bot<41> row_on_detect_bot<41>
+ row_off_detect_bot<62> row_off_detect_bot<61> row_on_detect_bot<40> row_off_detect_bot<40>
+ row_off_detect_bot<39> row_on_detect_bot<39> row_on_detect_bot<38> row_off_detect_bot<38>
+ row_off_detect_bot<37> row_on_detect_bot<61> detect_pulse_global_bot_left row_on_detect_bot<60>
+ row_off_detect_bot<60> row_off_detect_bot<59> row_on_detect_bot<59> row_on_detect_bot<58>
+ row_off_detect_bot<58> row_off_detect_bot<57> row_on_detect_bot<57> row_on_detect_bot<56>
+ row_off_detect_bot<56> ndetect_pulse_global_bot_left row_off_detect_bot<55> pre_charge_global_bot_left
+ row_on_detect_bot<55> row_on_detect_bot<54> row_off_detect_bot<54> row_off_detect_bot<53>
+ row_on_detect_bot<53> row_on_detect_bot<52> row_off_detect_bot<52> row_off_detect_bot<51>
+ row_on_detect_bot<51> row_off_detect_bot<63> dac_config_6 dac_config_0
Xpixel_layout_tile_bot_0 row_on_detect_bot<2> row_on_detect_bot<3> row_on_detect_bot<4>
+ row_on_detect_bot<5> row_on_detect_bot<6> row_on_detect_bot<7> row_on_detect_bot<8>
+ row_on_detect_bot<9> row_on_detect_bot<10> row_on_detect_bot<11> row_on_detect_bot<12>
+ row_on_detect_bot<13> row_on_detect_bot<16> row_on_detect_bot<21> row_on_detect_bot<24>
+ row_on_detect_bot<26> row_on_detect_bot<27> row_on_detect_bot<30> row_on_detect_bot<31>
+ row_on_detect_bot<32> row_off_detect_bot<0> row_off_detect_bot<1> row_off_detect_bot<2>
+ row_off_detect_bot<3> row_off_detect_bot<6> row_off_detect_bot<7> row_off_detect_bot<12>
+ row_off_detect_bot<13> row_off_detect_bot<14> row_off_detect_bot<15> row_off_detect_bot<17>
+ row_off_detect_bot<18> row_off_detect_bot<19> row_off_detect_bot<20> row_off_detect_bot<21>
+ row_off_detect_bot<22> row_off_detect_bot<23> row_off_detect_bot<24> row_off_detect_bot<26>
+ row_off_detect_bot<28> row_off_detect_bot<29> row_on_detect_bot<42> row_on_detect_bot<43>
+ row_on_detect_bot<44> row_on_detect_bot<45> row_on_detect_bot<46> row_on_detect_bot<47>
+ row_on_detect_bot<48> row_on_detect_bot<49> row_off_detect_bot<34> row_off_detect_bot<36>
+ row_off_detect_bot<37> row_off_detect_bot<38> row_off_detect_bot<39> row_off_detect_bot<42>
+ row_off_detect_bot<43> row_on_detect_bot<56> row_on_detect_bot<57> row_on_detect_bot<52>
+ row_on_detect_bot<53> row_off_detect_bot<54> row_off_detect_bot<55> row_off_detect_bot<56>
+ row_off_detect_bot<57> row_off_detect_bot<58> row_off_detect_bot<59> row_on_detect_bot<60>
+ row_off_detect_bot<60> row_off_detect_bot<61> vssc1 ndetect_pulse_global_bot_left
+ array_col_bot_right<56> col_event_rst_bot_right<60> col_event_rst_bot_right<59>
+ col_event_rst_bot_right<58> col_event_rst_bot_right<57> col_event_rst_bot_right<56>
+ col_event_rst_bot_right<63> array_col_bot_right<53> array_col_bot_right<54> array_col_bot_right<55>
+ col_event_rst_bot_right<53> col_event_rst_bot_right<52> col_event_rst_bot_right<51>
+ col_event_rst_bot_right<50> col_event_rst_bot_right<55> col_event_rst_bot_right<54>
+ col_event_rst_bot_right<49> col_event_rst_bot_right<34> col_event_rst_bot_right<44>
+ col_event_rst_bot_right<43> col_event_rst_bot_right<35> col_event_rst_bot_right<36>
+ array_col_bot_right<35> col_event_rst_bot_right<32> col_event_rst_bot_right<33>
+ array_col_bot_right<15> array_col_bot_right<14> col_event_rst_bot_right<24> col_event_rst_bot_right<8>
+ col_event_rst_bot_right<21> col_event_rst_bot_right<22> col_event_rst_bot_right<14>
+ col_event_rst_bot_right<23> col_event_rst_bot_right<0> col_event_rst_bot_right<19>
+ col_event_rst_bot_right<1> col_event_rst_bot_right<2> col_event_rst_bot_right<7>
+ array_col_bot_right<3> array_col_bot_right<19> array_col_bot_right<2> array_col_bot_right<1>
+ array_col_bot_right<0> vdda1 vdda1 row_on_detect_bot<22> row_on_detect_bot<23> vdda1
+ vdda1 vdda1 vdda1 vdda1 vdda1 vdda1 row_off_detect_bot<48> row_on_detect_bot<17>
+ row_off_detect_bot<32> row_off_detect_bot<49> row_on_detect_bot<40> vssc1 row_off_detect_bot<33>
+ row_on_detect_bot<41> vdda1 vdda1 col_event_rst_bot_right<9> row_on_detect_bot<36>
+ vssc1 col_event_rst_bot_right<10> row_off_detect_bot<27> array_col_bot_right<10>
+ col_event_rst_bot_right<45> array_col_bot_right<47> col_event_rst_bot_right<46>
+ row_on_detect_bot<37> array_col_bot_right<12> vssc1 vssc1 vdda1 row_off_detect_bot<10>
+ row_off_detect_bot<25> col_event_rst_bot_right<25> vdda1 col_event_rst_bot_right<26>
+ array_col_bot_right<27> row_off_detect_bot<11> vssc1 vssc1 vdda1 vssc1 vdda1 row_off_detect_bot<52>
+ vdda1 row_off_detect_bot<44> vdda1 row_on_detect_bot<14> row_off_detect_bot<53>
+ row_off_detect_bot<45> col_event_rst_bot_right<11> col_event_rst_bot_right<12> col_event_rst_bot_right<47>
+ row_on_detect_bot<15> array_col_bot_right<29> array_col_bot_right<48> vssc1 vssc1
+ array_col_bot_right<49> col_event_rst_bot_right<27> col_event_rst_bot_right<28>
+ vssc1 row_off_detect_bot<62> vssc1 vdda1 row_off_detect_bot<46> row_on_detect_bot<54>
+ vssc1 row_off_detect_bot<63> vssc1 col_event_rst_bot_right<30> row_off_detect_bot<8>
+ row_off_detect_bot<47> row_on_detect_bot<55> col_event_rst_bot_right<48> array_col_bot_right<61>
+ vssc1 row_on_detect_bot<50> vssc1 row_off_detect_bot<9> array_col_bot_right<46>
+ vdda1 col_event_rst_bot_right<3> vssc1 vdda1 row_on_detect_bot<51> col_event_rst_bot_right<4>
+ array_col_bot_right<7> array_col_bot_right<39> vdda1 col_event_rst_bot_right<40>
+ vssc1 array_col_bot_right<6> col_event_rst_bot_right<37> col_event_rst_bot_right<38>
+ array_col_bot_right<38> col_event_rst_bot_right<13> array_col_bot_right<50> vssc1
+ vssc1 row_on_detect_bot<25> array_col_bot_right<57> array_col_bot_right<11> col_event_rst_bot_right<15>
+ col_event_rst_bot_right<16> vssc1 array_col_bot_right<51> vdda1 vssc1 vdda1 row_on_detect_bot<0>
+ array_col_bot_right<63> array_col_bot_right<42> array_col_bot_right<21> array_col_bot_right<60>
+ col_event_rst_bot_right<29> array_col_bot_right<13> row_on_detect_bot<1> row_off_detect_bot<30>
+ row_off_detect_bot<40> array_col_bot_right<31> array_col_bot_right<18> col_event_rst_bot_right<31>
+ array_col_bot_right<8> row_on_detect_bot<38> array_col_bot_right<59> col_event_rst_bot_right<20>
+ row_off_detect_bot<35> row_off_detect_bot<31> vdda1 array_col_bot_right<62> row_off_detect_bot<41>
+ array_col_bot_right<30> array_col_bot_right<5> vssc1 row_on_detect_bot<39> array_col_bot_right<52>
+ col_event_rst_bot_right<61> array_col_bot_right<58> array_col_bot_right<37> col_event_rst_bot_right<62>
+ array_col_bot_right<24> vdda1 col_event_rst_bot_right<5> array_col_bot_right<9>
+ array_col_bot_right<25> col_event_rst_bot_right<6> vssc1 vdda1 array_col_bot_right<4>
+ vdda1 row_on_detect_bot<62> col_event_rst_bot_right<41> row_off_detect_bot<4> row_on_detect_bot<18>
+ vssc1 col_event_rst_bot_right<42> array_col_bot_right<20> array_col_bot_right<36>
+ vdda1 vssc1 vssc1 col_event_rst_bot_right<39> row_on_detect_bot<63> vssc1 row_off_detect_bot<5>
+ row_on_detect_bot<19> vssc1 row_on_detect_bot<28> array_col_bot_right<40> row_on_detect_bot<34>
+ array_col_bot_right<26> array_col_bot_right<17> array_col_bot_right<32> vssc1 array_col_bot_right<41>
+ row_off_detect_bot<50> col_event_rst_bot_right<17> dac_config_6 array_col_bot_right<34>
+ col_event_rst_bot_right<18> row_on_detect_bot<29> row_on_detect_bot<35> vdda1 dac_config_4
+ array_col_bot_right<33> array_col_bot_right<22> row_on_detect_bot<58> array_col_bot_right<44>
+ array_col_bot_right<23> vssc1 array_col_bot_right<16> row_off_detect_bot<51> vssc1
+ vdda1 vdda1 row_on_detect_bot<33> dac_config_3 array_col_bot_right<28> detect_pulse_global_bot_left
+ vdda1 array_col_bot_right<43> vdda1 row_on_detect_bot<59> array_col_bot_right<45>
+ row_on_detect_bot<61> dac_config_0 row_off_detect_bot<16> pre_charge_global_bot_left
+ row_on_detect_bot<20> dac_config_1 vdda1 vssa1 dac_config_2 dac_config_5 pixel_layout_tile_bot
Xpixel_layout_tile_bot_1 row_on_detect_bot<2> row_on_detect_bot<3> row_on_detect_bot<4>
+ row_on_detect_bot<5> row_on_detect_bot<6> row_on_detect_bot<7> row_on_detect_bot<8>
+ row_on_detect_bot<9> row_on_detect_bot<10> row_on_detect_bot<11> row_on_detect_bot<12>
+ row_on_detect_bot<13> row_on_detect_bot<16> row_on_detect_bot<21> row_on_detect_bot<24>
+ row_on_detect_bot<26> row_on_detect_bot<27> row_on_detect_bot<30> row_on_detect_bot<31>
+ row_on_detect_bot<32> row_off_detect_bot<0> row_off_detect_bot<1> row_off_detect_bot<2>
+ row_off_detect_bot<3> row_off_detect_bot<6> row_off_detect_bot<7> row_off_detect_bot<12>
+ row_off_detect_bot<13> row_off_detect_bot<14> row_off_detect_bot<15> row_off_detect_bot<17>
+ row_off_detect_bot<18> row_off_detect_bot<19> row_off_detect_bot<20> row_off_detect_bot<21>
+ row_off_detect_bot<22> row_off_detect_bot<23> row_off_detect_bot<24> row_off_detect_bot<26>
+ row_off_detect_bot<28> row_off_detect_bot<29> row_on_detect_bot<42> row_on_detect_bot<43>
+ row_on_detect_bot<44> row_on_detect_bot<45> row_on_detect_bot<46> row_on_detect_bot<47>
+ row_on_detect_bot<48> row_on_detect_bot<49> row_off_detect_bot<34> row_off_detect_bot<36>
+ row_off_detect_bot<37> row_off_detect_bot<38> row_off_detect_bot<39> row_off_detect_bot<42>
+ row_off_detect_bot<43> row_on_detect_bot<56> row_on_detect_bot<57> row_on_detect_bot<52>
+ row_on_detect_bot<53> row_off_detect_bot<54> row_off_detect_bot<55> row_off_detect_bot<56>
+ row_off_detect_bot<57> row_off_detect_bot<58> row_off_detect_bot<59> row_on_detect_bot<60>
+ row_off_detect_bot<60> row_off_detect_bot<61> vssc1 ndetect_pulse_global_bot_left
+ array_col_bot_left<56> col_event_rst_bot_left<60> col_event_rst_bot_left<59> col_event_rst_bot_left<58>
+ col_event_rst_bot_left<57> col_event_rst_bot_left<56> col_event_rst_bot_left<63>
+ array_col_bot_left<53> array_col_bot_left<54> array_col_bot_left<55> col_event_rst_bot_left<53>
+ col_event_rst_bot_left<52> col_event_rst_bot_left<51> col_event_rst_bot_left<50>
+ col_event_rst_bot_left<55> col_event_rst_bot_left<54> col_event_rst_bot_left<49>
+ col_event_rst_bot_left<34> col_event_rst_bot_left<44> col_event_rst_bot_left<43>
+ col_event_rst_bot_left<35> col_event_rst_bot_left<36> array_col_bot_left<35> col_event_rst_bot_left<32>
+ col_event_rst_bot_left<33> array_col_bot_left<15> array_col_bot_left<14> col_event_rst_bot_left<24>
+ col_event_rst_bot_left<8> col_event_rst_bot_left<21> col_event_rst_bot_left<22>
+ col_event_rst_bot_left<14> col_event_rst_bot_left<23> col_event_rst_bot_left<0>
+ col_event_rst_bot_left<19> col_event_rst_bot_left<1> col_event_rst_bot_left<2> col_event_rst_bot_left<7>
+ array_col_bot_left<3> array_col_bot_left<19> array_col_bot_left<2> array_col_bot_left<1>
+ array_col_bot_left<0> vdda1 vdda1 row_on_detect_bot<22> row_on_detect_bot<23> vdda1
+ vdda1 vdda1 vdda1 vdda1 vdda1 vdda1 row_off_detect_bot<48> row_on_detect_bot<17>
+ row_off_detect_bot<32> row_off_detect_bot<49> row_on_detect_bot<40> vssc1 row_off_detect_bot<33>
+ row_on_detect_bot<41> vdda1 vdda1 col_event_rst_bot_left<9> row_on_detect_bot<36>
+ vssc1 col_event_rst_bot_left<10> row_off_detect_bot<27> array_col_bot_left<10> col_event_rst_bot_left<45>
+ array_col_bot_left<47> col_event_rst_bot_left<46> row_on_detect_bot<37> array_col_bot_left<12>
+ vssc1 vssc1 vdda1 row_off_detect_bot<10> row_off_detect_bot<25> col_event_rst_bot_left<25>
+ vdda1 col_event_rst_bot_left<26> array_col_bot_left<27> row_off_detect_bot<11> vssc1
+ vssc1 vdda1 vssc1 vdda1 row_off_detect_bot<52> vdda1 row_off_detect_bot<44> vdda1
+ row_on_detect_bot<14> row_off_detect_bot<53> row_off_detect_bot<45> col_event_rst_bot_left<11>
+ col_event_rst_bot_left<12> col_event_rst_bot_left<47> row_on_detect_bot<15> array_col_bot_left<29>
+ array_col_bot_left<48> vssc1 vssc1 array_col_bot_left<49> col_event_rst_bot_left<27>
+ col_event_rst_bot_left<28> vssc1 row_off_detect_bot<62> vssc1 vdda1 row_off_detect_bot<46>
+ row_on_detect_bot<54> vssc1 row_off_detect_bot<63> vssc1 col_event_rst_bot_left<30>
+ row_off_detect_bot<8> row_off_detect_bot<47> row_on_detect_bot<55> col_event_rst_bot_left<48>
+ array_col_bot_left<61> vssc1 row_on_detect_bot<50> vssc1 row_off_detect_bot<9> array_col_bot_left<46>
+ vdda1 col_event_rst_bot_left<3> vssc1 vdda1 row_on_detect_bot<51> col_event_rst_bot_left<4>
+ array_col_bot_left<7> array_col_bot_left<39> vdda1 col_event_rst_bot_left<40> vssc1
+ array_col_bot_left<6> col_event_rst_bot_left<37> col_event_rst_bot_left<38> array_col_bot_left<38>
+ col_event_rst_bot_left<13> array_col_bot_left<50> vssc1 vssc1 row_on_detect_bot<25>
+ array_col_bot_left<57> array_col_bot_left<11> col_event_rst_bot_left<15> col_event_rst_bot_left<16>
+ vssc1 array_col_bot_left<51> vdda1 vssc1 vdda1 row_on_detect_bot<0> array_col_bot_left<63>
+ array_col_bot_left<42> array_col_bot_left<21> array_col_bot_left<60> col_event_rst_bot_left<29>
+ array_col_bot_left<13> row_on_detect_bot<1> row_off_detect_bot<30> row_off_detect_bot<40>
+ array_col_bot_left<31> array_col_bot_left<18> col_event_rst_bot_left<31> array_col_bot_left<8>
+ row_on_detect_bot<38> array_col_bot_left<59> col_event_rst_bot_left<20> row_off_detect_bot<35>
+ row_off_detect_bot<31> vdda1 array_col_bot_left<62> row_off_detect_bot<41> array_col_bot_left<30>
+ array_col_bot_left<5> vssc1 row_on_detect_bot<39> array_col_bot_left<52> col_event_rst_bot_left<61>
+ array_col_bot_left<58> array_col_bot_left<37> col_event_rst_bot_left<62> array_col_bot_left<24>
+ vdda1 col_event_rst_bot_left<5> array_col_bot_left<9> array_col_bot_left<25> col_event_rst_bot_left<6>
+ vssc1 vdda1 array_col_bot_left<4> vdda1 row_on_detect_bot<62> col_event_rst_bot_left<41>
+ row_off_detect_bot<4> row_on_detect_bot<18> vssc1 col_event_rst_bot_left<42> array_col_bot_left<20>
+ array_col_bot_left<36> vdda1 vssc1 vssc1 col_event_rst_bot_left<39> row_on_detect_bot<63>
+ vssc1 row_off_detect_bot<5> row_on_detect_bot<19> vssc1 row_on_detect_bot<28> array_col_bot_left<40>
+ row_on_detect_bot<34> array_col_bot_left<26> array_col_bot_left<17> array_col_bot_left<32>
+ vssc1 array_col_bot_left<41> row_off_detect_bot<50> col_event_rst_bot_left<17> dac_config_6
+ array_col_bot_left<34> col_event_rst_bot_left<18> row_on_detect_bot<29> row_on_detect_bot<35>
+ vdda1 dac_config_4 array_col_bot_left<33> array_col_bot_left<22> row_on_detect_bot<58>
+ array_col_bot_left<44> array_col_bot_left<23> vssc1 array_col_bot_left<16> row_off_detect_bot<51>
+ vssc1 vdda1 vdda1 row_on_detect_bot<33> dac_config_3 array_col_bot_left<28> detect_pulse_global_bot_left
+ vdda1 array_col_bot_left<43> vdda1 row_on_detect_bot<59> array_col_bot_left<45>
+ row_on_detect_bot<61> dac_config_0 row_off_detect_bot<16> pre_charge_global_bot_left
+ row_on_detect_bot<20> dac_config_1 vdda1 vssa1 dac_config_2 dac_config_5 pixel_layout_tile_bot
Xpixel_layout_tile_0 array_col_top_left<16> array_col_top_left<17> array_col_top_left<18>
+ array_col_top_left<19> col_event_rst_top_left<27> col_event_rst_top_left<20> col_event_rst_top_left<19>
+ col_event_rst_top_left<18> col_event_rst_top_left<17> col_event_rst_top_left<16>
+ array_col_top_left<0> array_col_top_left<1> array_col_top_left<2> array_col_top_left<3>
+ array_col_top_left<4> array_col_top_left<5> array_col_top_left<6> array_col_top_left<7>
+ array_col_top_left<14> array_col_top_left<15> col_event_rst_top_left<14> col_event_rst_top_left<5>
+ col_event_rst_top_left<4> col_event_rst_top_left<3> col_event_rst_top_left<1> array_col_top_left<34>
+ array_col_top_left<35> array_col_top_left<36> array_col_top_left<37> array_col_top_left<38>
+ array_col_top_left<39> array_col_top_left<40> array_col_top_left<41> col_event_rst_top_left<38>
+ col_event_rst_top_left<37> col_event_rst_top_left<36> col_event_rst_top_left<35>
+ col_event_rst_top_left<33> col_event_rst_top_left<32> col_event_rst_top_left<45>
+ col_event_rst_top_left<46> row_off_detect_top<2> row_off_detect_top<3> ndetect_pulse_global_top_left
+ detect_pulse_global_top_left row_off_detect_top<5> row_on_detect_top<4> row_on_detect_top<5>
+ row_on_detect_top<8> row_on_detect_top<9> row_off_detect_top<0> row_off_detect_top<1>
+ array_col_top_left<63> array_col_top_left<62> array_col_top_left<57> array_col_top_left<56>
+ array_col_top_left<55> array_col_top_left<54> col_event_rst_top_left<54> col_event_rst_top_left<55>
+ col_event_rst_top_left<56> col_event_rst_top_left<57> col_event_rst_top_left<58>
+ array_col_top_left<53> col_event_rst_top_left<61> col_event_rst_top_left<62> col_event_rst_top_left<49>
+ col_event_rst_top_left<50> col_event_rst_top_left<51> col_event_rst_top_left<52>
+ col_event_rst_top_left<53> col_event_rst_top_left<63> row_off_detect_top<18> row_off_detect_top<26>
+ row_on_detect_top<12> row_off_detect_top<27> row_off_detect_top<19> row_on_detect_top<16>
+ row_on_detect_top<17> row_on_detect_top<20> row_on_detect_top<21> row_off_detect_top<28>
+ row_off_detect_top<29> row_off_detect_top<60> row_off_detect_top<61> row_off_detect_top<62>
+ row_off_detect_top<63> row_off_detect_top<36> row_off_detect_top<37> row_off_detect_top<40>
+ row_off_detect_top<41> row_off_detect_top<42> row_off_detect_top<43> row_off_detect_top<44>
+ row_off_detect_top<45> row_off_detect_top<46> row_off_detect_top<47> row_off_detect_top<48>
+ row_off_detect_top<49> row_on_detect_top<30> row_on_detect_top<31> row_on_detect_top<32>
+ row_on_detect_top<33> row_on_detect_top<38> row_on_detect_top<39> row_on_detect_top<48>
+ row_on_detect_top<49> row_on_detect_top<52> row_on_detect_top<53> row_on_detect_top<56>
+ row_on_detect_top<57> row_on_detect_top<58> row_on_detect_top<59> col_event_rst_top_left<13>
+ col_event_rst_top_left<28> array_col_top_left<52> array_col_top_left<49> array_col_top_left<48>
+ col_event_rst_top_left<6> col_event_rst_top_left<47> row_off_detect_top<34> array_col_top_left<51>
+ row_off_detect_top<35> array_col_top_left<50> col_event_rst_top_left<29> array_col_top_left<31>
+ col_event_rst_top_left<30> row_off_detect_top<14> vssc1 array_col_top_left<30> row_off_detect_top<15>
+ row_off_detect_top<32> row_on_detect_top<24> row_off_detect_top<33> row_on_detect_top<25>
+ row_off_detect_top<16> array_col_top_left<47> row_on_detect_top<0> col_event_rst_top_left<7>
+ array_col_top_left<13> col_event_rst_top_left<8> vssc1 row_on_detect_top<22> row_off_detect_top<17>
+ row_on_detect_top<26> row_on_detect_top<1> array_col_top_left<46> vssc1 row_on_detect_top<2>
+ row_on_detect_top<23> array_col_top_left<12> row_on_detect_top<62> vssc1 row_off_detect_top<12>
+ row_off_detect_top<56> row_on_detect_top<3> row_on_detect_top<28> array_col_top_left<29>
+ row_on_detect_top<63> row_off_detect_top<13> row_off_detect_top<57> row_on_detect_top<13>
+ col_event_rst_top_left<31> col_event_rst_top_left<48> row_on_detect_top<29> row_on_detect_top<10>
+ array_col_top_left<28> row_on_detect_top<11> col_event_rst_top_left<39> vssc1 col_event_rst_top_left<40>
+ row_off_detect_top<38> row_on_detect_top<6> row_off_detect_top<39> vssc1 col_event_rst_top_left<42>
+ array_col_top_left<45> vssc1 row_on_detect_top<7> array_col_top_left<11> vssc1 row_off_detect_top<52>
+ row_on_detect_top<42> row_on_detect_top<50> col_event_rst_top_left<9> col_event_rst_top_left<10>
+ array_col_top_left<44> array_col_top_left<61> row_off_detect_top<53> vssc1 array_col_top_left<10>
+ row_on_detect_top<43> array_col_top_left<23> row_on_detect_top<51> vssc1 pre_charge_global_top_left
+ dac_config_6 col_event_rst_top_left<24> vssc1 array_col_top_left<60> array_col_top_left<27>
+ row_off_detect_top<10> col_event_rst_top_left<21> row_on_detect_top<40> row_on_detect_top<54>
+ col_event_rst_top_left<22> array_col_top_left<22> row_on_detect_top<27> row_on_detect_top<18>
+ row_off_detect_top<11> vssc1 array_col_top_left<26> row_on_detect_top<55> row_off_detect_top<22>
+ row_off_detect_top<20> row_on_detect_top<19> row_off_detect_top<54> vssc1 vssc1
+ row_off_detect_top<23> row_off_detect_top<21> row_on_detect_top<14> row_on_detect_top<36>
+ row_on_detect_top<46> row_off_detect_top<55> col_event_rst_top_left<41> vssc1 vssc1
+ vssc1 row_off_detect_top<58> row_on_detect_top<15> row_on_detect_top<37> row_on_detect_top<47>
+ row_on_detect_top<34> array_col_top_left<43> col_event_rst_top_left<2> col_event_rst_top_left<43>
+ vssc1 col_event_rst_top_left<44> array_col_top_left<9> row_off_detect_top<59> row_off_detect_top<8>
+ col_event_rst_top_left<15> row_on_detect_top<35> col_event_rst_top_left<0> array_col_top_left<42>
+ vssc1 array_col_top_left<59> row_off_detect_top<9> col_event_rst_top_left<11> array_col_top_left<8>
+ array_col_top_left<21> col_event_rst_top_left<12> vssc1 vssc1 col_event_rst_top_left<59>
+ row_off_detect_top<6> col_event_rst_top_left<60> vssc1 array_col_top_left<58> row_on_detect_top<60>
+ vssc1 array_col_top_left<25> col_event_rst_top_left<25> col_event_rst_top_left<26>
+ row_on_detect_top<44> vssc1 vssc1 array_col_top_left<20> row_off_detect_top<30>
+ row_off_detect_top<50> row_off_detect_top<7> row_on_detect_top<41> row_off_detect_top<24>
+ col_event_rst_top_left<23> row_on_detect_top<61> vssc1 array_col_top_left<24> row_on_detect_top<45>
+ array_col_top_left<33> vssc1 row_off_detect_top<31> row_off_detect_top<51> row_off_detect_top<25>
+ vssc1 col_event_rst_top_left<34> vssc1 array_col_top_left<32> vssc1 row_off_detect_top<4>
+ vssc1 vdda1 dac_config_4 dac_config_3 dac_config_2 dac_config_0 dac_config_1 dac_config_5
+ vssa1 vssc1 vdda1 pixel_layout_tile
Xpixel_layout_tile_1 array_col_top_right<16> array_col_top_right<17> array_col_top_right<18>
+ array_col_top_right<19> col_event_rst_top_right<27> col_event_rst_top_right<20>
+ col_event_rst_top_right<19> col_event_rst_top_right<18> col_event_rst_top_right<17>
+ col_event_rst_top_right<16> array_col_top_right<0> array_col_top_right<1> array_col_top_right<2>
+ array_col_top_right<3> array_col_top_right<4> array_col_top_right<5> array_col_top_right<6>
+ array_col_top_right<7> array_col_top_right<14> array_col_top_right<15> col_event_rst_top_right<14>
+ col_event_rst_top_right<5> col_event_rst_top_right<4> col_event_rst_top_right<3>
+ col_event_rst_top_right<1> array_col_top_right<34> array_col_top_right<35> array_col_top_right<36>
+ array_col_top_right<37> array_col_top_right<38> array_col_top_right<39> array_col_top_right<40>
+ array_col_top_right<41> col_event_rst_top_right<38> col_event_rst_top_right<37>
+ col_event_rst_top_right<36> col_event_rst_top_right<35> col_event_rst_top_right<33>
+ col_event_rst_top_right<32> col_event_rst_top_right<45> col_event_rst_top_right<46>
+ row_off_detect_top<2> row_off_detect_top<3> ndetect_pulse_global_top_left detect_pulse_global_top_left
+ row_off_detect_top<5> row_on_detect_top<4> row_on_detect_top<5> row_on_detect_top<8>
+ row_on_detect_top<9> row_off_detect_top<0> row_off_detect_top<1> array_col_top_right<63>
+ array_col_top_right<62> array_col_top_right<57> array_col_top_right<56> array_col_top_right<55>
+ array_col_top_right<54> col_event_rst_top_right<54> col_event_rst_top_right<55>
+ col_event_rst_top_right<56> col_event_rst_top_right<57> col_event_rst_top_right<58>
+ array_col_top_right<53> col_event_rst_top_right<61> col_event_rst_top_right<62>
+ col_event_rst_top_right<49> col_event_rst_top_right<50> col_event_rst_top_right<51>
+ col_event_rst_top_right<52> col_event_rst_top_right<53> col_event_rst_top_right<63>
+ row_off_detect_top<18> row_off_detect_top<26> row_on_detect_top<12> row_off_detect_top<27>
+ row_off_detect_top<19> row_on_detect_top<16> row_on_detect_top<17> row_on_detect_top<20>
+ row_on_detect_top<21> row_off_detect_top<28> row_off_detect_top<29> row_off_detect_top<60>
+ row_off_detect_top<61> row_off_detect_top<62> row_off_detect_top<63> row_off_detect_top<36>
+ row_off_detect_top<37> row_off_detect_top<40> row_off_detect_top<41> row_off_detect_top<42>
+ row_off_detect_top<43> row_off_detect_top<44> row_off_detect_top<45> row_off_detect_top<46>
+ row_off_detect_top<47> row_off_detect_top<48> row_off_detect_top<49> row_on_detect_top<30>
+ row_on_detect_top<31> row_on_detect_top<32> row_on_detect_top<33> row_on_detect_top<38>
+ row_on_detect_top<39> row_on_detect_top<48> row_on_detect_top<49> row_on_detect_top<52>
+ row_on_detect_top<53> row_on_detect_top<56> row_on_detect_top<57> row_on_detect_top<58>
+ row_on_detect_top<59> col_event_rst_top_right<13> col_event_rst_top_right<28> array_col_top_right<52>
+ array_col_top_right<49> array_col_top_right<48> col_event_rst_top_right<6> col_event_rst_top_right<47>
+ row_off_detect_top<34> array_col_top_right<51> row_off_detect_top<35> array_col_top_right<50>
+ col_event_rst_top_right<29> array_col_top_right<31> col_event_rst_top_right<30>
+ row_off_detect_top<14> vssc1 array_col_top_right<30> row_off_detect_top<15> row_off_detect_top<32>
+ row_on_detect_top<24> row_off_detect_top<33> row_on_detect_top<25> row_off_detect_top<16>
+ array_col_top_right<47> row_on_detect_top<0> col_event_rst_top_right<7> array_col_top_right<13>
+ col_event_rst_top_right<8> vssc1 row_on_detect_top<22> row_off_detect_top<17> row_on_detect_top<26>
+ row_on_detect_top<1> array_col_top_right<46> vssc1 row_on_detect_top<2> row_on_detect_top<23>
+ array_col_top_right<12> row_on_detect_top<62> vssc1 row_off_detect_top<12> row_off_detect_top<56>
+ row_on_detect_top<3> row_on_detect_top<28> array_col_top_right<29> row_on_detect_top<63>
+ row_off_detect_top<13> row_off_detect_top<57> row_on_detect_top<13> col_event_rst_top_right<31>
+ col_event_rst_top_right<48> row_on_detect_top<29> row_on_detect_top<10> array_col_top_right<28>
+ row_on_detect_top<11> col_event_rst_top_right<39> vssc1 col_event_rst_top_right<40>
+ row_off_detect_top<38> row_on_detect_top<6> row_off_detect_top<39> vssc1 col_event_rst_top_right<42>
+ array_col_top_right<45> vssc1 row_on_detect_top<7> array_col_top_right<11> vssc1
+ row_off_detect_top<52> row_on_detect_top<42> row_on_detect_top<50> col_event_rst_top_right<9>
+ col_event_rst_top_right<10> array_col_top_right<44> array_col_top_right<61> row_off_detect_top<53>
+ vssc1 array_col_top_right<10> row_on_detect_top<43> array_col_top_right<23> row_on_detect_top<51>
+ vssc1 pre_charge_global_top_left dac_config_6 col_event_rst_top_right<24> vssc1
+ array_col_top_right<60> array_col_top_right<27> row_off_detect_top<10> col_event_rst_top_right<21>
+ row_on_detect_top<40> row_on_detect_top<54> col_event_rst_top_right<22> array_col_top_right<22>
+ row_on_detect_top<27> row_on_detect_top<18> row_off_detect_top<11> vssc1 array_col_top_right<26>
+ row_on_detect_top<55> row_off_detect_top<22> row_off_detect_top<20> row_on_detect_top<19>
+ row_off_detect_top<54> vssc1 vssc1 row_off_detect_top<23> row_off_detect_top<21>
+ row_on_detect_top<14> row_on_detect_top<36> row_on_detect_top<46> row_off_detect_top<55>
+ col_event_rst_top_right<41> vssc1 vssc1 vssc1 row_off_detect_top<58> row_on_detect_top<15>
+ row_on_detect_top<37> row_on_detect_top<47> row_on_detect_top<34> array_col_top_right<43>
+ col_event_rst_top_right<2> col_event_rst_top_right<43> vssc1 col_event_rst_top_right<44>
+ array_col_top_right<9> row_off_detect_top<59> row_off_detect_top<8> col_event_rst_top_right<15>
+ row_on_detect_top<35> col_event_rst_top_right<0> array_col_top_right<42> vssc1 array_col_top_right<59>
+ row_off_detect_top<9> col_event_rst_top_right<11> array_col_top_right<8> array_col_top_right<21>
+ col_event_rst_top_right<12> vssc1 vssc1 col_event_rst_top_right<59> row_off_detect_top<6>
+ col_event_rst_top_right<60> vssc1 array_col_top_right<58> row_on_detect_top<60>
+ vssc1 array_col_top_right<25> col_event_rst_top_right<25> col_event_rst_top_right<26>
+ row_on_detect_top<44> vssc1 vssc1 array_col_top_right<20> row_off_detect_top<30>
+ row_off_detect_top<50> row_off_detect_top<7> row_on_detect_top<41> row_off_detect_top<24>
+ col_event_rst_top_right<23> row_on_detect_top<61> vssc1 array_col_top_right<24>
+ row_on_detect_top<45> array_col_top_right<33> vssc1 row_off_detect_top<31> row_off_detect_top<51>
+ row_off_detect_top<25> vssc1 col_event_rst_top_right<34> vssc1 array_col_top_right<32>
+ vssc1 row_off_detect_top<4> vssc1 vdda1 dac_config_4 dac_config_3 dac_config_2 dac_config_0
+ dac_config_1 dac_config_5 vssa1 vssc1 vdda1 pixel_layout_tile
.ends
