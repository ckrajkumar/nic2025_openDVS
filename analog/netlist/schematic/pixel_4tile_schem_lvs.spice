** sch_path: /home/alienfalcon/Projects/skywater/open_dvs_py312/open_dvs/git_dvs/nic2025_openDVS/analog/xschem/pixel_4tile.sch
* 2-pin LVS stub for Magic photodiode (avoids dummy_25/26)
.subckt sky130_fd_pr__model__parasitic__diode_ps2dn PLUS MINUS
.ends

.subckt pixel_4tile_schem vdda1 vssa1 dac_config_0 dac_config_2 dac_config_1 dac_config_3
+ dac_config_5 dac_config_4 dac_config_6 pre_charge_global_bot_left row_off_detect_top[63]
+ row_off_detect_top[62] row_off_detect_top[61] row_off_detect_top[60]
+ row_off_detect_top[59] row_off_detect_top[58] row_off_detect_top[57]
+ row_off_detect_top[56] row_off_detect_top[55] row_off_detect_top[54]
+ row_off_detect_top[53] row_off_detect_top[52] row_off_detect_top[51]
+ row_off_detect_top[50] row_off_detect_top[49] row_off_detect_top[48]
+ row_off_detect_top[47] row_off_detect_top[46] row_off_detect_top[45]
+ row_off_detect_top[44] row_off_detect_top[43] row_off_detect_top[42]
+ row_off_detect_top[41] row_off_detect_top[40] row_off_detect_top[39]
+ row_off_detect_top[38] row_off_detect_top[37] row_off_detect_top[36]
+ row_off_detect_top[35] row_off_detect_top[34] row_off_detect_top[33]
+ row_off_detect_top[32] row_off_detect_top[31] row_off_detect_top[30]
+ row_off_detect_top[29] row_off_detect_top[28] row_off_detect_top[27]
+ row_off_detect_top[26] row_off_detect_top[25] row_off_detect_top[24]
+ row_off_detect_top[23] row_off_detect_top[22] row_off_detect_top[21]
+ row_off_detect_top[20] row_off_detect_top[19] row_off_detect_top[18]
+ row_off_detect_top[17] row_off_detect_top[16] row_off_detect_top[15]
+ row_off_detect_top[14] row_off_detect_top[13] row_off_detect_top[12]
+ row_off_detect_top[11] row_off_detect_top[10] row_off_detect_top[9]
+ row_off_detect_top[8] row_off_detect_top[7] row_off_detect_top[6] row_off_detect_top[5]
+ row_off_detect_top[4] row_off_detect_top[3] row_off_detect_top[2] row_off_detect_top[1]
+ row_off_detect_top[0] row_on_detect_top[63] row_on_detect_top[62] row_on_detect_top[61]
+ row_on_detect_top[60] row_on_detect_top[59] row_on_detect_top[58] row_on_detect_top[57]
+ row_on_detect_top[56] row_on_detect_top[55] row_on_detect_top[54] row_on_detect_top[53]
+ row_on_detect_top[52] row_on_detect_top[51] row_on_detect_top[50] row_on_detect_top[49]
+ row_on_detect_top[48] row_on_detect_top[47] row_on_detect_top[46] row_on_detect_top[45]
+ row_on_detect_top[44] row_on_detect_top[43] row_on_detect_top[42] row_on_detect_top[41]
+ row_on_detect_top[40] row_on_detect_top[39] row_on_detect_top[38] row_on_detect_top[37]
+ row_on_detect_top[36] row_on_detect_top[35] row_on_detect_top[34] row_on_detect_top[33]
+ row_on_detect_top[32] row_on_detect_top[31] row_on_detect_top[30] row_on_detect_top[29]
+ row_on_detect_top[28] row_on_detect_top[27] row_on_detect_top[26] row_on_detect_top[25]
+ row_on_detect_top[24] row_on_detect_top[23] row_on_detect_top[22] row_on_detect_top[21]
+ row_on_detect_top[20] row_on_detect_top[19] row_on_detect_top[18] row_on_detect_top[17]
+ row_on_detect_top[16] row_on_detect_top[15] row_on_detect_top[14] row_on_detect_top[13]
+ row_on_detect_top[12] row_on_detect_top[11] row_on_detect_top[10] row_on_detect_top[9]
+ row_on_detect_top[8] row_on_detect_top[7] row_on_detect_top[6] row_on_detect_top[5]
+ row_on_detect_top[4] row_on_detect_top[3] row_on_detect_top[2] row_on_detect_top[1]
+ row_on_detect_top[0] row_off_detect_bot[63] row_off_detect_bot[62]
+ row_off_detect_bot[61] row_off_detect_bot[60] row_off_detect_bot[59]
+ row_off_detect_bot[58] row_off_detect_bot[57] row_off_detect_bot[56]
+ row_off_detect_bot[55] row_off_detect_bot[54] row_off_detect_bot[53]
+ row_off_detect_bot[52] row_off_detect_bot[51] row_off_detect_bot[50]
+ row_off_detect_bot[49] row_off_detect_bot[48] row_off_detect_bot[47]
+ row_off_detect_bot[46] row_off_detect_bot[45] row_off_detect_bot[44]
+ row_off_detect_bot[43] row_off_detect_bot[42] row_off_detect_bot[41]
+ row_off_detect_bot[40] row_off_detect_bot[39] row_off_detect_bot[38]
+ row_off_detect_bot[37] row_off_detect_bot[36] row_off_detect_bot[35]
+ row_off_detect_bot[34] row_off_detect_bot[33] row_off_detect_bot[32]
+ row_off_detect_bot[31] row_off_detect_bot[30] row_off_detect_bot[29]
+ row_off_detect_bot[28] row_off_detect_bot[27] row_off_detect_bot[26]
+ row_off_detect_bot[25] row_off_detect_bot[24] row_off_detect_bot[23]
+ row_off_detect_bot[22] row_off_detect_bot[21] row_off_detect_bot[20]
+ row_off_detect_bot[19] row_off_detect_bot[18] row_off_detect_bot[17]
+ row_off_detect_bot[16] row_off_detect_bot[15] row_off_detect_bot[14]
+ row_off_detect_bot[13] row_off_detect_bot[12] row_off_detect_bot[11]
+ row_off_detect_bot[10] row_off_detect_bot[9] row_off_detect_bot[8] row_off_detect_bot[7]
+ row_off_detect_bot[6] row_off_detect_bot[5] row_off_detect_bot[4] row_off_detect_bot[3]
+ row_off_detect_bot[2] row_off_detect_bot[1] row_off_detect_bot[0] row_on_detect_bot[63]
+ row_on_detect_bot[62] row_on_detect_bot[61] row_on_detect_bot[60] row_on_detect_bot[59]
+ row_on_detect_bot[58] row_on_detect_bot[57] row_on_detect_bot[56] row_on_detect_bot[55]
+ row_on_detect_bot[54] row_on_detect_bot[53] row_on_detect_bot[52] row_on_detect_bot[51]
+ row_on_detect_bot[50] row_on_detect_bot[49] row_on_detect_bot[48] row_on_detect_bot[47]
+ row_on_detect_bot[46] row_on_detect_bot[45] row_on_detect_bot[44] row_on_detect_bot[43]
+ row_on_detect_bot[42] row_on_detect_bot[41] row_on_detect_bot[40] row_on_detect_bot[39]
+ row_on_detect_bot[38] row_on_detect_bot[37] row_on_detect_bot[36] row_on_detect_bot[35]
+ row_on_detect_bot[34] row_on_detect_bot[33] row_on_detect_bot[32] row_on_detect_bot[31]
+ row_on_detect_bot[30] row_on_detect_bot[29] row_on_detect_bot[28] row_on_detect_bot[27]
+ row_on_detect_bot[26] row_on_detect_bot[25] row_on_detect_bot[24] row_on_detect_bot[23]
+ row_on_detect_bot[22] row_on_detect_bot[21] row_on_detect_bot[20] row_on_detect_bot[19]
+ row_on_detect_bot[18] row_on_detect_bot[17] row_on_detect_bot[16] row_on_detect_bot[15]
+ row_on_detect_bot[14] row_on_detect_bot[13] row_on_detect_bot[12] row_on_detect_bot[11]
+ row_on_detect_bot[10] row_on_detect_bot[9] row_on_detect_bot[8] row_on_detect_bot[7]
+ row_on_detect_bot[6] row_on_detect_bot[5] row_on_detect_bot[4] row_on_detect_bot[3]
+ row_on_detect_bot[2] row_on_detect_bot[1] row_on_detect_bot[0]
+ detect_pulse_global_top_left ndetect_pulse_global_top_left pre_charge_global_top_left
+ detect_pulse_global_bot_left ndetect_pulse_global_bot_left array_col_top_left[63]
+ array_col_top_left[62] array_col_top_left[61] array_col_top_left[60]
+ array_col_top_left[59] array_col_top_left[58] array_col_top_left[57]
+ array_col_top_left[56] array_col_top_left[55] array_col_top_left[54]
+ array_col_top_left[53] array_col_top_left[52] array_col_top_left[51]
+ array_col_top_left[50] array_col_top_left[49] array_col_top_left[48]
+ array_col_top_left[47] array_col_top_left[46] array_col_top_left[45]
+ array_col_top_left[44] array_col_top_left[43] array_col_top_left[42]
+ array_col_top_left[41] array_col_top_left[40] array_col_top_left[39]
+ array_col_top_left[38] array_col_top_left[37] array_col_top_left[36]
+ array_col_top_left[35] array_col_top_left[34] array_col_top_left[33]
+ array_col_top_left[32] array_col_top_left[31] array_col_top_left[30]
+ array_col_top_left[29] array_col_top_left[28] array_col_top_left[27]
+ array_col_top_left[26] array_col_top_left[25] array_col_top_left[24]
+ array_col_top_left[23] array_col_top_left[22] array_col_top_left[21]
+ array_col_top_left[20] array_col_top_left[19] array_col_top_left[18]
+ array_col_top_left[17] array_col_top_left[16] array_col_top_left[15]
+ array_col_top_left[14] array_col_top_left[13] array_col_top_left[12]
+ array_col_top_left[11] array_col_top_left[10] array_col_top_left[9]
+ array_col_top_left[8] array_col_top_left[7] array_col_top_left[6] array_col_top_left[5]
+ array_col_top_left[4] array_col_top_left[3] array_col_top_left[2] array_col_top_left[1]
+ array_col_top_left[0] array_col_top_right[63] array_col_top_right[62]
+ array_col_top_right[61] array_col_top_right[60] array_col_top_right[59]
+ array_col_top_right[58] array_col_top_right[57] array_col_top_right[56]
+ array_col_top_right[55] array_col_top_right[54] array_col_top_right[53]
+ array_col_top_right[52] array_col_top_right[51] array_col_top_right[50]
+ array_col_top_right[49] array_col_top_right[48] array_col_top_right[47]
+ array_col_top_right[46] array_col_top_right[45] array_col_top_right[44]
+ array_col_top_right[43] array_col_top_right[42] array_col_top_right[41]
+ array_col_top_right[40] array_col_top_right[39] array_col_top_right[38]
+ array_col_top_right[37] array_col_top_right[36] array_col_top_right[35]
+ array_col_top_right[34] array_col_top_right[33] array_col_top_right[32]
+ array_col_top_right[31] array_col_top_right[30] array_col_top_right[29]
+ array_col_top_right[28] array_col_top_right[27] array_col_top_right[26]
+ array_col_top_right[25] array_col_top_right[24] array_col_top_right[23]
+ array_col_top_right[22] array_col_top_right[21] array_col_top_right[20]
+ array_col_top_right[19] array_col_top_right[18] array_col_top_right[17]
+ array_col_top_right[16] array_col_top_right[15] array_col_top_right[14]
+ array_col_top_right[13] array_col_top_right[12] array_col_top_right[11]
+ array_col_top_right[10] array_col_top_right[9] array_col_top_right[8]
+ array_col_top_right[7] array_col_top_right[6] array_col_top_right[5]
+ array_col_top_right[4] array_col_top_right[3] array_col_top_right[2]
+ array_col_top_right[1] array_col_top_right[0] array_col_bot_left[63]
+ array_col_bot_left[62] array_col_bot_left[61] array_col_bot_left[60]
+ array_col_bot_left[59] array_col_bot_left[58] array_col_bot_left[57]
+ array_col_bot_left[56] array_col_bot_left[55] array_col_bot_left[54]
+ array_col_bot_left[53] array_col_bot_left[52] array_col_bot_left[51]
+ array_col_bot_left[50] array_col_bot_left[49] array_col_bot_left[48]
+ array_col_bot_left[47] array_col_bot_left[46] array_col_bot_left[45]
+ array_col_bot_left[44] array_col_bot_left[43] array_col_bot_left[42]
+ array_col_bot_left[41] array_col_bot_left[40] array_col_bot_left[39]
+ array_col_bot_left[38] array_col_bot_left[37] array_col_bot_left[36]
+ array_col_bot_left[35] array_col_bot_left[34] array_col_bot_left[33]
+ array_col_bot_left[32] array_col_bot_left[31] array_col_bot_left[30]
+ array_col_bot_left[29] array_col_bot_left[28] array_col_bot_left[27]
+ array_col_bot_left[26] array_col_bot_left[25] array_col_bot_left[24]
+ array_col_bot_left[23] array_col_bot_left[22] array_col_bot_left[21]
+ array_col_bot_left[20] array_col_bot_left[19] array_col_bot_left[18]
+ array_col_bot_left[17] array_col_bot_left[16] array_col_bot_left[15]
+ array_col_bot_left[14] array_col_bot_left[13] array_col_bot_left[12]
+ array_col_bot_left[11] array_col_bot_left[10] array_col_bot_left[9]
+ array_col_bot_left[8] array_col_bot_left[7] array_col_bot_left[6] array_col_bot_left[5]
+ array_col_bot_left[4] array_col_bot_left[3] array_col_bot_left[2] array_col_bot_left[1]
+ array_col_bot_left[0] array_col_bot_right[63] array_col_bot_right[62]
+ array_col_bot_right[61] array_col_bot_right[60] array_col_bot_right[59]
+ array_col_bot_right[58] array_col_bot_right[57] array_col_bot_right[56]
+ array_col_bot_right[55] array_col_bot_right[54] array_col_bot_right[53]
+ array_col_bot_right[52] array_col_bot_right[51] array_col_bot_right[50]
+ array_col_bot_right[49] array_col_bot_right[48] array_col_bot_right[47]
+ array_col_bot_right[46] array_col_bot_right[45] array_col_bot_right[44]
+ array_col_bot_right[43] array_col_bot_right[42] array_col_bot_right[41]
+ array_col_bot_right[40] array_col_bot_right[39] array_col_bot_right[38]
+ array_col_bot_right[37] array_col_bot_right[36] array_col_bot_right[35]
+ array_col_bot_right[34] array_col_bot_right[33] array_col_bot_right[32]
+ array_col_bot_right[31] array_col_bot_right[30] array_col_bot_right[29]
+ array_col_bot_right[28] array_col_bot_right[27] array_col_bot_right[26]
+ array_col_bot_right[25] array_col_bot_right[24] array_col_bot_right[23]
+ array_col_bot_right[22] array_col_bot_right[21] array_col_bot_right[20]
+ array_col_bot_right[19] array_col_bot_right[18] array_col_bot_right[17]
+ array_col_bot_right[16] array_col_bot_right[15] array_col_bot_right[14]
+ array_col_bot_right[13] array_col_bot_right[12] array_col_bot_right[11]
+ array_col_bot_right[10] array_col_bot_right[9] array_col_bot_right[8]
+ array_col_bot_right[7] array_col_bot_right[6] array_col_bot_right[5]
+ array_col_bot_right[4] array_col_bot_right[3] array_col_bot_right[2]
+ array_col_bot_right[1] array_col_bot_right[0] col_event_rst_top_left[63]
+ col_event_rst_top_left[62] col_event_rst_top_left[61] col_event_rst_top_left[60]
+ col_event_rst_top_left[59] col_event_rst_top_left[58] col_event_rst_top_left[57]
+ col_event_rst_top_left[56] col_event_rst_top_left[55] col_event_rst_top_left[54]
+ col_event_rst_top_left[53] col_event_rst_top_left[52] col_event_rst_top_left[51]
+ col_event_rst_top_left[50] col_event_rst_top_left[49] col_event_rst_top_left[48]
+ col_event_rst_top_left[47] col_event_rst_top_left[46] col_event_rst_top_left[45]
+ col_event_rst_top_left[44] col_event_rst_top_left[43] col_event_rst_top_left[42]
+ col_event_rst_top_left[41] col_event_rst_top_left[40] col_event_rst_top_left[39]
+ col_event_rst_top_left[38] col_event_rst_top_left[37] col_event_rst_top_left[36]
+ col_event_rst_top_left[35] col_event_rst_top_left[34] col_event_rst_top_left[33]
+ col_event_rst_top_left[32] col_event_rst_top_left[31] col_event_rst_top_left[30]
+ col_event_rst_top_left[29] col_event_rst_top_left[28] col_event_rst_top_left[27]
+ col_event_rst_top_left[26] col_event_rst_top_left[25] col_event_rst_top_left[24]
+ col_event_rst_top_left[23] col_event_rst_top_left[22] col_event_rst_top_left[21]
+ col_event_rst_top_left[20] col_event_rst_top_left[19] col_event_rst_top_left[18]
+ col_event_rst_top_left[17] col_event_rst_top_left[16] col_event_rst_top_left[15]
+ col_event_rst_top_left[14] col_event_rst_top_left[13] col_event_rst_top_left[12]
+ col_event_rst_top_left[11] col_event_rst_top_left[10] col_event_rst_top_left[9]
+ col_event_rst_top_left[8] col_event_rst_top_left[7] col_event_rst_top_left[6]
+ col_event_rst_top_left[5] col_event_rst_top_left[4] col_event_rst_top_left[3]
+ col_event_rst_top_left[2] col_event_rst_top_left[1] col_event_rst_top_left[0]
+ col_event_rst_top_right[63] col_event_rst_top_right[62] col_event_rst_top_right[61]
+ col_event_rst_top_right[60] col_event_rst_top_right[59] col_event_rst_top_right[58]
+ col_event_rst_top_right[57] col_event_rst_top_right[56] col_event_rst_top_right[55]
+ col_event_rst_top_right[54] col_event_rst_top_right[53] col_event_rst_top_right[52]
+ col_event_rst_top_right[51] col_event_rst_top_right[50] col_event_rst_top_right[49]
+ col_event_rst_top_right[48] col_event_rst_top_right[47] col_event_rst_top_right[46]
+ col_event_rst_top_right[45] col_event_rst_top_right[44] col_event_rst_top_right[43]
+ col_event_rst_top_right[42] col_event_rst_top_right[41] col_event_rst_top_right[40]
+ col_event_rst_top_right[39] col_event_rst_top_right[38] col_event_rst_top_right[37]
+ col_event_rst_top_right[36] col_event_rst_top_right[35] col_event_rst_top_right[34]
+ col_event_rst_top_right[33] col_event_rst_top_right[32] col_event_rst_top_right[31]
+ col_event_rst_top_right[30] col_event_rst_top_right[29] col_event_rst_top_right[28]
+ col_event_rst_top_right[27] col_event_rst_top_right[26] col_event_rst_top_right[25]
+ col_event_rst_top_right[24] col_event_rst_top_right[23] col_event_rst_top_right[22]
+ col_event_rst_top_right[21] col_event_rst_top_right[20] col_event_rst_top_right[19]
+ col_event_rst_top_right[18] col_event_rst_top_right[17] col_event_rst_top_right[16]
+ col_event_rst_top_right[15] col_event_rst_top_right[14] col_event_rst_top_right[13]
+ col_event_rst_top_right[12] col_event_rst_top_right[11] col_event_rst_top_right[10]
+ col_event_rst_top_right[9] col_event_rst_top_right[8] col_event_rst_top_right[7]
+ col_event_rst_top_right[6] col_event_rst_top_right[5] col_event_rst_top_right[4]
+ col_event_rst_top_right[3] col_event_rst_top_right[2] col_event_rst_top_right[1]
+ col_event_rst_top_right[0] col_event_rst_bot_left[63] col_event_rst_bot_left[62]
+ col_event_rst_bot_left[61] col_event_rst_bot_left[60] col_event_rst_bot_left[59]
+ col_event_rst_bot_left[58] col_event_rst_bot_left[57] col_event_rst_bot_left[56]
+ col_event_rst_bot_left[55] col_event_rst_bot_left[54] col_event_rst_bot_left[53]
+ col_event_rst_bot_left[52] col_event_rst_bot_left[51] col_event_rst_bot_left[50]
+ col_event_rst_bot_left[49] col_event_rst_bot_left[48] col_event_rst_bot_left[47]
+ col_event_rst_bot_left[46] col_event_rst_bot_left[45] col_event_rst_bot_left[44]
+ col_event_rst_bot_left[43] col_event_rst_bot_left[42] col_event_rst_bot_left[41]
+ col_event_rst_bot_left[40] col_event_rst_bot_left[39] col_event_rst_bot_left[38]
+ col_event_rst_bot_left[37] col_event_rst_bot_left[36] col_event_rst_bot_left[35]
+ col_event_rst_bot_left[34] col_event_rst_bot_left[33] col_event_rst_bot_left[32]
+ col_event_rst_bot_left[31] col_event_rst_bot_left[30] col_event_rst_bot_left[29]
+ col_event_rst_bot_left[28] col_event_rst_bot_left[27] col_event_rst_bot_left[26]
+ col_event_rst_bot_left[25] col_event_rst_bot_left[24] col_event_rst_bot_left[23]
+ col_event_rst_bot_left[22] col_event_rst_bot_left[21] col_event_rst_bot_left[20]
+ col_event_rst_bot_left[19] col_event_rst_bot_left[18] col_event_rst_bot_left[17]
+ col_event_rst_bot_left[16] col_event_rst_bot_left[15] col_event_rst_bot_left[14]
+ col_event_rst_bot_left[13] col_event_rst_bot_left[12] col_event_rst_bot_left[11]
+ col_event_rst_bot_left[10] col_event_rst_bot_left[9] col_event_rst_bot_left[8]
+ col_event_rst_bot_left[7] col_event_rst_bot_left[6] col_event_rst_bot_left[5]
+ col_event_rst_bot_left[4] col_event_rst_bot_left[3] col_event_rst_bot_left[2]
+ col_event_rst_bot_left[1] col_event_rst_bot_left[0] col_event_rst_bot_right[63]
+ col_event_rst_bot_right[62] col_event_rst_bot_right[61] col_event_rst_bot_right[60]
+ col_event_rst_bot_right[59] col_event_rst_bot_right[58] col_event_rst_bot_right[57]
+ col_event_rst_bot_right[56] col_event_rst_bot_right[55] col_event_rst_bot_right[54]
+ col_event_rst_bot_right[53] col_event_rst_bot_right[52] col_event_rst_bot_right[51]
+ col_event_rst_bot_right[50] col_event_rst_bot_right[49] col_event_rst_bot_right[48]
+ col_event_rst_bot_right[47] col_event_rst_bot_right[46] col_event_rst_bot_right[45]
+ col_event_rst_bot_right[44] col_event_rst_bot_right[43] col_event_rst_bot_right[42]
+ col_event_rst_bot_right[41] col_event_rst_bot_right[40] col_event_rst_bot_right[39]
+ col_event_rst_bot_right[38] col_event_rst_bot_right[37] col_event_rst_bot_right[36]
+ col_event_rst_bot_right[35] col_event_rst_bot_right[34] col_event_rst_bot_right[33]
+ col_event_rst_bot_right[32] col_event_rst_bot_right[31] col_event_rst_bot_right[30]
+ col_event_rst_bot_right[29] col_event_rst_bot_right[28] col_event_rst_bot_right[27]
+ col_event_rst_bot_right[26] col_event_rst_bot_right[25] col_event_rst_bot_right[24]
+ col_event_rst_bot_right[23] col_event_rst_bot_right[22] col_event_rst_bot_right[21]
+ col_event_rst_bot_right[20] col_event_rst_bot_right[19] col_event_rst_bot_right[18]
+ col_event_rst_bot_right[17] col_event_rst_bot_right[16] col_event_rst_bot_right[15]
+ col_event_rst_bot_right[14] col_event_rst_bot_right[13] col_event_rst_bot_right[12]
+ col_event_rst_bot_right[11] col_event_rst_bot_right[10] col_event_rst_bot_right[9]
+ col_event_rst_bot_right[8] col_event_rst_bot_right[7] col_event_rst_bot_right[6]
+ col_event_rst_bot_right[5] col_event_rst_bot_right[4] col_event_rst_bot_right[3]
+ col_event_rst_bot_right[2] col_event_rst_bot_right[1] col_event_rst_bot_right[0] vssc1
x1_x0 dac_config_3 dac_config_5 col_event_rst_top_left[63] dac_config_4
+ row_on_detect_top[1] dac_config_0 dac_config_1 row_off_detect_top[0] x1_net1
+ dac_config_2 vdda1 vssa1 vssc1 col_event_rst_top_left[62] x1_net2 row_on_detect_top[0]
+ row_off_detect_top[1] openDVS_pixel2x2_top
x1_x1 dac_config_3 dac_config_5 col_event_rst_top_left[61] dac_config_4
+ row_on_detect_top[1] dac_config_0 dac_config_1 row_off_detect_top[0] x1_net5
+ dac_config_2 vdda1 vssa1 vssc1 col_event_rst_top_left[60] x1_net6 row_on_detect_top[0]
+ row_off_detect_top[1] openDVS_pixel2x2_top
x1_x2 dac_config_3 dac_config_5 col_event_rst_top_left[59] dac_config_4
+ row_on_detect_top[1] dac_config_0 dac_config_1 row_off_detect_top[0] x1_net9
+ dac_config_2 vdda1 vssa1 vssc1 col_event_rst_top_left[58] x1_net10 row_on_detect_top[0]
+ row_off_detect_top[1] openDVS_pixel2x2_top
x1_x3 dac_config_3 dac_config_5 col_event_rst_top_left[57] dac_config_4
+ row_on_detect_top[1] dac_config_0 dac_config_1 row_off_detect_top[0] x1_net13
+ dac_config_2 vdda1 vssa1 vssc1 col_event_rst_top_left[56] x1_net14 row_on_detect_top[0]
+ row_off_detect_top[1] openDVS_pixel2x2_top
x1_x4 dac_config_3 dac_config_5 col_event_rst_top_left[55] dac_config_4
+ row_on_detect_top[1] dac_config_0 dac_config_1 row_off_detect_top[0] x1_net17
+ dac_config_2 vdda1 vssa1 vssc1 col_event_rst_top_left[54] x1_net18 row_on_detect_top[0]
+ row_off_detect_top[1] openDVS_pixel2x2_top
x1_x5 dac_config_3 dac_config_5 col_event_rst_top_left[53] dac_config_4
+ row_on_detect_top[1] dac_config_0 dac_config_1 row_off_detect_top[0] x1_net21
+ dac_config_2 vdda1 vssa1 vssc1 col_event_rst_top_left[52] x1_net22 row_on_detect_top[0]
+ row_off_detect_top[1] openDVS_pixel2x2_top
x1_x6 dac_config_3 dac_config_5 col_event_rst_top_left[51] dac_config_4
+ row_on_detect_top[1] dac_config_0 dac_config_1 row_off_detect_top[0] x1_net25
+ dac_config_2 vdda1 vssa1 vssc1 col_event_rst_top_left[50] x1_net26 row_on_detect_top[0]
+ row_off_detect_top[1] openDVS_pixel2x2_top
x1_x7 dac_config_3 dac_config_5 col_event_rst_top_left[49] dac_config_4
+ row_on_detect_top[1] dac_config_0 dac_config_1 row_off_detect_top[0] x1_net29
+ dac_config_2 vdda1 vssa1 vssc1 col_event_rst_top_left[48] x1_net30 row_on_detect_top[0]
+ row_off_detect_top[1] openDVS_pixel2x2_top
x1_x8 dac_config_3 dac_config_5 col_event_rst_top_left[47] dac_config_4
+ row_on_detect_top[1] dac_config_0 dac_config_1 row_off_detect_top[0] x1_net33
+ dac_config_2 vdda1 vssa1 vssc1 col_event_rst_top_left[46] x1_net34 row_on_detect_top[0]
+ row_off_detect_top[1] openDVS_pixel2x2_top
x1_x9 dac_config_3 dac_config_5 col_event_rst_top_left[45] dac_config_4
+ row_on_detect_top[1] dac_config_0 dac_config_1 row_off_detect_top[0] x1_net37
+ dac_config_2 vdda1 vssa1 vssc1 col_event_rst_top_left[44] x1_net38 row_on_detect_top[0]
+ row_off_detect_top[1] openDVS_pixel2x2_top
x1_x10 dac_config_3 dac_config_5 col_event_rst_top_left[43] dac_config_4
+ row_on_detect_top[1] dac_config_0 dac_config_1 row_off_detect_top[0] x1_net41
+ dac_config_2 vdda1 vssa1 vssc1 col_event_rst_top_left[42] x1_net42 row_on_detect_top[0]
+ row_off_detect_top[1] openDVS_pixel2x2_top
x1_x11 dac_config_3 dac_config_5 col_event_rst_top_left[41] dac_config_4
+ row_on_detect_top[1] dac_config_0 dac_config_1 row_off_detect_top[0] x1_net45
+ dac_config_2 vdda1 vssa1 vssc1 col_event_rst_top_left[40] x1_net46 row_on_detect_top[0]
+ row_off_detect_top[1] openDVS_pixel2x2_top
x1_x12 dac_config_3 dac_config_5 col_event_rst_top_left[39] dac_config_4
+ row_on_detect_top[1] dac_config_0 dac_config_1 row_off_detect_top[0] x1_net49
+ dac_config_2 vdda1 vssa1 vssc1 col_event_rst_top_left[38] x1_net50 row_on_detect_top[0]
+ row_off_detect_top[1] openDVS_pixel2x2_top
x1_x13 dac_config_3 dac_config_5 col_event_rst_top_left[37] dac_config_4
+ row_on_detect_top[1] dac_config_0 dac_config_1 row_off_detect_top[0] x1_net53
+ dac_config_2 vdda1 vssa1 vssc1 col_event_rst_top_left[36] x1_net54 row_on_detect_top[0]
+ row_off_detect_top[1] openDVS_pixel2x2_top
x1_x14 dac_config_3 dac_config_5 col_event_rst_top_left[35] dac_config_4
+ row_on_detect_top[1] dac_config_0 dac_config_1 row_off_detect_top[0] x1_net57
+ dac_config_2 vdda1 vssa1 vssc1 col_event_rst_top_left[34] x1_net58 row_on_detect_top[0]
+ row_off_detect_top[1] openDVS_pixel2x2_top
x1_x15 dac_config_3 dac_config_5 col_event_rst_top_left[33] dac_config_4
+ row_on_detect_top[1] dac_config_0 dac_config_1 row_off_detect_top[0] x1_net61
+ dac_config_2 vdda1 vssa1 vssc1 col_event_rst_top_left[32] x1_net62 row_on_detect_top[0]
+ row_off_detect_top[1] openDVS_pixel2x2_top
x1_x16 dac_config_3 dac_config_5 col_event_rst_top_left[31] dac_config_4
+ row_on_detect_top[1] dac_config_0 dac_config_1 row_off_detect_top[0] x1_net65
+ dac_config_2 vdda1 vssa1 vssc1 col_event_rst_top_left[30] x1_net66 row_on_detect_top[0]
+ row_off_detect_top[1] openDVS_pixel2x2_top
x1_x17 dac_config_3 dac_config_5 col_event_rst_top_left[29] dac_config_4
+ row_on_detect_top[1] dac_config_0 dac_config_1 row_off_detect_top[0] x1_net69
+ dac_config_2 vdda1 vssa1 vssc1 col_event_rst_top_left[28] x1_net70 row_on_detect_top[0]
+ row_off_detect_top[1] openDVS_pixel2x2_top
x1_x18 dac_config_3 dac_config_5 col_event_rst_top_left[27] dac_config_4
+ row_on_detect_top[1] dac_config_0 dac_config_1 row_off_detect_top[0] x1_net73
+ dac_config_2 vdda1 vssa1 vssc1 col_event_rst_top_left[26] x1_net74 row_on_detect_top[0]
+ row_off_detect_top[1] openDVS_pixel2x2_top
x1_x19 dac_config_3 dac_config_5 col_event_rst_top_left[25] dac_config_4
+ row_on_detect_top[1] dac_config_0 dac_config_1 row_off_detect_top[0] x1_net77
+ dac_config_2 vdda1 vssa1 vssc1 col_event_rst_top_left[24] x1_net78 row_on_detect_top[0]
+ row_off_detect_top[1] openDVS_pixel2x2_top
x1_x20 dac_config_3 dac_config_5 col_event_rst_top_left[23] dac_config_4
+ row_on_detect_top[1] dac_config_0 dac_config_1 row_off_detect_top[0] x1_net81
+ dac_config_2 vdda1 vssa1 vssc1 col_event_rst_top_left[22] x1_net82 row_on_detect_top[0]
+ row_off_detect_top[1] openDVS_pixel2x2_top
x1_x21 dac_config_3 dac_config_5 col_event_rst_top_left[21] dac_config_4
+ row_on_detect_top[1] dac_config_0 dac_config_1 row_off_detect_top[0] x1_net85
+ dac_config_2 vdda1 vssa1 vssc1 col_event_rst_top_left[20] x1_net86 row_on_detect_top[0]
+ row_off_detect_top[1] openDVS_pixel2x2_top
x1_x22 dac_config_3 dac_config_5 col_event_rst_top_left[19] dac_config_4
+ row_on_detect_top[1] dac_config_0 dac_config_1 row_off_detect_top[0] x1_net89
+ dac_config_2 vdda1 vssa1 vssc1 col_event_rst_top_left[18] x1_net90 row_on_detect_top[0]
+ row_off_detect_top[1] openDVS_pixel2x2_top
x1_x23 dac_config_3 dac_config_5 col_event_rst_top_left[17] dac_config_4
+ row_on_detect_top[1] dac_config_0 dac_config_1 row_off_detect_top[0] x1_net93
+ dac_config_2 vdda1 vssa1 vssc1 col_event_rst_top_left[16] x1_net94 row_on_detect_top[0]
+ row_off_detect_top[1] openDVS_pixel2x2_top
x1_x24 dac_config_3 dac_config_5 col_event_rst_top_left[15] dac_config_4
+ row_on_detect_top[1] dac_config_0 dac_config_1 row_off_detect_top[0] x1_net97
+ dac_config_2 vdda1 vssa1 vssc1 col_event_rst_top_left[14] x1_net98 row_on_detect_top[0]
+ row_off_detect_top[1] openDVS_pixel2x2_top
x1_x25 dac_config_3 dac_config_5 col_event_rst_top_left[13] dac_config_4
+ row_on_detect_top[1] dac_config_0 dac_config_1 row_off_detect_top[0] x1_net101
+ dac_config_2 vdda1 vssa1 vssc1 col_event_rst_top_left[12] x1_net102 row_on_detect_top[0]
+ row_off_detect_top[1] openDVS_pixel2x2_top
x1_x26 dac_config_3 dac_config_5 col_event_rst_top_left[11] dac_config_4
+ row_on_detect_top[1] dac_config_0 dac_config_1 row_off_detect_top[0] x1_net105
+ dac_config_2 vdda1 vssa1 vssc1 col_event_rst_top_left[10] x1_net106 row_on_detect_top[0]
+ row_off_detect_top[1] openDVS_pixel2x2_top
x1_x27 dac_config_3 dac_config_5 col_event_rst_top_left[9] dac_config_4
+ row_on_detect_top[1] dac_config_0 dac_config_1 row_off_detect_top[0] x1_net109
+ dac_config_2 vdda1 vssa1 vssc1 col_event_rst_top_left[8] x1_net110 row_on_detect_top[0]
+ row_off_detect_top[1] openDVS_pixel2x2_top
x1_x28 dac_config_3 dac_config_5 col_event_rst_top_left[7] dac_config_4
+ row_on_detect_top[1] dac_config_0 dac_config_1 row_off_detect_top[0] x1_net113
+ dac_config_2 vdda1 vssa1 vssc1 col_event_rst_top_left[6] x1_net114 row_on_detect_top[0]
+ row_off_detect_top[1] openDVS_pixel2x2_top
x1_x29 dac_config_3 dac_config_5 col_event_rst_top_left[5] dac_config_4
+ row_on_detect_top[1] dac_config_0 dac_config_1 row_off_detect_top[0] x1_net117
+ dac_config_2 vdda1 vssa1 vssc1 col_event_rst_top_left[4] x1_net118 row_on_detect_top[0]
+ row_off_detect_top[1] openDVS_pixel2x2_top
x1_x30 dac_config_3 dac_config_5 col_event_rst_top_left[3] dac_config_4
+ row_on_detect_top[1] dac_config_0 dac_config_1 row_off_detect_top[0] x1_net121
+ dac_config_2 vdda1 vssa1 vssc1 col_event_rst_top_left[2] x1_net122 row_on_detect_top[0]
+ row_off_detect_top[1] openDVS_pixel2x2_top
x1_x31 dac_config_3 dac_config_5 col_event_rst_top_left[1] dac_config_4
+ row_on_detect_top[1] dac_config_0 dac_config_1 row_off_detect_top[0] x1_net125
+ dac_config_2 vdda1 vssa1 vssc1 col_event_rst_top_left[0] x1_net126 row_on_detect_top[0]
+ row_off_detect_top[1] openDVS_pixel2x2_top
x1_x32 dac_config_3 dac_config_5 col_event_rst_top_left[63] dac_config_4
+ row_on_detect_top[3] dac_config_0 dac_config_1 row_off_detect_top[2] x1_net1
+ dac_config_2 vdda1 vssa1 vssc1 col_event_rst_top_left[62] x1_net2 row_on_detect_top[2]
+ row_off_detect_top[3] openDVS_pixel2x2_top
x1_x33 dac_config_3 dac_config_5 col_event_rst_top_left[61] dac_config_4
+ row_on_detect_top[3] dac_config_0 dac_config_1 row_off_detect_top[2] x1_net5
+ dac_config_2 vdda1 vssa1 vssc1 col_event_rst_top_left[60] x1_net6 row_on_detect_top[2]
+ row_off_detect_top[3] openDVS_pixel2x2_top
x1_x34 dac_config_3 dac_config_5 col_event_rst_top_left[59] dac_config_4
+ row_on_detect_top[3] dac_config_0 dac_config_1 row_off_detect_top[2] x1_net9
+ dac_config_2 vdda1 vssa1 vssc1 col_event_rst_top_left[58] x1_net10 row_on_detect_top[2]
+ row_off_detect_top[3] openDVS_pixel2x2_top
x1_x35 dac_config_3 dac_config_5 col_event_rst_top_left[57] dac_config_4
+ row_on_detect_top[3] dac_config_0 dac_config_1 row_off_detect_top[2] x1_net13
+ dac_config_2 vdda1 vssa1 vssc1 col_event_rst_top_left[56] x1_net14 row_on_detect_top[2]
+ row_off_detect_top[3] openDVS_pixel2x2_top
x1_x36 dac_config_3 dac_config_5 col_event_rst_top_left[55] dac_config_4
+ row_on_detect_top[3] dac_config_0 dac_config_1 row_off_detect_top[2] x1_net17
+ dac_config_2 vdda1 vssa1 vssc1 col_event_rst_top_left[54] x1_net18 row_on_detect_top[2]
+ row_off_detect_top[3] openDVS_pixel2x2_top
x1_x37 dac_config_3 dac_config_5 col_event_rst_top_left[53] dac_config_4
+ row_on_detect_top[3] dac_config_0 dac_config_1 row_off_detect_top[2] x1_net21
+ dac_config_2 vdda1 vssa1 vssc1 col_event_rst_top_left[52] x1_net22 row_on_detect_top[2]
+ row_off_detect_top[3] openDVS_pixel2x2_top
x1_x38 dac_config_3 dac_config_5 col_event_rst_top_left[51] dac_config_4
+ row_on_detect_top[3] dac_config_0 dac_config_1 row_off_detect_top[2] x1_net25
+ dac_config_2 vdda1 vssa1 vssc1 col_event_rst_top_left[50] x1_net26 row_on_detect_top[2]
+ row_off_detect_top[3] openDVS_pixel2x2_top
x1_x39 dac_config_3 dac_config_5 col_event_rst_top_left[49] dac_config_4
+ row_on_detect_top[3] dac_config_0 dac_config_1 row_off_detect_top[2] x1_net29
+ dac_config_2 vdda1 vssa1 vssc1 col_event_rst_top_left[48] x1_net30 row_on_detect_top[2]
+ row_off_detect_top[3] openDVS_pixel2x2_top
x1_x40 dac_config_3 dac_config_5 col_event_rst_top_left[47] dac_config_4
+ row_on_detect_top[3] dac_config_0 dac_config_1 row_off_detect_top[2] x1_net33
+ dac_config_2 vdda1 vssa1 vssc1 col_event_rst_top_left[46] x1_net34 row_on_detect_top[2]
+ row_off_detect_top[3] openDVS_pixel2x2_top
x1_x41 dac_config_3 dac_config_5 col_event_rst_top_left[45] dac_config_4
+ row_on_detect_top[3] dac_config_0 dac_config_1 row_off_detect_top[2] x1_net37
+ dac_config_2 vdda1 vssa1 vssc1 col_event_rst_top_left[44] x1_net38 row_on_detect_top[2]
+ row_off_detect_top[3] openDVS_pixel2x2_top
x1_x42 dac_config_3 dac_config_5 col_event_rst_top_left[43] dac_config_4
+ row_on_detect_top[3] dac_config_0 dac_config_1 row_off_detect_top[2] x1_net41
+ dac_config_2 vdda1 vssa1 vssc1 col_event_rst_top_left[42] x1_net42 row_on_detect_top[2]
+ row_off_detect_top[3] openDVS_pixel2x2_top
x1_x43 dac_config_3 dac_config_5 col_event_rst_top_left[41] dac_config_4
+ row_on_detect_top[3] dac_config_0 dac_config_1 row_off_detect_top[2] x1_net45
+ dac_config_2 vdda1 vssa1 vssc1 col_event_rst_top_left[40] x1_net46 row_on_detect_top[2]
+ row_off_detect_top[3] openDVS_pixel2x2_top
x1_x44 dac_config_3 dac_config_5 col_event_rst_top_left[39] dac_config_4
+ row_on_detect_top[3] dac_config_0 dac_config_1 row_off_detect_top[2] x1_net49
+ dac_config_2 vdda1 vssa1 vssc1 col_event_rst_top_left[38] x1_net50 row_on_detect_top[2]
+ row_off_detect_top[3] openDVS_pixel2x2_top
x1_x45 dac_config_3 dac_config_5 col_event_rst_top_left[37] dac_config_4
+ row_on_detect_top[3] dac_config_0 dac_config_1 row_off_detect_top[2] x1_net53
+ dac_config_2 vdda1 vssa1 vssc1 col_event_rst_top_left[36] x1_net54 row_on_detect_top[2]
+ row_off_detect_top[3] openDVS_pixel2x2_top
x1_x46 dac_config_3 dac_config_5 col_event_rst_top_left[35] dac_config_4
+ row_on_detect_top[3] dac_config_0 dac_config_1 row_off_detect_top[2] x1_net57
+ dac_config_2 vdda1 vssa1 vssc1 col_event_rst_top_left[34] x1_net58 row_on_detect_top[2]
+ row_off_detect_top[3] openDVS_pixel2x2_top
x1_x47 dac_config_3 dac_config_5 col_event_rst_top_left[33] dac_config_4
+ row_on_detect_top[3] dac_config_0 dac_config_1 row_off_detect_top[2] x1_net61
+ dac_config_2 vdda1 vssa1 vssc1 col_event_rst_top_left[32] x1_net62 row_on_detect_top[2]
+ row_off_detect_top[3] openDVS_pixel2x2_top
x1_x48 dac_config_3 dac_config_5 col_event_rst_top_left[31] dac_config_4
+ row_on_detect_top[3] dac_config_0 dac_config_1 row_off_detect_top[2] x1_net65
+ dac_config_2 vdda1 vssa1 vssc1 col_event_rst_top_left[30] x1_net66 row_on_detect_top[2]
+ row_off_detect_top[3] openDVS_pixel2x2_top
x1_x49 dac_config_3 dac_config_5 col_event_rst_top_left[29] dac_config_4
+ row_on_detect_top[3] dac_config_0 dac_config_1 row_off_detect_top[2] x1_net69
+ dac_config_2 vdda1 vssa1 vssc1 col_event_rst_top_left[28] x1_net70 row_on_detect_top[2]
+ row_off_detect_top[3] openDVS_pixel2x2_top
x1_x50 dac_config_3 dac_config_5 col_event_rst_top_left[27] dac_config_4
+ row_on_detect_top[3] dac_config_0 dac_config_1 row_off_detect_top[2] x1_net73
+ dac_config_2 vdda1 vssa1 vssc1 col_event_rst_top_left[26] x1_net74 row_on_detect_top[2]
+ row_off_detect_top[3] openDVS_pixel2x2_top
x1_x51 dac_config_3 dac_config_5 col_event_rst_top_left[25] dac_config_4
+ row_on_detect_top[3] dac_config_0 dac_config_1 row_off_detect_top[2] x1_net77
+ dac_config_2 vdda1 vssa1 vssc1 col_event_rst_top_left[24] x1_net78 row_on_detect_top[2]
+ row_off_detect_top[3] openDVS_pixel2x2_top
x1_x52 dac_config_3 dac_config_5 col_event_rst_top_left[23] dac_config_4
+ row_on_detect_top[3] dac_config_0 dac_config_1 row_off_detect_top[2] x1_net81
+ dac_config_2 vdda1 vssa1 vssc1 col_event_rst_top_left[22] x1_net82 row_on_detect_top[2]
+ row_off_detect_top[3] openDVS_pixel2x2_top
x1_x53 dac_config_3 dac_config_5 col_event_rst_top_left[21] dac_config_4
+ row_on_detect_top[3] dac_config_0 dac_config_1 row_off_detect_top[2] x1_net85
+ dac_config_2 vdda1 vssa1 vssc1 col_event_rst_top_left[20] x1_net86 row_on_detect_top[2]
+ row_off_detect_top[3] openDVS_pixel2x2_top
x1_x54 dac_config_3 dac_config_5 col_event_rst_top_left[19] dac_config_4
+ row_on_detect_top[3] dac_config_0 dac_config_1 row_off_detect_top[2] x1_net89
+ dac_config_2 vdda1 vssa1 vssc1 col_event_rst_top_left[18] x1_net90 row_on_detect_top[2]
+ row_off_detect_top[3] openDVS_pixel2x2_top
x1_x55 dac_config_3 dac_config_5 col_event_rst_top_left[17] dac_config_4
+ row_on_detect_top[3] dac_config_0 dac_config_1 row_off_detect_top[2] x1_net93
+ dac_config_2 vdda1 vssa1 vssc1 col_event_rst_top_left[16] x1_net94 row_on_detect_top[2]
+ row_off_detect_top[3] openDVS_pixel2x2_top
x1_x56 dac_config_3 dac_config_5 col_event_rst_top_left[15] dac_config_4
+ row_on_detect_top[3] dac_config_0 dac_config_1 row_off_detect_top[2] x1_net97
+ dac_config_2 vdda1 vssa1 vssc1 col_event_rst_top_left[14] x1_net98 row_on_detect_top[2]
+ row_off_detect_top[3] openDVS_pixel2x2_top
x1_x57 dac_config_3 dac_config_5 col_event_rst_top_left[13] dac_config_4
+ row_on_detect_top[3] dac_config_0 dac_config_1 row_off_detect_top[2] x1_net101
+ dac_config_2 vdda1 vssa1 vssc1 col_event_rst_top_left[12] x1_net102 row_on_detect_top[2]
+ row_off_detect_top[3] openDVS_pixel2x2_top
x1_x58 dac_config_3 dac_config_5 col_event_rst_top_left[11] dac_config_4
+ row_on_detect_top[3] dac_config_0 dac_config_1 row_off_detect_top[2] x1_net105
+ dac_config_2 vdda1 vssa1 vssc1 col_event_rst_top_left[10] x1_net106 row_on_detect_top[2]
+ row_off_detect_top[3] openDVS_pixel2x2_top
x1_x59 dac_config_3 dac_config_5 col_event_rst_top_left[9] dac_config_4
+ row_on_detect_top[3] dac_config_0 dac_config_1 row_off_detect_top[2] x1_net109
+ dac_config_2 vdda1 vssa1 vssc1 col_event_rst_top_left[8] x1_net110 row_on_detect_top[2]
+ row_off_detect_top[3] openDVS_pixel2x2_top
x1_x60 dac_config_3 dac_config_5 col_event_rst_top_left[7] dac_config_4
+ row_on_detect_top[3] dac_config_0 dac_config_1 row_off_detect_top[2] x1_net113
+ dac_config_2 vdda1 vssa1 vssc1 col_event_rst_top_left[6] x1_net114 row_on_detect_top[2]
+ row_off_detect_top[3] openDVS_pixel2x2_top
x1_x61 dac_config_3 dac_config_5 col_event_rst_top_left[5] dac_config_4
+ row_on_detect_top[3] dac_config_0 dac_config_1 row_off_detect_top[2] x1_net117
+ dac_config_2 vdda1 vssa1 vssc1 col_event_rst_top_left[4] x1_net118 row_on_detect_top[2]
+ row_off_detect_top[3] openDVS_pixel2x2_top
x1_x62 dac_config_3 dac_config_5 col_event_rst_top_left[3] dac_config_4
+ row_on_detect_top[3] dac_config_0 dac_config_1 row_off_detect_top[2] x1_net121
+ dac_config_2 vdda1 vssa1 vssc1 col_event_rst_top_left[2] x1_net122 row_on_detect_top[2]
+ row_off_detect_top[3] openDVS_pixel2x2_top
x1_x63 dac_config_3 dac_config_5 col_event_rst_top_left[1] dac_config_4
+ row_on_detect_top[3] dac_config_0 dac_config_1 row_off_detect_top[2] x1_net125
+ dac_config_2 vdda1 vssa1 vssc1 col_event_rst_top_left[0] x1_net126 row_on_detect_top[2]
+ row_off_detect_top[3] openDVS_pixel2x2_top
x1_x64 dac_config_3 dac_config_5 col_event_rst_top_left[63] dac_config_4
+ row_on_detect_top[5] dac_config_0 dac_config_1 row_off_detect_top[4] x1_net1
+ dac_config_2 vdda1 vssa1 vssc1 col_event_rst_top_left[62] x1_net2 row_on_detect_top[4]
+ row_off_detect_top[5] openDVS_pixel2x2_top
x1_x65 dac_config_3 dac_config_5 col_event_rst_top_left[61] dac_config_4
+ row_on_detect_top[5] dac_config_0 dac_config_1 row_off_detect_top[4] x1_net5
+ dac_config_2 vdda1 vssa1 vssc1 col_event_rst_top_left[60] x1_net6 row_on_detect_top[4]
+ row_off_detect_top[5] openDVS_pixel2x2_top
x1_x66 dac_config_3 dac_config_5 col_event_rst_top_left[59] dac_config_4
+ row_on_detect_top[5] dac_config_0 dac_config_1 row_off_detect_top[4] x1_net9
+ dac_config_2 vdda1 vssa1 vssc1 col_event_rst_top_left[58] x1_net10 row_on_detect_top[4]
+ row_off_detect_top[5] openDVS_pixel2x2_top
x1_x67 dac_config_3 dac_config_5 col_event_rst_top_left[57] dac_config_4
+ row_on_detect_top[5] dac_config_0 dac_config_1 row_off_detect_top[4] x1_net13
+ dac_config_2 vdda1 vssa1 vssc1 col_event_rst_top_left[56] x1_net14 row_on_detect_top[4]
+ row_off_detect_top[5] openDVS_pixel2x2_top
x1_x68 dac_config_3 dac_config_5 col_event_rst_top_left[55] dac_config_4
+ row_on_detect_top[5] dac_config_0 dac_config_1 row_off_detect_top[4] x1_net17
+ dac_config_2 vdda1 vssa1 vssc1 col_event_rst_top_left[54] x1_net18 row_on_detect_top[4]
+ row_off_detect_top[5] openDVS_pixel2x2_top
x1_x69 dac_config_3 dac_config_5 col_event_rst_top_left[53] dac_config_4
+ row_on_detect_top[5] dac_config_0 dac_config_1 row_off_detect_top[4] x1_net21
+ dac_config_2 vdda1 vssa1 vssc1 col_event_rst_top_left[52] x1_net22 row_on_detect_top[4]
+ row_off_detect_top[5] openDVS_pixel2x2_top
x1_x70 dac_config_3 dac_config_5 col_event_rst_top_left[51] dac_config_4
+ row_on_detect_top[5] dac_config_0 dac_config_1 row_off_detect_top[4] x1_net25
+ dac_config_2 vdda1 vssa1 vssc1 col_event_rst_top_left[50] x1_net26 row_on_detect_top[4]
+ row_off_detect_top[5] openDVS_pixel2x2_top
x1_x71 dac_config_3 dac_config_5 col_event_rst_top_left[49] dac_config_4
+ row_on_detect_top[5] dac_config_0 dac_config_1 row_off_detect_top[4] x1_net29
+ dac_config_2 vdda1 vssa1 vssc1 col_event_rst_top_left[48] x1_net30 row_on_detect_top[4]
+ row_off_detect_top[5] openDVS_pixel2x2_top
x1_x72 dac_config_3 dac_config_5 col_event_rst_top_left[47] dac_config_4
+ row_on_detect_top[5] dac_config_0 dac_config_1 row_off_detect_top[4] x1_net33
+ dac_config_2 vdda1 vssa1 vssc1 col_event_rst_top_left[46] x1_net34 row_on_detect_top[4]
+ row_off_detect_top[5] openDVS_pixel2x2_top
x1_x73 dac_config_3 dac_config_5 col_event_rst_top_left[45] dac_config_4
+ row_on_detect_top[5] dac_config_0 dac_config_1 row_off_detect_top[4] x1_net37
+ dac_config_2 vdda1 vssa1 vssc1 col_event_rst_top_left[44] x1_net38 row_on_detect_top[4]
+ row_off_detect_top[5] openDVS_pixel2x2_top
x1_x74 dac_config_3 dac_config_5 col_event_rst_top_left[43] dac_config_4
+ row_on_detect_top[5] dac_config_0 dac_config_1 row_off_detect_top[4] x1_net41
+ dac_config_2 vdda1 vssa1 vssc1 col_event_rst_top_left[42] x1_net42 row_on_detect_top[4]
+ row_off_detect_top[5] openDVS_pixel2x2_top
x1_x75 dac_config_3 dac_config_5 col_event_rst_top_left[41] dac_config_4
+ row_on_detect_top[5] dac_config_0 dac_config_1 row_off_detect_top[4] x1_net45
+ dac_config_2 vdda1 vssa1 vssc1 col_event_rst_top_left[40] x1_net46 row_on_detect_top[4]
+ row_off_detect_top[5] openDVS_pixel2x2_top
x1_x76 dac_config_3 dac_config_5 col_event_rst_top_left[39] dac_config_4
+ row_on_detect_top[5] dac_config_0 dac_config_1 row_off_detect_top[4] x1_net49
+ dac_config_2 vdda1 vssa1 vssc1 col_event_rst_top_left[38] x1_net50 row_on_detect_top[4]
+ row_off_detect_top[5] openDVS_pixel2x2_top
x1_x77 dac_config_3 dac_config_5 col_event_rst_top_left[37] dac_config_4
+ row_on_detect_top[5] dac_config_0 dac_config_1 row_off_detect_top[4] x1_net53
+ dac_config_2 vdda1 vssa1 vssc1 col_event_rst_top_left[36] x1_net54 row_on_detect_top[4]
+ row_off_detect_top[5] openDVS_pixel2x2_top
x1_x78 dac_config_3 dac_config_5 col_event_rst_top_left[35] dac_config_4
+ row_on_detect_top[5] dac_config_0 dac_config_1 row_off_detect_top[4] x1_net57
+ dac_config_2 vdda1 vssa1 vssc1 col_event_rst_top_left[34] x1_net58 row_on_detect_top[4]
+ row_off_detect_top[5] openDVS_pixel2x2_top
x1_x79 dac_config_3 dac_config_5 col_event_rst_top_left[33] dac_config_4
+ row_on_detect_top[5] dac_config_0 dac_config_1 row_off_detect_top[4] x1_net61
+ dac_config_2 vdda1 vssa1 vssc1 col_event_rst_top_left[32] x1_net62 row_on_detect_top[4]
+ row_off_detect_top[5] openDVS_pixel2x2_top
x1_x80 dac_config_3 dac_config_5 col_event_rst_top_left[31] dac_config_4
+ row_on_detect_top[5] dac_config_0 dac_config_1 row_off_detect_top[4] x1_net65
+ dac_config_2 vdda1 vssa1 vssc1 col_event_rst_top_left[30] x1_net66 row_on_detect_top[4]
+ row_off_detect_top[5] openDVS_pixel2x2_top
x1_x81 dac_config_3 dac_config_5 col_event_rst_top_left[29] dac_config_4
+ row_on_detect_top[5] dac_config_0 dac_config_1 row_off_detect_top[4] x1_net69
+ dac_config_2 vdda1 vssa1 vssc1 col_event_rst_top_left[28] x1_net70 row_on_detect_top[4]
+ row_off_detect_top[5] openDVS_pixel2x2_top
x1_x82 dac_config_3 dac_config_5 col_event_rst_top_left[27] dac_config_4
+ row_on_detect_top[5] dac_config_0 dac_config_1 row_off_detect_top[4] x1_net73
+ dac_config_2 vdda1 vssa1 vssc1 col_event_rst_top_left[26] x1_net74 row_on_detect_top[4]
+ row_off_detect_top[5] openDVS_pixel2x2_top
x1_x83 dac_config_3 dac_config_5 col_event_rst_top_left[25] dac_config_4
+ row_on_detect_top[5] dac_config_0 dac_config_1 row_off_detect_top[4] x1_net77
+ dac_config_2 vdda1 vssa1 vssc1 col_event_rst_top_left[24] x1_net78 row_on_detect_top[4]
+ row_off_detect_top[5] openDVS_pixel2x2_top
x1_x84 dac_config_3 dac_config_5 col_event_rst_top_left[23] dac_config_4
+ row_on_detect_top[5] dac_config_0 dac_config_1 row_off_detect_top[4] x1_net81
+ dac_config_2 vdda1 vssa1 vssc1 col_event_rst_top_left[22] x1_net82 row_on_detect_top[4]
+ row_off_detect_top[5] openDVS_pixel2x2_top
x1_x85 dac_config_3 dac_config_5 col_event_rst_top_left[21] dac_config_4
+ row_on_detect_top[5] dac_config_0 dac_config_1 row_off_detect_top[4] x1_net85
+ dac_config_2 vdda1 vssa1 vssc1 col_event_rst_top_left[20] x1_net86 row_on_detect_top[4]
+ row_off_detect_top[5] openDVS_pixel2x2_top
x1_x86 dac_config_3 dac_config_5 col_event_rst_top_left[19] dac_config_4
+ row_on_detect_top[5] dac_config_0 dac_config_1 row_off_detect_top[4] x1_net89
+ dac_config_2 vdda1 vssa1 vssc1 col_event_rst_top_left[18] x1_net90 row_on_detect_top[4]
+ row_off_detect_top[5] openDVS_pixel2x2_top
x1_x87 dac_config_3 dac_config_5 col_event_rst_top_left[17] dac_config_4
+ row_on_detect_top[5] dac_config_0 dac_config_1 row_off_detect_top[4] x1_net93
+ dac_config_2 vdda1 vssa1 vssc1 col_event_rst_top_left[16] x1_net94 row_on_detect_top[4]
+ row_off_detect_top[5] openDVS_pixel2x2_top
x1_x88 dac_config_3 dac_config_5 col_event_rst_top_left[15] dac_config_4
+ row_on_detect_top[5] dac_config_0 dac_config_1 row_off_detect_top[4] x1_net97
+ dac_config_2 vdda1 vssa1 vssc1 col_event_rst_top_left[14] x1_net98 row_on_detect_top[4]
+ row_off_detect_top[5] openDVS_pixel2x2_top
x1_x89 dac_config_3 dac_config_5 col_event_rst_top_left[13] dac_config_4
+ row_on_detect_top[5] dac_config_0 dac_config_1 row_off_detect_top[4] x1_net101
+ dac_config_2 vdda1 vssa1 vssc1 col_event_rst_top_left[12] x1_net102 row_on_detect_top[4]
+ row_off_detect_top[5] openDVS_pixel2x2_top
x1_x90 dac_config_3 dac_config_5 col_event_rst_top_left[11] dac_config_4
+ row_on_detect_top[5] dac_config_0 dac_config_1 row_off_detect_top[4] x1_net105
+ dac_config_2 vdda1 vssa1 vssc1 col_event_rst_top_left[10] x1_net106 row_on_detect_top[4]
+ row_off_detect_top[5] openDVS_pixel2x2_top
x1_x91 dac_config_3 dac_config_5 col_event_rst_top_left[9] dac_config_4
+ row_on_detect_top[5] dac_config_0 dac_config_1 row_off_detect_top[4] x1_net109
+ dac_config_2 vdda1 vssa1 vssc1 col_event_rst_top_left[8] x1_net110 row_on_detect_top[4]
+ row_off_detect_top[5] openDVS_pixel2x2_top
x1_x92 dac_config_3 dac_config_5 col_event_rst_top_left[7] dac_config_4
+ row_on_detect_top[5] dac_config_0 dac_config_1 row_off_detect_top[4] x1_net113
+ dac_config_2 vdda1 vssa1 vssc1 col_event_rst_top_left[6] x1_net114 row_on_detect_top[4]
+ row_off_detect_top[5] openDVS_pixel2x2_top
x1_x93 dac_config_3 dac_config_5 col_event_rst_top_left[5] dac_config_4
+ row_on_detect_top[5] dac_config_0 dac_config_1 row_off_detect_top[4] x1_net117
+ dac_config_2 vdda1 vssa1 vssc1 col_event_rst_top_left[4] x1_net118 row_on_detect_top[4]
+ row_off_detect_top[5] openDVS_pixel2x2_top
x1_x94 dac_config_3 dac_config_5 col_event_rst_top_left[3] dac_config_4
+ row_on_detect_top[5] dac_config_0 dac_config_1 row_off_detect_top[4] x1_net121
+ dac_config_2 vdda1 vssa1 vssc1 col_event_rst_top_left[2] x1_net122 row_on_detect_top[4]
+ row_off_detect_top[5] openDVS_pixel2x2_top
x1_x95 dac_config_3 dac_config_5 col_event_rst_top_left[1] dac_config_4
+ row_on_detect_top[5] dac_config_0 dac_config_1 row_off_detect_top[4] x1_net125
+ dac_config_2 vdda1 vssa1 vssc1 col_event_rst_top_left[0] x1_net126 row_on_detect_top[4]
+ row_off_detect_top[5] openDVS_pixel2x2_top
x1_x96 dac_config_3 dac_config_5 col_event_rst_top_left[63] dac_config_4
+ row_on_detect_top[7] dac_config_0 dac_config_1 row_off_detect_top[6] x1_net1
+ dac_config_2 vdda1 vssa1 vssc1 col_event_rst_top_left[62] x1_net2 row_on_detect_top[6]
+ row_off_detect_top[7] openDVS_pixel2x2_top
x1_x97 dac_config_3 dac_config_5 col_event_rst_top_left[61] dac_config_4
+ row_on_detect_top[7] dac_config_0 dac_config_1 row_off_detect_top[6] x1_net5
+ dac_config_2 vdda1 vssa1 vssc1 col_event_rst_top_left[60] x1_net6 row_on_detect_top[6]
+ row_off_detect_top[7] openDVS_pixel2x2_top
x1_x98 dac_config_3 dac_config_5 col_event_rst_top_left[59] dac_config_4
+ row_on_detect_top[7] dac_config_0 dac_config_1 row_off_detect_top[6] x1_net9
+ dac_config_2 vdda1 vssa1 vssc1 col_event_rst_top_left[58] x1_net10 row_on_detect_top[6]
+ row_off_detect_top[7] openDVS_pixel2x2_top
x1_x99 dac_config_3 dac_config_5 col_event_rst_top_left[57] dac_config_4
+ row_on_detect_top[7] dac_config_0 dac_config_1 row_off_detect_top[6] x1_net13
+ dac_config_2 vdda1 vssa1 vssc1 col_event_rst_top_left[56] x1_net14 row_on_detect_top[6]
+ row_off_detect_top[7] openDVS_pixel2x2_top
x1_x100 dac_config_3 dac_config_5 col_event_rst_top_left[55] dac_config_4
+ row_on_detect_top[7] dac_config_0 dac_config_1 row_off_detect_top[6] x1_net17
+ dac_config_2 vdda1 vssa1 vssc1 col_event_rst_top_left[54] x1_net18 row_on_detect_top[6]
+ row_off_detect_top[7] openDVS_pixel2x2_top
x1_x101 dac_config_3 dac_config_5 col_event_rst_top_left[53] dac_config_4
+ row_on_detect_top[7] dac_config_0 dac_config_1 row_off_detect_top[6] x1_net21
+ dac_config_2 vdda1 vssa1 vssc1 col_event_rst_top_left[52] x1_net22 row_on_detect_top[6]
+ row_off_detect_top[7] openDVS_pixel2x2_top
x1_x102 dac_config_3 dac_config_5 col_event_rst_top_left[51] dac_config_4
+ row_on_detect_top[7] dac_config_0 dac_config_1 row_off_detect_top[6] x1_net25
+ dac_config_2 vdda1 vssa1 vssc1 col_event_rst_top_left[50] x1_net26 row_on_detect_top[6]
+ row_off_detect_top[7] openDVS_pixel2x2_top
x1_x103 dac_config_3 dac_config_5 col_event_rst_top_left[49] dac_config_4
+ row_on_detect_top[7] dac_config_0 dac_config_1 row_off_detect_top[6] x1_net29
+ dac_config_2 vdda1 vssa1 vssc1 col_event_rst_top_left[48] x1_net30 row_on_detect_top[6]
+ row_off_detect_top[7] openDVS_pixel2x2_top
x1_x104 dac_config_3 dac_config_5 col_event_rst_top_left[47] dac_config_4
+ row_on_detect_top[7] dac_config_0 dac_config_1 row_off_detect_top[6] x1_net33
+ dac_config_2 vdda1 vssa1 vssc1 col_event_rst_top_left[46] x1_net34 row_on_detect_top[6]
+ row_off_detect_top[7] openDVS_pixel2x2_top
x1_x105 dac_config_3 dac_config_5 col_event_rst_top_left[45] dac_config_4
+ row_on_detect_top[7] dac_config_0 dac_config_1 row_off_detect_top[6] x1_net37
+ dac_config_2 vdda1 vssa1 vssc1 col_event_rst_top_left[44] x1_net38 row_on_detect_top[6]
+ row_off_detect_top[7] openDVS_pixel2x2_top
x1_x106 dac_config_3 dac_config_5 col_event_rst_top_left[43] dac_config_4
+ row_on_detect_top[7] dac_config_0 dac_config_1 row_off_detect_top[6] x1_net41
+ dac_config_2 vdda1 vssa1 vssc1 col_event_rst_top_left[42] x1_net42 row_on_detect_top[6]
+ row_off_detect_top[7] openDVS_pixel2x2_top
x1_x107 dac_config_3 dac_config_5 col_event_rst_top_left[41] dac_config_4
+ row_on_detect_top[7] dac_config_0 dac_config_1 row_off_detect_top[6] x1_net45
+ dac_config_2 vdda1 vssa1 vssc1 col_event_rst_top_left[40] x1_net46 row_on_detect_top[6]
+ row_off_detect_top[7] openDVS_pixel2x2_top
x1_x108 dac_config_3 dac_config_5 col_event_rst_top_left[39] dac_config_4
+ row_on_detect_top[7] dac_config_0 dac_config_1 row_off_detect_top[6] x1_net49
+ dac_config_2 vdda1 vssa1 vssc1 col_event_rst_top_left[38] x1_net50 row_on_detect_top[6]
+ row_off_detect_top[7] openDVS_pixel2x2_top
x1_x109 dac_config_3 dac_config_5 col_event_rst_top_left[37] dac_config_4
+ row_on_detect_top[7] dac_config_0 dac_config_1 row_off_detect_top[6] x1_net53
+ dac_config_2 vdda1 vssa1 vssc1 col_event_rst_top_left[36] x1_net54 row_on_detect_top[6]
+ row_off_detect_top[7] openDVS_pixel2x2_top
x1_x110 dac_config_3 dac_config_5 col_event_rst_top_left[35] dac_config_4
+ row_on_detect_top[7] dac_config_0 dac_config_1 row_off_detect_top[6] x1_net57
+ dac_config_2 vdda1 vssa1 vssc1 col_event_rst_top_left[34] x1_net58 row_on_detect_top[6]
+ row_off_detect_top[7] openDVS_pixel2x2_top
x1_x111 dac_config_3 dac_config_5 col_event_rst_top_left[33] dac_config_4
+ row_on_detect_top[7] dac_config_0 dac_config_1 row_off_detect_top[6] x1_net61
+ dac_config_2 vdda1 vssa1 vssc1 col_event_rst_top_left[32] x1_net62 row_on_detect_top[6]
+ row_off_detect_top[7] openDVS_pixel2x2_top
x1_x112 dac_config_3 dac_config_5 col_event_rst_top_left[31] dac_config_4
+ row_on_detect_top[7] dac_config_0 dac_config_1 row_off_detect_top[6] x1_net65
+ dac_config_2 vdda1 vssa1 vssc1 col_event_rst_top_left[30] x1_net66 row_on_detect_top[6]
+ row_off_detect_top[7] openDVS_pixel2x2_top
x1_x113 dac_config_3 dac_config_5 col_event_rst_top_left[29] dac_config_4
+ row_on_detect_top[7] dac_config_0 dac_config_1 row_off_detect_top[6] x1_net69
+ dac_config_2 vdda1 vssa1 vssc1 col_event_rst_top_left[28] x1_net70 row_on_detect_top[6]
+ row_off_detect_top[7] openDVS_pixel2x2_top
x1_x114 dac_config_3 dac_config_5 col_event_rst_top_left[27] dac_config_4
+ row_on_detect_top[7] dac_config_0 dac_config_1 row_off_detect_top[6] x1_net73
+ dac_config_2 vdda1 vssa1 vssc1 col_event_rst_top_left[26] x1_net74 row_on_detect_top[6]
+ row_off_detect_top[7] openDVS_pixel2x2_top
x1_x115 dac_config_3 dac_config_5 col_event_rst_top_left[25] dac_config_4
+ row_on_detect_top[7] dac_config_0 dac_config_1 row_off_detect_top[6] x1_net77
+ dac_config_2 vdda1 vssa1 vssc1 col_event_rst_top_left[24] x1_net78 row_on_detect_top[6]
+ row_off_detect_top[7] openDVS_pixel2x2_top
x1_x116 dac_config_3 dac_config_5 col_event_rst_top_left[23] dac_config_4
+ row_on_detect_top[7] dac_config_0 dac_config_1 row_off_detect_top[6] x1_net81
+ dac_config_2 vdda1 vssa1 vssc1 col_event_rst_top_left[22] x1_net82 row_on_detect_top[6]
+ row_off_detect_top[7] openDVS_pixel2x2_top
x1_x117 dac_config_3 dac_config_5 col_event_rst_top_left[21] dac_config_4
+ row_on_detect_top[7] dac_config_0 dac_config_1 row_off_detect_top[6] x1_net85
+ dac_config_2 vdda1 vssa1 vssc1 col_event_rst_top_left[20] x1_net86 row_on_detect_top[6]
+ row_off_detect_top[7] openDVS_pixel2x2_top
x1_x118 dac_config_3 dac_config_5 col_event_rst_top_left[19] dac_config_4
+ row_on_detect_top[7] dac_config_0 dac_config_1 row_off_detect_top[6] x1_net89
+ dac_config_2 vdda1 vssa1 vssc1 col_event_rst_top_left[18] x1_net90 row_on_detect_top[6]
+ row_off_detect_top[7] openDVS_pixel2x2_top
x1_x119 dac_config_3 dac_config_5 col_event_rst_top_left[17] dac_config_4
+ row_on_detect_top[7] dac_config_0 dac_config_1 row_off_detect_top[6] x1_net93
+ dac_config_2 vdda1 vssa1 vssc1 col_event_rst_top_left[16] x1_net94 row_on_detect_top[6]
+ row_off_detect_top[7] openDVS_pixel2x2_top
x1_x120 dac_config_3 dac_config_5 col_event_rst_top_left[15] dac_config_4
+ row_on_detect_top[7] dac_config_0 dac_config_1 row_off_detect_top[6] x1_net97
+ dac_config_2 vdda1 vssa1 vssc1 col_event_rst_top_left[14] x1_net98 row_on_detect_top[6]
+ row_off_detect_top[7] openDVS_pixel2x2_top
x1_x121 dac_config_3 dac_config_5 col_event_rst_top_left[13] dac_config_4
+ row_on_detect_top[7] dac_config_0 dac_config_1 row_off_detect_top[6] x1_net101
+ dac_config_2 vdda1 vssa1 vssc1 col_event_rst_top_left[12] x1_net102 row_on_detect_top[6]
+ row_off_detect_top[7] openDVS_pixel2x2_top
x1_x122 dac_config_3 dac_config_5 col_event_rst_top_left[11] dac_config_4
+ row_on_detect_top[7] dac_config_0 dac_config_1 row_off_detect_top[6] x1_net105
+ dac_config_2 vdda1 vssa1 vssc1 col_event_rst_top_left[10] x1_net106 row_on_detect_top[6]
+ row_off_detect_top[7] openDVS_pixel2x2_top
x1_x123 dac_config_3 dac_config_5 col_event_rst_top_left[9] dac_config_4
+ row_on_detect_top[7] dac_config_0 dac_config_1 row_off_detect_top[6] x1_net109
+ dac_config_2 vdda1 vssa1 vssc1 col_event_rst_top_left[8] x1_net110 row_on_detect_top[6]
+ row_off_detect_top[7] openDVS_pixel2x2_top
x1_x124 dac_config_3 dac_config_5 col_event_rst_top_left[7] dac_config_4
+ row_on_detect_top[7] dac_config_0 dac_config_1 row_off_detect_top[6] x1_net113
+ dac_config_2 vdda1 vssa1 vssc1 col_event_rst_top_left[6] x1_net114 row_on_detect_top[6]
+ row_off_detect_top[7] openDVS_pixel2x2_top
x1_x125 dac_config_3 dac_config_5 col_event_rst_top_left[5] dac_config_4
+ row_on_detect_top[7] dac_config_0 dac_config_1 row_off_detect_top[6] x1_net117
+ dac_config_2 vdda1 vssa1 vssc1 col_event_rst_top_left[4] x1_net118 row_on_detect_top[6]
+ row_off_detect_top[7] openDVS_pixel2x2_top
x1_x126 dac_config_3 dac_config_5 col_event_rst_top_left[3] dac_config_4
+ row_on_detect_top[7] dac_config_0 dac_config_1 row_off_detect_top[6] x1_net121
+ dac_config_2 vdda1 vssa1 vssc1 col_event_rst_top_left[2] x1_net122 row_on_detect_top[6]
+ row_off_detect_top[7] openDVS_pixel2x2_top
x1_x127 dac_config_3 dac_config_5 col_event_rst_top_left[1] dac_config_4
+ row_on_detect_top[7] dac_config_0 dac_config_1 row_off_detect_top[6] x1_net125
+ dac_config_2 vdda1 vssa1 vssc1 col_event_rst_top_left[0] x1_net126 row_on_detect_top[6]
+ row_off_detect_top[7] openDVS_pixel2x2_top
x1_x128 dac_config_3 dac_config_5 col_event_rst_top_left[63] dac_config_4
+ row_on_detect_top[9] dac_config_0 dac_config_1 row_off_detect_top[8] x1_net1
+ dac_config_2 vdda1 vssa1 vssc1 col_event_rst_top_left[62] x1_net2 row_on_detect_top[8]
+ row_off_detect_top[9] openDVS_pixel2x2_top
x1_x129 dac_config_3 dac_config_5 col_event_rst_top_left[61] dac_config_4
+ row_on_detect_top[9] dac_config_0 dac_config_1 row_off_detect_top[8] x1_net5
+ dac_config_2 vdda1 vssa1 vssc1 col_event_rst_top_left[60] x1_net6 row_on_detect_top[8]
+ row_off_detect_top[9] openDVS_pixel2x2_top
x1_x130 dac_config_3 dac_config_5 col_event_rst_top_left[59] dac_config_4
+ row_on_detect_top[9] dac_config_0 dac_config_1 row_off_detect_top[8] x1_net9
+ dac_config_2 vdda1 vssa1 vssc1 col_event_rst_top_left[58] x1_net10 row_on_detect_top[8]
+ row_off_detect_top[9] openDVS_pixel2x2_top
x1_x131 dac_config_3 dac_config_5 col_event_rst_top_left[57] dac_config_4
+ row_on_detect_top[9] dac_config_0 dac_config_1 row_off_detect_top[8] x1_net13
+ dac_config_2 vdda1 vssa1 vssc1 col_event_rst_top_left[56] x1_net14 row_on_detect_top[8]
+ row_off_detect_top[9] openDVS_pixel2x2_top
x1_x132 dac_config_3 dac_config_5 col_event_rst_top_left[55] dac_config_4
+ row_on_detect_top[9] dac_config_0 dac_config_1 row_off_detect_top[8] x1_net17
+ dac_config_2 vdda1 vssa1 vssc1 col_event_rst_top_left[54] x1_net18 row_on_detect_top[8]
+ row_off_detect_top[9] openDVS_pixel2x2_top
x1_x133 dac_config_3 dac_config_5 col_event_rst_top_left[53] dac_config_4
+ row_on_detect_top[9] dac_config_0 dac_config_1 row_off_detect_top[8] x1_net21
+ dac_config_2 vdda1 vssa1 vssc1 col_event_rst_top_left[52] x1_net22 row_on_detect_top[8]
+ row_off_detect_top[9] openDVS_pixel2x2_top
x1_x134 dac_config_3 dac_config_5 col_event_rst_top_left[51] dac_config_4
+ row_on_detect_top[9] dac_config_0 dac_config_1 row_off_detect_top[8] x1_net25
+ dac_config_2 vdda1 vssa1 vssc1 col_event_rst_top_left[50] x1_net26 row_on_detect_top[8]
+ row_off_detect_top[9] openDVS_pixel2x2_top
x1_x135 dac_config_3 dac_config_5 col_event_rst_top_left[49] dac_config_4
+ row_on_detect_top[9] dac_config_0 dac_config_1 row_off_detect_top[8] x1_net29
+ dac_config_2 vdda1 vssa1 vssc1 col_event_rst_top_left[48] x1_net30 row_on_detect_top[8]
+ row_off_detect_top[9] openDVS_pixel2x2_top
x1_x136 dac_config_3 dac_config_5 col_event_rst_top_left[47] dac_config_4
+ row_on_detect_top[9] dac_config_0 dac_config_1 row_off_detect_top[8] x1_net33
+ dac_config_2 vdda1 vssa1 vssc1 col_event_rst_top_left[46] x1_net34 row_on_detect_top[8]
+ row_off_detect_top[9] openDVS_pixel2x2_top
x1_x137 dac_config_3 dac_config_5 col_event_rst_top_left[45] dac_config_4
+ row_on_detect_top[9] dac_config_0 dac_config_1 row_off_detect_top[8] x1_net37
+ dac_config_2 vdda1 vssa1 vssc1 col_event_rst_top_left[44] x1_net38 row_on_detect_top[8]
+ row_off_detect_top[9] openDVS_pixel2x2_top
x1_x138 dac_config_3 dac_config_5 col_event_rst_top_left[43] dac_config_4
+ row_on_detect_top[9] dac_config_0 dac_config_1 row_off_detect_top[8] x1_net41
+ dac_config_2 vdda1 vssa1 vssc1 col_event_rst_top_left[42] x1_net42 row_on_detect_top[8]
+ row_off_detect_top[9] openDVS_pixel2x2_top
x1_x139 dac_config_3 dac_config_5 col_event_rst_top_left[41] dac_config_4
+ row_on_detect_top[9] dac_config_0 dac_config_1 row_off_detect_top[8] x1_net45
+ dac_config_2 vdda1 vssa1 vssc1 col_event_rst_top_left[40] x1_net46 row_on_detect_top[8]
+ row_off_detect_top[9] openDVS_pixel2x2_top
x1_x140 dac_config_3 dac_config_5 col_event_rst_top_left[39] dac_config_4
+ row_on_detect_top[9] dac_config_0 dac_config_1 row_off_detect_top[8] x1_net49
+ dac_config_2 vdda1 vssa1 vssc1 col_event_rst_top_left[38] x1_net50 row_on_detect_top[8]
+ row_off_detect_top[9] openDVS_pixel2x2_top
x1_x141 dac_config_3 dac_config_5 col_event_rst_top_left[37] dac_config_4
+ row_on_detect_top[9] dac_config_0 dac_config_1 row_off_detect_top[8] x1_net53
+ dac_config_2 vdda1 vssa1 vssc1 col_event_rst_top_left[36] x1_net54 row_on_detect_top[8]
+ row_off_detect_top[9] openDVS_pixel2x2_top
x1_x142 dac_config_3 dac_config_5 col_event_rst_top_left[35] dac_config_4
+ row_on_detect_top[9] dac_config_0 dac_config_1 row_off_detect_top[8] x1_net57
+ dac_config_2 vdda1 vssa1 vssc1 col_event_rst_top_left[34] x1_net58 row_on_detect_top[8]
+ row_off_detect_top[9] openDVS_pixel2x2_top
x1_x143 dac_config_3 dac_config_5 col_event_rst_top_left[33] dac_config_4
+ row_on_detect_top[9] dac_config_0 dac_config_1 row_off_detect_top[8] x1_net61
+ dac_config_2 vdda1 vssa1 vssc1 col_event_rst_top_left[32] x1_net62 row_on_detect_top[8]
+ row_off_detect_top[9] openDVS_pixel2x2_top
x1_x144 dac_config_3 dac_config_5 col_event_rst_top_left[31] dac_config_4
+ row_on_detect_top[9] dac_config_0 dac_config_1 row_off_detect_top[8] x1_net65
+ dac_config_2 vdda1 vssa1 vssc1 col_event_rst_top_left[30] x1_net66 row_on_detect_top[8]
+ row_off_detect_top[9] openDVS_pixel2x2_top
x1_x145 dac_config_3 dac_config_5 col_event_rst_top_left[29] dac_config_4
+ row_on_detect_top[9] dac_config_0 dac_config_1 row_off_detect_top[8] x1_net69
+ dac_config_2 vdda1 vssa1 vssc1 col_event_rst_top_left[28] x1_net70 row_on_detect_top[8]
+ row_off_detect_top[9] openDVS_pixel2x2_top
x1_x146 dac_config_3 dac_config_5 col_event_rst_top_left[27] dac_config_4
+ row_on_detect_top[9] dac_config_0 dac_config_1 row_off_detect_top[8] x1_net73
+ dac_config_2 vdda1 vssa1 vssc1 col_event_rst_top_left[26] x1_net74 row_on_detect_top[8]
+ row_off_detect_top[9] openDVS_pixel2x2_top
x1_x147 dac_config_3 dac_config_5 col_event_rst_top_left[25] dac_config_4
+ row_on_detect_top[9] dac_config_0 dac_config_1 row_off_detect_top[8] x1_net77
+ dac_config_2 vdda1 vssa1 vssc1 col_event_rst_top_left[24] x1_net78 row_on_detect_top[8]
+ row_off_detect_top[9] openDVS_pixel2x2_top
x1_x148 dac_config_3 dac_config_5 col_event_rst_top_left[23] dac_config_4
+ row_on_detect_top[9] dac_config_0 dac_config_1 row_off_detect_top[8] x1_net81
+ dac_config_2 vdda1 vssa1 vssc1 col_event_rst_top_left[22] x1_net82 row_on_detect_top[8]
+ row_off_detect_top[9] openDVS_pixel2x2_top
x1_x149 dac_config_3 dac_config_5 col_event_rst_top_left[21] dac_config_4
+ row_on_detect_top[9] dac_config_0 dac_config_1 row_off_detect_top[8] x1_net85
+ dac_config_2 vdda1 vssa1 vssc1 col_event_rst_top_left[20] x1_net86 row_on_detect_top[8]
+ row_off_detect_top[9] openDVS_pixel2x2_top
x1_x150 dac_config_3 dac_config_5 col_event_rst_top_left[19] dac_config_4
+ row_on_detect_top[9] dac_config_0 dac_config_1 row_off_detect_top[8] x1_net89
+ dac_config_2 vdda1 vssa1 vssc1 col_event_rst_top_left[18] x1_net90 row_on_detect_top[8]
+ row_off_detect_top[9] openDVS_pixel2x2_top
x1_x151 dac_config_3 dac_config_5 col_event_rst_top_left[17] dac_config_4
+ row_on_detect_top[9] dac_config_0 dac_config_1 row_off_detect_top[8] x1_net93
+ dac_config_2 vdda1 vssa1 vssc1 col_event_rst_top_left[16] x1_net94 row_on_detect_top[8]
+ row_off_detect_top[9] openDVS_pixel2x2_top
x1_x152 dac_config_3 dac_config_5 col_event_rst_top_left[15] dac_config_4
+ row_on_detect_top[9] dac_config_0 dac_config_1 row_off_detect_top[8] x1_net97
+ dac_config_2 vdda1 vssa1 vssc1 col_event_rst_top_left[14] x1_net98 row_on_detect_top[8]
+ row_off_detect_top[9] openDVS_pixel2x2_top
x1_x153 dac_config_3 dac_config_5 col_event_rst_top_left[13] dac_config_4
+ row_on_detect_top[9] dac_config_0 dac_config_1 row_off_detect_top[8] x1_net101
+ dac_config_2 vdda1 vssa1 vssc1 col_event_rst_top_left[12] x1_net102 row_on_detect_top[8]
+ row_off_detect_top[9] openDVS_pixel2x2_top
x1_x154 dac_config_3 dac_config_5 col_event_rst_top_left[11] dac_config_4
+ row_on_detect_top[9] dac_config_0 dac_config_1 row_off_detect_top[8] x1_net105
+ dac_config_2 vdda1 vssa1 vssc1 col_event_rst_top_left[10] x1_net106 row_on_detect_top[8]
+ row_off_detect_top[9] openDVS_pixel2x2_top
x1_x155 dac_config_3 dac_config_5 col_event_rst_top_left[9] dac_config_4
+ row_on_detect_top[9] dac_config_0 dac_config_1 row_off_detect_top[8] x1_net109
+ dac_config_2 vdda1 vssa1 vssc1 col_event_rst_top_left[8] x1_net110 row_on_detect_top[8]
+ row_off_detect_top[9] openDVS_pixel2x2_top
x1_x156 dac_config_3 dac_config_5 col_event_rst_top_left[7] dac_config_4
+ row_on_detect_top[9] dac_config_0 dac_config_1 row_off_detect_top[8] x1_net113
+ dac_config_2 vdda1 vssa1 vssc1 col_event_rst_top_left[6] x1_net114 row_on_detect_top[8]
+ row_off_detect_top[9] openDVS_pixel2x2_top
x1_x157 dac_config_3 dac_config_5 col_event_rst_top_left[5] dac_config_4
+ row_on_detect_top[9] dac_config_0 dac_config_1 row_off_detect_top[8] x1_net117
+ dac_config_2 vdda1 vssa1 vssc1 col_event_rst_top_left[4] x1_net118 row_on_detect_top[8]
+ row_off_detect_top[9] openDVS_pixel2x2_top
x1_x158 dac_config_3 dac_config_5 col_event_rst_top_left[3] dac_config_4
+ row_on_detect_top[9] dac_config_0 dac_config_1 row_off_detect_top[8] x1_net121
+ dac_config_2 vdda1 vssa1 vssc1 col_event_rst_top_left[2] x1_net122 row_on_detect_top[8]
+ row_off_detect_top[9] openDVS_pixel2x2_top
x1_x159 dac_config_3 dac_config_5 col_event_rst_top_left[1] dac_config_4
+ row_on_detect_top[9] dac_config_0 dac_config_1 row_off_detect_top[8] x1_net125
+ dac_config_2 vdda1 vssa1 vssc1 col_event_rst_top_left[0] x1_net126 row_on_detect_top[8]
+ row_off_detect_top[9] openDVS_pixel2x2_top
x1_x160 dac_config_3 dac_config_5 col_event_rst_top_left[63] dac_config_4
+ row_on_detect_top[11] dac_config_0 dac_config_1 row_off_detect_top[10] x1_net1
+ dac_config_2 vdda1 vssa1 vssc1 col_event_rst_top_left[62] x1_net2 row_on_detect_top[10]
+ row_off_detect_top[11] openDVS_pixel2x2_top
x1_x161 dac_config_3 dac_config_5 col_event_rst_top_left[61] dac_config_4
+ row_on_detect_top[11] dac_config_0 dac_config_1 row_off_detect_top[10] x1_net5
+ dac_config_2 vdda1 vssa1 vssc1 col_event_rst_top_left[60] x1_net6 row_on_detect_top[10]
+ row_off_detect_top[11] openDVS_pixel2x2_top
x1_x162 dac_config_3 dac_config_5 col_event_rst_top_left[59] dac_config_4
+ row_on_detect_top[11] dac_config_0 dac_config_1 row_off_detect_top[10] x1_net9
+ dac_config_2 vdda1 vssa1 vssc1 col_event_rst_top_left[58] x1_net10 row_on_detect_top[10]
+ row_off_detect_top[11] openDVS_pixel2x2_top
x1_x163 dac_config_3 dac_config_5 col_event_rst_top_left[57] dac_config_4
+ row_on_detect_top[11] dac_config_0 dac_config_1 row_off_detect_top[10] x1_net13
+ dac_config_2 vdda1 vssa1 vssc1 col_event_rst_top_left[56] x1_net14 row_on_detect_top[10]
+ row_off_detect_top[11] openDVS_pixel2x2_top
x1_x164 dac_config_3 dac_config_5 col_event_rst_top_left[55] dac_config_4
+ row_on_detect_top[11] dac_config_0 dac_config_1 row_off_detect_top[10] x1_net17
+ dac_config_2 vdda1 vssa1 vssc1 col_event_rst_top_left[54] x1_net18 row_on_detect_top[10]
+ row_off_detect_top[11] openDVS_pixel2x2_top
x1_x165 dac_config_3 dac_config_5 col_event_rst_top_left[53] dac_config_4
+ row_on_detect_top[11] dac_config_0 dac_config_1 row_off_detect_top[10] x1_net21
+ dac_config_2 vdda1 vssa1 vssc1 col_event_rst_top_left[52] x1_net22 row_on_detect_top[10]
+ row_off_detect_top[11] openDVS_pixel2x2_top
x1_x166 dac_config_3 dac_config_5 col_event_rst_top_left[51] dac_config_4
+ row_on_detect_top[11] dac_config_0 dac_config_1 row_off_detect_top[10] x1_net25
+ dac_config_2 vdda1 vssa1 vssc1 col_event_rst_top_left[50] x1_net26 row_on_detect_top[10]
+ row_off_detect_top[11] openDVS_pixel2x2_top
x1_x167 dac_config_3 dac_config_5 col_event_rst_top_left[49] dac_config_4
+ row_on_detect_top[11] dac_config_0 dac_config_1 row_off_detect_top[10] x1_net29
+ dac_config_2 vdda1 vssa1 vssc1 col_event_rst_top_left[48] x1_net30 row_on_detect_top[10]
+ row_off_detect_top[11] openDVS_pixel2x2_top
x1_x168 dac_config_3 dac_config_5 col_event_rst_top_left[47] dac_config_4
+ row_on_detect_top[11] dac_config_0 dac_config_1 row_off_detect_top[10] x1_net33
+ dac_config_2 vdda1 vssa1 vssc1 col_event_rst_top_left[46] x1_net34 row_on_detect_top[10]
+ row_off_detect_top[11] openDVS_pixel2x2_top
x1_x169 dac_config_3 dac_config_5 col_event_rst_top_left[45] dac_config_4
+ row_on_detect_top[11] dac_config_0 dac_config_1 row_off_detect_top[10] x1_net37
+ dac_config_2 vdda1 vssa1 vssc1 col_event_rst_top_left[44] x1_net38 row_on_detect_top[10]
+ row_off_detect_top[11] openDVS_pixel2x2_top
x1_x170 dac_config_3 dac_config_5 col_event_rst_top_left[43] dac_config_4
+ row_on_detect_top[11] dac_config_0 dac_config_1 row_off_detect_top[10] x1_net41
+ dac_config_2 vdda1 vssa1 vssc1 col_event_rst_top_left[42] x1_net42 row_on_detect_top[10]
+ row_off_detect_top[11] openDVS_pixel2x2_top
x1_x171 dac_config_3 dac_config_5 col_event_rst_top_left[41] dac_config_4
+ row_on_detect_top[11] dac_config_0 dac_config_1 row_off_detect_top[10] x1_net45
+ dac_config_2 vdda1 vssa1 vssc1 col_event_rst_top_left[40] x1_net46 row_on_detect_top[10]
+ row_off_detect_top[11] openDVS_pixel2x2_top
x1_x172 dac_config_3 dac_config_5 col_event_rst_top_left[39] dac_config_4
+ row_on_detect_top[11] dac_config_0 dac_config_1 row_off_detect_top[10] x1_net49
+ dac_config_2 vdda1 vssa1 vssc1 col_event_rst_top_left[38] x1_net50 row_on_detect_top[10]
+ row_off_detect_top[11] openDVS_pixel2x2_top
x1_x173 dac_config_3 dac_config_5 col_event_rst_top_left[37] dac_config_4
+ row_on_detect_top[11] dac_config_0 dac_config_1 row_off_detect_top[10] x1_net53
+ dac_config_2 vdda1 vssa1 vssc1 col_event_rst_top_left[36] x1_net54 row_on_detect_top[10]
+ row_off_detect_top[11] openDVS_pixel2x2_top
x1_x174 dac_config_3 dac_config_5 col_event_rst_top_left[35] dac_config_4
+ row_on_detect_top[11] dac_config_0 dac_config_1 row_off_detect_top[10] x1_net57
+ dac_config_2 vdda1 vssa1 vssc1 col_event_rst_top_left[34] x1_net58 row_on_detect_top[10]
+ row_off_detect_top[11] openDVS_pixel2x2_top
x1_x175 dac_config_3 dac_config_5 col_event_rst_top_left[33] dac_config_4
+ row_on_detect_top[11] dac_config_0 dac_config_1 row_off_detect_top[10] x1_net61
+ dac_config_2 vdda1 vssa1 vssc1 col_event_rst_top_left[32] x1_net62 row_on_detect_top[10]
+ row_off_detect_top[11] openDVS_pixel2x2_top
x1_x176 dac_config_3 dac_config_5 col_event_rst_top_left[31] dac_config_4
+ row_on_detect_top[11] dac_config_0 dac_config_1 row_off_detect_top[10] x1_net65
+ dac_config_2 vdda1 vssa1 vssc1 col_event_rst_top_left[30] x1_net66 row_on_detect_top[10]
+ row_off_detect_top[11] openDVS_pixel2x2_top
x1_x177 dac_config_3 dac_config_5 col_event_rst_top_left[29] dac_config_4
+ row_on_detect_top[11] dac_config_0 dac_config_1 row_off_detect_top[10] x1_net69
+ dac_config_2 vdda1 vssa1 vssc1 col_event_rst_top_left[28] x1_net70 row_on_detect_top[10]
+ row_off_detect_top[11] openDVS_pixel2x2_top
x1_x178 dac_config_3 dac_config_5 col_event_rst_top_left[27] dac_config_4
+ row_on_detect_top[11] dac_config_0 dac_config_1 row_off_detect_top[10] x1_net73
+ dac_config_2 vdda1 vssa1 vssc1 col_event_rst_top_left[26] x1_net74 row_on_detect_top[10]
+ row_off_detect_top[11] openDVS_pixel2x2_top
x1_x179 dac_config_3 dac_config_5 col_event_rst_top_left[25] dac_config_4
+ row_on_detect_top[11] dac_config_0 dac_config_1 row_off_detect_top[10] x1_net77
+ dac_config_2 vdda1 vssa1 vssc1 col_event_rst_top_left[24] x1_net78 row_on_detect_top[10]
+ row_off_detect_top[11] openDVS_pixel2x2_top
x1_x180 dac_config_3 dac_config_5 col_event_rst_top_left[23] dac_config_4
+ row_on_detect_top[11] dac_config_0 dac_config_1 row_off_detect_top[10] x1_net81
+ dac_config_2 vdda1 vssa1 vssc1 col_event_rst_top_left[22] x1_net82 row_on_detect_top[10]
+ row_off_detect_top[11] openDVS_pixel2x2_top
x1_x181 dac_config_3 dac_config_5 col_event_rst_top_left[21] dac_config_4
+ row_on_detect_top[11] dac_config_0 dac_config_1 row_off_detect_top[10] x1_net85
+ dac_config_2 vdda1 vssa1 vssc1 col_event_rst_top_left[20] x1_net86 row_on_detect_top[10]
+ row_off_detect_top[11] openDVS_pixel2x2_top
x1_x182 dac_config_3 dac_config_5 col_event_rst_top_left[19] dac_config_4
+ row_on_detect_top[11] dac_config_0 dac_config_1 row_off_detect_top[10] x1_net89
+ dac_config_2 vdda1 vssa1 vssc1 col_event_rst_top_left[18] x1_net90 row_on_detect_top[10]
+ row_off_detect_top[11] openDVS_pixel2x2_top
x1_x183 dac_config_3 dac_config_5 col_event_rst_top_left[17] dac_config_4
+ row_on_detect_top[11] dac_config_0 dac_config_1 row_off_detect_top[10] x1_net93
+ dac_config_2 vdda1 vssa1 vssc1 col_event_rst_top_left[16] x1_net94 row_on_detect_top[10]
+ row_off_detect_top[11] openDVS_pixel2x2_top
x1_x184 dac_config_3 dac_config_5 col_event_rst_top_left[15] dac_config_4
+ row_on_detect_top[11] dac_config_0 dac_config_1 row_off_detect_top[10] x1_net97
+ dac_config_2 vdda1 vssa1 vssc1 col_event_rst_top_left[14] x1_net98 row_on_detect_top[10]
+ row_off_detect_top[11] openDVS_pixel2x2_top
x1_x185 dac_config_3 dac_config_5 col_event_rst_top_left[13] dac_config_4
+ row_on_detect_top[11] dac_config_0 dac_config_1 row_off_detect_top[10] x1_net101
+ dac_config_2 vdda1 vssa1 vssc1 col_event_rst_top_left[12] x1_net102
+ row_on_detect_top[10] row_off_detect_top[11] openDVS_pixel2x2_top
x1_x186 dac_config_3 dac_config_5 col_event_rst_top_left[11] dac_config_4
+ row_on_detect_top[11] dac_config_0 dac_config_1 row_off_detect_top[10] x1_net105
+ dac_config_2 vdda1 vssa1 vssc1 col_event_rst_top_left[10] x1_net106
+ row_on_detect_top[10] row_off_detect_top[11] openDVS_pixel2x2_top
x1_x187 dac_config_3 dac_config_5 col_event_rst_top_left[9] dac_config_4
+ row_on_detect_top[11] dac_config_0 dac_config_1 row_off_detect_top[10] x1_net109
+ dac_config_2 vdda1 vssa1 vssc1 col_event_rst_top_left[8] x1_net110 row_on_detect_top[10]
+ row_off_detect_top[11] openDVS_pixel2x2_top
x1_x188 dac_config_3 dac_config_5 col_event_rst_top_left[7] dac_config_4
+ row_on_detect_top[11] dac_config_0 dac_config_1 row_off_detect_top[10] x1_net113
+ dac_config_2 vdda1 vssa1 vssc1 col_event_rst_top_left[6] x1_net114 row_on_detect_top[10]
+ row_off_detect_top[11] openDVS_pixel2x2_top
x1_x189 dac_config_3 dac_config_5 col_event_rst_top_left[5] dac_config_4
+ row_on_detect_top[11] dac_config_0 dac_config_1 row_off_detect_top[10] x1_net117
+ dac_config_2 vdda1 vssa1 vssc1 col_event_rst_top_left[4] x1_net118 row_on_detect_top[10]
+ row_off_detect_top[11] openDVS_pixel2x2_top
x1_x190 dac_config_3 dac_config_5 col_event_rst_top_left[3] dac_config_4
+ row_on_detect_top[11] dac_config_0 dac_config_1 row_off_detect_top[10] x1_net121
+ dac_config_2 vdda1 vssa1 vssc1 col_event_rst_top_left[2] x1_net122 row_on_detect_top[10]
+ row_off_detect_top[11] openDVS_pixel2x2_top
x1_x191 dac_config_3 dac_config_5 col_event_rst_top_left[1] dac_config_4
+ row_on_detect_top[11] dac_config_0 dac_config_1 row_off_detect_top[10] x1_net125
+ dac_config_2 vdda1 vssa1 vssc1 col_event_rst_top_left[0] x1_net126 row_on_detect_top[10]
+ row_off_detect_top[11] openDVS_pixel2x2_top
x1_x192 dac_config_3 dac_config_5 col_event_rst_top_left[63] dac_config_4
+ row_on_detect_top[13] dac_config_0 dac_config_1 row_off_detect_top[12] x1_net1
+ dac_config_2 vdda1 vssa1 vssc1 col_event_rst_top_left[62] x1_net2 row_on_detect_top[12]
+ row_off_detect_top[13] openDVS_pixel2x2_top
x1_x193 dac_config_3 dac_config_5 col_event_rst_top_left[61] dac_config_4
+ row_on_detect_top[13] dac_config_0 dac_config_1 row_off_detect_top[12] x1_net5
+ dac_config_2 vdda1 vssa1 vssc1 col_event_rst_top_left[60] x1_net6 row_on_detect_top[12]
+ row_off_detect_top[13] openDVS_pixel2x2_top
x1_x194 dac_config_3 dac_config_5 col_event_rst_top_left[59] dac_config_4
+ row_on_detect_top[13] dac_config_0 dac_config_1 row_off_detect_top[12] x1_net9
+ dac_config_2 vdda1 vssa1 vssc1 col_event_rst_top_left[58] x1_net10 row_on_detect_top[12]
+ row_off_detect_top[13] openDVS_pixel2x2_top
x1_x195 dac_config_3 dac_config_5 col_event_rst_top_left[57] dac_config_4
+ row_on_detect_top[13] dac_config_0 dac_config_1 row_off_detect_top[12] x1_net13
+ dac_config_2 vdda1 vssa1 vssc1 col_event_rst_top_left[56] x1_net14 row_on_detect_top[12]
+ row_off_detect_top[13] openDVS_pixel2x2_top
x1_x196 dac_config_3 dac_config_5 col_event_rst_top_left[55] dac_config_4
+ row_on_detect_top[13] dac_config_0 dac_config_1 row_off_detect_top[12] x1_net17
+ dac_config_2 vdda1 vssa1 vssc1 col_event_rst_top_left[54] x1_net18 row_on_detect_top[12]
+ row_off_detect_top[13] openDVS_pixel2x2_top
x1_x197 dac_config_3 dac_config_5 col_event_rst_top_left[53] dac_config_4
+ row_on_detect_top[13] dac_config_0 dac_config_1 row_off_detect_top[12] x1_net21
+ dac_config_2 vdda1 vssa1 vssc1 col_event_rst_top_left[52] x1_net22 row_on_detect_top[12]
+ row_off_detect_top[13] openDVS_pixel2x2_top
x1_x198 dac_config_3 dac_config_5 col_event_rst_top_left[51] dac_config_4
+ row_on_detect_top[13] dac_config_0 dac_config_1 row_off_detect_top[12] x1_net25
+ dac_config_2 vdda1 vssa1 vssc1 col_event_rst_top_left[50] x1_net26 row_on_detect_top[12]
+ row_off_detect_top[13] openDVS_pixel2x2_top
x1_x199 dac_config_3 dac_config_5 col_event_rst_top_left[49] dac_config_4
+ row_on_detect_top[13] dac_config_0 dac_config_1 row_off_detect_top[12] x1_net29
+ dac_config_2 vdda1 vssa1 vssc1 col_event_rst_top_left[48] x1_net30 row_on_detect_top[12]
+ row_off_detect_top[13] openDVS_pixel2x2_top
x1_x200 dac_config_3 dac_config_5 col_event_rst_top_left[47] dac_config_4
+ row_on_detect_top[13] dac_config_0 dac_config_1 row_off_detect_top[12] x1_net33
+ dac_config_2 vdda1 vssa1 vssc1 col_event_rst_top_left[46] x1_net34 row_on_detect_top[12]
+ row_off_detect_top[13] openDVS_pixel2x2_top
x1_x201 dac_config_3 dac_config_5 col_event_rst_top_left[45] dac_config_4
+ row_on_detect_top[13] dac_config_0 dac_config_1 row_off_detect_top[12] x1_net37
+ dac_config_2 vdda1 vssa1 vssc1 col_event_rst_top_left[44] x1_net38 row_on_detect_top[12]
+ row_off_detect_top[13] openDVS_pixel2x2_top
x1_x202 dac_config_3 dac_config_5 col_event_rst_top_left[43] dac_config_4
+ row_on_detect_top[13] dac_config_0 dac_config_1 row_off_detect_top[12] x1_net41
+ dac_config_2 vdda1 vssa1 vssc1 col_event_rst_top_left[42] x1_net42 row_on_detect_top[12]
+ row_off_detect_top[13] openDVS_pixel2x2_top
x1_x203 dac_config_3 dac_config_5 col_event_rst_top_left[41] dac_config_4
+ row_on_detect_top[13] dac_config_0 dac_config_1 row_off_detect_top[12] x1_net45
+ dac_config_2 vdda1 vssa1 vssc1 col_event_rst_top_left[40] x1_net46 row_on_detect_top[12]
+ row_off_detect_top[13] openDVS_pixel2x2_top
x1_x204 dac_config_3 dac_config_5 col_event_rst_top_left[39] dac_config_4
+ row_on_detect_top[13] dac_config_0 dac_config_1 row_off_detect_top[12] x1_net49
+ dac_config_2 vdda1 vssa1 vssc1 col_event_rst_top_left[38] x1_net50 row_on_detect_top[12]
+ row_off_detect_top[13] openDVS_pixel2x2_top
x1_x205 dac_config_3 dac_config_5 col_event_rst_top_left[37] dac_config_4
+ row_on_detect_top[13] dac_config_0 dac_config_1 row_off_detect_top[12] x1_net53
+ dac_config_2 vdda1 vssa1 vssc1 col_event_rst_top_left[36] x1_net54 row_on_detect_top[12]
+ row_off_detect_top[13] openDVS_pixel2x2_top
x1_x206 dac_config_3 dac_config_5 col_event_rst_top_left[35] dac_config_4
+ row_on_detect_top[13] dac_config_0 dac_config_1 row_off_detect_top[12] x1_net57
+ dac_config_2 vdda1 vssa1 vssc1 col_event_rst_top_left[34] x1_net58 row_on_detect_top[12]
+ row_off_detect_top[13] openDVS_pixel2x2_top
x1_x207 dac_config_3 dac_config_5 col_event_rst_top_left[33] dac_config_4
+ row_on_detect_top[13] dac_config_0 dac_config_1 row_off_detect_top[12] x1_net61
+ dac_config_2 vdda1 vssa1 vssc1 col_event_rst_top_left[32] x1_net62 row_on_detect_top[12]
+ row_off_detect_top[13] openDVS_pixel2x2_top
x1_x208 dac_config_3 dac_config_5 col_event_rst_top_left[31] dac_config_4
+ row_on_detect_top[13] dac_config_0 dac_config_1 row_off_detect_top[12] x1_net65
+ dac_config_2 vdda1 vssa1 vssc1 col_event_rst_top_left[30] x1_net66 row_on_detect_top[12]
+ row_off_detect_top[13] openDVS_pixel2x2_top
x1_x209 dac_config_3 dac_config_5 col_event_rst_top_left[29] dac_config_4
+ row_on_detect_top[13] dac_config_0 dac_config_1 row_off_detect_top[12] x1_net69
+ dac_config_2 vdda1 vssa1 vssc1 col_event_rst_top_left[28] x1_net70 row_on_detect_top[12]
+ row_off_detect_top[13] openDVS_pixel2x2_top
x1_x210 dac_config_3 dac_config_5 col_event_rst_top_left[27] dac_config_4
+ row_on_detect_top[13] dac_config_0 dac_config_1 row_off_detect_top[12] x1_net73
+ dac_config_2 vdda1 vssa1 vssc1 col_event_rst_top_left[26] x1_net74 row_on_detect_top[12]
+ row_off_detect_top[13] openDVS_pixel2x2_top
x1_x211 dac_config_3 dac_config_5 col_event_rst_top_left[25] dac_config_4
+ row_on_detect_top[13] dac_config_0 dac_config_1 row_off_detect_top[12] x1_net77
+ dac_config_2 vdda1 vssa1 vssc1 col_event_rst_top_left[24] x1_net78 row_on_detect_top[12]
+ row_off_detect_top[13] openDVS_pixel2x2_top
x1_x212 dac_config_3 dac_config_5 col_event_rst_top_left[23] dac_config_4
+ row_on_detect_top[13] dac_config_0 dac_config_1 row_off_detect_top[12] x1_net81
+ dac_config_2 vdda1 vssa1 vssc1 col_event_rst_top_left[22] x1_net82 row_on_detect_top[12]
+ row_off_detect_top[13] openDVS_pixel2x2_top
x1_x213 dac_config_3 dac_config_5 col_event_rst_top_left[21] dac_config_4
+ row_on_detect_top[13] dac_config_0 dac_config_1 row_off_detect_top[12] x1_net85
+ dac_config_2 vdda1 vssa1 vssc1 col_event_rst_top_left[20] x1_net86 row_on_detect_top[12]
+ row_off_detect_top[13] openDVS_pixel2x2_top
x1_x214 dac_config_3 dac_config_5 col_event_rst_top_left[19] dac_config_4
+ row_on_detect_top[13] dac_config_0 dac_config_1 row_off_detect_top[12] x1_net89
+ dac_config_2 vdda1 vssa1 vssc1 col_event_rst_top_left[18] x1_net90 row_on_detect_top[12]
+ row_off_detect_top[13] openDVS_pixel2x2_top
x1_x215 dac_config_3 dac_config_5 col_event_rst_top_left[17] dac_config_4
+ row_on_detect_top[13] dac_config_0 dac_config_1 row_off_detect_top[12] x1_net93
+ dac_config_2 vdda1 vssa1 vssc1 col_event_rst_top_left[16] x1_net94 row_on_detect_top[12]
+ row_off_detect_top[13] openDVS_pixel2x2_top
x1_x216 dac_config_3 dac_config_5 col_event_rst_top_left[15] dac_config_4
+ row_on_detect_top[13] dac_config_0 dac_config_1 row_off_detect_top[12] x1_net97
+ dac_config_2 vdda1 vssa1 vssc1 col_event_rst_top_left[14] x1_net98 row_on_detect_top[12]
+ row_off_detect_top[13] openDVS_pixel2x2_top
x1_x217 dac_config_3 dac_config_5 col_event_rst_top_left[13] dac_config_4
+ row_on_detect_top[13] dac_config_0 dac_config_1 row_off_detect_top[12] x1_net101
+ dac_config_2 vdda1 vssa1 vssc1 col_event_rst_top_left[12] x1_net102
+ row_on_detect_top[12] row_off_detect_top[13] openDVS_pixel2x2_top
x1_x218 dac_config_3 dac_config_5 col_event_rst_top_left[11] dac_config_4
+ row_on_detect_top[13] dac_config_0 dac_config_1 row_off_detect_top[12] x1_net105
+ dac_config_2 vdda1 vssa1 vssc1 col_event_rst_top_left[10] x1_net106
+ row_on_detect_top[12] row_off_detect_top[13] openDVS_pixel2x2_top
x1_x219 dac_config_3 dac_config_5 col_event_rst_top_left[9] dac_config_4
+ row_on_detect_top[13] dac_config_0 dac_config_1 row_off_detect_top[12] x1_net109
+ dac_config_2 vdda1 vssa1 vssc1 col_event_rst_top_left[8] x1_net110 row_on_detect_top[12]
+ row_off_detect_top[13] openDVS_pixel2x2_top
x1_x220 dac_config_3 dac_config_5 col_event_rst_top_left[7] dac_config_4
+ row_on_detect_top[13] dac_config_0 dac_config_1 row_off_detect_top[12] x1_net113
+ dac_config_2 vdda1 vssa1 vssc1 col_event_rst_top_left[6] x1_net114 row_on_detect_top[12]
+ row_off_detect_top[13] openDVS_pixel2x2_top
x1_x221 dac_config_3 dac_config_5 col_event_rst_top_left[5] dac_config_4
+ row_on_detect_top[13] dac_config_0 dac_config_1 row_off_detect_top[12] x1_net117
+ dac_config_2 vdda1 vssa1 vssc1 col_event_rst_top_left[4] x1_net118 row_on_detect_top[12]
+ row_off_detect_top[13] openDVS_pixel2x2_top
x1_x222 dac_config_3 dac_config_5 col_event_rst_top_left[3] dac_config_4
+ row_on_detect_top[13] dac_config_0 dac_config_1 row_off_detect_top[12] x1_net121
+ dac_config_2 vdda1 vssa1 vssc1 col_event_rst_top_left[2] x1_net122 row_on_detect_top[12]
+ row_off_detect_top[13] openDVS_pixel2x2_top
x1_x223 dac_config_3 dac_config_5 col_event_rst_top_left[1] dac_config_4
+ row_on_detect_top[13] dac_config_0 dac_config_1 row_off_detect_top[12] x1_net125
+ dac_config_2 vdda1 vssa1 vssc1 col_event_rst_top_left[0] x1_net126 row_on_detect_top[12]
+ row_off_detect_top[13] openDVS_pixel2x2_top
x1_x224 dac_config_3 dac_config_5 col_event_rst_top_left[63] dac_config_4
+ row_on_detect_top[15] dac_config_0 dac_config_1 row_off_detect_top[14] x1_net1
+ dac_config_2 vdda1 vssa1 vssc1 col_event_rst_top_left[62] x1_net2 row_on_detect_top[14]
+ row_off_detect_top[15] openDVS_pixel2x2_top
x1_x225 dac_config_3 dac_config_5 col_event_rst_top_left[61] dac_config_4
+ row_on_detect_top[15] dac_config_0 dac_config_1 row_off_detect_top[14] x1_net5
+ dac_config_2 vdda1 vssa1 vssc1 col_event_rst_top_left[60] x1_net6 row_on_detect_top[14]
+ row_off_detect_top[15] openDVS_pixel2x2_top
x1_x226 dac_config_3 dac_config_5 col_event_rst_top_left[59] dac_config_4
+ row_on_detect_top[15] dac_config_0 dac_config_1 row_off_detect_top[14] x1_net9
+ dac_config_2 vdda1 vssa1 vssc1 col_event_rst_top_left[58] x1_net10 row_on_detect_top[14]
+ row_off_detect_top[15] openDVS_pixel2x2_top
x1_x227 dac_config_3 dac_config_5 col_event_rst_top_left[57] dac_config_4
+ row_on_detect_top[15] dac_config_0 dac_config_1 row_off_detect_top[14] x1_net13
+ dac_config_2 vdda1 vssa1 vssc1 col_event_rst_top_left[56] x1_net14 row_on_detect_top[14]
+ row_off_detect_top[15] openDVS_pixel2x2_top
x1_x228 dac_config_3 dac_config_5 col_event_rst_top_left[55] dac_config_4
+ row_on_detect_top[15] dac_config_0 dac_config_1 row_off_detect_top[14] x1_net17
+ dac_config_2 vdda1 vssa1 vssc1 col_event_rst_top_left[54] x1_net18 row_on_detect_top[14]
+ row_off_detect_top[15] openDVS_pixel2x2_top
x1_x229 dac_config_3 dac_config_5 col_event_rst_top_left[53] dac_config_4
+ row_on_detect_top[15] dac_config_0 dac_config_1 row_off_detect_top[14] x1_net21
+ dac_config_2 vdda1 vssa1 vssc1 col_event_rst_top_left[52] x1_net22 row_on_detect_top[14]
+ row_off_detect_top[15] openDVS_pixel2x2_top
x1_x230 dac_config_3 dac_config_5 col_event_rst_top_left[51] dac_config_4
+ row_on_detect_top[15] dac_config_0 dac_config_1 row_off_detect_top[14] x1_net25
+ dac_config_2 vdda1 vssa1 vssc1 col_event_rst_top_left[50] x1_net26 row_on_detect_top[14]
+ row_off_detect_top[15] openDVS_pixel2x2_top
x1_x231 dac_config_3 dac_config_5 col_event_rst_top_left[49] dac_config_4
+ row_on_detect_top[15] dac_config_0 dac_config_1 row_off_detect_top[14] x1_net29
+ dac_config_2 vdda1 vssa1 vssc1 col_event_rst_top_left[48] x1_net30 row_on_detect_top[14]
+ row_off_detect_top[15] openDVS_pixel2x2_top
x1_x232 dac_config_3 dac_config_5 col_event_rst_top_left[47] dac_config_4
+ row_on_detect_top[15] dac_config_0 dac_config_1 row_off_detect_top[14] x1_net33
+ dac_config_2 vdda1 vssa1 vssc1 col_event_rst_top_left[46] x1_net34 row_on_detect_top[14]
+ row_off_detect_top[15] openDVS_pixel2x2_top
x1_x233 dac_config_3 dac_config_5 col_event_rst_top_left[45] dac_config_4
+ row_on_detect_top[15] dac_config_0 dac_config_1 row_off_detect_top[14] x1_net37
+ dac_config_2 vdda1 vssa1 vssc1 col_event_rst_top_left[44] x1_net38 row_on_detect_top[14]
+ row_off_detect_top[15] openDVS_pixel2x2_top
x1_x234 dac_config_3 dac_config_5 col_event_rst_top_left[43] dac_config_4
+ row_on_detect_top[15] dac_config_0 dac_config_1 row_off_detect_top[14] x1_net41
+ dac_config_2 vdda1 vssa1 vssc1 col_event_rst_top_left[42] x1_net42 row_on_detect_top[14]
+ row_off_detect_top[15] openDVS_pixel2x2_top
x1_x235 dac_config_3 dac_config_5 col_event_rst_top_left[41] dac_config_4
+ row_on_detect_top[15] dac_config_0 dac_config_1 row_off_detect_top[14] x1_net45
+ dac_config_2 vdda1 vssa1 vssc1 col_event_rst_top_left[40] x1_net46 row_on_detect_top[14]
+ row_off_detect_top[15] openDVS_pixel2x2_top
x1_x236 dac_config_3 dac_config_5 col_event_rst_top_left[39] dac_config_4
+ row_on_detect_top[15] dac_config_0 dac_config_1 row_off_detect_top[14] x1_net49
+ dac_config_2 vdda1 vssa1 vssc1 col_event_rst_top_left[38] x1_net50 row_on_detect_top[14]
+ row_off_detect_top[15] openDVS_pixel2x2_top
x1_x237 dac_config_3 dac_config_5 col_event_rst_top_left[37] dac_config_4
+ row_on_detect_top[15] dac_config_0 dac_config_1 row_off_detect_top[14] x1_net53
+ dac_config_2 vdda1 vssa1 vssc1 col_event_rst_top_left[36] x1_net54 row_on_detect_top[14]
+ row_off_detect_top[15] openDVS_pixel2x2_top
x1_x238 dac_config_3 dac_config_5 col_event_rst_top_left[35] dac_config_4
+ row_on_detect_top[15] dac_config_0 dac_config_1 row_off_detect_top[14] x1_net57
+ dac_config_2 vdda1 vssa1 vssc1 col_event_rst_top_left[34] x1_net58 row_on_detect_top[14]
+ row_off_detect_top[15] openDVS_pixel2x2_top
x1_x239 dac_config_3 dac_config_5 col_event_rst_top_left[33] dac_config_4
+ row_on_detect_top[15] dac_config_0 dac_config_1 row_off_detect_top[14] x1_net61
+ dac_config_2 vdda1 vssa1 vssc1 col_event_rst_top_left[32] x1_net62 row_on_detect_top[14]
+ row_off_detect_top[15] openDVS_pixel2x2_top
x1_x240 dac_config_3 dac_config_5 col_event_rst_top_left[31] dac_config_4
+ row_on_detect_top[15] dac_config_0 dac_config_1 row_off_detect_top[14] x1_net65
+ dac_config_2 vdda1 vssa1 vssc1 col_event_rst_top_left[30] x1_net66 row_on_detect_top[14]
+ row_off_detect_top[15] openDVS_pixel2x2_top
x1_x241 dac_config_3 dac_config_5 col_event_rst_top_left[29] dac_config_4
+ row_on_detect_top[15] dac_config_0 dac_config_1 row_off_detect_top[14] x1_net69
+ dac_config_2 vdda1 vssa1 vssc1 col_event_rst_top_left[28] x1_net70 row_on_detect_top[14]
+ row_off_detect_top[15] openDVS_pixel2x2_top
x1_x242 dac_config_3 dac_config_5 col_event_rst_top_left[27] dac_config_4
+ row_on_detect_top[15] dac_config_0 dac_config_1 row_off_detect_top[14] x1_net73
+ dac_config_2 vdda1 vssa1 vssc1 col_event_rst_top_left[26] x1_net74 row_on_detect_top[14]
+ row_off_detect_top[15] openDVS_pixel2x2_top
x1_x243 dac_config_3 dac_config_5 col_event_rst_top_left[25] dac_config_4
+ row_on_detect_top[15] dac_config_0 dac_config_1 row_off_detect_top[14] x1_net77
+ dac_config_2 vdda1 vssa1 vssc1 col_event_rst_top_left[24] x1_net78 row_on_detect_top[14]
+ row_off_detect_top[15] openDVS_pixel2x2_top
x1_x244 dac_config_3 dac_config_5 col_event_rst_top_left[23] dac_config_4
+ row_on_detect_top[15] dac_config_0 dac_config_1 row_off_detect_top[14] x1_net81
+ dac_config_2 vdda1 vssa1 vssc1 col_event_rst_top_left[22] x1_net82 row_on_detect_top[14]
+ row_off_detect_top[15] openDVS_pixel2x2_top
x1_x245 dac_config_3 dac_config_5 col_event_rst_top_left[21] dac_config_4
+ row_on_detect_top[15] dac_config_0 dac_config_1 row_off_detect_top[14] x1_net85
+ dac_config_2 vdda1 vssa1 vssc1 col_event_rst_top_left[20] x1_net86 row_on_detect_top[14]
+ row_off_detect_top[15] openDVS_pixel2x2_top
x1_x246 dac_config_3 dac_config_5 col_event_rst_top_left[19] dac_config_4
+ row_on_detect_top[15] dac_config_0 dac_config_1 row_off_detect_top[14] x1_net89
+ dac_config_2 vdda1 vssa1 vssc1 col_event_rst_top_left[18] x1_net90 row_on_detect_top[14]
+ row_off_detect_top[15] openDVS_pixel2x2_top
x1_x247 dac_config_3 dac_config_5 col_event_rst_top_left[17] dac_config_4
+ row_on_detect_top[15] dac_config_0 dac_config_1 row_off_detect_top[14] x1_net93
+ dac_config_2 vdda1 vssa1 vssc1 col_event_rst_top_left[16] x1_net94 row_on_detect_top[14]
+ row_off_detect_top[15] openDVS_pixel2x2_top
x1_x248 dac_config_3 dac_config_5 col_event_rst_top_left[15] dac_config_4
+ row_on_detect_top[15] dac_config_0 dac_config_1 row_off_detect_top[14] x1_net97
+ dac_config_2 vdda1 vssa1 vssc1 col_event_rst_top_left[14] x1_net98 row_on_detect_top[14]
+ row_off_detect_top[15] openDVS_pixel2x2_top
x1_x249 dac_config_3 dac_config_5 col_event_rst_top_left[13] dac_config_4
+ row_on_detect_top[15] dac_config_0 dac_config_1 row_off_detect_top[14] x1_net101
+ dac_config_2 vdda1 vssa1 vssc1 col_event_rst_top_left[12] x1_net102
+ row_on_detect_top[14] row_off_detect_top[15] openDVS_pixel2x2_top
x1_x250 dac_config_3 dac_config_5 col_event_rst_top_left[11] dac_config_4
+ row_on_detect_top[15] dac_config_0 dac_config_1 row_off_detect_top[14] x1_net105
+ dac_config_2 vdda1 vssa1 vssc1 col_event_rst_top_left[10] x1_net106
+ row_on_detect_top[14] row_off_detect_top[15] openDVS_pixel2x2_top
x1_x251 dac_config_3 dac_config_5 col_event_rst_top_left[9] dac_config_4
+ row_on_detect_top[15] dac_config_0 dac_config_1 row_off_detect_top[14] x1_net109
+ dac_config_2 vdda1 vssa1 vssc1 col_event_rst_top_left[8] x1_net110 row_on_detect_top[14]
+ row_off_detect_top[15] openDVS_pixel2x2_top
x1_x252 dac_config_3 dac_config_5 col_event_rst_top_left[7] dac_config_4
+ row_on_detect_top[15] dac_config_0 dac_config_1 row_off_detect_top[14] x1_net113
+ dac_config_2 vdda1 vssa1 vssc1 col_event_rst_top_left[6] x1_net114 row_on_detect_top[14]
+ row_off_detect_top[15] openDVS_pixel2x2_top
x1_x253 dac_config_3 dac_config_5 col_event_rst_top_left[5] dac_config_4
+ row_on_detect_top[15] dac_config_0 dac_config_1 row_off_detect_top[14] x1_net117
+ dac_config_2 vdda1 vssa1 vssc1 col_event_rst_top_left[4] x1_net118 row_on_detect_top[14]
+ row_off_detect_top[15] openDVS_pixel2x2_top
x1_x254 dac_config_3 dac_config_5 col_event_rst_top_left[3] dac_config_4
+ row_on_detect_top[15] dac_config_0 dac_config_1 row_off_detect_top[14] x1_net121
+ dac_config_2 vdda1 vssa1 vssc1 col_event_rst_top_left[2] x1_net122 row_on_detect_top[14]
+ row_off_detect_top[15] openDVS_pixel2x2_top
x1_x255 dac_config_3 dac_config_5 col_event_rst_top_left[1] dac_config_4
+ row_on_detect_top[15] dac_config_0 dac_config_1 row_off_detect_top[14] x1_net125
+ dac_config_2 vdda1 vssa1 vssc1 col_event_rst_top_left[0] x1_net126 row_on_detect_top[14]
+ row_off_detect_top[15] openDVS_pixel2x2_top
x1_x256 dac_config_3 dac_config_5 col_event_rst_top_left[63] dac_config_4
+ row_on_detect_top[17] dac_config_0 dac_config_1 row_off_detect_top[16] x1_net1
+ dac_config_2 vdda1 vssa1 vssc1 col_event_rst_top_left[62] x1_net2 row_on_detect_top[16]
+ row_off_detect_top[17] openDVS_pixel2x2_top
x1_x257 dac_config_3 dac_config_5 col_event_rst_top_left[61] dac_config_4
+ row_on_detect_top[17] dac_config_0 dac_config_1 row_off_detect_top[16] x1_net5
+ dac_config_2 vdda1 vssa1 vssc1 col_event_rst_top_left[60] x1_net6 row_on_detect_top[16]
+ row_off_detect_top[17] openDVS_pixel2x2_top
x1_x258 dac_config_3 dac_config_5 col_event_rst_top_left[59] dac_config_4
+ row_on_detect_top[17] dac_config_0 dac_config_1 row_off_detect_top[16] x1_net9
+ dac_config_2 vdda1 vssa1 vssc1 col_event_rst_top_left[58] x1_net10 row_on_detect_top[16]
+ row_off_detect_top[17] openDVS_pixel2x2_top
x1_x259 dac_config_3 dac_config_5 col_event_rst_top_left[57] dac_config_4
+ row_on_detect_top[17] dac_config_0 dac_config_1 row_off_detect_top[16] x1_net13
+ dac_config_2 vdda1 vssa1 vssc1 col_event_rst_top_left[56] x1_net14 row_on_detect_top[16]
+ row_off_detect_top[17] openDVS_pixel2x2_top
x1_x260 dac_config_3 dac_config_5 col_event_rst_top_left[55] dac_config_4
+ row_on_detect_top[17] dac_config_0 dac_config_1 row_off_detect_top[16] x1_net17
+ dac_config_2 vdda1 vssa1 vssc1 col_event_rst_top_left[54] x1_net18 row_on_detect_top[16]
+ row_off_detect_top[17] openDVS_pixel2x2_top
x1_x261 dac_config_3 dac_config_5 col_event_rst_top_left[53] dac_config_4
+ row_on_detect_top[17] dac_config_0 dac_config_1 row_off_detect_top[16] x1_net21
+ dac_config_2 vdda1 vssa1 vssc1 col_event_rst_top_left[52] x1_net22 row_on_detect_top[16]
+ row_off_detect_top[17] openDVS_pixel2x2_top
x1_x262 dac_config_3 dac_config_5 col_event_rst_top_left[51] dac_config_4
+ row_on_detect_top[17] dac_config_0 dac_config_1 row_off_detect_top[16] x1_net25
+ dac_config_2 vdda1 vssa1 vssc1 col_event_rst_top_left[50] x1_net26 row_on_detect_top[16]
+ row_off_detect_top[17] openDVS_pixel2x2_top
x1_x263 dac_config_3 dac_config_5 col_event_rst_top_left[49] dac_config_4
+ row_on_detect_top[17] dac_config_0 dac_config_1 row_off_detect_top[16] x1_net29
+ dac_config_2 vdda1 vssa1 vssc1 col_event_rst_top_left[48] x1_net30 row_on_detect_top[16]
+ row_off_detect_top[17] openDVS_pixel2x2_top
x1_x264 dac_config_3 dac_config_5 col_event_rst_top_left[47] dac_config_4
+ row_on_detect_top[17] dac_config_0 dac_config_1 row_off_detect_top[16] x1_net33
+ dac_config_2 vdda1 vssa1 vssc1 col_event_rst_top_left[46] x1_net34 row_on_detect_top[16]
+ row_off_detect_top[17] openDVS_pixel2x2_top
x1_x265 dac_config_3 dac_config_5 col_event_rst_top_left[45] dac_config_4
+ row_on_detect_top[17] dac_config_0 dac_config_1 row_off_detect_top[16] x1_net37
+ dac_config_2 vdda1 vssa1 vssc1 col_event_rst_top_left[44] x1_net38 row_on_detect_top[16]
+ row_off_detect_top[17] openDVS_pixel2x2_top
x1_x266 dac_config_3 dac_config_5 col_event_rst_top_left[43] dac_config_4
+ row_on_detect_top[17] dac_config_0 dac_config_1 row_off_detect_top[16] x1_net41
+ dac_config_2 vdda1 vssa1 vssc1 col_event_rst_top_left[42] x1_net42 row_on_detect_top[16]
+ row_off_detect_top[17] openDVS_pixel2x2_top
x1_x267 dac_config_3 dac_config_5 col_event_rst_top_left[41] dac_config_4
+ row_on_detect_top[17] dac_config_0 dac_config_1 row_off_detect_top[16] x1_net45
+ dac_config_2 vdda1 vssa1 vssc1 col_event_rst_top_left[40] x1_net46 row_on_detect_top[16]
+ row_off_detect_top[17] openDVS_pixel2x2_top
x1_x268 dac_config_3 dac_config_5 col_event_rst_top_left[39] dac_config_4
+ row_on_detect_top[17] dac_config_0 dac_config_1 row_off_detect_top[16] x1_net49
+ dac_config_2 vdda1 vssa1 vssc1 col_event_rst_top_left[38] x1_net50 row_on_detect_top[16]
+ row_off_detect_top[17] openDVS_pixel2x2_top
x1_x269 dac_config_3 dac_config_5 col_event_rst_top_left[37] dac_config_4
+ row_on_detect_top[17] dac_config_0 dac_config_1 row_off_detect_top[16] x1_net53
+ dac_config_2 vdda1 vssa1 vssc1 col_event_rst_top_left[36] x1_net54 row_on_detect_top[16]
+ row_off_detect_top[17] openDVS_pixel2x2_top
x1_x270 dac_config_3 dac_config_5 col_event_rst_top_left[35] dac_config_4
+ row_on_detect_top[17] dac_config_0 dac_config_1 row_off_detect_top[16] x1_net57
+ dac_config_2 vdda1 vssa1 vssc1 col_event_rst_top_left[34] x1_net58 row_on_detect_top[16]
+ row_off_detect_top[17] openDVS_pixel2x2_top
x1_x271 dac_config_3 dac_config_5 col_event_rst_top_left[33] dac_config_4
+ row_on_detect_top[17] dac_config_0 dac_config_1 row_off_detect_top[16] x1_net61
+ dac_config_2 vdda1 vssa1 vssc1 col_event_rst_top_left[32] x1_net62 row_on_detect_top[16]
+ row_off_detect_top[17] openDVS_pixel2x2_top
x1_x272 dac_config_3 dac_config_5 col_event_rst_top_left[31] dac_config_4
+ row_on_detect_top[17] dac_config_0 dac_config_1 row_off_detect_top[16] x1_net65
+ dac_config_2 vdda1 vssa1 vssc1 col_event_rst_top_left[30] x1_net66 row_on_detect_top[16]
+ row_off_detect_top[17] openDVS_pixel2x2_top
x1_x273 dac_config_3 dac_config_5 col_event_rst_top_left[29] dac_config_4
+ row_on_detect_top[17] dac_config_0 dac_config_1 row_off_detect_top[16] x1_net69
+ dac_config_2 vdda1 vssa1 vssc1 col_event_rst_top_left[28] x1_net70 row_on_detect_top[16]
+ row_off_detect_top[17] openDVS_pixel2x2_top
x1_x274 dac_config_3 dac_config_5 col_event_rst_top_left[27] dac_config_4
+ row_on_detect_top[17] dac_config_0 dac_config_1 row_off_detect_top[16] x1_net73
+ dac_config_2 vdda1 vssa1 vssc1 col_event_rst_top_left[26] x1_net74 row_on_detect_top[16]
+ row_off_detect_top[17] openDVS_pixel2x2_top
x1_x275 dac_config_3 dac_config_5 col_event_rst_top_left[25] dac_config_4
+ row_on_detect_top[17] dac_config_0 dac_config_1 row_off_detect_top[16] x1_net77
+ dac_config_2 vdda1 vssa1 vssc1 col_event_rst_top_left[24] x1_net78 row_on_detect_top[16]
+ row_off_detect_top[17] openDVS_pixel2x2_top
x1_x276 dac_config_3 dac_config_5 col_event_rst_top_left[23] dac_config_4
+ row_on_detect_top[17] dac_config_0 dac_config_1 row_off_detect_top[16] x1_net81
+ dac_config_2 vdda1 vssa1 vssc1 col_event_rst_top_left[22] x1_net82 row_on_detect_top[16]
+ row_off_detect_top[17] openDVS_pixel2x2_top
x1_x277 dac_config_3 dac_config_5 col_event_rst_top_left[21] dac_config_4
+ row_on_detect_top[17] dac_config_0 dac_config_1 row_off_detect_top[16] x1_net85
+ dac_config_2 vdda1 vssa1 vssc1 col_event_rst_top_left[20] x1_net86 row_on_detect_top[16]
+ row_off_detect_top[17] openDVS_pixel2x2_top
x1_x278 dac_config_3 dac_config_5 col_event_rst_top_left[19] dac_config_4
+ row_on_detect_top[17] dac_config_0 dac_config_1 row_off_detect_top[16] x1_net89
+ dac_config_2 vdda1 vssa1 vssc1 col_event_rst_top_left[18] x1_net90 row_on_detect_top[16]
+ row_off_detect_top[17] openDVS_pixel2x2_top
x1_x279 dac_config_3 dac_config_5 col_event_rst_top_left[17] dac_config_4
+ row_on_detect_top[17] dac_config_0 dac_config_1 row_off_detect_top[16] x1_net93
+ dac_config_2 vdda1 vssa1 vssc1 col_event_rst_top_left[16] x1_net94 row_on_detect_top[16]
+ row_off_detect_top[17] openDVS_pixel2x2_top
x1_x280 dac_config_3 dac_config_5 col_event_rst_top_left[15] dac_config_4
+ row_on_detect_top[17] dac_config_0 dac_config_1 row_off_detect_top[16] x1_net97
+ dac_config_2 vdda1 vssa1 vssc1 col_event_rst_top_left[14] x1_net98 row_on_detect_top[16]
+ row_off_detect_top[17] openDVS_pixel2x2_top
x1_x281 dac_config_3 dac_config_5 col_event_rst_top_left[13] dac_config_4
+ row_on_detect_top[17] dac_config_0 dac_config_1 row_off_detect_top[16] x1_net101
+ dac_config_2 vdda1 vssa1 vssc1 col_event_rst_top_left[12] x1_net102
+ row_on_detect_top[16] row_off_detect_top[17] openDVS_pixel2x2_top
x1_x282 dac_config_3 dac_config_5 col_event_rst_top_left[11] dac_config_4
+ row_on_detect_top[17] dac_config_0 dac_config_1 row_off_detect_top[16] x1_net105
+ dac_config_2 vdda1 vssa1 vssc1 col_event_rst_top_left[10] x1_net106
+ row_on_detect_top[16] row_off_detect_top[17] openDVS_pixel2x2_top
x1_x283 dac_config_3 dac_config_5 col_event_rst_top_left[9] dac_config_4
+ row_on_detect_top[17] dac_config_0 dac_config_1 row_off_detect_top[16] x1_net109
+ dac_config_2 vdda1 vssa1 vssc1 col_event_rst_top_left[8] x1_net110 row_on_detect_top[16]
+ row_off_detect_top[17] openDVS_pixel2x2_top
x1_x284 dac_config_3 dac_config_5 col_event_rst_top_left[7] dac_config_4
+ row_on_detect_top[17] dac_config_0 dac_config_1 row_off_detect_top[16] x1_net113
+ dac_config_2 vdda1 vssa1 vssc1 col_event_rst_top_left[6] x1_net114 row_on_detect_top[16]
+ row_off_detect_top[17] openDVS_pixel2x2_top
x1_x285 dac_config_3 dac_config_5 col_event_rst_top_left[5] dac_config_4
+ row_on_detect_top[17] dac_config_0 dac_config_1 row_off_detect_top[16] x1_net117
+ dac_config_2 vdda1 vssa1 vssc1 col_event_rst_top_left[4] x1_net118 row_on_detect_top[16]
+ row_off_detect_top[17] openDVS_pixel2x2_top
x1_x286 dac_config_3 dac_config_5 col_event_rst_top_left[3] dac_config_4
+ row_on_detect_top[17] dac_config_0 dac_config_1 row_off_detect_top[16] x1_net121
+ dac_config_2 vdda1 vssa1 vssc1 col_event_rst_top_left[2] x1_net122 row_on_detect_top[16]
+ row_off_detect_top[17] openDVS_pixel2x2_top
x1_x287 dac_config_3 dac_config_5 col_event_rst_top_left[1] dac_config_4
+ row_on_detect_top[17] dac_config_0 dac_config_1 row_off_detect_top[16] x1_net125
+ dac_config_2 vdda1 vssa1 vssc1 col_event_rst_top_left[0] x1_net126 row_on_detect_top[16]
+ row_off_detect_top[17] openDVS_pixel2x2_top
x1_x288 dac_config_3 dac_config_5 col_event_rst_top_left[63] dac_config_4
+ row_on_detect_top[19] dac_config_0 dac_config_1 row_off_detect_top[18] x1_net1
+ dac_config_2 vdda1 vssa1 vssc1 col_event_rst_top_left[62] x1_net2 row_on_detect_top[18]
+ row_off_detect_top[19] openDVS_pixel2x2_top
x1_x289 dac_config_3 dac_config_5 col_event_rst_top_left[61] dac_config_4
+ row_on_detect_top[19] dac_config_0 dac_config_1 row_off_detect_top[18] x1_net5
+ dac_config_2 vdda1 vssa1 vssc1 col_event_rst_top_left[60] x1_net6 row_on_detect_top[18]
+ row_off_detect_top[19] openDVS_pixel2x2_top
x1_x290 dac_config_3 dac_config_5 col_event_rst_top_left[59] dac_config_4
+ row_on_detect_top[19] dac_config_0 dac_config_1 row_off_detect_top[18] x1_net9
+ dac_config_2 vdda1 vssa1 vssc1 col_event_rst_top_left[58] x1_net10 row_on_detect_top[18]
+ row_off_detect_top[19] openDVS_pixel2x2_top
x1_x291 dac_config_3 dac_config_5 col_event_rst_top_left[57] dac_config_4
+ row_on_detect_top[19] dac_config_0 dac_config_1 row_off_detect_top[18] x1_net13
+ dac_config_2 vdda1 vssa1 vssc1 col_event_rst_top_left[56] x1_net14 row_on_detect_top[18]
+ row_off_detect_top[19] openDVS_pixel2x2_top
x1_x292 dac_config_3 dac_config_5 col_event_rst_top_left[55] dac_config_4
+ row_on_detect_top[19] dac_config_0 dac_config_1 row_off_detect_top[18] x1_net17
+ dac_config_2 vdda1 vssa1 vssc1 col_event_rst_top_left[54] x1_net18 row_on_detect_top[18]
+ row_off_detect_top[19] openDVS_pixel2x2_top
x1_x293 dac_config_3 dac_config_5 col_event_rst_top_left[53] dac_config_4
+ row_on_detect_top[19] dac_config_0 dac_config_1 row_off_detect_top[18] x1_net21
+ dac_config_2 vdda1 vssa1 vssc1 col_event_rst_top_left[52] x1_net22 row_on_detect_top[18]
+ row_off_detect_top[19] openDVS_pixel2x2_top
x1_x294 dac_config_3 dac_config_5 col_event_rst_top_left[51] dac_config_4
+ row_on_detect_top[19] dac_config_0 dac_config_1 row_off_detect_top[18] x1_net25
+ dac_config_2 vdda1 vssa1 vssc1 col_event_rst_top_left[50] x1_net26 row_on_detect_top[18]
+ row_off_detect_top[19] openDVS_pixel2x2_top
x1_x295 dac_config_3 dac_config_5 col_event_rst_top_left[49] dac_config_4
+ row_on_detect_top[19] dac_config_0 dac_config_1 row_off_detect_top[18] x1_net29
+ dac_config_2 vdda1 vssa1 vssc1 col_event_rst_top_left[48] x1_net30 row_on_detect_top[18]
+ row_off_detect_top[19] openDVS_pixel2x2_top
x1_x296 dac_config_3 dac_config_5 col_event_rst_top_left[47] dac_config_4
+ row_on_detect_top[19] dac_config_0 dac_config_1 row_off_detect_top[18] x1_net33
+ dac_config_2 vdda1 vssa1 vssc1 col_event_rst_top_left[46] x1_net34 row_on_detect_top[18]
+ row_off_detect_top[19] openDVS_pixel2x2_top
x1_x297 dac_config_3 dac_config_5 col_event_rst_top_left[45] dac_config_4
+ row_on_detect_top[19] dac_config_0 dac_config_1 row_off_detect_top[18] x1_net37
+ dac_config_2 vdda1 vssa1 vssc1 col_event_rst_top_left[44] x1_net38 row_on_detect_top[18]
+ row_off_detect_top[19] openDVS_pixel2x2_top
x1_x298 dac_config_3 dac_config_5 col_event_rst_top_left[43] dac_config_4
+ row_on_detect_top[19] dac_config_0 dac_config_1 row_off_detect_top[18] x1_net41
+ dac_config_2 vdda1 vssa1 vssc1 col_event_rst_top_left[42] x1_net42 row_on_detect_top[18]
+ row_off_detect_top[19] openDVS_pixel2x2_top
x1_x299 dac_config_3 dac_config_5 col_event_rst_top_left[41] dac_config_4
+ row_on_detect_top[19] dac_config_0 dac_config_1 row_off_detect_top[18] x1_net45
+ dac_config_2 vdda1 vssa1 vssc1 col_event_rst_top_left[40] x1_net46 row_on_detect_top[18]
+ row_off_detect_top[19] openDVS_pixel2x2_top
x1_x300 dac_config_3 dac_config_5 col_event_rst_top_left[39] dac_config_4
+ row_on_detect_top[19] dac_config_0 dac_config_1 row_off_detect_top[18] x1_net49
+ dac_config_2 vdda1 vssa1 vssc1 col_event_rst_top_left[38] x1_net50 row_on_detect_top[18]
+ row_off_detect_top[19] openDVS_pixel2x2_top
x1_x301 dac_config_3 dac_config_5 col_event_rst_top_left[37] dac_config_4
+ row_on_detect_top[19] dac_config_0 dac_config_1 row_off_detect_top[18] x1_net53
+ dac_config_2 vdda1 vssa1 vssc1 col_event_rst_top_left[36] x1_net54 row_on_detect_top[18]
+ row_off_detect_top[19] openDVS_pixel2x2_top
x1_x302 dac_config_3 dac_config_5 col_event_rst_top_left[35] dac_config_4
+ row_on_detect_top[19] dac_config_0 dac_config_1 row_off_detect_top[18] x1_net57
+ dac_config_2 vdda1 vssa1 vssc1 col_event_rst_top_left[34] x1_net58 row_on_detect_top[18]
+ row_off_detect_top[19] openDVS_pixel2x2_top
x1_x303 dac_config_3 dac_config_5 col_event_rst_top_left[33] dac_config_4
+ row_on_detect_top[19] dac_config_0 dac_config_1 row_off_detect_top[18] x1_net61
+ dac_config_2 vdda1 vssa1 vssc1 col_event_rst_top_left[32] x1_net62 row_on_detect_top[18]
+ row_off_detect_top[19] openDVS_pixel2x2_top
x1_x304 dac_config_3 dac_config_5 col_event_rst_top_left[31] dac_config_4
+ row_on_detect_top[19] dac_config_0 dac_config_1 row_off_detect_top[18] x1_net65
+ dac_config_2 vdda1 vssa1 vssc1 col_event_rst_top_left[30] x1_net66 row_on_detect_top[18]
+ row_off_detect_top[19] openDVS_pixel2x2_top
x1_x305 dac_config_3 dac_config_5 col_event_rst_top_left[29] dac_config_4
+ row_on_detect_top[19] dac_config_0 dac_config_1 row_off_detect_top[18] x1_net69
+ dac_config_2 vdda1 vssa1 vssc1 col_event_rst_top_left[28] x1_net70 row_on_detect_top[18]
+ row_off_detect_top[19] openDVS_pixel2x2_top
x1_x306 dac_config_3 dac_config_5 col_event_rst_top_left[27] dac_config_4
+ row_on_detect_top[19] dac_config_0 dac_config_1 row_off_detect_top[18] x1_net73
+ dac_config_2 vdda1 vssa1 vssc1 col_event_rst_top_left[26] x1_net74 row_on_detect_top[18]
+ row_off_detect_top[19] openDVS_pixel2x2_top
x1_x307 dac_config_3 dac_config_5 col_event_rst_top_left[25] dac_config_4
+ row_on_detect_top[19] dac_config_0 dac_config_1 row_off_detect_top[18] x1_net77
+ dac_config_2 vdda1 vssa1 vssc1 col_event_rst_top_left[24] x1_net78 row_on_detect_top[18]
+ row_off_detect_top[19] openDVS_pixel2x2_top
x1_x308 dac_config_3 dac_config_5 col_event_rst_top_left[23] dac_config_4
+ row_on_detect_top[19] dac_config_0 dac_config_1 row_off_detect_top[18] x1_net81
+ dac_config_2 vdda1 vssa1 vssc1 col_event_rst_top_left[22] x1_net82 row_on_detect_top[18]
+ row_off_detect_top[19] openDVS_pixel2x2_top
x1_x309 dac_config_3 dac_config_5 col_event_rst_top_left[21] dac_config_4
+ row_on_detect_top[19] dac_config_0 dac_config_1 row_off_detect_top[18] x1_net85
+ dac_config_2 vdda1 vssa1 vssc1 col_event_rst_top_left[20] x1_net86 row_on_detect_top[18]
+ row_off_detect_top[19] openDVS_pixel2x2_top
x1_x310 dac_config_3 dac_config_5 col_event_rst_top_left[19] dac_config_4
+ row_on_detect_top[19] dac_config_0 dac_config_1 row_off_detect_top[18] x1_net89
+ dac_config_2 vdda1 vssa1 vssc1 col_event_rst_top_left[18] x1_net90 row_on_detect_top[18]
+ row_off_detect_top[19] openDVS_pixel2x2_top
x1_x311 dac_config_3 dac_config_5 col_event_rst_top_left[17] dac_config_4
+ row_on_detect_top[19] dac_config_0 dac_config_1 row_off_detect_top[18] x1_net93
+ dac_config_2 vdda1 vssa1 vssc1 col_event_rst_top_left[16] x1_net94 row_on_detect_top[18]
+ row_off_detect_top[19] openDVS_pixel2x2_top
x1_x312 dac_config_3 dac_config_5 col_event_rst_top_left[15] dac_config_4
+ row_on_detect_top[19] dac_config_0 dac_config_1 row_off_detect_top[18] x1_net97
+ dac_config_2 vdda1 vssa1 vssc1 col_event_rst_top_left[14] x1_net98 row_on_detect_top[18]
+ row_off_detect_top[19] openDVS_pixel2x2_top
x1_x313 dac_config_3 dac_config_5 col_event_rst_top_left[13] dac_config_4
+ row_on_detect_top[19] dac_config_0 dac_config_1 row_off_detect_top[18] x1_net101
+ dac_config_2 vdda1 vssa1 vssc1 col_event_rst_top_left[12] x1_net102
+ row_on_detect_top[18] row_off_detect_top[19] openDVS_pixel2x2_top
x1_x314 dac_config_3 dac_config_5 col_event_rst_top_left[11] dac_config_4
+ row_on_detect_top[19] dac_config_0 dac_config_1 row_off_detect_top[18] x1_net105
+ dac_config_2 vdda1 vssa1 vssc1 col_event_rst_top_left[10] x1_net106
+ row_on_detect_top[18] row_off_detect_top[19] openDVS_pixel2x2_top
x1_x315 dac_config_3 dac_config_5 col_event_rst_top_left[9] dac_config_4
+ row_on_detect_top[19] dac_config_0 dac_config_1 row_off_detect_top[18] x1_net109
+ dac_config_2 vdda1 vssa1 vssc1 col_event_rst_top_left[8] x1_net110 row_on_detect_top[18]
+ row_off_detect_top[19] openDVS_pixel2x2_top
x1_x316 dac_config_3 dac_config_5 col_event_rst_top_left[7] dac_config_4
+ row_on_detect_top[19] dac_config_0 dac_config_1 row_off_detect_top[18] x1_net113
+ dac_config_2 vdda1 vssa1 vssc1 col_event_rst_top_left[6] x1_net114 row_on_detect_top[18]
+ row_off_detect_top[19] openDVS_pixel2x2_top
x1_x317 dac_config_3 dac_config_5 col_event_rst_top_left[5] dac_config_4
+ row_on_detect_top[19] dac_config_0 dac_config_1 row_off_detect_top[18] x1_net117
+ dac_config_2 vdda1 vssa1 vssc1 col_event_rst_top_left[4] x1_net118 row_on_detect_top[18]
+ row_off_detect_top[19] openDVS_pixel2x2_top
x1_x318 dac_config_3 dac_config_5 col_event_rst_top_left[3] dac_config_4
+ row_on_detect_top[19] dac_config_0 dac_config_1 row_off_detect_top[18] x1_net121
+ dac_config_2 vdda1 vssa1 vssc1 col_event_rst_top_left[2] x1_net122 row_on_detect_top[18]
+ row_off_detect_top[19] openDVS_pixel2x2_top
x1_x319 dac_config_3 dac_config_5 col_event_rst_top_left[1] dac_config_4
+ row_on_detect_top[19] dac_config_0 dac_config_1 row_off_detect_top[18] x1_net125
+ dac_config_2 vdda1 vssa1 vssc1 col_event_rst_top_left[0] x1_net126 row_on_detect_top[18]
+ row_off_detect_top[19] openDVS_pixel2x2_top
x1_x320 dac_config_3 dac_config_5 col_event_rst_top_left[63] dac_config_4
+ row_on_detect_top[21] dac_config_0 dac_config_1 row_off_detect_top[20] x1_net1
+ dac_config_2 vdda1 vssa1 vssc1 col_event_rst_top_left[62] x1_net2 row_on_detect_top[20]
+ row_off_detect_top[21] openDVS_pixel2x2_top
x1_x321 dac_config_3 dac_config_5 col_event_rst_top_left[61] dac_config_4
+ row_on_detect_top[21] dac_config_0 dac_config_1 row_off_detect_top[20] x1_net5
+ dac_config_2 vdda1 vssa1 vssc1 col_event_rst_top_left[60] x1_net6 row_on_detect_top[20]
+ row_off_detect_top[21] openDVS_pixel2x2_top
x1_x322 dac_config_3 dac_config_5 col_event_rst_top_left[59] dac_config_4
+ row_on_detect_top[21] dac_config_0 dac_config_1 row_off_detect_top[20] x1_net9
+ dac_config_2 vdda1 vssa1 vssc1 col_event_rst_top_left[58] x1_net10 row_on_detect_top[20]
+ row_off_detect_top[21] openDVS_pixel2x2_top
x1_x323 dac_config_3 dac_config_5 col_event_rst_top_left[57] dac_config_4
+ row_on_detect_top[21] dac_config_0 dac_config_1 row_off_detect_top[20] x1_net13
+ dac_config_2 vdda1 vssa1 vssc1 col_event_rst_top_left[56] x1_net14 row_on_detect_top[20]
+ row_off_detect_top[21] openDVS_pixel2x2_top
x1_x324 dac_config_3 dac_config_5 col_event_rst_top_left[55] dac_config_4
+ row_on_detect_top[21] dac_config_0 dac_config_1 row_off_detect_top[20] x1_net17
+ dac_config_2 vdda1 vssa1 vssc1 col_event_rst_top_left[54] x1_net18 row_on_detect_top[20]
+ row_off_detect_top[21] openDVS_pixel2x2_top
x1_x325 dac_config_3 dac_config_5 col_event_rst_top_left[53] dac_config_4
+ row_on_detect_top[21] dac_config_0 dac_config_1 row_off_detect_top[20] x1_net21
+ dac_config_2 vdda1 vssa1 vssc1 col_event_rst_top_left[52] x1_net22 row_on_detect_top[20]
+ row_off_detect_top[21] openDVS_pixel2x2_top
x1_x326 dac_config_3 dac_config_5 col_event_rst_top_left[51] dac_config_4
+ row_on_detect_top[21] dac_config_0 dac_config_1 row_off_detect_top[20] x1_net25
+ dac_config_2 vdda1 vssa1 vssc1 col_event_rst_top_left[50] x1_net26 row_on_detect_top[20]
+ row_off_detect_top[21] openDVS_pixel2x2_top
x1_x327 dac_config_3 dac_config_5 col_event_rst_top_left[49] dac_config_4
+ row_on_detect_top[21] dac_config_0 dac_config_1 row_off_detect_top[20] x1_net29
+ dac_config_2 vdda1 vssa1 vssc1 col_event_rst_top_left[48] x1_net30 row_on_detect_top[20]
+ row_off_detect_top[21] openDVS_pixel2x2_top
x1_x328 dac_config_3 dac_config_5 col_event_rst_top_left[47] dac_config_4
+ row_on_detect_top[21] dac_config_0 dac_config_1 row_off_detect_top[20] x1_net33
+ dac_config_2 vdda1 vssa1 vssc1 col_event_rst_top_left[46] x1_net34 row_on_detect_top[20]
+ row_off_detect_top[21] openDVS_pixel2x2_top
x1_x329 dac_config_3 dac_config_5 col_event_rst_top_left[45] dac_config_4
+ row_on_detect_top[21] dac_config_0 dac_config_1 row_off_detect_top[20] x1_net37
+ dac_config_2 vdda1 vssa1 vssc1 col_event_rst_top_left[44] x1_net38 row_on_detect_top[20]
+ row_off_detect_top[21] openDVS_pixel2x2_top
x1_x330 dac_config_3 dac_config_5 col_event_rst_top_left[43] dac_config_4
+ row_on_detect_top[21] dac_config_0 dac_config_1 row_off_detect_top[20] x1_net41
+ dac_config_2 vdda1 vssa1 vssc1 col_event_rst_top_left[42] x1_net42 row_on_detect_top[20]
+ row_off_detect_top[21] openDVS_pixel2x2_top
x1_x331 dac_config_3 dac_config_5 col_event_rst_top_left[41] dac_config_4
+ row_on_detect_top[21] dac_config_0 dac_config_1 row_off_detect_top[20] x1_net45
+ dac_config_2 vdda1 vssa1 vssc1 col_event_rst_top_left[40] x1_net46 row_on_detect_top[20]
+ row_off_detect_top[21] openDVS_pixel2x2_top
x1_x332 dac_config_3 dac_config_5 col_event_rst_top_left[39] dac_config_4
+ row_on_detect_top[21] dac_config_0 dac_config_1 row_off_detect_top[20] x1_net49
+ dac_config_2 vdda1 vssa1 vssc1 col_event_rst_top_left[38] x1_net50 row_on_detect_top[20]
+ row_off_detect_top[21] openDVS_pixel2x2_top
x1_x333 dac_config_3 dac_config_5 col_event_rst_top_left[37] dac_config_4
+ row_on_detect_top[21] dac_config_0 dac_config_1 row_off_detect_top[20] x1_net53
+ dac_config_2 vdda1 vssa1 vssc1 col_event_rst_top_left[36] x1_net54 row_on_detect_top[20]
+ row_off_detect_top[21] openDVS_pixel2x2_top
x1_x334 dac_config_3 dac_config_5 col_event_rst_top_left[35] dac_config_4
+ row_on_detect_top[21] dac_config_0 dac_config_1 row_off_detect_top[20] x1_net57
+ dac_config_2 vdda1 vssa1 vssc1 col_event_rst_top_left[34] x1_net58 row_on_detect_top[20]
+ row_off_detect_top[21] openDVS_pixel2x2_top
x1_x335 dac_config_3 dac_config_5 col_event_rst_top_left[33] dac_config_4
+ row_on_detect_top[21] dac_config_0 dac_config_1 row_off_detect_top[20] x1_net61
+ dac_config_2 vdda1 vssa1 vssc1 col_event_rst_top_left[32] x1_net62 row_on_detect_top[20]
+ row_off_detect_top[21] openDVS_pixel2x2_top
x1_x336 dac_config_3 dac_config_5 col_event_rst_top_left[31] dac_config_4
+ row_on_detect_top[21] dac_config_0 dac_config_1 row_off_detect_top[20] x1_net65
+ dac_config_2 vdda1 vssa1 vssc1 col_event_rst_top_left[30] x1_net66 row_on_detect_top[20]
+ row_off_detect_top[21] openDVS_pixel2x2_top
x1_x337 dac_config_3 dac_config_5 col_event_rst_top_left[29] dac_config_4
+ row_on_detect_top[21] dac_config_0 dac_config_1 row_off_detect_top[20] x1_net69
+ dac_config_2 vdda1 vssa1 vssc1 col_event_rst_top_left[28] x1_net70 row_on_detect_top[20]
+ row_off_detect_top[21] openDVS_pixel2x2_top
x1_x338 dac_config_3 dac_config_5 col_event_rst_top_left[27] dac_config_4
+ row_on_detect_top[21] dac_config_0 dac_config_1 row_off_detect_top[20] x1_net73
+ dac_config_2 vdda1 vssa1 vssc1 col_event_rst_top_left[26] x1_net74 row_on_detect_top[20]
+ row_off_detect_top[21] openDVS_pixel2x2_top
x1_x339 dac_config_3 dac_config_5 col_event_rst_top_left[25] dac_config_4
+ row_on_detect_top[21] dac_config_0 dac_config_1 row_off_detect_top[20] x1_net77
+ dac_config_2 vdda1 vssa1 vssc1 col_event_rst_top_left[24] x1_net78 row_on_detect_top[20]
+ row_off_detect_top[21] openDVS_pixel2x2_top
x1_x340 dac_config_3 dac_config_5 col_event_rst_top_left[23] dac_config_4
+ row_on_detect_top[21] dac_config_0 dac_config_1 row_off_detect_top[20] x1_net81
+ dac_config_2 vdda1 vssa1 vssc1 col_event_rst_top_left[22] x1_net82 row_on_detect_top[20]
+ row_off_detect_top[21] openDVS_pixel2x2_top
x1_x341 dac_config_3 dac_config_5 col_event_rst_top_left[21] dac_config_4
+ row_on_detect_top[21] dac_config_0 dac_config_1 row_off_detect_top[20] x1_net85
+ dac_config_2 vdda1 vssa1 vssc1 col_event_rst_top_left[20] x1_net86 row_on_detect_top[20]
+ row_off_detect_top[21] openDVS_pixel2x2_top
x1_x342 dac_config_3 dac_config_5 col_event_rst_top_left[19] dac_config_4
+ row_on_detect_top[21] dac_config_0 dac_config_1 row_off_detect_top[20] x1_net89
+ dac_config_2 vdda1 vssa1 vssc1 col_event_rst_top_left[18] x1_net90 row_on_detect_top[20]
+ row_off_detect_top[21] openDVS_pixel2x2_top
x1_x343 dac_config_3 dac_config_5 col_event_rst_top_left[17] dac_config_4
+ row_on_detect_top[21] dac_config_0 dac_config_1 row_off_detect_top[20] x1_net93
+ dac_config_2 vdda1 vssa1 vssc1 col_event_rst_top_left[16] x1_net94 row_on_detect_top[20]
+ row_off_detect_top[21] openDVS_pixel2x2_top
x1_x344 dac_config_3 dac_config_5 col_event_rst_top_left[15] dac_config_4
+ row_on_detect_top[21] dac_config_0 dac_config_1 row_off_detect_top[20] x1_net97
+ dac_config_2 vdda1 vssa1 vssc1 col_event_rst_top_left[14] x1_net98 row_on_detect_top[20]
+ row_off_detect_top[21] openDVS_pixel2x2_top
x1_x345 dac_config_3 dac_config_5 col_event_rst_top_left[13] dac_config_4
+ row_on_detect_top[21] dac_config_0 dac_config_1 row_off_detect_top[20] x1_net101
+ dac_config_2 vdda1 vssa1 vssc1 col_event_rst_top_left[12] x1_net102
+ row_on_detect_top[20] row_off_detect_top[21] openDVS_pixel2x2_top
x1_x346 dac_config_3 dac_config_5 col_event_rst_top_left[11] dac_config_4
+ row_on_detect_top[21] dac_config_0 dac_config_1 row_off_detect_top[20] x1_net105
+ dac_config_2 vdda1 vssa1 vssc1 col_event_rst_top_left[10] x1_net106
+ row_on_detect_top[20] row_off_detect_top[21] openDVS_pixel2x2_top
x1_x347 dac_config_3 dac_config_5 col_event_rst_top_left[9] dac_config_4
+ row_on_detect_top[21] dac_config_0 dac_config_1 row_off_detect_top[20] x1_net109
+ dac_config_2 vdda1 vssa1 vssc1 col_event_rst_top_left[8] x1_net110 row_on_detect_top[20]
+ row_off_detect_top[21] openDVS_pixel2x2_top
x1_x348 dac_config_3 dac_config_5 col_event_rst_top_left[7] dac_config_4
+ row_on_detect_top[21] dac_config_0 dac_config_1 row_off_detect_top[20] x1_net113
+ dac_config_2 vdda1 vssa1 vssc1 col_event_rst_top_left[6] x1_net114 row_on_detect_top[20]
+ row_off_detect_top[21] openDVS_pixel2x2_top
x1_x349 dac_config_3 dac_config_5 col_event_rst_top_left[5] dac_config_4
+ row_on_detect_top[21] dac_config_0 dac_config_1 row_off_detect_top[20] x1_net117
+ dac_config_2 vdda1 vssa1 vssc1 col_event_rst_top_left[4] x1_net118 row_on_detect_top[20]
+ row_off_detect_top[21] openDVS_pixel2x2_top
x1_x350 dac_config_3 dac_config_5 col_event_rst_top_left[3] dac_config_4
+ row_on_detect_top[21] dac_config_0 dac_config_1 row_off_detect_top[20] x1_net121
+ dac_config_2 vdda1 vssa1 vssc1 col_event_rst_top_left[2] x1_net122 row_on_detect_top[20]
+ row_off_detect_top[21] openDVS_pixel2x2_top
x1_x351 dac_config_3 dac_config_5 col_event_rst_top_left[1] dac_config_4
+ row_on_detect_top[21] dac_config_0 dac_config_1 row_off_detect_top[20] x1_net125
+ dac_config_2 vdda1 vssa1 vssc1 col_event_rst_top_left[0] x1_net126 row_on_detect_top[20]
+ row_off_detect_top[21] openDVS_pixel2x2_top
x1_x352 dac_config_3 dac_config_5 col_event_rst_top_left[63] dac_config_4
+ row_on_detect_top[23] dac_config_0 dac_config_1 row_off_detect_top[22] x1_net1
+ dac_config_2 vdda1 vssa1 vssc1 col_event_rst_top_left[62] x1_net2 row_on_detect_top[22]
+ row_off_detect_top[23] openDVS_pixel2x2_top
x1_x353 dac_config_3 dac_config_5 col_event_rst_top_left[61] dac_config_4
+ row_on_detect_top[23] dac_config_0 dac_config_1 row_off_detect_top[22] x1_net5
+ dac_config_2 vdda1 vssa1 vssc1 col_event_rst_top_left[60] x1_net6 row_on_detect_top[22]
+ row_off_detect_top[23] openDVS_pixel2x2_top
x1_x354 dac_config_3 dac_config_5 col_event_rst_top_left[59] dac_config_4
+ row_on_detect_top[23] dac_config_0 dac_config_1 row_off_detect_top[22] x1_net9
+ dac_config_2 vdda1 vssa1 vssc1 col_event_rst_top_left[58] x1_net10 row_on_detect_top[22]
+ row_off_detect_top[23] openDVS_pixel2x2_top
x1_x355 dac_config_3 dac_config_5 col_event_rst_top_left[57] dac_config_4
+ row_on_detect_top[23] dac_config_0 dac_config_1 row_off_detect_top[22] x1_net13
+ dac_config_2 vdda1 vssa1 vssc1 col_event_rst_top_left[56] x1_net14 row_on_detect_top[22]
+ row_off_detect_top[23] openDVS_pixel2x2_top
x1_x356 dac_config_3 dac_config_5 col_event_rst_top_left[55] dac_config_4
+ row_on_detect_top[23] dac_config_0 dac_config_1 row_off_detect_top[22] x1_net17
+ dac_config_2 vdda1 vssa1 vssc1 col_event_rst_top_left[54] x1_net18 row_on_detect_top[22]
+ row_off_detect_top[23] openDVS_pixel2x2_top
x1_x357 dac_config_3 dac_config_5 col_event_rst_top_left[53] dac_config_4
+ row_on_detect_top[23] dac_config_0 dac_config_1 row_off_detect_top[22] x1_net21
+ dac_config_2 vdda1 vssa1 vssc1 col_event_rst_top_left[52] x1_net22 row_on_detect_top[22]
+ row_off_detect_top[23] openDVS_pixel2x2_top
x1_x358 dac_config_3 dac_config_5 col_event_rst_top_left[51] dac_config_4
+ row_on_detect_top[23] dac_config_0 dac_config_1 row_off_detect_top[22] x1_net25
+ dac_config_2 vdda1 vssa1 vssc1 col_event_rst_top_left[50] x1_net26 row_on_detect_top[22]
+ row_off_detect_top[23] openDVS_pixel2x2_top
x1_x359 dac_config_3 dac_config_5 col_event_rst_top_left[49] dac_config_4
+ row_on_detect_top[23] dac_config_0 dac_config_1 row_off_detect_top[22] x1_net29
+ dac_config_2 vdda1 vssa1 vssc1 col_event_rst_top_left[48] x1_net30 row_on_detect_top[22]
+ row_off_detect_top[23] openDVS_pixel2x2_top
x1_x360 dac_config_3 dac_config_5 col_event_rst_top_left[47] dac_config_4
+ row_on_detect_top[23] dac_config_0 dac_config_1 row_off_detect_top[22] x1_net33
+ dac_config_2 vdda1 vssa1 vssc1 col_event_rst_top_left[46] x1_net34 row_on_detect_top[22]
+ row_off_detect_top[23] openDVS_pixel2x2_top
x1_x361 dac_config_3 dac_config_5 col_event_rst_top_left[45] dac_config_4
+ row_on_detect_top[23] dac_config_0 dac_config_1 row_off_detect_top[22] x1_net37
+ dac_config_2 vdda1 vssa1 vssc1 col_event_rst_top_left[44] x1_net38 row_on_detect_top[22]
+ row_off_detect_top[23] openDVS_pixel2x2_top
x1_x362 dac_config_3 dac_config_5 col_event_rst_top_left[43] dac_config_4
+ row_on_detect_top[23] dac_config_0 dac_config_1 row_off_detect_top[22] x1_net41
+ dac_config_2 vdda1 vssa1 vssc1 col_event_rst_top_left[42] x1_net42 row_on_detect_top[22]
+ row_off_detect_top[23] openDVS_pixel2x2_top
x1_x363 dac_config_3 dac_config_5 col_event_rst_top_left[41] dac_config_4
+ row_on_detect_top[23] dac_config_0 dac_config_1 row_off_detect_top[22] x1_net45
+ dac_config_2 vdda1 vssa1 vssc1 col_event_rst_top_left[40] x1_net46 row_on_detect_top[22]
+ row_off_detect_top[23] openDVS_pixel2x2_top
x1_x364 dac_config_3 dac_config_5 col_event_rst_top_left[39] dac_config_4
+ row_on_detect_top[23] dac_config_0 dac_config_1 row_off_detect_top[22] x1_net49
+ dac_config_2 vdda1 vssa1 vssc1 col_event_rst_top_left[38] x1_net50 row_on_detect_top[22]
+ row_off_detect_top[23] openDVS_pixel2x2_top
x1_x365 dac_config_3 dac_config_5 col_event_rst_top_left[37] dac_config_4
+ row_on_detect_top[23] dac_config_0 dac_config_1 row_off_detect_top[22] x1_net53
+ dac_config_2 vdda1 vssa1 vssc1 col_event_rst_top_left[36] x1_net54 row_on_detect_top[22]
+ row_off_detect_top[23] openDVS_pixel2x2_top
x1_x366 dac_config_3 dac_config_5 col_event_rst_top_left[35] dac_config_4
+ row_on_detect_top[23] dac_config_0 dac_config_1 row_off_detect_top[22] x1_net57
+ dac_config_2 vdda1 vssa1 vssc1 col_event_rst_top_left[34] x1_net58 row_on_detect_top[22]
+ row_off_detect_top[23] openDVS_pixel2x2_top
x1_x367 dac_config_3 dac_config_5 col_event_rst_top_left[33] dac_config_4
+ row_on_detect_top[23] dac_config_0 dac_config_1 row_off_detect_top[22] x1_net61
+ dac_config_2 vdda1 vssa1 vssc1 col_event_rst_top_left[32] x1_net62 row_on_detect_top[22]
+ row_off_detect_top[23] openDVS_pixel2x2_top
x1_x368 dac_config_3 dac_config_5 col_event_rst_top_left[31] dac_config_4
+ row_on_detect_top[23] dac_config_0 dac_config_1 row_off_detect_top[22] x1_net65
+ dac_config_2 vdda1 vssa1 vssc1 col_event_rst_top_left[30] x1_net66 row_on_detect_top[22]
+ row_off_detect_top[23] openDVS_pixel2x2_top
x1_x369 dac_config_3 dac_config_5 col_event_rst_top_left[29] dac_config_4
+ row_on_detect_top[23] dac_config_0 dac_config_1 row_off_detect_top[22] x1_net69
+ dac_config_2 vdda1 vssa1 vssc1 col_event_rst_top_left[28] x1_net70 row_on_detect_top[22]
+ row_off_detect_top[23] openDVS_pixel2x2_top
x1_x370 dac_config_3 dac_config_5 col_event_rst_top_left[27] dac_config_4
+ row_on_detect_top[23] dac_config_0 dac_config_1 row_off_detect_top[22] x1_net73
+ dac_config_2 vdda1 vssa1 vssc1 col_event_rst_top_left[26] x1_net74 row_on_detect_top[22]
+ row_off_detect_top[23] openDVS_pixel2x2_top
x1_x371 dac_config_3 dac_config_5 col_event_rst_top_left[25] dac_config_4
+ row_on_detect_top[23] dac_config_0 dac_config_1 row_off_detect_top[22] x1_net77
+ dac_config_2 vdda1 vssa1 vssc1 col_event_rst_top_left[24] x1_net78 row_on_detect_top[22]
+ row_off_detect_top[23] openDVS_pixel2x2_top
x1_x372 dac_config_3 dac_config_5 col_event_rst_top_left[23] dac_config_4
+ row_on_detect_top[23] dac_config_0 dac_config_1 row_off_detect_top[22] x1_net81
+ dac_config_2 vdda1 vssa1 vssc1 col_event_rst_top_left[22] x1_net82 row_on_detect_top[22]
+ row_off_detect_top[23] openDVS_pixel2x2_top
x1_x373 dac_config_3 dac_config_5 col_event_rst_top_left[21] dac_config_4
+ row_on_detect_top[23] dac_config_0 dac_config_1 row_off_detect_top[22] x1_net85
+ dac_config_2 vdda1 vssa1 vssc1 col_event_rst_top_left[20] x1_net86 row_on_detect_top[22]
+ row_off_detect_top[23] openDVS_pixel2x2_top
x1_x374 dac_config_3 dac_config_5 col_event_rst_top_left[19] dac_config_4
+ row_on_detect_top[23] dac_config_0 dac_config_1 row_off_detect_top[22] x1_net89
+ dac_config_2 vdda1 vssa1 vssc1 col_event_rst_top_left[18] x1_net90 row_on_detect_top[22]
+ row_off_detect_top[23] openDVS_pixel2x2_top
x1_x375 dac_config_3 dac_config_5 col_event_rst_top_left[17] dac_config_4
+ row_on_detect_top[23] dac_config_0 dac_config_1 row_off_detect_top[22] x1_net93
+ dac_config_2 vdda1 vssa1 vssc1 col_event_rst_top_left[16] x1_net94 row_on_detect_top[22]
+ row_off_detect_top[23] openDVS_pixel2x2_top
x1_x376 dac_config_3 dac_config_5 col_event_rst_top_left[15] dac_config_4
+ row_on_detect_top[23] dac_config_0 dac_config_1 row_off_detect_top[22] x1_net97
+ dac_config_2 vdda1 vssa1 vssc1 col_event_rst_top_left[14] x1_net98 row_on_detect_top[22]
+ row_off_detect_top[23] openDVS_pixel2x2_top
x1_x377 dac_config_3 dac_config_5 col_event_rst_top_left[13] dac_config_4
+ row_on_detect_top[23] dac_config_0 dac_config_1 row_off_detect_top[22] x1_net101
+ dac_config_2 vdda1 vssa1 vssc1 col_event_rst_top_left[12] x1_net102
+ row_on_detect_top[22] row_off_detect_top[23] openDVS_pixel2x2_top
x1_x378 dac_config_3 dac_config_5 col_event_rst_top_left[11] dac_config_4
+ row_on_detect_top[23] dac_config_0 dac_config_1 row_off_detect_top[22] x1_net105
+ dac_config_2 vdda1 vssa1 vssc1 col_event_rst_top_left[10] x1_net106
+ row_on_detect_top[22] row_off_detect_top[23] openDVS_pixel2x2_top
x1_x379 dac_config_3 dac_config_5 col_event_rst_top_left[9] dac_config_4
+ row_on_detect_top[23] dac_config_0 dac_config_1 row_off_detect_top[22] x1_net109
+ dac_config_2 vdda1 vssa1 vssc1 col_event_rst_top_left[8] x1_net110 row_on_detect_top[22]
+ row_off_detect_top[23] openDVS_pixel2x2_top
x1_x380 dac_config_3 dac_config_5 col_event_rst_top_left[7] dac_config_4
+ row_on_detect_top[23] dac_config_0 dac_config_1 row_off_detect_top[22] x1_net113
+ dac_config_2 vdda1 vssa1 vssc1 col_event_rst_top_left[6] x1_net114 row_on_detect_top[22]
+ row_off_detect_top[23] openDVS_pixel2x2_top
x1_x381 dac_config_3 dac_config_5 col_event_rst_top_left[5] dac_config_4
+ row_on_detect_top[23] dac_config_0 dac_config_1 row_off_detect_top[22] x1_net117
+ dac_config_2 vdda1 vssa1 vssc1 col_event_rst_top_left[4] x1_net118 row_on_detect_top[22]
+ row_off_detect_top[23] openDVS_pixel2x2_top
x1_x382 dac_config_3 dac_config_5 col_event_rst_top_left[3] dac_config_4
+ row_on_detect_top[23] dac_config_0 dac_config_1 row_off_detect_top[22] x1_net121
+ dac_config_2 vdda1 vssa1 vssc1 col_event_rst_top_left[2] x1_net122 row_on_detect_top[22]
+ row_off_detect_top[23] openDVS_pixel2x2_top
x1_x383 dac_config_3 dac_config_5 col_event_rst_top_left[1] dac_config_4
+ row_on_detect_top[23] dac_config_0 dac_config_1 row_off_detect_top[22] x1_net125
+ dac_config_2 vdda1 vssa1 vssc1 col_event_rst_top_left[0] x1_net126 row_on_detect_top[22]
+ row_off_detect_top[23] openDVS_pixel2x2_top
x1_x384 dac_config_3 dac_config_5 col_event_rst_top_left[63] dac_config_4
+ row_on_detect_top[25] dac_config_0 dac_config_1 row_off_detect_top[24] x1_net1
+ dac_config_2 vdda1 vssa1 vssc1 col_event_rst_top_left[62] x1_net2 row_on_detect_top[24]
+ row_off_detect_top[25] openDVS_pixel2x2_top
x1_x385 dac_config_3 dac_config_5 col_event_rst_top_left[61] dac_config_4
+ row_on_detect_top[25] dac_config_0 dac_config_1 row_off_detect_top[24] x1_net5
+ dac_config_2 vdda1 vssa1 vssc1 col_event_rst_top_left[60] x1_net6 row_on_detect_top[24]
+ row_off_detect_top[25] openDVS_pixel2x2_top
x1_x386 dac_config_3 dac_config_5 col_event_rst_top_left[59] dac_config_4
+ row_on_detect_top[25] dac_config_0 dac_config_1 row_off_detect_top[24] x1_net9
+ dac_config_2 vdda1 vssa1 vssc1 col_event_rst_top_left[58] x1_net10 row_on_detect_top[24]
+ row_off_detect_top[25] openDVS_pixel2x2_top
x1_x387 dac_config_3 dac_config_5 col_event_rst_top_left[57] dac_config_4
+ row_on_detect_top[25] dac_config_0 dac_config_1 row_off_detect_top[24] x1_net13
+ dac_config_2 vdda1 vssa1 vssc1 col_event_rst_top_left[56] x1_net14 row_on_detect_top[24]
+ row_off_detect_top[25] openDVS_pixel2x2_top
x1_x388 dac_config_3 dac_config_5 col_event_rst_top_left[55] dac_config_4
+ row_on_detect_top[25] dac_config_0 dac_config_1 row_off_detect_top[24] x1_net17
+ dac_config_2 vdda1 vssa1 vssc1 col_event_rst_top_left[54] x1_net18 row_on_detect_top[24]
+ row_off_detect_top[25] openDVS_pixel2x2_top
x1_x389 dac_config_3 dac_config_5 col_event_rst_top_left[53] dac_config_4
+ row_on_detect_top[25] dac_config_0 dac_config_1 row_off_detect_top[24] x1_net21
+ dac_config_2 vdda1 vssa1 vssc1 col_event_rst_top_left[52] x1_net22 row_on_detect_top[24]
+ row_off_detect_top[25] openDVS_pixel2x2_top
x1_x390 dac_config_3 dac_config_5 col_event_rst_top_left[51] dac_config_4
+ row_on_detect_top[25] dac_config_0 dac_config_1 row_off_detect_top[24] x1_net25
+ dac_config_2 vdda1 vssa1 vssc1 col_event_rst_top_left[50] x1_net26 row_on_detect_top[24]
+ row_off_detect_top[25] openDVS_pixel2x2_top
x1_x391 dac_config_3 dac_config_5 col_event_rst_top_left[49] dac_config_4
+ row_on_detect_top[25] dac_config_0 dac_config_1 row_off_detect_top[24] x1_net29
+ dac_config_2 vdda1 vssa1 vssc1 col_event_rst_top_left[48] x1_net30 row_on_detect_top[24]
+ row_off_detect_top[25] openDVS_pixel2x2_top
x1_x392 dac_config_3 dac_config_5 col_event_rst_top_left[47] dac_config_4
+ row_on_detect_top[25] dac_config_0 dac_config_1 row_off_detect_top[24] x1_net33
+ dac_config_2 vdda1 vssa1 vssc1 col_event_rst_top_left[46] x1_net34 row_on_detect_top[24]
+ row_off_detect_top[25] openDVS_pixel2x2_top
x1_x393 dac_config_3 dac_config_5 col_event_rst_top_left[45] dac_config_4
+ row_on_detect_top[25] dac_config_0 dac_config_1 row_off_detect_top[24] x1_net37
+ dac_config_2 vdda1 vssa1 vssc1 col_event_rst_top_left[44] x1_net38 row_on_detect_top[24]
+ row_off_detect_top[25] openDVS_pixel2x2_top
x1_x394 dac_config_3 dac_config_5 col_event_rst_top_left[43] dac_config_4
+ row_on_detect_top[25] dac_config_0 dac_config_1 row_off_detect_top[24] x1_net41
+ dac_config_2 vdda1 vssa1 vssc1 col_event_rst_top_left[42] x1_net42 row_on_detect_top[24]
+ row_off_detect_top[25] openDVS_pixel2x2_top
x1_x395 dac_config_3 dac_config_5 col_event_rst_top_left[41] dac_config_4
+ row_on_detect_top[25] dac_config_0 dac_config_1 row_off_detect_top[24] x1_net45
+ dac_config_2 vdda1 vssa1 vssc1 col_event_rst_top_left[40] x1_net46 row_on_detect_top[24]
+ row_off_detect_top[25] openDVS_pixel2x2_top
x1_x396 dac_config_3 dac_config_5 col_event_rst_top_left[39] dac_config_4
+ row_on_detect_top[25] dac_config_0 dac_config_1 row_off_detect_top[24] x1_net49
+ dac_config_2 vdda1 vssa1 vssc1 col_event_rst_top_left[38] x1_net50 row_on_detect_top[24]
+ row_off_detect_top[25] openDVS_pixel2x2_top
x1_x397 dac_config_3 dac_config_5 col_event_rst_top_left[37] dac_config_4
+ row_on_detect_top[25] dac_config_0 dac_config_1 row_off_detect_top[24] x1_net53
+ dac_config_2 vdda1 vssa1 vssc1 col_event_rst_top_left[36] x1_net54 row_on_detect_top[24]
+ row_off_detect_top[25] openDVS_pixel2x2_top
x1_x398 dac_config_3 dac_config_5 col_event_rst_top_left[35] dac_config_4
+ row_on_detect_top[25] dac_config_0 dac_config_1 row_off_detect_top[24] x1_net57
+ dac_config_2 vdda1 vssa1 vssc1 col_event_rst_top_left[34] x1_net58 row_on_detect_top[24]
+ row_off_detect_top[25] openDVS_pixel2x2_top
x1_x399 dac_config_3 dac_config_5 col_event_rst_top_left[33] dac_config_4
+ row_on_detect_top[25] dac_config_0 dac_config_1 row_off_detect_top[24] x1_net61
+ dac_config_2 vdda1 vssa1 vssc1 col_event_rst_top_left[32] x1_net62 row_on_detect_top[24]
+ row_off_detect_top[25] openDVS_pixel2x2_top
x1_x400 dac_config_3 dac_config_5 col_event_rst_top_left[31] dac_config_4
+ row_on_detect_top[25] dac_config_0 dac_config_1 row_off_detect_top[24] x1_net65
+ dac_config_2 vdda1 vssa1 vssc1 col_event_rst_top_left[30] x1_net66 row_on_detect_top[24]
+ row_off_detect_top[25] openDVS_pixel2x2_top
x1_x401 dac_config_3 dac_config_5 col_event_rst_top_left[29] dac_config_4
+ row_on_detect_top[25] dac_config_0 dac_config_1 row_off_detect_top[24] x1_net69
+ dac_config_2 vdda1 vssa1 vssc1 col_event_rst_top_left[28] x1_net70 row_on_detect_top[24]
+ row_off_detect_top[25] openDVS_pixel2x2_top
x1_x402 dac_config_3 dac_config_5 col_event_rst_top_left[27] dac_config_4
+ row_on_detect_top[25] dac_config_0 dac_config_1 row_off_detect_top[24] x1_net73
+ dac_config_2 vdda1 vssa1 vssc1 col_event_rst_top_left[26] x1_net74 row_on_detect_top[24]
+ row_off_detect_top[25] openDVS_pixel2x2_top
x1_x403 dac_config_3 dac_config_5 col_event_rst_top_left[25] dac_config_4
+ row_on_detect_top[25] dac_config_0 dac_config_1 row_off_detect_top[24] x1_net77
+ dac_config_2 vdda1 vssa1 vssc1 col_event_rst_top_left[24] x1_net78 row_on_detect_top[24]
+ row_off_detect_top[25] openDVS_pixel2x2_top
x1_x404 dac_config_3 dac_config_5 col_event_rst_top_left[23] dac_config_4
+ row_on_detect_top[25] dac_config_0 dac_config_1 row_off_detect_top[24] x1_net81
+ dac_config_2 vdda1 vssa1 vssc1 col_event_rst_top_left[22] x1_net82 row_on_detect_top[24]
+ row_off_detect_top[25] openDVS_pixel2x2_top
x1_x405 dac_config_3 dac_config_5 col_event_rst_top_left[21] dac_config_4
+ row_on_detect_top[25] dac_config_0 dac_config_1 row_off_detect_top[24] x1_net85
+ dac_config_2 vdda1 vssa1 vssc1 col_event_rst_top_left[20] x1_net86 row_on_detect_top[24]
+ row_off_detect_top[25] openDVS_pixel2x2_top
x1_x406 dac_config_3 dac_config_5 col_event_rst_top_left[19] dac_config_4
+ row_on_detect_top[25] dac_config_0 dac_config_1 row_off_detect_top[24] x1_net89
+ dac_config_2 vdda1 vssa1 vssc1 col_event_rst_top_left[18] x1_net90 row_on_detect_top[24]
+ row_off_detect_top[25] openDVS_pixel2x2_top
x1_x407 dac_config_3 dac_config_5 col_event_rst_top_left[17] dac_config_4
+ row_on_detect_top[25] dac_config_0 dac_config_1 row_off_detect_top[24] x1_net93
+ dac_config_2 vdda1 vssa1 vssc1 col_event_rst_top_left[16] x1_net94 row_on_detect_top[24]
+ row_off_detect_top[25] openDVS_pixel2x2_top
x1_x408 dac_config_3 dac_config_5 col_event_rst_top_left[15] dac_config_4
+ row_on_detect_top[25] dac_config_0 dac_config_1 row_off_detect_top[24] x1_net97
+ dac_config_2 vdda1 vssa1 vssc1 col_event_rst_top_left[14] x1_net98 row_on_detect_top[24]
+ row_off_detect_top[25] openDVS_pixel2x2_top
x1_x409 dac_config_3 dac_config_5 col_event_rst_top_left[13] dac_config_4
+ row_on_detect_top[25] dac_config_0 dac_config_1 row_off_detect_top[24] x1_net101
+ dac_config_2 vdda1 vssa1 vssc1 col_event_rst_top_left[12] x1_net102
+ row_on_detect_top[24] row_off_detect_top[25] openDVS_pixel2x2_top
x1_x410 dac_config_3 dac_config_5 col_event_rst_top_left[11] dac_config_4
+ row_on_detect_top[25] dac_config_0 dac_config_1 row_off_detect_top[24] x1_net105
+ dac_config_2 vdda1 vssa1 vssc1 col_event_rst_top_left[10] x1_net106
+ row_on_detect_top[24] row_off_detect_top[25] openDVS_pixel2x2_top
x1_x411 dac_config_3 dac_config_5 col_event_rst_top_left[9] dac_config_4
+ row_on_detect_top[25] dac_config_0 dac_config_1 row_off_detect_top[24] x1_net109
+ dac_config_2 vdda1 vssa1 vssc1 col_event_rst_top_left[8] x1_net110 row_on_detect_top[24]
+ row_off_detect_top[25] openDVS_pixel2x2_top
x1_x412 dac_config_3 dac_config_5 col_event_rst_top_left[7] dac_config_4
+ row_on_detect_top[25] dac_config_0 dac_config_1 row_off_detect_top[24] x1_net113
+ dac_config_2 vdda1 vssa1 vssc1 col_event_rst_top_left[6] x1_net114 row_on_detect_top[24]
+ row_off_detect_top[25] openDVS_pixel2x2_top
x1_x413 dac_config_3 dac_config_5 col_event_rst_top_left[5] dac_config_4
+ row_on_detect_top[25] dac_config_0 dac_config_1 row_off_detect_top[24] x1_net117
+ dac_config_2 vdda1 vssa1 vssc1 col_event_rst_top_left[4] x1_net118 row_on_detect_top[24]
+ row_off_detect_top[25] openDVS_pixel2x2_top
x1_x414 dac_config_3 dac_config_5 col_event_rst_top_left[3] dac_config_4
+ row_on_detect_top[25] dac_config_0 dac_config_1 row_off_detect_top[24] x1_net121
+ dac_config_2 vdda1 vssa1 vssc1 col_event_rst_top_left[2] x1_net122 row_on_detect_top[24]
+ row_off_detect_top[25] openDVS_pixel2x2_top
x1_x415 dac_config_3 dac_config_5 col_event_rst_top_left[1] dac_config_4
+ row_on_detect_top[25] dac_config_0 dac_config_1 row_off_detect_top[24] x1_net125
+ dac_config_2 vdda1 vssa1 vssc1 col_event_rst_top_left[0] x1_net126 row_on_detect_top[24]
+ row_off_detect_top[25] openDVS_pixel2x2_top
x1_x416 dac_config_3 dac_config_5 col_event_rst_top_left[63] dac_config_4
+ row_on_detect_top[27] dac_config_0 dac_config_1 row_off_detect_top[26] x1_net1
+ dac_config_2 vdda1 vssa1 vssc1 col_event_rst_top_left[62] x1_net2 row_on_detect_top[26]
+ row_off_detect_top[27] openDVS_pixel2x2_top
x1_x417 dac_config_3 dac_config_5 col_event_rst_top_left[61] dac_config_4
+ row_on_detect_top[27] dac_config_0 dac_config_1 row_off_detect_top[26] x1_net5
+ dac_config_2 vdda1 vssa1 vssc1 col_event_rst_top_left[60] x1_net6 row_on_detect_top[26]
+ row_off_detect_top[27] openDVS_pixel2x2_top
x1_x418 dac_config_3 dac_config_5 col_event_rst_top_left[59] dac_config_4
+ row_on_detect_top[27] dac_config_0 dac_config_1 row_off_detect_top[26] x1_net9
+ dac_config_2 vdda1 vssa1 vssc1 col_event_rst_top_left[58] x1_net10 row_on_detect_top[26]
+ row_off_detect_top[27] openDVS_pixel2x2_top
x1_x419 dac_config_3 dac_config_5 col_event_rst_top_left[57] dac_config_4
+ row_on_detect_top[27] dac_config_0 dac_config_1 row_off_detect_top[26] x1_net13
+ dac_config_2 vdda1 vssa1 vssc1 col_event_rst_top_left[56] x1_net14 row_on_detect_top[26]
+ row_off_detect_top[27] openDVS_pixel2x2_top
x1_x420 dac_config_3 dac_config_5 col_event_rst_top_left[55] dac_config_4
+ row_on_detect_top[27] dac_config_0 dac_config_1 row_off_detect_top[26] x1_net17
+ dac_config_2 vdda1 vssa1 vssc1 col_event_rst_top_left[54] x1_net18 row_on_detect_top[26]
+ row_off_detect_top[27] openDVS_pixel2x2_top
x1_x421 dac_config_3 dac_config_5 col_event_rst_top_left[53] dac_config_4
+ row_on_detect_top[27] dac_config_0 dac_config_1 row_off_detect_top[26] x1_net21
+ dac_config_2 vdda1 vssa1 vssc1 col_event_rst_top_left[52] x1_net22 row_on_detect_top[26]
+ row_off_detect_top[27] openDVS_pixel2x2_top
x1_x422 dac_config_3 dac_config_5 col_event_rst_top_left[51] dac_config_4
+ row_on_detect_top[27] dac_config_0 dac_config_1 row_off_detect_top[26] x1_net25
+ dac_config_2 vdda1 vssa1 vssc1 col_event_rst_top_left[50] x1_net26 row_on_detect_top[26]
+ row_off_detect_top[27] openDVS_pixel2x2_top
x1_x423 dac_config_3 dac_config_5 col_event_rst_top_left[49] dac_config_4
+ row_on_detect_top[27] dac_config_0 dac_config_1 row_off_detect_top[26] x1_net29
+ dac_config_2 vdda1 vssa1 vssc1 col_event_rst_top_left[48] x1_net30 row_on_detect_top[26]
+ row_off_detect_top[27] openDVS_pixel2x2_top
x1_x424 dac_config_3 dac_config_5 col_event_rst_top_left[47] dac_config_4
+ row_on_detect_top[27] dac_config_0 dac_config_1 row_off_detect_top[26] x1_net33
+ dac_config_2 vdda1 vssa1 vssc1 col_event_rst_top_left[46] x1_net34 row_on_detect_top[26]
+ row_off_detect_top[27] openDVS_pixel2x2_top
x1_x425 dac_config_3 dac_config_5 col_event_rst_top_left[45] dac_config_4
+ row_on_detect_top[27] dac_config_0 dac_config_1 row_off_detect_top[26] x1_net37
+ dac_config_2 vdda1 vssa1 vssc1 col_event_rst_top_left[44] x1_net38 row_on_detect_top[26]
+ row_off_detect_top[27] openDVS_pixel2x2_top
x1_x426 dac_config_3 dac_config_5 col_event_rst_top_left[43] dac_config_4
+ row_on_detect_top[27] dac_config_0 dac_config_1 row_off_detect_top[26] x1_net41
+ dac_config_2 vdda1 vssa1 vssc1 col_event_rst_top_left[42] x1_net42 row_on_detect_top[26]
+ row_off_detect_top[27] openDVS_pixel2x2_top
x1_x427 dac_config_3 dac_config_5 col_event_rst_top_left[41] dac_config_4
+ row_on_detect_top[27] dac_config_0 dac_config_1 row_off_detect_top[26] x1_net45
+ dac_config_2 vdda1 vssa1 vssc1 col_event_rst_top_left[40] x1_net46 row_on_detect_top[26]
+ row_off_detect_top[27] openDVS_pixel2x2_top
x1_x428 dac_config_3 dac_config_5 col_event_rst_top_left[39] dac_config_4
+ row_on_detect_top[27] dac_config_0 dac_config_1 row_off_detect_top[26] x1_net49
+ dac_config_2 vdda1 vssa1 vssc1 col_event_rst_top_left[38] x1_net50 row_on_detect_top[26]
+ row_off_detect_top[27] openDVS_pixel2x2_top
x1_x429 dac_config_3 dac_config_5 col_event_rst_top_left[37] dac_config_4
+ row_on_detect_top[27] dac_config_0 dac_config_1 row_off_detect_top[26] x1_net53
+ dac_config_2 vdda1 vssa1 vssc1 col_event_rst_top_left[36] x1_net54 row_on_detect_top[26]
+ row_off_detect_top[27] openDVS_pixel2x2_top
x1_x430 dac_config_3 dac_config_5 col_event_rst_top_left[35] dac_config_4
+ row_on_detect_top[27] dac_config_0 dac_config_1 row_off_detect_top[26] x1_net57
+ dac_config_2 vdda1 vssa1 vssc1 col_event_rst_top_left[34] x1_net58 row_on_detect_top[26]
+ row_off_detect_top[27] openDVS_pixel2x2_top
x1_x431 dac_config_3 dac_config_5 col_event_rst_top_left[33] dac_config_4
+ row_on_detect_top[27] dac_config_0 dac_config_1 row_off_detect_top[26] x1_net61
+ dac_config_2 vdda1 vssa1 vssc1 col_event_rst_top_left[32] x1_net62 row_on_detect_top[26]
+ row_off_detect_top[27] openDVS_pixel2x2_top
x1_x432 dac_config_3 dac_config_5 col_event_rst_top_left[31] dac_config_4
+ row_on_detect_top[27] dac_config_0 dac_config_1 row_off_detect_top[26] x1_net65
+ dac_config_2 vdda1 vssa1 vssc1 col_event_rst_top_left[30] x1_net66 row_on_detect_top[26]
+ row_off_detect_top[27] openDVS_pixel2x2_top
x1_x433 dac_config_3 dac_config_5 col_event_rst_top_left[29] dac_config_4
+ row_on_detect_top[27] dac_config_0 dac_config_1 row_off_detect_top[26] x1_net69
+ dac_config_2 vdda1 vssa1 vssc1 col_event_rst_top_left[28] x1_net70 row_on_detect_top[26]
+ row_off_detect_top[27] openDVS_pixel2x2_top
x1_x434 dac_config_3 dac_config_5 col_event_rst_top_left[27] dac_config_4
+ row_on_detect_top[27] dac_config_0 dac_config_1 row_off_detect_top[26] x1_net73
+ dac_config_2 vdda1 vssa1 vssc1 col_event_rst_top_left[26] x1_net74 row_on_detect_top[26]
+ row_off_detect_top[27] openDVS_pixel2x2_top
x1_x435 dac_config_3 dac_config_5 col_event_rst_top_left[25] dac_config_4
+ row_on_detect_top[27] dac_config_0 dac_config_1 row_off_detect_top[26] x1_net77
+ dac_config_2 vdda1 vssa1 vssc1 col_event_rst_top_left[24] x1_net78 row_on_detect_top[26]
+ row_off_detect_top[27] openDVS_pixel2x2_top
x1_x436 dac_config_3 dac_config_5 col_event_rst_top_left[23] dac_config_4
+ row_on_detect_top[27] dac_config_0 dac_config_1 row_off_detect_top[26] x1_net81
+ dac_config_2 vdda1 vssa1 vssc1 col_event_rst_top_left[22] x1_net82 row_on_detect_top[26]
+ row_off_detect_top[27] openDVS_pixel2x2_top
x1_x437 dac_config_3 dac_config_5 col_event_rst_top_left[21] dac_config_4
+ row_on_detect_top[27] dac_config_0 dac_config_1 row_off_detect_top[26] x1_net85
+ dac_config_2 vdda1 vssa1 vssc1 col_event_rst_top_left[20] x1_net86 row_on_detect_top[26]
+ row_off_detect_top[27] openDVS_pixel2x2_top
x1_x438 dac_config_3 dac_config_5 col_event_rst_top_left[19] dac_config_4
+ row_on_detect_top[27] dac_config_0 dac_config_1 row_off_detect_top[26] x1_net89
+ dac_config_2 vdda1 vssa1 vssc1 col_event_rst_top_left[18] x1_net90 row_on_detect_top[26]
+ row_off_detect_top[27] openDVS_pixel2x2_top
x1_x439 dac_config_3 dac_config_5 col_event_rst_top_left[17] dac_config_4
+ row_on_detect_top[27] dac_config_0 dac_config_1 row_off_detect_top[26] x1_net93
+ dac_config_2 vdda1 vssa1 vssc1 col_event_rst_top_left[16] x1_net94 row_on_detect_top[26]
+ row_off_detect_top[27] openDVS_pixel2x2_top
x1_x440 dac_config_3 dac_config_5 col_event_rst_top_left[15] dac_config_4
+ row_on_detect_top[27] dac_config_0 dac_config_1 row_off_detect_top[26] x1_net97
+ dac_config_2 vdda1 vssa1 vssc1 col_event_rst_top_left[14] x1_net98 row_on_detect_top[26]
+ row_off_detect_top[27] openDVS_pixel2x2_top
x1_x441 dac_config_3 dac_config_5 col_event_rst_top_left[13] dac_config_4
+ row_on_detect_top[27] dac_config_0 dac_config_1 row_off_detect_top[26] x1_net101
+ dac_config_2 vdda1 vssa1 vssc1 col_event_rst_top_left[12] x1_net102
+ row_on_detect_top[26] row_off_detect_top[27] openDVS_pixel2x2_top
x1_x442 dac_config_3 dac_config_5 col_event_rst_top_left[11] dac_config_4
+ row_on_detect_top[27] dac_config_0 dac_config_1 row_off_detect_top[26] x1_net105
+ dac_config_2 vdda1 vssa1 vssc1 col_event_rst_top_left[10] x1_net106
+ row_on_detect_top[26] row_off_detect_top[27] openDVS_pixel2x2_top
x1_x443 dac_config_3 dac_config_5 col_event_rst_top_left[9] dac_config_4
+ row_on_detect_top[27] dac_config_0 dac_config_1 row_off_detect_top[26] x1_net109
+ dac_config_2 vdda1 vssa1 vssc1 col_event_rst_top_left[8] x1_net110 row_on_detect_top[26]
+ row_off_detect_top[27] openDVS_pixel2x2_top
x1_x444 dac_config_3 dac_config_5 col_event_rst_top_left[7] dac_config_4
+ row_on_detect_top[27] dac_config_0 dac_config_1 row_off_detect_top[26] x1_net113
+ dac_config_2 vdda1 vssa1 vssc1 col_event_rst_top_left[6] x1_net114 row_on_detect_top[26]
+ row_off_detect_top[27] openDVS_pixel2x2_top
x1_x445 dac_config_3 dac_config_5 col_event_rst_top_left[5] dac_config_4
+ row_on_detect_top[27] dac_config_0 dac_config_1 row_off_detect_top[26] x1_net117
+ dac_config_2 vdda1 vssa1 vssc1 col_event_rst_top_left[4] x1_net118 row_on_detect_top[26]
+ row_off_detect_top[27] openDVS_pixel2x2_top
x1_x446 dac_config_3 dac_config_5 col_event_rst_top_left[3] dac_config_4
+ row_on_detect_top[27] dac_config_0 dac_config_1 row_off_detect_top[26] x1_net121
+ dac_config_2 vdda1 vssa1 vssc1 col_event_rst_top_left[2] x1_net122 row_on_detect_top[26]
+ row_off_detect_top[27] openDVS_pixel2x2_top
x1_x447 dac_config_3 dac_config_5 col_event_rst_top_left[1] dac_config_4
+ row_on_detect_top[27] dac_config_0 dac_config_1 row_off_detect_top[26] x1_net125
+ dac_config_2 vdda1 vssa1 vssc1 col_event_rst_top_left[0] x1_net126 row_on_detect_top[26]
+ row_off_detect_top[27] openDVS_pixel2x2_top
x1_x448 dac_config_3 dac_config_5 col_event_rst_top_left[63] dac_config_4
+ row_on_detect_top[29] dac_config_0 dac_config_1 row_off_detect_top[28] x1_net1
+ dac_config_2 vdda1 vssa1 vssc1 col_event_rst_top_left[62] x1_net2 row_on_detect_top[28]
+ row_off_detect_top[29] openDVS_pixel2x2_top
x1_x449 dac_config_3 dac_config_5 col_event_rst_top_left[61] dac_config_4
+ row_on_detect_top[29] dac_config_0 dac_config_1 row_off_detect_top[28] x1_net5
+ dac_config_2 vdda1 vssa1 vssc1 col_event_rst_top_left[60] x1_net6 row_on_detect_top[28]
+ row_off_detect_top[29] openDVS_pixel2x2_top
x1_x450 dac_config_3 dac_config_5 col_event_rst_top_left[59] dac_config_4
+ row_on_detect_top[29] dac_config_0 dac_config_1 row_off_detect_top[28] x1_net9
+ dac_config_2 vdda1 vssa1 vssc1 col_event_rst_top_left[58] x1_net10 row_on_detect_top[28]
+ row_off_detect_top[29] openDVS_pixel2x2_top
x1_x451 dac_config_3 dac_config_5 col_event_rst_top_left[57] dac_config_4
+ row_on_detect_top[29] dac_config_0 dac_config_1 row_off_detect_top[28] x1_net13
+ dac_config_2 vdda1 vssa1 vssc1 col_event_rst_top_left[56] x1_net14 row_on_detect_top[28]
+ row_off_detect_top[29] openDVS_pixel2x2_top
x1_x452 dac_config_3 dac_config_5 col_event_rst_top_left[55] dac_config_4
+ row_on_detect_top[29] dac_config_0 dac_config_1 row_off_detect_top[28] x1_net17
+ dac_config_2 vdda1 vssa1 vssc1 col_event_rst_top_left[54] x1_net18 row_on_detect_top[28]
+ row_off_detect_top[29] openDVS_pixel2x2_top
x1_x453 dac_config_3 dac_config_5 col_event_rst_top_left[53] dac_config_4
+ row_on_detect_top[29] dac_config_0 dac_config_1 row_off_detect_top[28] x1_net21
+ dac_config_2 vdda1 vssa1 vssc1 col_event_rst_top_left[52] x1_net22 row_on_detect_top[28]
+ row_off_detect_top[29] openDVS_pixel2x2_top
x1_x454 dac_config_3 dac_config_5 col_event_rst_top_left[51] dac_config_4
+ row_on_detect_top[29] dac_config_0 dac_config_1 row_off_detect_top[28] x1_net25
+ dac_config_2 vdda1 vssa1 vssc1 col_event_rst_top_left[50] x1_net26 row_on_detect_top[28]
+ row_off_detect_top[29] openDVS_pixel2x2_top
x1_x455 dac_config_3 dac_config_5 col_event_rst_top_left[49] dac_config_4
+ row_on_detect_top[29] dac_config_0 dac_config_1 row_off_detect_top[28] x1_net29
+ dac_config_2 vdda1 vssa1 vssc1 col_event_rst_top_left[48] x1_net30 row_on_detect_top[28]
+ row_off_detect_top[29] openDVS_pixel2x2_top
x1_x456 dac_config_3 dac_config_5 col_event_rst_top_left[47] dac_config_4
+ row_on_detect_top[29] dac_config_0 dac_config_1 row_off_detect_top[28] x1_net33
+ dac_config_2 vdda1 vssa1 vssc1 col_event_rst_top_left[46] x1_net34 row_on_detect_top[28]
+ row_off_detect_top[29] openDVS_pixel2x2_top
x1_x457 dac_config_3 dac_config_5 col_event_rst_top_left[45] dac_config_4
+ row_on_detect_top[29] dac_config_0 dac_config_1 row_off_detect_top[28] x1_net37
+ dac_config_2 vdda1 vssa1 vssc1 col_event_rst_top_left[44] x1_net38 row_on_detect_top[28]
+ row_off_detect_top[29] openDVS_pixel2x2_top
x1_x458 dac_config_3 dac_config_5 col_event_rst_top_left[43] dac_config_4
+ row_on_detect_top[29] dac_config_0 dac_config_1 row_off_detect_top[28] x1_net41
+ dac_config_2 vdda1 vssa1 vssc1 col_event_rst_top_left[42] x1_net42 row_on_detect_top[28]
+ row_off_detect_top[29] openDVS_pixel2x2_top
x1_x459 dac_config_3 dac_config_5 col_event_rst_top_left[41] dac_config_4
+ row_on_detect_top[29] dac_config_0 dac_config_1 row_off_detect_top[28] x1_net45
+ dac_config_2 vdda1 vssa1 vssc1 col_event_rst_top_left[40] x1_net46 row_on_detect_top[28]
+ row_off_detect_top[29] openDVS_pixel2x2_top
x1_x460 dac_config_3 dac_config_5 col_event_rst_top_left[39] dac_config_4
+ row_on_detect_top[29] dac_config_0 dac_config_1 row_off_detect_top[28] x1_net49
+ dac_config_2 vdda1 vssa1 vssc1 col_event_rst_top_left[38] x1_net50 row_on_detect_top[28]
+ row_off_detect_top[29] openDVS_pixel2x2_top
x1_x461 dac_config_3 dac_config_5 col_event_rst_top_left[37] dac_config_4
+ row_on_detect_top[29] dac_config_0 dac_config_1 row_off_detect_top[28] x1_net53
+ dac_config_2 vdda1 vssa1 vssc1 col_event_rst_top_left[36] x1_net54 row_on_detect_top[28]
+ row_off_detect_top[29] openDVS_pixel2x2_top
x1_x462 dac_config_3 dac_config_5 col_event_rst_top_left[35] dac_config_4
+ row_on_detect_top[29] dac_config_0 dac_config_1 row_off_detect_top[28] x1_net57
+ dac_config_2 vdda1 vssa1 vssc1 col_event_rst_top_left[34] x1_net58 row_on_detect_top[28]
+ row_off_detect_top[29] openDVS_pixel2x2_top
x1_x463 dac_config_3 dac_config_5 col_event_rst_top_left[33] dac_config_4
+ row_on_detect_top[29] dac_config_0 dac_config_1 row_off_detect_top[28] x1_net61
+ dac_config_2 vdda1 vssa1 vssc1 col_event_rst_top_left[32] x1_net62 row_on_detect_top[28]
+ row_off_detect_top[29] openDVS_pixel2x2_top
x1_x464 dac_config_3 dac_config_5 col_event_rst_top_left[31] dac_config_4
+ row_on_detect_top[29] dac_config_0 dac_config_1 row_off_detect_top[28] x1_net65
+ dac_config_2 vdda1 vssa1 vssc1 col_event_rst_top_left[30] x1_net66 row_on_detect_top[28]
+ row_off_detect_top[29] openDVS_pixel2x2_top
x1_x465 dac_config_3 dac_config_5 col_event_rst_top_left[29] dac_config_4
+ row_on_detect_top[29] dac_config_0 dac_config_1 row_off_detect_top[28] x1_net69
+ dac_config_2 vdda1 vssa1 vssc1 col_event_rst_top_left[28] x1_net70 row_on_detect_top[28]
+ row_off_detect_top[29] openDVS_pixel2x2_top
x1_x466 dac_config_3 dac_config_5 col_event_rst_top_left[27] dac_config_4
+ row_on_detect_top[29] dac_config_0 dac_config_1 row_off_detect_top[28] x1_net73
+ dac_config_2 vdda1 vssa1 vssc1 col_event_rst_top_left[26] x1_net74 row_on_detect_top[28]
+ row_off_detect_top[29] openDVS_pixel2x2_top
x1_x467 dac_config_3 dac_config_5 col_event_rst_top_left[25] dac_config_4
+ row_on_detect_top[29] dac_config_0 dac_config_1 row_off_detect_top[28] x1_net77
+ dac_config_2 vdda1 vssa1 vssc1 col_event_rst_top_left[24] x1_net78 row_on_detect_top[28]
+ row_off_detect_top[29] openDVS_pixel2x2_top
x1_x468 dac_config_3 dac_config_5 col_event_rst_top_left[23] dac_config_4
+ row_on_detect_top[29] dac_config_0 dac_config_1 row_off_detect_top[28] x1_net81
+ dac_config_2 vdda1 vssa1 vssc1 col_event_rst_top_left[22] x1_net82 row_on_detect_top[28]
+ row_off_detect_top[29] openDVS_pixel2x2_top
x1_x469 dac_config_3 dac_config_5 col_event_rst_top_left[21] dac_config_4
+ row_on_detect_top[29] dac_config_0 dac_config_1 row_off_detect_top[28] x1_net85
+ dac_config_2 vdda1 vssa1 vssc1 col_event_rst_top_left[20] x1_net86 row_on_detect_top[28]
+ row_off_detect_top[29] openDVS_pixel2x2_top
x1_x470 dac_config_3 dac_config_5 col_event_rst_top_left[19] dac_config_4
+ row_on_detect_top[29] dac_config_0 dac_config_1 row_off_detect_top[28] x1_net89
+ dac_config_2 vdda1 vssa1 vssc1 col_event_rst_top_left[18] x1_net90 row_on_detect_top[28]
+ row_off_detect_top[29] openDVS_pixel2x2_top
x1_x471 dac_config_3 dac_config_5 col_event_rst_top_left[17] dac_config_4
+ row_on_detect_top[29] dac_config_0 dac_config_1 row_off_detect_top[28] x1_net93
+ dac_config_2 vdda1 vssa1 vssc1 col_event_rst_top_left[16] x1_net94 row_on_detect_top[28]
+ row_off_detect_top[29] openDVS_pixel2x2_top
x1_x472 dac_config_3 dac_config_5 col_event_rst_top_left[15] dac_config_4
+ row_on_detect_top[29] dac_config_0 dac_config_1 row_off_detect_top[28] x1_net97
+ dac_config_2 vdda1 vssa1 vssc1 col_event_rst_top_left[14] x1_net98 row_on_detect_top[28]
+ row_off_detect_top[29] openDVS_pixel2x2_top
x1_x473 dac_config_3 dac_config_5 col_event_rst_top_left[13] dac_config_4
+ row_on_detect_top[29] dac_config_0 dac_config_1 row_off_detect_top[28] x1_net101
+ dac_config_2 vdda1 vssa1 vssc1 col_event_rst_top_left[12] x1_net102
+ row_on_detect_top[28] row_off_detect_top[29] openDVS_pixel2x2_top
x1_x474 dac_config_3 dac_config_5 col_event_rst_top_left[11] dac_config_4
+ row_on_detect_top[29] dac_config_0 dac_config_1 row_off_detect_top[28] x1_net105
+ dac_config_2 vdda1 vssa1 vssc1 col_event_rst_top_left[10] x1_net106
+ row_on_detect_top[28] row_off_detect_top[29] openDVS_pixel2x2_top
x1_x475 dac_config_3 dac_config_5 col_event_rst_top_left[9] dac_config_4
+ row_on_detect_top[29] dac_config_0 dac_config_1 row_off_detect_top[28] x1_net109
+ dac_config_2 vdda1 vssa1 vssc1 col_event_rst_top_left[8] x1_net110 row_on_detect_top[28]
+ row_off_detect_top[29] openDVS_pixel2x2_top
x1_x476 dac_config_3 dac_config_5 col_event_rst_top_left[7] dac_config_4
+ row_on_detect_top[29] dac_config_0 dac_config_1 row_off_detect_top[28] x1_net113
+ dac_config_2 vdda1 vssa1 vssc1 col_event_rst_top_left[6] x1_net114 row_on_detect_top[28]
+ row_off_detect_top[29] openDVS_pixel2x2_top
x1_x477 dac_config_3 dac_config_5 col_event_rst_top_left[5] dac_config_4
+ row_on_detect_top[29] dac_config_0 dac_config_1 row_off_detect_top[28] x1_net117
+ dac_config_2 vdda1 vssa1 vssc1 col_event_rst_top_left[4] x1_net118 row_on_detect_top[28]
+ row_off_detect_top[29] openDVS_pixel2x2_top
x1_x478 dac_config_3 dac_config_5 col_event_rst_top_left[3] dac_config_4
+ row_on_detect_top[29] dac_config_0 dac_config_1 row_off_detect_top[28] x1_net121
+ dac_config_2 vdda1 vssa1 vssc1 col_event_rst_top_left[2] x1_net122 row_on_detect_top[28]
+ row_off_detect_top[29] openDVS_pixel2x2_top
x1_x479 dac_config_3 dac_config_5 col_event_rst_top_left[1] dac_config_4
+ row_on_detect_top[29] dac_config_0 dac_config_1 row_off_detect_top[28] x1_net125
+ dac_config_2 vdda1 vssa1 vssc1 col_event_rst_top_left[0] x1_net126 row_on_detect_top[28]
+ row_off_detect_top[29] openDVS_pixel2x2_top
x1_x480 dac_config_3 dac_config_5 col_event_rst_top_left[63] dac_config_4
+ row_on_detect_top[31] dac_config_0 dac_config_1 row_off_detect_top[30] x1_net1
+ dac_config_2 vdda1 vssa1 vssc1 col_event_rst_top_left[62] x1_net2 row_on_detect_top[30]
+ row_off_detect_top[31] openDVS_pixel2x2_top
x1_x481 dac_config_3 dac_config_5 col_event_rst_top_left[61] dac_config_4
+ row_on_detect_top[31] dac_config_0 dac_config_1 row_off_detect_top[30] x1_net5
+ dac_config_2 vdda1 vssa1 vssc1 col_event_rst_top_left[60] x1_net6 row_on_detect_top[30]
+ row_off_detect_top[31] openDVS_pixel2x2_top
x1_x482 dac_config_3 dac_config_5 col_event_rst_top_left[59] dac_config_4
+ row_on_detect_top[31] dac_config_0 dac_config_1 row_off_detect_top[30] x1_net9
+ dac_config_2 vdda1 vssa1 vssc1 col_event_rst_top_left[58] x1_net10 row_on_detect_top[30]
+ row_off_detect_top[31] openDVS_pixel2x2_top
x1_x483 dac_config_3 dac_config_5 col_event_rst_top_left[57] dac_config_4
+ row_on_detect_top[31] dac_config_0 dac_config_1 row_off_detect_top[30] x1_net13
+ dac_config_2 vdda1 vssa1 vssc1 col_event_rst_top_left[56] x1_net14 row_on_detect_top[30]
+ row_off_detect_top[31] openDVS_pixel2x2_top
x1_x484 dac_config_3 dac_config_5 col_event_rst_top_left[55] dac_config_4
+ row_on_detect_top[31] dac_config_0 dac_config_1 row_off_detect_top[30] x1_net17
+ dac_config_2 vdda1 vssa1 vssc1 col_event_rst_top_left[54] x1_net18 row_on_detect_top[30]
+ row_off_detect_top[31] openDVS_pixel2x2_top
x1_x485 dac_config_3 dac_config_5 col_event_rst_top_left[53] dac_config_4
+ row_on_detect_top[31] dac_config_0 dac_config_1 row_off_detect_top[30] x1_net21
+ dac_config_2 vdda1 vssa1 vssc1 col_event_rst_top_left[52] x1_net22 row_on_detect_top[30]
+ row_off_detect_top[31] openDVS_pixel2x2_top
x1_x486 dac_config_3 dac_config_5 col_event_rst_top_left[51] dac_config_4
+ row_on_detect_top[31] dac_config_0 dac_config_1 row_off_detect_top[30] x1_net25
+ dac_config_2 vdda1 vssa1 vssc1 col_event_rst_top_left[50] x1_net26 row_on_detect_top[30]
+ row_off_detect_top[31] openDVS_pixel2x2_top
x1_x487 dac_config_3 dac_config_5 col_event_rst_top_left[49] dac_config_4
+ row_on_detect_top[31] dac_config_0 dac_config_1 row_off_detect_top[30] x1_net29
+ dac_config_2 vdda1 vssa1 vssc1 col_event_rst_top_left[48] x1_net30 row_on_detect_top[30]
+ row_off_detect_top[31] openDVS_pixel2x2_top
x1_x488 dac_config_3 dac_config_5 col_event_rst_top_left[47] dac_config_4
+ row_on_detect_top[31] dac_config_0 dac_config_1 row_off_detect_top[30] x1_net33
+ dac_config_2 vdda1 vssa1 vssc1 col_event_rst_top_left[46] x1_net34 row_on_detect_top[30]
+ row_off_detect_top[31] openDVS_pixel2x2_top
x1_x489 dac_config_3 dac_config_5 col_event_rst_top_left[45] dac_config_4
+ row_on_detect_top[31] dac_config_0 dac_config_1 row_off_detect_top[30] x1_net37
+ dac_config_2 vdda1 vssa1 vssc1 col_event_rst_top_left[44] x1_net38 row_on_detect_top[30]
+ row_off_detect_top[31] openDVS_pixel2x2_top
x1_x490 dac_config_3 dac_config_5 col_event_rst_top_left[43] dac_config_4
+ row_on_detect_top[31] dac_config_0 dac_config_1 row_off_detect_top[30] x1_net41
+ dac_config_2 vdda1 vssa1 vssc1 col_event_rst_top_left[42] x1_net42 row_on_detect_top[30]
+ row_off_detect_top[31] openDVS_pixel2x2_top
x1_x491 dac_config_3 dac_config_5 col_event_rst_top_left[41] dac_config_4
+ row_on_detect_top[31] dac_config_0 dac_config_1 row_off_detect_top[30] x1_net45
+ dac_config_2 vdda1 vssa1 vssc1 col_event_rst_top_left[40] x1_net46 row_on_detect_top[30]
+ row_off_detect_top[31] openDVS_pixel2x2_top
x1_x492 dac_config_3 dac_config_5 col_event_rst_top_left[39] dac_config_4
+ row_on_detect_top[31] dac_config_0 dac_config_1 row_off_detect_top[30] x1_net49
+ dac_config_2 vdda1 vssa1 vssc1 col_event_rst_top_left[38] x1_net50 row_on_detect_top[30]
+ row_off_detect_top[31] openDVS_pixel2x2_top
x1_x493 dac_config_3 dac_config_5 col_event_rst_top_left[37] dac_config_4
+ row_on_detect_top[31] dac_config_0 dac_config_1 row_off_detect_top[30] x1_net53
+ dac_config_2 vdda1 vssa1 vssc1 col_event_rst_top_left[36] x1_net54 row_on_detect_top[30]
+ row_off_detect_top[31] openDVS_pixel2x2_top
x1_x494 dac_config_3 dac_config_5 col_event_rst_top_left[35] dac_config_4
+ row_on_detect_top[31] dac_config_0 dac_config_1 row_off_detect_top[30] x1_net57
+ dac_config_2 vdda1 vssa1 vssc1 col_event_rst_top_left[34] x1_net58 row_on_detect_top[30]
+ row_off_detect_top[31] openDVS_pixel2x2_top
x1_x495 dac_config_3 dac_config_5 col_event_rst_top_left[33] dac_config_4
+ row_on_detect_top[31] dac_config_0 dac_config_1 row_off_detect_top[30] x1_net61
+ dac_config_2 vdda1 vssa1 vssc1 col_event_rst_top_left[32] x1_net62 row_on_detect_top[30]
+ row_off_detect_top[31] openDVS_pixel2x2_top
x1_x496 dac_config_3 dac_config_5 col_event_rst_top_left[31] dac_config_4
+ row_on_detect_top[31] dac_config_0 dac_config_1 row_off_detect_top[30] x1_net65
+ dac_config_2 vdda1 vssa1 vssc1 col_event_rst_top_left[30] x1_net66 row_on_detect_top[30]
+ row_off_detect_top[31] openDVS_pixel2x2_top
x1_x497 dac_config_3 dac_config_5 col_event_rst_top_left[29] dac_config_4
+ row_on_detect_top[31] dac_config_0 dac_config_1 row_off_detect_top[30] x1_net69
+ dac_config_2 vdda1 vssa1 vssc1 col_event_rst_top_left[28] x1_net70 row_on_detect_top[30]
+ row_off_detect_top[31] openDVS_pixel2x2_top
x1_x498 dac_config_3 dac_config_5 col_event_rst_top_left[27] dac_config_4
+ row_on_detect_top[31] dac_config_0 dac_config_1 row_off_detect_top[30] x1_net73
+ dac_config_2 vdda1 vssa1 vssc1 col_event_rst_top_left[26] x1_net74 row_on_detect_top[30]
+ row_off_detect_top[31] openDVS_pixel2x2_top
x1_x499 dac_config_3 dac_config_5 col_event_rst_top_left[25] dac_config_4
+ row_on_detect_top[31] dac_config_0 dac_config_1 row_off_detect_top[30] x1_net77
+ dac_config_2 vdda1 vssa1 vssc1 col_event_rst_top_left[24] x1_net78 row_on_detect_top[30]
+ row_off_detect_top[31] openDVS_pixel2x2_top
x1_x500 dac_config_3 dac_config_5 col_event_rst_top_left[23] dac_config_4
+ row_on_detect_top[31] dac_config_0 dac_config_1 row_off_detect_top[30] x1_net81
+ dac_config_2 vdda1 vssa1 vssc1 col_event_rst_top_left[22] x1_net82 row_on_detect_top[30]
+ row_off_detect_top[31] openDVS_pixel2x2_top
x1_x501 dac_config_3 dac_config_5 col_event_rst_top_left[21] dac_config_4
+ row_on_detect_top[31] dac_config_0 dac_config_1 row_off_detect_top[30] x1_net85
+ dac_config_2 vdda1 vssa1 vssc1 col_event_rst_top_left[20] x1_net86 row_on_detect_top[30]
+ row_off_detect_top[31] openDVS_pixel2x2_top
x1_x502 dac_config_3 dac_config_5 col_event_rst_top_left[19] dac_config_4
+ row_on_detect_top[31] dac_config_0 dac_config_1 row_off_detect_top[30] x1_net89
+ dac_config_2 vdda1 vssa1 vssc1 col_event_rst_top_left[18] x1_net90 row_on_detect_top[30]
+ row_off_detect_top[31] openDVS_pixel2x2_top
x1_x503 dac_config_3 dac_config_5 col_event_rst_top_left[17] dac_config_4
+ row_on_detect_top[31] dac_config_0 dac_config_1 row_off_detect_top[30] x1_net93
+ dac_config_2 vdda1 vssa1 vssc1 col_event_rst_top_left[16] x1_net94 row_on_detect_top[30]
+ row_off_detect_top[31] openDVS_pixel2x2_top
x1_x504 dac_config_3 dac_config_5 col_event_rst_top_left[15] dac_config_4
+ row_on_detect_top[31] dac_config_0 dac_config_1 row_off_detect_top[30] x1_net97
+ dac_config_2 vdda1 vssa1 vssc1 col_event_rst_top_left[14] x1_net98 row_on_detect_top[30]
+ row_off_detect_top[31] openDVS_pixel2x2_top
x1_x505 dac_config_3 dac_config_5 col_event_rst_top_left[13] dac_config_4
+ row_on_detect_top[31] dac_config_0 dac_config_1 row_off_detect_top[30] x1_net101
+ dac_config_2 vdda1 vssa1 vssc1 col_event_rst_top_left[12] x1_net102
+ row_on_detect_top[30] row_off_detect_top[31] openDVS_pixel2x2_top
x1_x506 dac_config_3 dac_config_5 col_event_rst_top_left[11] dac_config_4
+ row_on_detect_top[31] dac_config_0 dac_config_1 row_off_detect_top[30] x1_net105
+ dac_config_2 vdda1 vssa1 vssc1 col_event_rst_top_left[10] x1_net106
+ row_on_detect_top[30] row_off_detect_top[31] openDVS_pixel2x2_top
x1_x507 dac_config_3 dac_config_5 col_event_rst_top_left[9] dac_config_4
+ row_on_detect_top[31] dac_config_0 dac_config_1 row_off_detect_top[30] x1_net109
+ dac_config_2 vdda1 vssa1 vssc1 col_event_rst_top_left[8] x1_net110 row_on_detect_top[30]
+ row_off_detect_top[31] openDVS_pixel2x2_top
x1_x508 dac_config_3 dac_config_5 col_event_rst_top_left[7] dac_config_4
+ row_on_detect_top[31] dac_config_0 dac_config_1 row_off_detect_top[30] x1_net113
+ dac_config_2 vdda1 vssa1 vssc1 col_event_rst_top_left[6] x1_net114 row_on_detect_top[30]
+ row_off_detect_top[31] openDVS_pixel2x2_top
x1_x509 dac_config_3 dac_config_5 col_event_rst_top_left[5] dac_config_4
+ row_on_detect_top[31] dac_config_0 dac_config_1 row_off_detect_top[30] x1_net117
+ dac_config_2 vdda1 vssa1 vssc1 col_event_rst_top_left[4] x1_net118 row_on_detect_top[30]
+ row_off_detect_top[31] openDVS_pixel2x2_top
x1_x510 dac_config_3 dac_config_5 col_event_rst_top_left[3] dac_config_4
+ row_on_detect_top[31] dac_config_0 dac_config_1 row_off_detect_top[30] x1_net121
+ dac_config_2 vdda1 vssa1 vssc1 col_event_rst_top_left[2] x1_net122 row_on_detect_top[30]
+ row_off_detect_top[31] openDVS_pixel2x2_top
x1_x511 dac_config_3 dac_config_5 col_event_rst_top_left[1] dac_config_4
+ row_on_detect_top[31] dac_config_0 dac_config_1 row_off_detect_top[30] x1_net125
+ dac_config_2 vdda1 vssa1 vssc1 col_event_rst_top_left[0] x1_net126 row_on_detect_top[30]
+ row_off_detect_top[31] openDVS_pixel2x2_top
x1_x512 dac_config_3 dac_config_5 col_event_rst_top_left[63] dac_config_4
+ row_on_detect_top[33] dac_config_0 dac_config_1 row_off_detect_top[32] x1_net1
+ dac_config_2 vdda1 vssa1 vssc1 col_event_rst_top_left[62] x1_net2 row_on_detect_top[32]
+ row_off_detect_top[33] openDVS_pixel2x2_top
x1_x513 dac_config_3 dac_config_5 col_event_rst_top_left[61] dac_config_4
+ row_on_detect_top[33] dac_config_0 dac_config_1 row_off_detect_top[32] x1_net5
+ dac_config_2 vdda1 vssa1 vssc1 col_event_rst_top_left[60] x1_net6 row_on_detect_top[32]
+ row_off_detect_top[33] openDVS_pixel2x2_top
x1_x514 dac_config_3 dac_config_5 col_event_rst_top_left[59] dac_config_4
+ row_on_detect_top[33] dac_config_0 dac_config_1 row_off_detect_top[32] x1_net9
+ dac_config_2 vdda1 vssa1 vssc1 col_event_rst_top_left[58] x1_net10 row_on_detect_top[32]
+ row_off_detect_top[33] openDVS_pixel2x2_top
x1_x515 dac_config_3 dac_config_5 col_event_rst_top_left[57] dac_config_4
+ row_on_detect_top[33] dac_config_0 dac_config_1 row_off_detect_top[32] x1_net13
+ dac_config_2 vdda1 vssa1 vssc1 col_event_rst_top_left[56] x1_net14 row_on_detect_top[32]
+ row_off_detect_top[33] openDVS_pixel2x2_top
x1_x516 dac_config_3 dac_config_5 col_event_rst_top_left[55] dac_config_4
+ row_on_detect_top[33] dac_config_0 dac_config_1 row_off_detect_top[32] x1_net17
+ dac_config_2 vdda1 vssa1 vssc1 col_event_rst_top_left[54] x1_net18 row_on_detect_top[32]
+ row_off_detect_top[33] openDVS_pixel2x2_top
x1_x517 dac_config_3 dac_config_5 col_event_rst_top_left[53] dac_config_4
+ row_on_detect_top[33] dac_config_0 dac_config_1 row_off_detect_top[32] x1_net21
+ dac_config_2 vdda1 vssa1 vssc1 col_event_rst_top_left[52] x1_net22 row_on_detect_top[32]
+ row_off_detect_top[33] openDVS_pixel2x2_top
x1_x518 dac_config_3 dac_config_5 col_event_rst_top_left[51] dac_config_4
+ row_on_detect_top[33] dac_config_0 dac_config_1 row_off_detect_top[32] x1_net25
+ dac_config_2 vdda1 vssa1 vssc1 col_event_rst_top_left[50] x1_net26 row_on_detect_top[32]
+ row_off_detect_top[33] openDVS_pixel2x2_top
x1_x519 dac_config_3 dac_config_5 col_event_rst_top_left[49] dac_config_4
+ row_on_detect_top[33] dac_config_0 dac_config_1 row_off_detect_top[32] x1_net29
+ dac_config_2 vdda1 vssa1 vssc1 col_event_rst_top_left[48] x1_net30 row_on_detect_top[32]
+ row_off_detect_top[33] openDVS_pixel2x2_top
x1_x520 dac_config_3 dac_config_5 col_event_rst_top_left[47] dac_config_4
+ row_on_detect_top[33] dac_config_0 dac_config_1 row_off_detect_top[32] x1_net33
+ dac_config_2 vdda1 vssa1 vssc1 col_event_rst_top_left[46] x1_net34 row_on_detect_top[32]
+ row_off_detect_top[33] openDVS_pixel2x2_top
x1_x521 dac_config_3 dac_config_5 col_event_rst_top_left[45] dac_config_4
+ row_on_detect_top[33] dac_config_0 dac_config_1 row_off_detect_top[32] x1_net37
+ dac_config_2 vdda1 vssa1 vssc1 col_event_rst_top_left[44] x1_net38 row_on_detect_top[32]
+ row_off_detect_top[33] openDVS_pixel2x2_top
x1_x522 dac_config_3 dac_config_5 col_event_rst_top_left[43] dac_config_4
+ row_on_detect_top[33] dac_config_0 dac_config_1 row_off_detect_top[32] x1_net41
+ dac_config_2 vdda1 vssa1 vssc1 col_event_rst_top_left[42] x1_net42 row_on_detect_top[32]
+ row_off_detect_top[33] openDVS_pixel2x2_top
x1_x523 dac_config_3 dac_config_5 col_event_rst_top_left[41] dac_config_4
+ row_on_detect_top[33] dac_config_0 dac_config_1 row_off_detect_top[32] x1_net45
+ dac_config_2 vdda1 vssa1 vssc1 col_event_rst_top_left[40] x1_net46 row_on_detect_top[32]
+ row_off_detect_top[33] openDVS_pixel2x2_top
x1_x524 dac_config_3 dac_config_5 col_event_rst_top_left[39] dac_config_4
+ row_on_detect_top[33] dac_config_0 dac_config_1 row_off_detect_top[32] x1_net49
+ dac_config_2 vdda1 vssa1 vssc1 col_event_rst_top_left[38] x1_net50 row_on_detect_top[32]
+ row_off_detect_top[33] openDVS_pixel2x2_top
x1_x525 dac_config_3 dac_config_5 col_event_rst_top_left[37] dac_config_4
+ row_on_detect_top[33] dac_config_0 dac_config_1 row_off_detect_top[32] x1_net53
+ dac_config_2 vdda1 vssa1 vssc1 col_event_rst_top_left[36] x1_net54 row_on_detect_top[32]
+ row_off_detect_top[33] openDVS_pixel2x2_top
x1_x526 dac_config_3 dac_config_5 col_event_rst_top_left[35] dac_config_4
+ row_on_detect_top[33] dac_config_0 dac_config_1 row_off_detect_top[32] x1_net57
+ dac_config_2 vdda1 vssa1 vssc1 col_event_rst_top_left[34] x1_net58 row_on_detect_top[32]
+ row_off_detect_top[33] openDVS_pixel2x2_top
x1_x527 dac_config_3 dac_config_5 col_event_rst_top_left[33] dac_config_4
+ row_on_detect_top[33] dac_config_0 dac_config_1 row_off_detect_top[32] x1_net61
+ dac_config_2 vdda1 vssa1 vssc1 col_event_rst_top_left[32] x1_net62 row_on_detect_top[32]
+ row_off_detect_top[33] openDVS_pixel2x2_top
x1_x528 dac_config_3 dac_config_5 col_event_rst_top_left[31] dac_config_4
+ row_on_detect_top[33] dac_config_0 dac_config_1 row_off_detect_top[32] x1_net65
+ dac_config_2 vdda1 vssa1 vssc1 col_event_rst_top_left[30] x1_net66 row_on_detect_top[32]
+ row_off_detect_top[33] openDVS_pixel2x2_top
x1_x529 dac_config_3 dac_config_5 col_event_rst_top_left[29] dac_config_4
+ row_on_detect_top[33] dac_config_0 dac_config_1 row_off_detect_top[32] x1_net69
+ dac_config_2 vdda1 vssa1 vssc1 col_event_rst_top_left[28] x1_net70 row_on_detect_top[32]
+ row_off_detect_top[33] openDVS_pixel2x2_top
x1_x530 dac_config_3 dac_config_5 col_event_rst_top_left[27] dac_config_4
+ row_on_detect_top[33] dac_config_0 dac_config_1 row_off_detect_top[32] x1_net73
+ dac_config_2 vdda1 vssa1 vssc1 col_event_rst_top_left[26] x1_net74 row_on_detect_top[32]
+ row_off_detect_top[33] openDVS_pixel2x2_top
x1_x531 dac_config_3 dac_config_5 col_event_rst_top_left[25] dac_config_4
+ row_on_detect_top[33] dac_config_0 dac_config_1 row_off_detect_top[32] x1_net77
+ dac_config_2 vdda1 vssa1 vssc1 col_event_rst_top_left[24] x1_net78 row_on_detect_top[32]
+ row_off_detect_top[33] openDVS_pixel2x2_top
x1_x532 dac_config_3 dac_config_5 col_event_rst_top_left[23] dac_config_4
+ row_on_detect_top[33] dac_config_0 dac_config_1 row_off_detect_top[32] x1_net81
+ dac_config_2 vdda1 vssa1 vssc1 col_event_rst_top_left[22] x1_net82 row_on_detect_top[32]
+ row_off_detect_top[33] openDVS_pixel2x2_top
x1_x533 dac_config_3 dac_config_5 col_event_rst_top_left[21] dac_config_4
+ row_on_detect_top[33] dac_config_0 dac_config_1 row_off_detect_top[32] x1_net85
+ dac_config_2 vdda1 vssa1 vssc1 col_event_rst_top_left[20] x1_net86 row_on_detect_top[32]
+ row_off_detect_top[33] openDVS_pixel2x2_top
x1_x534 dac_config_3 dac_config_5 col_event_rst_top_left[19] dac_config_4
+ row_on_detect_top[33] dac_config_0 dac_config_1 row_off_detect_top[32] x1_net89
+ dac_config_2 vdda1 vssa1 vssc1 col_event_rst_top_left[18] x1_net90 row_on_detect_top[32]
+ row_off_detect_top[33] openDVS_pixel2x2_top
x1_x535 dac_config_3 dac_config_5 col_event_rst_top_left[17] dac_config_4
+ row_on_detect_top[33] dac_config_0 dac_config_1 row_off_detect_top[32] x1_net93
+ dac_config_2 vdda1 vssa1 vssc1 col_event_rst_top_left[16] x1_net94 row_on_detect_top[32]
+ row_off_detect_top[33] openDVS_pixel2x2_top
x1_x536 dac_config_3 dac_config_5 col_event_rst_top_left[15] dac_config_4
+ row_on_detect_top[33] dac_config_0 dac_config_1 row_off_detect_top[32] x1_net97
+ dac_config_2 vdda1 vssa1 vssc1 col_event_rst_top_left[14] x1_net98 row_on_detect_top[32]
+ row_off_detect_top[33] openDVS_pixel2x2_top
x1_x537 dac_config_3 dac_config_5 col_event_rst_top_left[13] dac_config_4
+ row_on_detect_top[33] dac_config_0 dac_config_1 row_off_detect_top[32] x1_net101
+ dac_config_2 vdda1 vssa1 vssc1 col_event_rst_top_left[12] x1_net102
+ row_on_detect_top[32] row_off_detect_top[33] openDVS_pixel2x2_top
x1_x538 dac_config_3 dac_config_5 col_event_rst_top_left[11] dac_config_4
+ row_on_detect_top[33] dac_config_0 dac_config_1 row_off_detect_top[32] x1_net105
+ dac_config_2 vdda1 vssa1 vssc1 col_event_rst_top_left[10] x1_net106
+ row_on_detect_top[32] row_off_detect_top[33] openDVS_pixel2x2_top
x1_x539 dac_config_3 dac_config_5 col_event_rst_top_left[9] dac_config_4
+ row_on_detect_top[33] dac_config_0 dac_config_1 row_off_detect_top[32] x1_net109
+ dac_config_2 vdda1 vssa1 vssc1 col_event_rst_top_left[8] x1_net110 row_on_detect_top[32]
+ row_off_detect_top[33] openDVS_pixel2x2_top
x1_x540 dac_config_3 dac_config_5 col_event_rst_top_left[7] dac_config_4
+ row_on_detect_top[33] dac_config_0 dac_config_1 row_off_detect_top[32] x1_net113
+ dac_config_2 vdda1 vssa1 vssc1 col_event_rst_top_left[6] x1_net114 row_on_detect_top[32]
+ row_off_detect_top[33] openDVS_pixel2x2_top
x1_x541 dac_config_3 dac_config_5 col_event_rst_top_left[5] dac_config_4
+ row_on_detect_top[33] dac_config_0 dac_config_1 row_off_detect_top[32] x1_net117
+ dac_config_2 vdda1 vssa1 vssc1 col_event_rst_top_left[4] x1_net118 row_on_detect_top[32]
+ row_off_detect_top[33] openDVS_pixel2x2_top
x1_x542 dac_config_3 dac_config_5 col_event_rst_top_left[3] dac_config_4
+ row_on_detect_top[33] dac_config_0 dac_config_1 row_off_detect_top[32] x1_net121
+ dac_config_2 vdda1 vssa1 vssc1 col_event_rst_top_left[2] x1_net122 row_on_detect_top[32]
+ row_off_detect_top[33] openDVS_pixel2x2_top
x1_x543 dac_config_3 dac_config_5 col_event_rst_top_left[1] dac_config_4
+ row_on_detect_top[33] dac_config_0 dac_config_1 row_off_detect_top[32] x1_net125
+ dac_config_2 vdda1 vssa1 vssc1 col_event_rst_top_left[0] x1_net126 row_on_detect_top[32]
+ row_off_detect_top[33] openDVS_pixel2x2_top
x1_x544 dac_config_3 dac_config_5 col_event_rst_top_left[63] dac_config_4
+ row_on_detect_top[35] dac_config_0 dac_config_1 row_off_detect_top[34] x1_net1
+ dac_config_2 vdda1 vssa1 vssc1 col_event_rst_top_left[62] x1_net2 row_on_detect_top[34]
+ row_off_detect_top[35] openDVS_pixel2x2_top
x1_x545 dac_config_3 dac_config_5 col_event_rst_top_left[61] dac_config_4
+ row_on_detect_top[35] dac_config_0 dac_config_1 row_off_detect_top[34] x1_net5
+ dac_config_2 vdda1 vssa1 vssc1 col_event_rst_top_left[60] x1_net6 row_on_detect_top[34]
+ row_off_detect_top[35] openDVS_pixel2x2_top
x1_x546 dac_config_3 dac_config_5 col_event_rst_top_left[59] dac_config_4
+ row_on_detect_top[35] dac_config_0 dac_config_1 row_off_detect_top[34] x1_net9
+ dac_config_2 vdda1 vssa1 vssc1 col_event_rst_top_left[58] x1_net10 row_on_detect_top[34]
+ row_off_detect_top[35] openDVS_pixel2x2_top
x1_x547 dac_config_3 dac_config_5 col_event_rst_top_left[57] dac_config_4
+ row_on_detect_top[35] dac_config_0 dac_config_1 row_off_detect_top[34] x1_net13
+ dac_config_2 vdda1 vssa1 vssc1 col_event_rst_top_left[56] x1_net14 row_on_detect_top[34]
+ row_off_detect_top[35] openDVS_pixel2x2_top
x1_x548 dac_config_3 dac_config_5 col_event_rst_top_left[55] dac_config_4
+ row_on_detect_top[35] dac_config_0 dac_config_1 row_off_detect_top[34] x1_net17
+ dac_config_2 vdda1 vssa1 vssc1 col_event_rst_top_left[54] x1_net18 row_on_detect_top[34]
+ row_off_detect_top[35] openDVS_pixel2x2_top
x1_x549 dac_config_3 dac_config_5 col_event_rst_top_left[53] dac_config_4
+ row_on_detect_top[35] dac_config_0 dac_config_1 row_off_detect_top[34] x1_net21
+ dac_config_2 vdda1 vssa1 vssc1 col_event_rst_top_left[52] x1_net22 row_on_detect_top[34]
+ row_off_detect_top[35] openDVS_pixel2x2_top
x1_x550 dac_config_3 dac_config_5 col_event_rst_top_left[51] dac_config_4
+ row_on_detect_top[35] dac_config_0 dac_config_1 row_off_detect_top[34] x1_net25
+ dac_config_2 vdda1 vssa1 vssc1 col_event_rst_top_left[50] x1_net26 row_on_detect_top[34]
+ row_off_detect_top[35] openDVS_pixel2x2_top
x1_x551 dac_config_3 dac_config_5 col_event_rst_top_left[49] dac_config_4
+ row_on_detect_top[35] dac_config_0 dac_config_1 row_off_detect_top[34] x1_net29
+ dac_config_2 vdda1 vssa1 vssc1 col_event_rst_top_left[48] x1_net30 row_on_detect_top[34]
+ row_off_detect_top[35] openDVS_pixel2x2_top
x1_x552 dac_config_3 dac_config_5 col_event_rst_top_left[47] dac_config_4
+ row_on_detect_top[35] dac_config_0 dac_config_1 row_off_detect_top[34] x1_net33
+ dac_config_2 vdda1 vssa1 vssc1 col_event_rst_top_left[46] x1_net34 row_on_detect_top[34]
+ row_off_detect_top[35] openDVS_pixel2x2_top
x1_x553 dac_config_3 dac_config_5 col_event_rst_top_left[45] dac_config_4
+ row_on_detect_top[35] dac_config_0 dac_config_1 row_off_detect_top[34] x1_net37
+ dac_config_2 vdda1 vssa1 vssc1 col_event_rst_top_left[44] x1_net38 row_on_detect_top[34]
+ row_off_detect_top[35] openDVS_pixel2x2_top
x1_x554 dac_config_3 dac_config_5 col_event_rst_top_left[43] dac_config_4
+ row_on_detect_top[35] dac_config_0 dac_config_1 row_off_detect_top[34] x1_net41
+ dac_config_2 vdda1 vssa1 vssc1 col_event_rst_top_left[42] x1_net42 row_on_detect_top[34]
+ row_off_detect_top[35] openDVS_pixel2x2_top
x1_x555 dac_config_3 dac_config_5 col_event_rst_top_left[41] dac_config_4
+ row_on_detect_top[35] dac_config_0 dac_config_1 row_off_detect_top[34] x1_net45
+ dac_config_2 vdda1 vssa1 vssc1 col_event_rst_top_left[40] x1_net46 row_on_detect_top[34]
+ row_off_detect_top[35] openDVS_pixel2x2_top
x1_x556 dac_config_3 dac_config_5 col_event_rst_top_left[39] dac_config_4
+ row_on_detect_top[35] dac_config_0 dac_config_1 row_off_detect_top[34] x1_net49
+ dac_config_2 vdda1 vssa1 vssc1 col_event_rst_top_left[38] x1_net50 row_on_detect_top[34]
+ row_off_detect_top[35] openDVS_pixel2x2_top
x1_x557 dac_config_3 dac_config_5 col_event_rst_top_left[37] dac_config_4
+ row_on_detect_top[35] dac_config_0 dac_config_1 row_off_detect_top[34] x1_net53
+ dac_config_2 vdda1 vssa1 vssc1 col_event_rst_top_left[36] x1_net54 row_on_detect_top[34]
+ row_off_detect_top[35] openDVS_pixel2x2_top
x1_x558 dac_config_3 dac_config_5 col_event_rst_top_left[35] dac_config_4
+ row_on_detect_top[35] dac_config_0 dac_config_1 row_off_detect_top[34] x1_net57
+ dac_config_2 vdda1 vssa1 vssc1 col_event_rst_top_left[34] x1_net58 row_on_detect_top[34]
+ row_off_detect_top[35] openDVS_pixel2x2_top
x1_x559 dac_config_3 dac_config_5 col_event_rst_top_left[33] dac_config_4
+ row_on_detect_top[35] dac_config_0 dac_config_1 row_off_detect_top[34] x1_net61
+ dac_config_2 vdda1 vssa1 vssc1 col_event_rst_top_left[32] x1_net62 row_on_detect_top[34]
+ row_off_detect_top[35] openDVS_pixel2x2_top
x1_x560 dac_config_3 dac_config_5 col_event_rst_top_left[31] dac_config_4
+ row_on_detect_top[35] dac_config_0 dac_config_1 row_off_detect_top[34] x1_net65
+ dac_config_2 vdda1 vssa1 vssc1 col_event_rst_top_left[30] x1_net66 row_on_detect_top[34]
+ row_off_detect_top[35] openDVS_pixel2x2_top
x1_x561 dac_config_3 dac_config_5 col_event_rst_top_left[29] dac_config_4
+ row_on_detect_top[35] dac_config_0 dac_config_1 row_off_detect_top[34] x1_net69
+ dac_config_2 vdda1 vssa1 vssc1 col_event_rst_top_left[28] x1_net70 row_on_detect_top[34]
+ row_off_detect_top[35] openDVS_pixel2x2_top
x1_x562 dac_config_3 dac_config_5 col_event_rst_top_left[27] dac_config_4
+ row_on_detect_top[35] dac_config_0 dac_config_1 row_off_detect_top[34] x1_net73
+ dac_config_2 vdda1 vssa1 vssc1 col_event_rst_top_left[26] x1_net74 row_on_detect_top[34]
+ row_off_detect_top[35] openDVS_pixel2x2_top
x1_x563 dac_config_3 dac_config_5 col_event_rst_top_left[25] dac_config_4
+ row_on_detect_top[35] dac_config_0 dac_config_1 row_off_detect_top[34] x1_net77
+ dac_config_2 vdda1 vssa1 vssc1 col_event_rst_top_left[24] x1_net78 row_on_detect_top[34]
+ row_off_detect_top[35] openDVS_pixel2x2_top
x1_x564 dac_config_3 dac_config_5 col_event_rst_top_left[23] dac_config_4
+ row_on_detect_top[35] dac_config_0 dac_config_1 row_off_detect_top[34] x1_net81
+ dac_config_2 vdda1 vssa1 vssc1 col_event_rst_top_left[22] x1_net82 row_on_detect_top[34]
+ row_off_detect_top[35] openDVS_pixel2x2_top
x1_x565 dac_config_3 dac_config_5 col_event_rst_top_left[21] dac_config_4
+ row_on_detect_top[35] dac_config_0 dac_config_1 row_off_detect_top[34] x1_net85
+ dac_config_2 vdda1 vssa1 vssc1 col_event_rst_top_left[20] x1_net86 row_on_detect_top[34]
+ row_off_detect_top[35] openDVS_pixel2x2_top
x1_x566 dac_config_3 dac_config_5 col_event_rst_top_left[19] dac_config_4
+ row_on_detect_top[35] dac_config_0 dac_config_1 row_off_detect_top[34] x1_net89
+ dac_config_2 vdda1 vssa1 vssc1 col_event_rst_top_left[18] x1_net90 row_on_detect_top[34]
+ row_off_detect_top[35] openDVS_pixel2x2_top
x1_x567 dac_config_3 dac_config_5 col_event_rst_top_left[17] dac_config_4
+ row_on_detect_top[35] dac_config_0 dac_config_1 row_off_detect_top[34] x1_net93
+ dac_config_2 vdda1 vssa1 vssc1 col_event_rst_top_left[16] x1_net94 row_on_detect_top[34]
+ row_off_detect_top[35] openDVS_pixel2x2_top
x1_x568 dac_config_3 dac_config_5 col_event_rst_top_left[15] dac_config_4
+ row_on_detect_top[35] dac_config_0 dac_config_1 row_off_detect_top[34] x1_net97
+ dac_config_2 vdda1 vssa1 vssc1 col_event_rst_top_left[14] x1_net98 row_on_detect_top[34]
+ row_off_detect_top[35] openDVS_pixel2x2_top
x1_x569 dac_config_3 dac_config_5 col_event_rst_top_left[13] dac_config_4
+ row_on_detect_top[35] dac_config_0 dac_config_1 row_off_detect_top[34] x1_net101
+ dac_config_2 vdda1 vssa1 vssc1 col_event_rst_top_left[12] x1_net102
+ row_on_detect_top[34] row_off_detect_top[35] openDVS_pixel2x2_top
x1_x570 dac_config_3 dac_config_5 col_event_rst_top_left[11] dac_config_4
+ row_on_detect_top[35] dac_config_0 dac_config_1 row_off_detect_top[34] x1_net105
+ dac_config_2 vdda1 vssa1 vssc1 col_event_rst_top_left[10] x1_net106
+ row_on_detect_top[34] row_off_detect_top[35] openDVS_pixel2x2_top
x1_x571 dac_config_3 dac_config_5 col_event_rst_top_left[9] dac_config_4
+ row_on_detect_top[35] dac_config_0 dac_config_1 row_off_detect_top[34] x1_net109
+ dac_config_2 vdda1 vssa1 vssc1 col_event_rst_top_left[8] x1_net110 row_on_detect_top[34]
+ row_off_detect_top[35] openDVS_pixel2x2_top
x1_x572 dac_config_3 dac_config_5 col_event_rst_top_left[7] dac_config_4
+ row_on_detect_top[35] dac_config_0 dac_config_1 row_off_detect_top[34] x1_net113
+ dac_config_2 vdda1 vssa1 vssc1 col_event_rst_top_left[6] x1_net114 row_on_detect_top[34]
+ row_off_detect_top[35] openDVS_pixel2x2_top
x1_x573 dac_config_3 dac_config_5 col_event_rst_top_left[5] dac_config_4
+ row_on_detect_top[35] dac_config_0 dac_config_1 row_off_detect_top[34] x1_net117
+ dac_config_2 vdda1 vssa1 vssc1 col_event_rst_top_left[4] x1_net118 row_on_detect_top[34]
+ row_off_detect_top[35] openDVS_pixel2x2_top
x1_x574 dac_config_3 dac_config_5 col_event_rst_top_left[3] dac_config_4
+ row_on_detect_top[35] dac_config_0 dac_config_1 row_off_detect_top[34] x1_net121
+ dac_config_2 vdda1 vssa1 vssc1 col_event_rst_top_left[2] x1_net122 row_on_detect_top[34]
+ row_off_detect_top[35] openDVS_pixel2x2_top
x1_x575 dac_config_3 dac_config_5 col_event_rst_top_left[1] dac_config_4
+ row_on_detect_top[35] dac_config_0 dac_config_1 row_off_detect_top[34] x1_net125
+ dac_config_2 vdda1 vssa1 vssc1 col_event_rst_top_left[0] x1_net126 row_on_detect_top[34]
+ row_off_detect_top[35] openDVS_pixel2x2_top
x1_x576 dac_config_3 dac_config_5 col_event_rst_top_left[63] dac_config_4
+ row_on_detect_top[37] dac_config_0 dac_config_1 row_off_detect_top[36] x1_net1
+ dac_config_2 vdda1 vssa1 vssc1 col_event_rst_top_left[62] x1_net2 row_on_detect_top[36]
+ row_off_detect_top[37] openDVS_pixel2x2_top
x1_x577 dac_config_3 dac_config_5 col_event_rst_top_left[61] dac_config_4
+ row_on_detect_top[37] dac_config_0 dac_config_1 row_off_detect_top[36] x1_net5
+ dac_config_2 vdda1 vssa1 vssc1 col_event_rst_top_left[60] x1_net6 row_on_detect_top[36]
+ row_off_detect_top[37] openDVS_pixel2x2_top
x1_x578 dac_config_3 dac_config_5 col_event_rst_top_left[59] dac_config_4
+ row_on_detect_top[37] dac_config_0 dac_config_1 row_off_detect_top[36] x1_net9
+ dac_config_2 vdda1 vssa1 vssc1 col_event_rst_top_left[58] x1_net10 row_on_detect_top[36]
+ row_off_detect_top[37] openDVS_pixel2x2_top
x1_x579 dac_config_3 dac_config_5 col_event_rst_top_left[57] dac_config_4
+ row_on_detect_top[37] dac_config_0 dac_config_1 row_off_detect_top[36] x1_net13
+ dac_config_2 vdda1 vssa1 vssc1 col_event_rst_top_left[56] x1_net14 row_on_detect_top[36]
+ row_off_detect_top[37] openDVS_pixel2x2_top
x1_x580 dac_config_3 dac_config_5 col_event_rst_top_left[55] dac_config_4
+ row_on_detect_top[37] dac_config_0 dac_config_1 row_off_detect_top[36] x1_net17
+ dac_config_2 vdda1 vssa1 vssc1 col_event_rst_top_left[54] x1_net18 row_on_detect_top[36]
+ row_off_detect_top[37] openDVS_pixel2x2_top
x1_x581 dac_config_3 dac_config_5 col_event_rst_top_left[53] dac_config_4
+ row_on_detect_top[37] dac_config_0 dac_config_1 row_off_detect_top[36] x1_net21
+ dac_config_2 vdda1 vssa1 vssc1 col_event_rst_top_left[52] x1_net22 row_on_detect_top[36]
+ row_off_detect_top[37] openDVS_pixel2x2_top
x1_x582 dac_config_3 dac_config_5 col_event_rst_top_left[51] dac_config_4
+ row_on_detect_top[37] dac_config_0 dac_config_1 row_off_detect_top[36] x1_net25
+ dac_config_2 vdda1 vssa1 vssc1 col_event_rst_top_left[50] x1_net26 row_on_detect_top[36]
+ row_off_detect_top[37] openDVS_pixel2x2_top
x1_x583 dac_config_3 dac_config_5 col_event_rst_top_left[49] dac_config_4
+ row_on_detect_top[37] dac_config_0 dac_config_1 row_off_detect_top[36] x1_net29
+ dac_config_2 vdda1 vssa1 vssc1 col_event_rst_top_left[48] x1_net30 row_on_detect_top[36]
+ row_off_detect_top[37] openDVS_pixel2x2_top
x1_x584 dac_config_3 dac_config_5 col_event_rst_top_left[47] dac_config_4
+ row_on_detect_top[37] dac_config_0 dac_config_1 row_off_detect_top[36] x1_net33
+ dac_config_2 vdda1 vssa1 vssc1 col_event_rst_top_left[46] x1_net34 row_on_detect_top[36]
+ row_off_detect_top[37] openDVS_pixel2x2_top
x1_x585 dac_config_3 dac_config_5 col_event_rst_top_left[45] dac_config_4
+ row_on_detect_top[37] dac_config_0 dac_config_1 row_off_detect_top[36] x1_net37
+ dac_config_2 vdda1 vssa1 vssc1 col_event_rst_top_left[44] x1_net38 row_on_detect_top[36]
+ row_off_detect_top[37] openDVS_pixel2x2_top
x1_x586 dac_config_3 dac_config_5 col_event_rst_top_left[43] dac_config_4
+ row_on_detect_top[37] dac_config_0 dac_config_1 row_off_detect_top[36] x1_net41
+ dac_config_2 vdda1 vssa1 vssc1 col_event_rst_top_left[42] x1_net42 row_on_detect_top[36]
+ row_off_detect_top[37] openDVS_pixel2x2_top
x1_x587 dac_config_3 dac_config_5 col_event_rst_top_left[41] dac_config_4
+ row_on_detect_top[37] dac_config_0 dac_config_1 row_off_detect_top[36] x1_net45
+ dac_config_2 vdda1 vssa1 vssc1 col_event_rst_top_left[40] x1_net46 row_on_detect_top[36]
+ row_off_detect_top[37] openDVS_pixel2x2_top
x1_x588 dac_config_3 dac_config_5 col_event_rst_top_left[39] dac_config_4
+ row_on_detect_top[37] dac_config_0 dac_config_1 row_off_detect_top[36] x1_net49
+ dac_config_2 vdda1 vssa1 vssc1 col_event_rst_top_left[38] x1_net50 row_on_detect_top[36]
+ row_off_detect_top[37] openDVS_pixel2x2_top
x1_x589 dac_config_3 dac_config_5 col_event_rst_top_left[37] dac_config_4
+ row_on_detect_top[37] dac_config_0 dac_config_1 row_off_detect_top[36] x1_net53
+ dac_config_2 vdda1 vssa1 vssc1 col_event_rst_top_left[36] x1_net54 row_on_detect_top[36]
+ row_off_detect_top[37] openDVS_pixel2x2_top
x1_x590 dac_config_3 dac_config_5 col_event_rst_top_left[35] dac_config_4
+ row_on_detect_top[37] dac_config_0 dac_config_1 row_off_detect_top[36] x1_net57
+ dac_config_2 vdda1 vssa1 vssc1 col_event_rst_top_left[34] x1_net58 row_on_detect_top[36]
+ row_off_detect_top[37] openDVS_pixel2x2_top
x1_x591 dac_config_3 dac_config_5 col_event_rst_top_left[33] dac_config_4
+ row_on_detect_top[37] dac_config_0 dac_config_1 row_off_detect_top[36] x1_net61
+ dac_config_2 vdda1 vssa1 vssc1 col_event_rst_top_left[32] x1_net62 row_on_detect_top[36]
+ row_off_detect_top[37] openDVS_pixel2x2_top
x1_x592 dac_config_3 dac_config_5 col_event_rst_top_left[31] dac_config_4
+ row_on_detect_top[37] dac_config_0 dac_config_1 row_off_detect_top[36] x1_net65
+ dac_config_2 vdda1 vssa1 vssc1 col_event_rst_top_left[30] x1_net66 row_on_detect_top[36]
+ row_off_detect_top[37] openDVS_pixel2x2_top
x1_x593 dac_config_3 dac_config_5 col_event_rst_top_left[29] dac_config_4
+ row_on_detect_top[37] dac_config_0 dac_config_1 row_off_detect_top[36] x1_net69
+ dac_config_2 vdda1 vssa1 vssc1 col_event_rst_top_left[28] x1_net70 row_on_detect_top[36]
+ row_off_detect_top[37] openDVS_pixel2x2_top
x1_x594 dac_config_3 dac_config_5 col_event_rst_top_left[27] dac_config_4
+ row_on_detect_top[37] dac_config_0 dac_config_1 row_off_detect_top[36] x1_net73
+ dac_config_2 vdda1 vssa1 vssc1 col_event_rst_top_left[26] x1_net74 row_on_detect_top[36]
+ row_off_detect_top[37] openDVS_pixel2x2_top
x1_x595 dac_config_3 dac_config_5 col_event_rst_top_left[25] dac_config_4
+ row_on_detect_top[37] dac_config_0 dac_config_1 row_off_detect_top[36] x1_net77
+ dac_config_2 vdda1 vssa1 vssc1 col_event_rst_top_left[24] x1_net78 row_on_detect_top[36]
+ row_off_detect_top[37] openDVS_pixel2x2_top
x1_x596 dac_config_3 dac_config_5 col_event_rst_top_left[23] dac_config_4
+ row_on_detect_top[37] dac_config_0 dac_config_1 row_off_detect_top[36] x1_net81
+ dac_config_2 vdda1 vssa1 vssc1 col_event_rst_top_left[22] x1_net82 row_on_detect_top[36]
+ row_off_detect_top[37] openDVS_pixel2x2_top
x1_x597 dac_config_3 dac_config_5 col_event_rst_top_left[21] dac_config_4
+ row_on_detect_top[37] dac_config_0 dac_config_1 row_off_detect_top[36] x1_net85
+ dac_config_2 vdda1 vssa1 vssc1 col_event_rst_top_left[20] x1_net86 row_on_detect_top[36]
+ row_off_detect_top[37] openDVS_pixel2x2_top
x1_x598 dac_config_3 dac_config_5 col_event_rst_top_left[19] dac_config_4
+ row_on_detect_top[37] dac_config_0 dac_config_1 row_off_detect_top[36] x1_net89
+ dac_config_2 vdda1 vssa1 vssc1 col_event_rst_top_left[18] x1_net90 row_on_detect_top[36]
+ row_off_detect_top[37] openDVS_pixel2x2_top
x1_x599 dac_config_3 dac_config_5 col_event_rst_top_left[17] dac_config_4
+ row_on_detect_top[37] dac_config_0 dac_config_1 row_off_detect_top[36] x1_net93
+ dac_config_2 vdda1 vssa1 vssc1 col_event_rst_top_left[16] x1_net94 row_on_detect_top[36]
+ row_off_detect_top[37] openDVS_pixel2x2_top
x1_x600 dac_config_3 dac_config_5 col_event_rst_top_left[15] dac_config_4
+ row_on_detect_top[37] dac_config_0 dac_config_1 row_off_detect_top[36] x1_net97
+ dac_config_2 vdda1 vssa1 vssc1 col_event_rst_top_left[14] x1_net98 row_on_detect_top[36]
+ row_off_detect_top[37] openDVS_pixel2x2_top
x1_x601 dac_config_3 dac_config_5 col_event_rst_top_left[13] dac_config_4
+ row_on_detect_top[37] dac_config_0 dac_config_1 row_off_detect_top[36] x1_net101
+ dac_config_2 vdda1 vssa1 vssc1 col_event_rst_top_left[12] x1_net102
+ row_on_detect_top[36] row_off_detect_top[37] openDVS_pixel2x2_top
x1_x602 dac_config_3 dac_config_5 col_event_rst_top_left[11] dac_config_4
+ row_on_detect_top[37] dac_config_0 dac_config_1 row_off_detect_top[36] x1_net105
+ dac_config_2 vdda1 vssa1 vssc1 col_event_rst_top_left[10] x1_net106
+ row_on_detect_top[36] row_off_detect_top[37] openDVS_pixel2x2_top
x1_x603 dac_config_3 dac_config_5 col_event_rst_top_left[9] dac_config_4
+ row_on_detect_top[37] dac_config_0 dac_config_1 row_off_detect_top[36] x1_net109
+ dac_config_2 vdda1 vssa1 vssc1 col_event_rst_top_left[8] x1_net110 row_on_detect_top[36]
+ row_off_detect_top[37] openDVS_pixel2x2_top
x1_x604 dac_config_3 dac_config_5 col_event_rst_top_left[7] dac_config_4
+ row_on_detect_top[37] dac_config_0 dac_config_1 row_off_detect_top[36] x1_net113
+ dac_config_2 vdda1 vssa1 vssc1 col_event_rst_top_left[6] x1_net114 row_on_detect_top[36]
+ row_off_detect_top[37] openDVS_pixel2x2_top
x1_x605 dac_config_3 dac_config_5 col_event_rst_top_left[5] dac_config_4
+ row_on_detect_top[37] dac_config_0 dac_config_1 row_off_detect_top[36] x1_net117
+ dac_config_2 vdda1 vssa1 vssc1 col_event_rst_top_left[4] x1_net118 row_on_detect_top[36]
+ row_off_detect_top[37] openDVS_pixel2x2_top
x1_x606 dac_config_3 dac_config_5 col_event_rst_top_left[3] dac_config_4
+ row_on_detect_top[37] dac_config_0 dac_config_1 row_off_detect_top[36] x1_net121
+ dac_config_2 vdda1 vssa1 vssc1 col_event_rst_top_left[2] x1_net122 row_on_detect_top[36]
+ row_off_detect_top[37] openDVS_pixel2x2_top
x1_x607 dac_config_3 dac_config_5 col_event_rst_top_left[1] dac_config_4
+ row_on_detect_top[37] dac_config_0 dac_config_1 row_off_detect_top[36] x1_net125
+ dac_config_2 vdda1 vssa1 vssc1 col_event_rst_top_left[0] x1_net126 row_on_detect_top[36]
+ row_off_detect_top[37] openDVS_pixel2x2_top
x1_x608 dac_config_3 dac_config_5 col_event_rst_top_left[63] dac_config_4
+ row_on_detect_top[39] dac_config_0 dac_config_1 row_off_detect_top[38] x1_net1
+ dac_config_2 vdda1 vssa1 vssc1 col_event_rst_top_left[62] x1_net2 row_on_detect_top[38]
+ row_off_detect_top[39] openDVS_pixel2x2_top
x1_x609 dac_config_3 dac_config_5 col_event_rst_top_left[61] dac_config_4
+ row_on_detect_top[39] dac_config_0 dac_config_1 row_off_detect_top[38] x1_net5
+ dac_config_2 vdda1 vssa1 vssc1 col_event_rst_top_left[60] x1_net6 row_on_detect_top[38]
+ row_off_detect_top[39] openDVS_pixel2x2_top
x1_x610 dac_config_3 dac_config_5 col_event_rst_top_left[59] dac_config_4
+ row_on_detect_top[39] dac_config_0 dac_config_1 row_off_detect_top[38] x1_net9
+ dac_config_2 vdda1 vssa1 vssc1 col_event_rst_top_left[58] x1_net10 row_on_detect_top[38]
+ row_off_detect_top[39] openDVS_pixel2x2_top
x1_x611 dac_config_3 dac_config_5 col_event_rst_top_left[57] dac_config_4
+ row_on_detect_top[39] dac_config_0 dac_config_1 row_off_detect_top[38] x1_net13
+ dac_config_2 vdda1 vssa1 vssc1 col_event_rst_top_left[56] x1_net14 row_on_detect_top[38]
+ row_off_detect_top[39] openDVS_pixel2x2_top
x1_x612 dac_config_3 dac_config_5 col_event_rst_top_left[55] dac_config_4
+ row_on_detect_top[39] dac_config_0 dac_config_1 row_off_detect_top[38] x1_net17
+ dac_config_2 vdda1 vssa1 vssc1 col_event_rst_top_left[54] x1_net18 row_on_detect_top[38]
+ row_off_detect_top[39] openDVS_pixel2x2_top
x1_x613 dac_config_3 dac_config_5 col_event_rst_top_left[53] dac_config_4
+ row_on_detect_top[39] dac_config_0 dac_config_1 row_off_detect_top[38] x1_net21
+ dac_config_2 vdda1 vssa1 vssc1 col_event_rst_top_left[52] x1_net22 row_on_detect_top[38]
+ row_off_detect_top[39] openDVS_pixel2x2_top
x1_x614 dac_config_3 dac_config_5 col_event_rst_top_left[51] dac_config_4
+ row_on_detect_top[39] dac_config_0 dac_config_1 row_off_detect_top[38] x1_net25
+ dac_config_2 vdda1 vssa1 vssc1 col_event_rst_top_left[50] x1_net26 row_on_detect_top[38]
+ row_off_detect_top[39] openDVS_pixel2x2_top
x1_x615 dac_config_3 dac_config_5 col_event_rst_top_left[49] dac_config_4
+ row_on_detect_top[39] dac_config_0 dac_config_1 row_off_detect_top[38] x1_net29
+ dac_config_2 vdda1 vssa1 vssc1 col_event_rst_top_left[48] x1_net30 row_on_detect_top[38]
+ row_off_detect_top[39] openDVS_pixel2x2_top
x1_x616 dac_config_3 dac_config_5 col_event_rst_top_left[47] dac_config_4
+ row_on_detect_top[39] dac_config_0 dac_config_1 row_off_detect_top[38] x1_net33
+ dac_config_2 vdda1 vssa1 vssc1 col_event_rst_top_left[46] x1_net34 row_on_detect_top[38]
+ row_off_detect_top[39] openDVS_pixel2x2_top
x1_x617 dac_config_3 dac_config_5 col_event_rst_top_left[45] dac_config_4
+ row_on_detect_top[39] dac_config_0 dac_config_1 row_off_detect_top[38] x1_net37
+ dac_config_2 vdda1 vssa1 vssc1 col_event_rst_top_left[44] x1_net38 row_on_detect_top[38]
+ row_off_detect_top[39] openDVS_pixel2x2_top
x1_x618 dac_config_3 dac_config_5 col_event_rst_top_left[43] dac_config_4
+ row_on_detect_top[39] dac_config_0 dac_config_1 row_off_detect_top[38] x1_net41
+ dac_config_2 vdda1 vssa1 vssc1 col_event_rst_top_left[42] x1_net42 row_on_detect_top[38]
+ row_off_detect_top[39] openDVS_pixel2x2_top
x1_x619 dac_config_3 dac_config_5 col_event_rst_top_left[41] dac_config_4
+ row_on_detect_top[39] dac_config_0 dac_config_1 row_off_detect_top[38] x1_net45
+ dac_config_2 vdda1 vssa1 vssc1 col_event_rst_top_left[40] x1_net46 row_on_detect_top[38]
+ row_off_detect_top[39] openDVS_pixel2x2_top
x1_x620 dac_config_3 dac_config_5 col_event_rst_top_left[39] dac_config_4
+ row_on_detect_top[39] dac_config_0 dac_config_1 row_off_detect_top[38] x1_net49
+ dac_config_2 vdda1 vssa1 vssc1 col_event_rst_top_left[38] x1_net50 row_on_detect_top[38]
+ row_off_detect_top[39] openDVS_pixel2x2_top
x1_x621 dac_config_3 dac_config_5 col_event_rst_top_left[37] dac_config_4
+ row_on_detect_top[39] dac_config_0 dac_config_1 row_off_detect_top[38] x1_net53
+ dac_config_2 vdda1 vssa1 vssc1 col_event_rst_top_left[36] x1_net54 row_on_detect_top[38]
+ row_off_detect_top[39] openDVS_pixel2x2_top
x1_x622 dac_config_3 dac_config_5 col_event_rst_top_left[35] dac_config_4
+ row_on_detect_top[39] dac_config_0 dac_config_1 row_off_detect_top[38] x1_net57
+ dac_config_2 vdda1 vssa1 vssc1 col_event_rst_top_left[34] x1_net58 row_on_detect_top[38]
+ row_off_detect_top[39] openDVS_pixel2x2_top
x1_x623 dac_config_3 dac_config_5 col_event_rst_top_left[33] dac_config_4
+ row_on_detect_top[39] dac_config_0 dac_config_1 row_off_detect_top[38] x1_net61
+ dac_config_2 vdda1 vssa1 vssc1 col_event_rst_top_left[32] x1_net62 row_on_detect_top[38]
+ row_off_detect_top[39] openDVS_pixel2x2_top
x1_x624 dac_config_3 dac_config_5 col_event_rst_top_left[31] dac_config_4
+ row_on_detect_top[39] dac_config_0 dac_config_1 row_off_detect_top[38] x1_net65
+ dac_config_2 vdda1 vssa1 vssc1 col_event_rst_top_left[30] x1_net66 row_on_detect_top[38]
+ row_off_detect_top[39] openDVS_pixel2x2_top
x1_x625 dac_config_3 dac_config_5 col_event_rst_top_left[29] dac_config_4
+ row_on_detect_top[39] dac_config_0 dac_config_1 row_off_detect_top[38] x1_net69
+ dac_config_2 vdda1 vssa1 vssc1 col_event_rst_top_left[28] x1_net70 row_on_detect_top[38]
+ row_off_detect_top[39] openDVS_pixel2x2_top
x1_x626 dac_config_3 dac_config_5 col_event_rst_top_left[27] dac_config_4
+ row_on_detect_top[39] dac_config_0 dac_config_1 row_off_detect_top[38] x1_net73
+ dac_config_2 vdda1 vssa1 vssc1 col_event_rst_top_left[26] x1_net74 row_on_detect_top[38]
+ row_off_detect_top[39] openDVS_pixel2x2_top
x1_x627 dac_config_3 dac_config_5 col_event_rst_top_left[25] dac_config_4
+ row_on_detect_top[39] dac_config_0 dac_config_1 row_off_detect_top[38] x1_net77
+ dac_config_2 vdda1 vssa1 vssc1 col_event_rst_top_left[24] x1_net78 row_on_detect_top[38]
+ row_off_detect_top[39] openDVS_pixel2x2_top
x1_x628 dac_config_3 dac_config_5 col_event_rst_top_left[23] dac_config_4
+ row_on_detect_top[39] dac_config_0 dac_config_1 row_off_detect_top[38] x1_net81
+ dac_config_2 vdda1 vssa1 vssc1 col_event_rst_top_left[22] x1_net82 row_on_detect_top[38]
+ row_off_detect_top[39] openDVS_pixel2x2_top
x1_x629 dac_config_3 dac_config_5 col_event_rst_top_left[21] dac_config_4
+ row_on_detect_top[39] dac_config_0 dac_config_1 row_off_detect_top[38] x1_net85
+ dac_config_2 vdda1 vssa1 vssc1 col_event_rst_top_left[20] x1_net86 row_on_detect_top[38]
+ row_off_detect_top[39] openDVS_pixel2x2_top
x1_x630 dac_config_3 dac_config_5 col_event_rst_top_left[19] dac_config_4
+ row_on_detect_top[39] dac_config_0 dac_config_1 row_off_detect_top[38] x1_net89
+ dac_config_2 vdda1 vssa1 vssc1 col_event_rst_top_left[18] x1_net90 row_on_detect_top[38]
+ row_off_detect_top[39] openDVS_pixel2x2_top
x1_x631 dac_config_3 dac_config_5 col_event_rst_top_left[17] dac_config_4
+ row_on_detect_top[39] dac_config_0 dac_config_1 row_off_detect_top[38] x1_net93
+ dac_config_2 vdda1 vssa1 vssc1 col_event_rst_top_left[16] x1_net94 row_on_detect_top[38]
+ row_off_detect_top[39] openDVS_pixel2x2_top
x1_x632 dac_config_3 dac_config_5 col_event_rst_top_left[15] dac_config_4
+ row_on_detect_top[39] dac_config_0 dac_config_1 row_off_detect_top[38] x1_net97
+ dac_config_2 vdda1 vssa1 vssc1 col_event_rst_top_left[14] x1_net98 row_on_detect_top[38]
+ row_off_detect_top[39] openDVS_pixel2x2_top
x1_x633 dac_config_3 dac_config_5 col_event_rst_top_left[13] dac_config_4
+ row_on_detect_top[39] dac_config_0 dac_config_1 row_off_detect_top[38] x1_net101
+ dac_config_2 vdda1 vssa1 vssc1 col_event_rst_top_left[12] x1_net102
+ row_on_detect_top[38] row_off_detect_top[39] openDVS_pixel2x2_top
x1_x634 dac_config_3 dac_config_5 col_event_rst_top_left[11] dac_config_4
+ row_on_detect_top[39] dac_config_0 dac_config_1 row_off_detect_top[38] x1_net105
+ dac_config_2 vdda1 vssa1 vssc1 col_event_rst_top_left[10] x1_net106
+ row_on_detect_top[38] row_off_detect_top[39] openDVS_pixel2x2_top
x1_x635 dac_config_3 dac_config_5 col_event_rst_top_left[9] dac_config_4
+ row_on_detect_top[39] dac_config_0 dac_config_1 row_off_detect_top[38] x1_net109
+ dac_config_2 vdda1 vssa1 vssc1 col_event_rst_top_left[8] x1_net110 row_on_detect_top[38]
+ row_off_detect_top[39] openDVS_pixel2x2_top
x1_x636 dac_config_3 dac_config_5 col_event_rst_top_left[7] dac_config_4
+ row_on_detect_top[39] dac_config_0 dac_config_1 row_off_detect_top[38] x1_net113
+ dac_config_2 vdda1 vssa1 vssc1 col_event_rst_top_left[6] x1_net114 row_on_detect_top[38]
+ row_off_detect_top[39] openDVS_pixel2x2_top
x1_x637 dac_config_3 dac_config_5 col_event_rst_top_left[5] dac_config_4
+ row_on_detect_top[39] dac_config_0 dac_config_1 row_off_detect_top[38] x1_net117
+ dac_config_2 vdda1 vssa1 vssc1 col_event_rst_top_left[4] x1_net118 row_on_detect_top[38]
+ row_off_detect_top[39] openDVS_pixel2x2_top
x1_x638 dac_config_3 dac_config_5 col_event_rst_top_left[3] dac_config_4
+ row_on_detect_top[39] dac_config_0 dac_config_1 row_off_detect_top[38] x1_net121
+ dac_config_2 vdda1 vssa1 vssc1 col_event_rst_top_left[2] x1_net122 row_on_detect_top[38]
+ row_off_detect_top[39] openDVS_pixel2x2_top
x1_x639 dac_config_3 dac_config_5 col_event_rst_top_left[1] dac_config_4
+ row_on_detect_top[39] dac_config_0 dac_config_1 row_off_detect_top[38] x1_net125
+ dac_config_2 vdda1 vssa1 vssc1 col_event_rst_top_left[0] x1_net126 row_on_detect_top[38]
+ row_off_detect_top[39] openDVS_pixel2x2_top
x1_x640 dac_config_3 dac_config_5 col_event_rst_top_left[63] dac_config_4
+ row_on_detect_top[41] dac_config_0 dac_config_1 row_off_detect_top[40] x1_net1
+ dac_config_2 vdda1 vssa1 vssc1 col_event_rst_top_left[62] x1_net2 row_on_detect_top[40]
+ row_off_detect_top[41] openDVS_pixel2x2_top
x1_x641 dac_config_3 dac_config_5 col_event_rst_top_left[61] dac_config_4
+ row_on_detect_top[41] dac_config_0 dac_config_1 row_off_detect_top[40] x1_net5
+ dac_config_2 vdda1 vssa1 vssc1 col_event_rst_top_left[60] x1_net6 row_on_detect_top[40]
+ row_off_detect_top[41] openDVS_pixel2x2_top
x1_x642 dac_config_3 dac_config_5 col_event_rst_top_left[59] dac_config_4
+ row_on_detect_top[41] dac_config_0 dac_config_1 row_off_detect_top[40] x1_net9
+ dac_config_2 vdda1 vssa1 vssc1 col_event_rst_top_left[58] x1_net10 row_on_detect_top[40]
+ row_off_detect_top[41] openDVS_pixel2x2_top
x1_x643 dac_config_3 dac_config_5 col_event_rst_top_left[57] dac_config_4
+ row_on_detect_top[41] dac_config_0 dac_config_1 row_off_detect_top[40] x1_net13
+ dac_config_2 vdda1 vssa1 vssc1 col_event_rst_top_left[56] x1_net14 row_on_detect_top[40]
+ row_off_detect_top[41] openDVS_pixel2x2_top
x1_x644 dac_config_3 dac_config_5 col_event_rst_top_left[55] dac_config_4
+ row_on_detect_top[41] dac_config_0 dac_config_1 row_off_detect_top[40] x1_net17
+ dac_config_2 vdda1 vssa1 vssc1 col_event_rst_top_left[54] x1_net18 row_on_detect_top[40]
+ row_off_detect_top[41] openDVS_pixel2x2_top
x1_x645 dac_config_3 dac_config_5 col_event_rst_top_left[53] dac_config_4
+ row_on_detect_top[41] dac_config_0 dac_config_1 row_off_detect_top[40] x1_net21
+ dac_config_2 vdda1 vssa1 vssc1 col_event_rst_top_left[52] x1_net22 row_on_detect_top[40]
+ row_off_detect_top[41] openDVS_pixel2x2_top
x1_x646 dac_config_3 dac_config_5 col_event_rst_top_left[51] dac_config_4
+ row_on_detect_top[41] dac_config_0 dac_config_1 row_off_detect_top[40] x1_net25
+ dac_config_2 vdda1 vssa1 vssc1 col_event_rst_top_left[50] x1_net26 row_on_detect_top[40]
+ row_off_detect_top[41] openDVS_pixel2x2_top
x1_x647 dac_config_3 dac_config_5 col_event_rst_top_left[49] dac_config_4
+ row_on_detect_top[41] dac_config_0 dac_config_1 row_off_detect_top[40] x1_net29
+ dac_config_2 vdda1 vssa1 vssc1 col_event_rst_top_left[48] x1_net30 row_on_detect_top[40]
+ row_off_detect_top[41] openDVS_pixel2x2_top
x1_x648 dac_config_3 dac_config_5 col_event_rst_top_left[47] dac_config_4
+ row_on_detect_top[41] dac_config_0 dac_config_1 row_off_detect_top[40] x1_net33
+ dac_config_2 vdda1 vssa1 vssc1 col_event_rst_top_left[46] x1_net34 row_on_detect_top[40]
+ row_off_detect_top[41] openDVS_pixel2x2_top
x1_x649 dac_config_3 dac_config_5 col_event_rst_top_left[45] dac_config_4
+ row_on_detect_top[41] dac_config_0 dac_config_1 row_off_detect_top[40] x1_net37
+ dac_config_2 vdda1 vssa1 vssc1 col_event_rst_top_left[44] x1_net38 row_on_detect_top[40]
+ row_off_detect_top[41] openDVS_pixel2x2_top
x1_x650 dac_config_3 dac_config_5 col_event_rst_top_left[43] dac_config_4
+ row_on_detect_top[41] dac_config_0 dac_config_1 row_off_detect_top[40] x1_net41
+ dac_config_2 vdda1 vssa1 vssc1 col_event_rst_top_left[42] x1_net42 row_on_detect_top[40]
+ row_off_detect_top[41] openDVS_pixel2x2_top
x1_x651 dac_config_3 dac_config_5 col_event_rst_top_left[41] dac_config_4
+ row_on_detect_top[41] dac_config_0 dac_config_1 row_off_detect_top[40] x1_net45
+ dac_config_2 vdda1 vssa1 vssc1 col_event_rst_top_left[40] x1_net46 row_on_detect_top[40]
+ row_off_detect_top[41] openDVS_pixel2x2_top
x1_x652 dac_config_3 dac_config_5 col_event_rst_top_left[39] dac_config_4
+ row_on_detect_top[41] dac_config_0 dac_config_1 row_off_detect_top[40] x1_net49
+ dac_config_2 vdda1 vssa1 vssc1 col_event_rst_top_left[38] x1_net50 row_on_detect_top[40]
+ row_off_detect_top[41] openDVS_pixel2x2_top
x1_x653 dac_config_3 dac_config_5 col_event_rst_top_left[37] dac_config_4
+ row_on_detect_top[41] dac_config_0 dac_config_1 row_off_detect_top[40] x1_net53
+ dac_config_2 vdda1 vssa1 vssc1 col_event_rst_top_left[36] x1_net54 row_on_detect_top[40]
+ row_off_detect_top[41] openDVS_pixel2x2_top
x1_x654 dac_config_3 dac_config_5 col_event_rst_top_left[35] dac_config_4
+ row_on_detect_top[41] dac_config_0 dac_config_1 row_off_detect_top[40] x1_net57
+ dac_config_2 vdda1 vssa1 vssc1 col_event_rst_top_left[34] x1_net58 row_on_detect_top[40]
+ row_off_detect_top[41] openDVS_pixel2x2_top
x1_x655 dac_config_3 dac_config_5 col_event_rst_top_left[33] dac_config_4
+ row_on_detect_top[41] dac_config_0 dac_config_1 row_off_detect_top[40] x1_net61
+ dac_config_2 vdda1 vssa1 vssc1 col_event_rst_top_left[32] x1_net62 row_on_detect_top[40]
+ row_off_detect_top[41] openDVS_pixel2x2_top
x1_x656 dac_config_3 dac_config_5 col_event_rst_top_left[31] dac_config_4
+ row_on_detect_top[41] dac_config_0 dac_config_1 row_off_detect_top[40] x1_net65
+ dac_config_2 vdda1 vssa1 vssc1 col_event_rst_top_left[30] x1_net66 row_on_detect_top[40]
+ row_off_detect_top[41] openDVS_pixel2x2_top
x1_x657 dac_config_3 dac_config_5 col_event_rst_top_left[29] dac_config_4
+ row_on_detect_top[41] dac_config_0 dac_config_1 row_off_detect_top[40] x1_net69
+ dac_config_2 vdda1 vssa1 vssc1 col_event_rst_top_left[28] x1_net70 row_on_detect_top[40]
+ row_off_detect_top[41] openDVS_pixel2x2_top
x1_x658 dac_config_3 dac_config_5 col_event_rst_top_left[27] dac_config_4
+ row_on_detect_top[41] dac_config_0 dac_config_1 row_off_detect_top[40] x1_net73
+ dac_config_2 vdda1 vssa1 vssc1 col_event_rst_top_left[26] x1_net74 row_on_detect_top[40]
+ row_off_detect_top[41] openDVS_pixel2x2_top
x1_x659 dac_config_3 dac_config_5 col_event_rst_top_left[25] dac_config_4
+ row_on_detect_top[41] dac_config_0 dac_config_1 row_off_detect_top[40] x1_net77
+ dac_config_2 vdda1 vssa1 vssc1 col_event_rst_top_left[24] x1_net78 row_on_detect_top[40]
+ row_off_detect_top[41] openDVS_pixel2x2_top
x1_x660 dac_config_3 dac_config_5 col_event_rst_top_left[23] dac_config_4
+ row_on_detect_top[41] dac_config_0 dac_config_1 row_off_detect_top[40] x1_net81
+ dac_config_2 vdda1 vssa1 vssc1 col_event_rst_top_left[22] x1_net82 row_on_detect_top[40]
+ row_off_detect_top[41] openDVS_pixel2x2_top
x1_x661 dac_config_3 dac_config_5 col_event_rst_top_left[21] dac_config_4
+ row_on_detect_top[41] dac_config_0 dac_config_1 row_off_detect_top[40] x1_net85
+ dac_config_2 vdda1 vssa1 vssc1 col_event_rst_top_left[20] x1_net86 row_on_detect_top[40]
+ row_off_detect_top[41] openDVS_pixel2x2_top
x1_x662 dac_config_3 dac_config_5 col_event_rst_top_left[19] dac_config_4
+ row_on_detect_top[41] dac_config_0 dac_config_1 row_off_detect_top[40] x1_net89
+ dac_config_2 vdda1 vssa1 vssc1 col_event_rst_top_left[18] x1_net90 row_on_detect_top[40]
+ row_off_detect_top[41] openDVS_pixel2x2_top
x1_x663 dac_config_3 dac_config_5 col_event_rst_top_left[17] dac_config_4
+ row_on_detect_top[41] dac_config_0 dac_config_1 row_off_detect_top[40] x1_net93
+ dac_config_2 vdda1 vssa1 vssc1 col_event_rst_top_left[16] x1_net94 row_on_detect_top[40]
+ row_off_detect_top[41] openDVS_pixel2x2_top
x1_x664 dac_config_3 dac_config_5 col_event_rst_top_left[15] dac_config_4
+ row_on_detect_top[41] dac_config_0 dac_config_1 row_off_detect_top[40] x1_net97
+ dac_config_2 vdda1 vssa1 vssc1 col_event_rst_top_left[14] x1_net98 row_on_detect_top[40]
+ row_off_detect_top[41] openDVS_pixel2x2_top
x1_x665 dac_config_3 dac_config_5 col_event_rst_top_left[13] dac_config_4
+ row_on_detect_top[41] dac_config_0 dac_config_1 row_off_detect_top[40] x1_net101
+ dac_config_2 vdda1 vssa1 vssc1 col_event_rst_top_left[12] x1_net102
+ row_on_detect_top[40] row_off_detect_top[41] openDVS_pixel2x2_top
x1_x666 dac_config_3 dac_config_5 col_event_rst_top_left[11] dac_config_4
+ row_on_detect_top[41] dac_config_0 dac_config_1 row_off_detect_top[40] x1_net105
+ dac_config_2 vdda1 vssa1 vssc1 col_event_rst_top_left[10] x1_net106
+ row_on_detect_top[40] row_off_detect_top[41] openDVS_pixel2x2_top
x1_x667 dac_config_3 dac_config_5 col_event_rst_top_left[9] dac_config_4
+ row_on_detect_top[41] dac_config_0 dac_config_1 row_off_detect_top[40] x1_net109
+ dac_config_2 vdda1 vssa1 vssc1 col_event_rst_top_left[8] x1_net110 row_on_detect_top[40]
+ row_off_detect_top[41] openDVS_pixel2x2_top
x1_x668 dac_config_3 dac_config_5 col_event_rst_top_left[7] dac_config_4
+ row_on_detect_top[41] dac_config_0 dac_config_1 row_off_detect_top[40] x1_net113
+ dac_config_2 vdda1 vssa1 vssc1 col_event_rst_top_left[6] x1_net114 row_on_detect_top[40]
+ row_off_detect_top[41] openDVS_pixel2x2_top
x1_x669 dac_config_3 dac_config_5 col_event_rst_top_left[5] dac_config_4
+ row_on_detect_top[41] dac_config_0 dac_config_1 row_off_detect_top[40] x1_net117
+ dac_config_2 vdda1 vssa1 vssc1 col_event_rst_top_left[4] x1_net118 row_on_detect_top[40]
+ row_off_detect_top[41] openDVS_pixel2x2_top
x1_x670 dac_config_3 dac_config_5 col_event_rst_top_left[3] dac_config_4
+ row_on_detect_top[41] dac_config_0 dac_config_1 row_off_detect_top[40] x1_net121
+ dac_config_2 vdda1 vssa1 vssc1 col_event_rst_top_left[2] x1_net122 row_on_detect_top[40]
+ row_off_detect_top[41] openDVS_pixel2x2_top
x1_x671 dac_config_3 dac_config_5 col_event_rst_top_left[1] dac_config_4
+ row_on_detect_top[41] dac_config_0 dac_config_1 row_off_detect_top[40] x1_net125
+ dac_config_2 vdda1 vssa1 vssc1 col_event_rst_top_left[0] x1_net126 row_on_detect_top[40]
+ row_off_detect_top[41] openDVS_pixel2x2_top
x1_x672 dac_config_3 dac_config_5 col_event_rst_top_left[63] dac_config_4
+ row_on_detect_top[43] dac_config_0 dac_config_1 row_off_detect_top[42] x1_net1
+ dac_config_2 vdda1 vssa1 vssc1 col_event_rst_top_left[62] x1_net2 row_on_detect_top[42]
+ row_off_detect_top[43] openDVS_pixel2x2_top
x1_x673 dac_config_3 dac_config_5 col_event_rst_top_left[61] dac_config_4
+ row_on_detect_top[43] dac_config_0 dac_config_1 row_off_detect_top[42] x1_net5
+ dac_config_2 vdda1 vssa1 vssc1 col_event_rst_top_left[60] x1_net6 row_on_detect_top[42]
+ row_off_detect_top[43] openDVS_pixel2x2_top
x1_x674 dac_config_3 dac_config_5 col_event_rst_top_left[59] dac_config_4
+ row_on_detect_top[43] dac_config_0 dac_config_1 row_off_detect_top[42] x1_net9
+ dac_config_2 vdda1 vssa1 vssc1 col_event_rst_top_left[58] x1_net10 row_on_detect_top[42]
+ row_off_detect_top[43] openDVS_pixel2x2_top
x1_x675 dac_config_3 dac_config_5 col_event_rst_top_left[57] dac_config_4
+ row_on_detect_top[43] dac_config_0 dac_config_1 row_off_detect_top[42] x1_net13
+ dac_config_2 vdda1 vssa1 vssc1 col_event_rst_top_left[56] x1_net14 row_on_detect_top[42]
+ row_off_detect_top[43] openDVS_pixel2x2_top
x1_x676 dac_config_3 dac_config_5 col_event_rst_top_left[55] dac_config_4
+ row_on_detect_top[43] dac_config_0 dac_config_1 row_off_detect_top[42] x1_net17
+ dac_config_2 vdda1 vssa1 vssc1 col_event_rst_top_left[54] x1_net18 row_on_detect_top[42]
+ row_off_detect_top[43] openDVS_pixel2x2_top
x1_x677 dac_config_3 dac_config_5 col_event_rst_top_left[53] dac_config_4
+ row_on_detect_top[43] dac_config_0 dac_config_1 row_off_detect_top[42] x1_net21
+ dac_config_2 vdda1 vssa1 vssc1 col_event_rst_top_left[52] x1_net22 row_on_detect_top[42]
+ row_off_detect_top[43] openDVS_pixel2x2_top
x1_x678 dac_config_3 dac_config_5 col_event_rst_top_left[51] dac_config_4
+ row_on_detect_top[43] dac_config_0 dac_config_1 row_off_detect_top[42] x1_net25
+ dac_config_2 vdda1 vssa1 vssc1 col_event_rst_top_left[50] x1_net26 row_on_detect_top[42]
+ row_off_detect_top[43] openDVS_pixel2x2_top
x1_x679 dac_config_3 dac_config_5 col_event_rst_top_left[49] dac_config_4
+ row_on_detect_top[43] dac_config_0 dac_config_1 row_off_detect_top[42] x1_net29
+ dac_config_2 vdda1 vssa1 vssc1 col_event_rst_top_left[48] x1_net30 row_on_detect_top[42]
+ row_off_detect_top[43] openDVS_pixel2x2_top
x1_x680 dac_config_3 dac_config_5 col_event_rst_top_left[47] dac_config_4
+ row_on_detect_top[43] dac_config_0 dac_config_1 row_off_detect_top[42] x1_net33
+ dac_config_2 vdda1 vssa1 vssc1 col_event_rst_top_left[46] x1_net34 row_on_detect_top[42]
+ row_off_detect_top[43] openDVS_pixel2x2_top
x1_x681 dac_config_3 dac_config_5 col_event_rst_top_left[45] dac_config_4
+ row_on_detect_top[43] dac_config_0 dac_config_1 row_off_detect_top[42] x1_net37
+ dac_config_2 vdda1 vssa1 vssc1 col_event_rst_top_left[44] x1_net38 row_on_detect_top[42]
+ row_off_detect_top[43] openDVS_pixel2x2_top
x1_x682 dac_config_3 dac_config_5 col_event_rst_top_left[43] dac_config_4
+ row_on_detect_top[43] dac_config_0 dac_config_1 row_off_detect_top[42] x1_net41
+ dac_config_2 vdda1 vssa1 vssc1 col_event_rst_top_left[42] x1_net42 row_on_detect_top[42]
+ row_off_detect_top[43] openDVS_pixel2x2_top
x1_x683 dac_config_3 dac_config_5 col_event_rst_top_left[41] dac_config_4
+ row_on_detect_top[43] dac_config_0 dac_config_1 row_off_detect_top[42] x1_net45
+ dac_config_2 vdda1 vssa1 vssc1 col_event_rst_top_left[40] x1_net46 row_on_detect_top[42]
+ row_off_detect_top[43] openDVS_pixel2x2_top
x1_x684 dac_config_3 dac_config_5 col_event_rst_top_left[39] dac_config_4
+ row_on_detect_top[43] dac_config_0 dac_config_1 row_off_detect_top[42] x1_net49
+ dac_config_2 vdda1 vssa1 vssc1 col_event_rst_top_left[38] x1_net50 row_on_detect_top[42]
+ row_off_detect_top[43] openDVS_pixel2x2_top
x1_x685 dac_config_3 dac_config_5 col_event_rst_top_left[37] dac_config_4
+ row_on_detect_top[43] dac_config_0 dac_config_1 row_off_detect_top[42] x1_net53
+ dac_config_2 vdda1 vssa1 vssc1 col_event_rst_top_left[36] x1_net54 row_on_detect_top[42]
+ row_off_detect_top[43] openDVS_pixel2x2_top
x1_x686 dac_config_3 dac_config_5 col_event_rst_top_left[35] dac_config_4
+ row_on_detect_top[43] dac_config_0 dac_config_1 row_off_detect_top[42] x1_net57
+ dac_config_2 vdda1 vssa1 vssc1 col_event_rst_top_left[34] x1_net58 row_on_detect_top[42]
+ row_off_detect_top[43] openDVS_pixel2x2_top
x1_x687 dac_config_3 dac_config_5 col_event_rst_top_left[33] dac_config_4
+ row_on_detect_top[43] dac_config_0 dac_config_1 row_off_detect_top[42] x1_net61
+ dac_config_2 vdda1 vssa1 vssc1 col_event_rst_top_left[32] x1_net62 row_on_detect_top[42]
+ row_off_detect_top[43] openDVS_pixel2x2_top
x1_x688 dac_config_3 dac_config_5 col_event_rst_top_left[31] dac_config_4
+ row_on_detect_top[43] dac_config_0 dac_config_1 row_off_detect_top[42] x1_net65
+ dac_config_2 vdda1 vssa1 vssc1 col_event_rst_top_left[30] x1_net66 row_on_detect_top[42]
+ row_off_detect_top[43] openDVS_pixel2x2_top
x1_x689 dac_config_3 dac_config_5 col_event_rst_top_left[29] dac_config_4
+ row_on_detect_top[43] dac_config_0 dac_config_1 row_off_detect_top[42] x1_net69
+ dac_config_2 vdda1 vssa1 vssc1 col_event_rst_top_left[28] x1_net70 row_on_detect_top[42]
+ row_off_detect_top[43] openDVS_pixel2x2_top
x1_x690 dac_config_3 dac_config_5 col_event_rst_top_left[27] dac_config_4
+ row_on_detect_top[43] dac_config_0 dac_config_1 row_off_detect_top[42] x1_net73
+ dac_config_2 vdda1 vssa1 vssc1 col_event_rst_top_left[26] x1_net74 row_on_detect_top[42]
+ row_off_detect_top[43] openDVS_pixel2x2_top
x1_x691 dac_config_3 dac_config_5 col_event_rst_top_left[25] dac_config_4
+ row_on_detect_top[43] dac_config_0 dac_config_1 row_off_detect_top[42] x1_net77
+ dac_config_2 vdda1 vssa1 vssc1 col_event_rst_top_left[24] x1_net78 row_on_detect_top[42]
+ row_off_detect_top[43] openDVS_pixel2x2_top
x1_x692 dac_config_3 dac_config_5 col_event_rst_top_left[23] dac_config_4
+ row_on_detect_top[43] dac_config_0 dac_config_1 row_off_detect_top[42] x1_net81
+ dac_config_2 vdda1 vssa1 vssc1 col_event_rst_top_left[22] x1_net82 row_on_detect_top[42]
+ row_off_detect_top[43] openDVS_pixel2x2_top
x1_x693 dac_config_3 dac_config_5 col_event_rst_top_left[21] dac_config_4
+ row_on_detect_top[43] dac_config_0 dac_config_1 row_off_detect_top[42] x1_net85
+ dac_config_2 vdda1 vssa1 vssc1 col_event_rst_top_left[20] x1_net86 row_on_detect_top[42]
+ row_off_detect_top[43] openDVS_pixel2x2_top
x1_x694 dac_config_3 dac_config_5 col_event_rst_top_left[19] dac_config_4
+ row_on_detect_top[43] dac_config_0 dac_config_1 row_off_detect_top[42] x1_net89
+ dac_config_2 vdda1 vssa1 vssc1 col_event_rst_top_left[18] x1_net90 row_on_detect_top[42]
+ row_off_detect_top[43] openDVS_pixel2x2_top
x1_x695 dac_config_3 dac_config_5 col_event_rst_top_left[17] dac_config_4
+ row_on_detect_top[43] dac_config_0 dac_config_1 row_off_detect_top[42] x1_net93
+ dac_config_2 vdda1 vssa1 vssc1 col_event_rst_top_left[16] x1_net94 row_on_detect_top[42]
+ row_off_detect_top[43] openDVS_pixel2x2_top
x1_x696 dac_config_3 dac_config_5 col_event_rst_top_left[15] dac_config_4
+ row_on_detect_top[43] dac_config_0 dac_config_1 row_off_detect_top[42] x1_net97
+ dac_config_2 vdda1 vssa1 vssc1 col_event_rst_top_left[14] x1_net98 row_on_detect_top[42]
+ row_off_detect_top[43] openDVS_pixel2x2_top
x1_x697 dac_config_3 dac_config_5 col_event_rst_top_left[13] dac_config_4
+ row_on_detect_top[43] dac_config_0 dac_config_1 row_off_detect_top[42] x1_net101
+ dac_config_2 vdda1 vssa1 vssc1 col_event_rst_top_left[12] x1_net102
+ row_on_detect_top[42] row_off_detect_top[43] openDVS_pixel2x2_top
x1_x698 dac_config_3 dac_config_5 col_event_rst_top_left[11] dac_config_4
+ row_on_detect_top[43] dac_config_0 dac_config_1 row_off_detect_top[42] x1_net105
+ dac_config_2 vdda1 vssa1 vssc1 col_event_rst_top_left[10] x1_net106
+ row_on_detect_top[42] row_off_detect_top[43] openDVS_pixel2x2_top
x1_x699 dac_config_3 dac_config_5 col_event_rst_top_left[9] dac_config_4
+ row_on_detect_top[43] dac_config_0 dac_config_1 row_off_detect_top[42] x1_net109
+ dac_config_2 vdda1 vssa1 vssc1 col_event_rst_top_left[8] x1_net110 row_on_detect_top[42]
+ row_off_detect_top[43] openDVS_pixel2x2_top
x1_x700 dac_config_3 dac_config_5 col_event_rst_top_left[7] dac_config_4
+ row_on_detect_top[43] dac_config_0 dac_config_1 row_off_detect_top[42] x1_net113
+ dac_config_2 vdda1 vssa1 vssc1 col_event_rst_top_left[6] x1_net114 row_on_detect_top[42]
+ row_off_detect_top[43] openDVS_pixel2x2_top
x1_x701 dac_config_3 dac_config_5 col_event_rst_top_left[5] dac_config_4
+ row_on_detect_top[43] dac_config_0 dac_config_1 row_off_detect_top[42] x1_net117
+ dac_config_2 vdda1 vssa1 vssc1 col_event_rst_top_left[4] x1_net118 row_on_detect_top[42]
+ row_off_detect_top[43] openDVS_pixel2x2_top
x1_x702 dac_config_3 dac_config_5 col_event_rst_top_left[3] dac_config_4
+ row_on_detect_top[43] dac_config_0 dac_config_1 row_off_detect_top[42] x1_net121
+ dac_config_2 vdda1 vssa1 vssc1 col_event_rst_top_left[2] x1_net122 row_on_detect_top[42]
+ row_off_detect_top[43] openDVS_pixel2x2_top
x1_x703 dac_config_3 dac_config_5 col_event_rst_top_left[1] dac_config_4
+ row_on_detect_top[43] dac_config_0 dac_config_1 row_off_detect_top[42] x1_net125
+ dac_config_2 vdda1 vssa1 vssc1 col_event_rst_top_left[0] x1_net126 row_on_detect_top[42]
+ row_off_detect_top[43] openDVS_pixel2x2_top
x1_x704 dac_config_3 dac_config_5 col_event_rst_top_left[63] dac_config_4
+ row_on_detect_top[45] dac_config_0 dac_config_1 row_off_detect_top[44] x1_net1
+ dac_config_2 vdda1 vssa1 vssc1 col_event_rst_top_left[62] x1_net2 row_on_detect_top[44]
+ row_off_detect_top[45] openDVS_pixel2x2_top
x1_x705 dac_config_3 dac_config_5 col_event_rst_top_left[61] dac_config_4
+ row_on_detect_top[45] dac_config_0 dac_config_1 row_off_detect_top[44] x1_net5
+ dac_config_2 vdda1 vssa1 vssc1 col_event_rst_top_left[60] x1_net6 row_on_detect_top[44]
+ row_off_detect_top[45] openDVS_pixel2x2_top
x1_x706 dac_config_3 dac_config_5 col_event_rst_top_left[59] dac_config_4
+ row_on_detect_top[45] dac_config_0 dac_config_1 row_off_detect_top[44] x1_net9
+ dac_config_2 vdda1 vssa1 vssc1 col_event_rst_top_left[58] x1_net10 row_on_detect_top[44]
+ row_off_detect_top[45] openDVS_pixel2x2_top
x1_x707 dac_config_3 dac_config_5 col_event_rst_top_left[57] dac_config_4
+ row_on_detect_top[45] dac_config_0 dac_config_1 row_off_detect_top[44] x1_net13
+ dac_config_2 vdda1 vssa1 vssc1 col_event_rst_top_left[56] x1_net14 row_on_detect_top[44]
+ row_off_detect_top[45] openDVS_pixel2x2_top
x1_x708 dac_config_3 dac_config_5 col_event_rst_top_left[55] dac_config_4
+ row_on_detect_top[45] dac_config_0 dac_config_1 row_off_detect_top[44] x1_net17
+ dac_config_2 vdda1 vssa1 vssc1 col_event_rst_top_left[54] x1_net18 row_on_detect_top[44]
+ row_off_detect_top[45] openDVS_pixel2x2_top
x1_x709 dac_config_3 dac_config_5 col_event_rst_top_left[53] dac_config_4
+ row_on_detect_top[45] dac_config_0 dac_config_1 row_off_detect_top[44] x1_net21
+ dac_config_2 vdda1 vssa1 vssc1 col_event_rst_top_left[52] x1_net22 row_on_detect_top[44]
+ row_off_detect_top[45] openDVS_pixel2x2_top
x1_x710 dac_config_3 dac_config_5 col_event_rst_top_left[51] dac_config_4
+ row_on_detect_top[45] dac_config_0 dac_config_1 row_off_detect_top[44] x1_net25
+ dac_config_2 vdda1 vssa1 vssc1 col_event_rst_top_left[50] x1_net26 row_on_detect_top[44]
+ row_off_detect_top[45] openDVS_pixel2x2_top
x1_x711 dac_config_3 dac_config_5 col_event_rst_top_left[49] dac_config_4
+ row_on_detect_top[45] dac_config_0 dac_config_1 row_off_detect_top[44] x1_net29
+ dac_config_2 vdda1 vssa1 vssc1 col_event_rst_top_left[48] x1_net30 row_on_detect_top[44]
+ row_off_detect_top[45] openDVS_pixel2x2_top
x1_x712 dac_config_3 dac_config_5 col_event_rst_top_left[47] dac_config_4
+ row_on_detect_top[45] dac_config_0 dac_config_1 row_off_detect_top[44] x1_net33
+ dac_config_2 vdda1 vssa1 vssc1 col_event_rst_top_left[46] x1_net34 row_on_detect_top[44]
+ row_off_detect_top[45] openDVS_pixel2x2_top
x1_x713 dac_config_3 dac_config_5 col_event_rst_top_left[45] dac_config_4
+ row_on_detect_top[45] dac_config_0 dac_config_1 row_off_detect_top[44] x1_net37
+ dac_config_2 vdda1 vssa1 vssc1 col_event_rst_top_left[44] x1_net38 row_on_detect_top[44]
+ row_off_detect_top[45] openDVS_pixel2x2_top
x1_x714 dac_config_3 dac_config_5 col_event_rst_top_left[43] dac_config_4
+ row_on_detect_top[45] dac_config_0 dac_config_1 row_off_detect_top[44] x1_net41
+ dac_config_2 vdda1 vssa1 vssc1 col_event_rst_top_left[42] x1_net42 row_on_detect_top[44]
+ row_off_detect_top[45] openDVS_pixel2x2_top
x1_x715 dac_config_3 dac_config_5 col_event_rst_top_left[41] dac_config_4
+ row_on_detect_top[45] dac_config_0 dac_config_1 row_off_detect_top[44] x1_net45
+ dac_config_2 vdda1 vssa1 vssc1 col_event_rst_top_left[40] x1_net46 row_on_detect_top[44]
+ row_off_detect_top[45] openDVS_pixel2x2_top
x1_x716 dac_config_3 dac_config_5 col_event_rst_top_left[39] dac_config_4
+ row_on_detect_top[45] dac_config_0 dac_config_1 row_off_detect_top[44] x1_net49
+ dac_config_2 vdda1 vssa1 vssc1 col_event_rst_top_left[38] x1_net50 row_on_detect_top[44]
+ row_off_detect_top[45] openDVS_pixel2x2_top
x1_x717 dac_config_3 dac_config_5 col_event_rst_top_left[37] dac_config_4
+ row_on_detect_top[45] dac_config_0 dac_config_1 row_off_detect_top[44] x1_net53
+ dac_config_2 vdda1 vssa1 vssc1 col_event_rst_top_left[36] x1_net54 row_on_detect_top[44]
+ row_off_detect_top[45] openDVS_pixel2x2_top
x1_x718 dac_config_3 dac_config_5 col_event_rst_top_left[35] dac_config_4
+ row_on_detect_top[45] dac_config_0 dac_config_1 row_off_detect_top[44] x1_net57
+ dac_config_2 vdda1 vssa1 vssc1 col_event_rst_top_left[34] x1_net58 row_on_detect_top[44]
+ row_off_detect_top[45] openDVS_pixel2x2_top
x1_x719 dac_config_3 dac_config_5 col_event_rst_top_left[33] dac_config_4
+ row_on_detect_top[45] dac_config_0 dac_config_1 row_off_detect_top[44] x1_net61
+ dac_config_2 vdda1 vssa1 vssc1 col_event_rst_top_left[32] x1_net62 row_on_detect_top[44]
+ row_off_detect_top[45] openDVS_pixel2x2_top
x1_x720 dac_config_3 dac_config_5 col_event_rst_top_left[31] dac_config_4
+ row_on_detect_top[45] dac_config_0 dac_config_1 row_off_detect_top[44] x1_net65
+ dac_config_2 vdda1 vssa1 vssc1 col_event_rst_top_left[30] x1_net66 row_on_detect_top[44]
+ row_off_detect_top[45] openDVS_pixel2x2_top
x1_x721 dac_config_3 dac_config_5 col_event_rst_top_left[29] dac_config_4
+ row_on_detect_top[45] dac_config_0 dac_config_1 row_off_detect_top[44] x1_net69
+ dac_config_2 vdda1 vssa1 vssc1 col_event_rst_top_left[28] x1_net70 row_on_detect_top[44]
+ row_off_detect_top[45] openDVS_pixel2x2_top
x1_x722 dac_config_3 dac_config_5 col_event_rst_top_left[27] dac_config_4
+ row_on_detect_top[45] dac_config_0 dac_config_1 row_off_detect_top[44] x1_net73
+ dac_config_2 vdda1 vssa1 vssc1 col_event_rst_top_left[26] x1_net74 row_on_detect_top[44]
+ row_off_detect_top[45] openDVS_pixel2x2_top
x1_x723 dac_config_3 dac_config_5 col_event_rst_top_left[25] dac_config_4
+ row_on_detect_top[45] dac_config_0 dac_config_1 row_off_detect_top[44] x1_net77
+ dac_config_2 vdda1 vssa1 vssc1 col_event_rst_top_left[24] x1_net78 row_on_detect_top[44]
+ row_off_detect_top[45] openDVS_pixel2x2_top
x1_x724 dac_config_3 dac_config_5 col_event_rst_top_left[23] dac_config_4
+ row_on_detect_top[45] dac_config_0 dac_config_1 row_off_detect_top[44] x1_net81
+ dac_config_2 vdda1 vssa1 vssc1 col_event_rst_top_left[22] x1_net82 row_on_detect_top[44]
+ row_off_detect_top[45] openDVS_pixel2x2_top
x1_x725 dac_config_3 dac_config_5 col_event_rst_top_left[21] dac_config_4
+ row_on_detect_top[45] dac_config_0 dac_config_1 row_off_detect_top[44] x1_net85
+ dac_config_2 vdda1 vssa1 vssc1 col_event_rst_top_left[20] x1_net86 row_on_detect_top[44]
+ row_off_detect_top[45] openDVS_pixel2x2_top
x1_x726 dac_config_3 dac_config_5 col_event_rst_top_left[19] dac_config_4
+ row_on_detect_top[45] dac_config_0 dac_config_1 row_off_detect_top[44] x1_net89
+ dac_config_2 vdda1 vssa1 vssc1 col_event_rst_top_left[18] x1_net90 row_on_detect_top[44]
+ row_off_detect_top[45] openDVS_pixel2x2_top
x1_x727 dac_config_3 dac_config_5 col_event_rst_top_left[17] dac_config_4
+ row_on_detect_top[45] dac_config_0 dac_config_1 row_off_detect_top[44] x1_net93
+ dac_config_2 vdda1 vssa1 vssc1 col_event_rst_top_left[16] x1_net94 row_on_detect_top[44]
+ row_off_detect_top[45] openDVS_pixel2x2_top
x1_x728 dac_config_3 dac_config_5 col_event_rst_top_left[15] dac_config_4
+ row_on_detect_top[45] dac_config_0 dac_config_1 row_off_detect_top[44] x1_net97
+ dac_config_2 vdda1 vssa1 vssc1 col_event_rst_top_left[14] x1_net98 row_on_detect_top[44]
+ row_off_detect_top[45] openDVS_pixel2x2_top
x1_x729 dac_config_3 dac_config_5 col_event_rst_top_left[13] dac_config_4
+ row_on_detect_top[45] dac_config_0 dac_config_1 row_off_detect_top[44] x1_net101
+ dac_config_2 vdda1 vssa1 vssc1 col_event_rst_top_left[12] x1_net102
+ row_on_detect_top[44] row_off_detect_top[45] openDVS_pixel2x2_top
x1_x730 dac_config_3 dac_config_5 col_event_rst_top_left[11] dac_config_4
+ row_on_detect_top[45] dac_config_0 dac_config_1 row_off_detect_top[44] x1_net105
+ dac_config_2 vdda1 vssa1 vssc1 col_event_rst_top_left[10] x1_net106
+ row_on_detect_top[44] row_off_detect_top[45] openDVS_pixel2x2_top
x1_x731 dac_config_3 dac_config_5 col_event_rst_top_left[9] dac_config_4
+ row_on_detect_top[45] dac_config_0 dac_config_1 row_off_detect_top[44] x1_net109
+ dac_config_2 vdda1 vssa1 vssc1 col_event_rst_top_left[8] x1_net110 row_on_detect_top[44]
+ row_off_detect_top[45] openDVS_pixel2x2_top
x1_x732 dac_config_3 dac_config_5 col_event_rst_top_left[7] dac_config_4
+ row_on_detect_top[45] dac_config_0 dac_config_1 row_off_detect_top[44] x1_net113
+ dac_config_2 vdda1 vssa1 vssc1 col_event_rst_top_left[6] x1_net114 row_on_detect_top[44]
+ row_off_detect_top[45] openDVS_pixel2x2_top
x1_x733 dac_config_3 dac_config_5 col_event_rst_top_left[5] dac_config_4
+ row_on_detect_top[45] dac_config_0 dac_config_1 row_off_detect_top[44] x1_net117
+ dac_config_2 vdda1 vssa1 vssc1 col_event_rst_top_left[4] x1_net118 row_on_detect_top[44]
+ row_off_detect_top[45] openDVS_pixel2x2_top
x1_x734 dac_config_3 dac_config_5 col_event_rst_top_left[3] dac_config_4
+ row_on_detect_top[45] dac_config_0 dac_config_1 row_off_detect_top[44] x1_net121
+ dac_config_2 vdda1 vssa1 vssc1 col_event_rst_top_left[2] x1_net122 row_on_detect_top[44]
+ row_off_detect_top[45] openDVS_pixel2x2_top
x1_x735 dac_config_3 dac_config_5 col_event_rst_top_left[1] dac_config_4
+ row_on_detect_top[45] dac_config_0 dac_config_1 row_off_detect_top[44] x1_net125
+ dac_config_2 vdda1 vssa1 vssc1 col_event_rst_top_left[0] x1_net126 row_on_detect_top[44]
+ row_off_detect_top[45] openDVS_pixel2x2_top
x1_x736 dac_config_3 dac_config_5 col_event_rst_top_left[63] dac_config_4
+ row_on_detect_top[47] dac_config_0 dac_config_1 row_off_detect_top[46] x1_net1
+ dac_config_2 vdda1 vssa1 vssc1 col_event_rst_top_left[62] x1_net2 row_on_detect_top[46]
+ row_off_detect_top[47] openDVS_pixel2x2_top
x1_x737 dac_config_3 dac_config_5 col_event_rst_top_left[61] dac_config_4
+ row_on_detect_top[47] dac_config_0 dac_config_1 row_off_detect_top[46] x1_net5
+ dac_config_2 vdda1 vssa1 vssc1 col_event_rst_top_left[60] x1_net6 row_on_detect_top[46]
+ row_off_detect_top[47] openDVS_pixel2x2_top
x1_x738 dac_config_3 dac_config_5 col_event_rst_top_left[59] dac_config_4
+ row_on_detect_top[47] dac_config_0 dac_config_1 row_off_detect_top[46] x1_net9
+ dac_config_2 vdda1 vssa1 vssc1 col_event_rst_top_left[58] x1_net10 row_on_detect_top[46]
+ row_off_detect_top[47] openDVS_pixel2x2_top
x1_x739 dac_config_3 dac_config_5 col_event_rst_top_left[57] dac_config_4
+ row_on_detect_top[47] dac_config_0 dac_config_1 row_off_detect_top[46] x1_net13
+ dac_config_2 vdda1 vssa1 vssc1 col_event_rst_top_left[56] x1_net14 row_on_detect_top[46]
+ row_off_detect_top[47] openDVS_pixel2x2_top
x1_x740 dac_config_3 dac_config_5 col_event_rst_top_left[55] dac_config_4
+ row_on_detect_top[47] dac_config_0 dac_config_1 row_off_detect_top[46] x1_net17
+ dac_config_2 vdda1 vssa1 vssc1 col_event_rst_top_left[54] x1_net18 row_on_detect_top[46]
+ row_off_detect_top[47] openDVS_pixel2x2_top
x1_x741 dac_config_3 dac_config_5 col_event_rst_top_left[53] dac_config_4
+ row_on_detect_top[47] dac_config_0 dac_config_1 row_off_detect_top[46] x1_net21
+ dac_config_2 vdda1 vssa1 vssc1 col_event_rst_top_left[52] x1_net22 row_on_detect_top[46]
+ row_off_detect_top[47] openDVS_pixel2x2_top
x1_x742 dac_config_3 dac_config_5 col_event_rst_top_left[51] dac_config_4
+ row_on_detect_top[47] dac_config_0 dac_config_1 row_off_detect_top[46] x1_net25
+ dac_config_2 vdda1 vssa1 vssc1 col_event_rst_top_left[50] x1_net26 row_on_detect_top[46]
+ row_off_detect_top[47] openDVS_pixel2x2_top
x1_x743 dac_config_3 dac_config_5 col_event_rst_top_left[49] dac_config_4
+ row_on_detect_top[47] dac_config_0 dac_config_1 row_off_detect_top[46] x1_net29
+ dac_config_2 vdda1 vssa1 vssc1 col_event_rst_top_left[48] x1_net30 row_on_detect_top[46]
+ row_off_detect_top[47] openDVS_pixel2x2_top
x1_x744 dac_config_3 dac_config_5 col_event_rst_top_left[47] dac_config_4
+ row_on_detect_top[47] dac_config_0 dac_config_1 row_off_detect_top[46] x1_net33
+ dac_config_2 vdda1 vssa1 vssc1 col_event_rst_top_left[46] x1_net34 row_on_detect_top[46]
+ row_off_detect_top[47] openDVS_pixel2x2_top
x1_x745 dac_config_3 dac_config_5 col_event_rst_top_left[45] dac_config_4
+ row_on_detect_top[47] dac_config_0 dac_config_1 row_off_detect_top[46] x1_net37
+ dac_config_2 vdda1 vssa1 vssc1 col_event_rst_top_left[44] x1_net38 row_on_detect_top[46]
+ row_off_detect_top[47] openDVS_pixel2x2_top
x1_x746 dac_config_3 dac_config_5 col_event_rst_top_left[43] dac_config_4
+ row_on_detect_top[47] dac_config_0 dac_config_1 row_off_detect_top[46] x1_net41
+ dac_config_2 vdda1 vssa1 vssc1 col_event_rst_top_left[42] x1_net42 row_on_detect_top[46]
+ row_off_detect_top[47] openDVS_pixel2x2_top
x1_x747 dac_config_3 dac_config_5 col_event_rst_top_left[41] dac_config_4
+ row_on_detect_top[47] dac_config_0 dac_config_1 row_off_detect_top[46] x1_net45
+ dac_config_2 vdda1 vssa1 vssc1 col_event_rst_top_left[40] x1_net46 row_on_detect_top[46]
+ row_off_detect_top[47] openDVS_pixel2x2_top
x1_x748 dac_config_3 dac_config_5 col_event_rst_top_left[39] dac_config_4
+ row_on_detect_top[47] dac_config_0 dac_config_1 row_off_detect_top[46] x1_net49
+ dac_config_2 vdda1 vssa1 vssc1 col_event_rst_top_left[38] x1_net50 row_on_detect_top[46]
+ row_off_detect_top[47] openDVS_pixel2x2_top
x1_x749 dac_config_3 dac_config_5 col_event_rst_top_left[37] dac_config_4
+ row_on_detect_top[47] dac_config_0 dac_config_1 row_off_detect_top[46] x1_net53
+ dac_config_2 vdda1 vssa1 vssc1 col_event_rst_top_left[36] x1_net54 row_on_detect_top[46]
+ row_off_detect_top[47] openDVS_pixel2x2_top
x1_x750 dac_config_3 dac_config_5 col_event_rst_top_left[35] dac_config_4
+ row_on_detect_top[47] dac_config_0 dac_config_1 row_off_detect_top[46] x1_net57
+ dac_config_2 vdda1 vssa1 vssc1 col_event_rst_top_left[34] x1_net58 row_on_detect_top[46]
+ row_off_detect_top[47] openDVS_pixel2x2_top
x1_x751 dac_config_3 dac_config_5 col_event_rst_top_left[33] dac_config_4
+ row_on_detect_top[47] dac_config_0 dac_config_1 row_off_detect_top[46] x1_net61
+ dac_config_2 vdda1 vssa1 vssc1 col_event_rst_top_left[32] x1_net62 row_on_detect_top[46]
+ row_off_detect_top[47] openDVS_pixel2x2_top
x1_x752 dac_config_3 dac_config_5 col_event_rst_top_left[31] dac_config_4
+ row_on_detect_top[47] dac_config_0 dac_config_1 row_off_detect_top[46] x1_net65
+ dac_config_2 vdda1 vssa1 vssc1 col_event_rst_top_left[30] x1_net66 row_on_detect_top[46]
+ row_off_detect_top[47] openDVS_pixel2x2_top
x1_x753 dac_config_3 dac_config_5 col_event_rst_top_left[29] dac_config_4
+ row_on_detect_top[47] dac_config_0 dac_config_1 row_off_detect_top[46] x1_net69
+ dac_config_2 vdda1 vssa1 vssc1 col_event_rst_top_left[28] x1_net70 row_on_detect_top[46]
+ row_off_detect_top[47] openDVS_pixel2x2_top
x1_x754 dac_config_3 dac_config_5 col_event_rst_top_left[27] dac_config_4
+ row_on_detect_top[47] dac_config_0 dac_config_1 row_off_detect_top[46] x1_net73
+ dac_config_2 vdda1 vssa1 vssc1 col_event_rst_top_left[26] x1_net74 row_on_detect_top[46]
+ row_off_detect_top[47] openDVS_pixel2x2_top
x1_x755 dac_config_3 dac_config_5 col_event_rst_top_left[25] dac_config_4
+ row_on_detect_top[47] dac_config_0 dac_config_1 row_off_detect_top[46] x1_net77
+ dac_config_2 vdda1 vssa1 vssc1 col_event_rst_top_left[24] x1_net78 row_on_detect_top[46]
+ row_off_detect_top[47] openDVS_pixel2x2_top
x1_x756 dac_config_3 dac_config_5 col_event_rst_top_left[23] dac_config_4
+ row_on_detect_top[47] dac_config_0 dac_config_1 row_off_detect_top[46] x1_net81
+ dac_config_2 vdda1 vssa1 vssc1 col_event_rst_top_left[22] x1_net82 row_on_detect_top[46]
+ row_off_detect_top[47] openDVS_pixel2x2_top
x1_x757 dac_config_3 dac_config_5 col_event_rst_top_left[21] dac_config_4
+ row_on_detect_top[47] dac_config_0 dac_config_1 row_off_detect_top[46] x1_net85
+ dac_config_2 vdda1 vssa1 vssc1 col_event_rst_top_left[20] x1_net86 row_on_detect_top[46]
+ row_off_detect_top[47] openDVS_pixel2x2_top
x1_x758 dac_config_3 dac_config_5 col_event_rst_top_left[19] dac_config_4
+ row_on_detect_top[47] dac_config_0 dac_config_1 row_off_detect_top[46] x1_net89
+ dac_config_2 vdda1 vssa1 vssc1 col_event_rst_top_left[18] x1_net90 row_on_detect_top[46]
+ row_off_detect_top[47] openDVS_pixel2x2_top
x1_x759 dac_config_3 dac_config_5 col_event_rst_top_left[17] dac_config_4
+ row_on_detect_top[47] dac_config_0 dac_config_1 row_off_detect_top[46] x1_net93
+ dac_config_2 vdda1 vssa1 vssc1 col_event_rst_top_left[16] x1_net94 row_on_detect_top[46]
+ row_off_detect_top[47] openDVS_pixel2x2_top
x1_x760 dac_config_3 dac_config_5 col_event_rst_top_left[15] dac_config_4
+ row_on_detect_top[47] dac_config_0 dac_config_1 row_off_detect_top[46] x1_net97
+ dac_config_2 vdda1 vssa1 vssc1 col_event_rst_top_left[14] x1_net98 row_on_detect_top[46]
+ row_off_detect_top[47] openDVS_pixel2x2_top
x1_x761 dac_config_3 dac_config_5 col_event_rst_top_left[13] dac_config_4
+ row_on_detect_top[47] dac_config_0 dac_config_1 row_off_detect_top[46] x1_net101
+ dac_config_2 vdda1 vssa1 vssc1 col_event_rst_top_left[12] x1_net102
+ row_on_detect_top[46] row_off_detect_top[47] openDVS_pixel2x2_top
x1_x762 dac_config_3 dac_config_5 col_event_rst_top_left[11] dac_config_4
+ row_on_detect_top[47] dac_config_0 dac_config_1 row_off_detect_top[46] x1_net105
+ dac_config_2 vdda1 vssa1 vssc1 col_event_rst_top_left[10] x1_net106
+ row_on_detect_top[46] row_off_detect_top[47] openDVS_pixel2x2_top
x1_x763 dac_config_3 dac_config_5 col_event_rst_top_left[9] dac_config_4
+ row_on_detect_top[47] dac_config_0 dac_config_1 row_off_detect_top[46] x1_net109
+ dac_config_2 vdda1 vssa1 vssc1 col_event_rst_top_left[8] x1_net110 row_on_detect_top[46]
+ row_off_detect_top[47] openDVS_pixel2x2_top
x1_x764 dac_config_3 dac_config_5 col_event_rst_top_left[7] dac_config_4
+ row_on_detect_top[47] dac_config_0 dac_config_1 row_off_detect_top[46] x1_net113
+ dac_config_2 vdda1 vssa1 vssc1 col_event_rst_top_left[6] x1_net114 row_on_detect_top[46]
+ row_off_detect_top[47] openDVS_pixel2x2_top
x1_x765 dac_config_3 dac_config_5 col_event_rst_top_left[5] dac_config_4
+ row_on_detect_top[47] dac_config_0 dac_config_1 row_off_detect_top[46] x1_net117
+ dac_config_2 vdda1 vssa1 vssc1 col_event_rst_top_left[4] x1_net118 row_on_detect_top[46]
+ row_off_detect_top[47] openDVS_pixel2x2_top
x1_x766 dac_config_3 dac_config_5 col_event_rst_top_left[3] dac_config_4
+ row_on_detect_top[47] dac_config_0 dac_config_1 row_off_detect_top[46] x1_net121
+ dac_config_2 vdda1 vssa1 vssc1 col_event_rst_top_left[2] x1_net122 row_on_detect_top[46]
+ row_off_detect_top[47] openDVS_pixel2x2_top
x1_x767 dac_config_3 dac_config_5 col_event_rst_top_left[1] dac_config_4
+ row_on_detect_top[47] dac_config_0 dac_config_1 row_off_detect_top[46] x1_net125
+ dac_config_2 vdda1 vssa1 vssc1 col_event_rst_top_left[0] x1_net126 row_on_detect_top[46]
+ row_off_detect_top[47] openDVS_pixel2x2_top
x1_x768 dac_config_3 dac_config_5 col_event_rst_top_left[63] dac_config_4
+ row_on_detect_top[49] dac_config_0 dac_config_1 row_off_detect_top[48] x1_net1
+ dac_config_2 vdda1 vssa1 vssc1 col_event_rst_top_left[62] x1_net2 row_on_detect_top[48]
+ row_off_detect_top[49] openDVS_pixel2x2_top
x1_x769 dac_config_3 dac_config_5 col_event_rst_top_left[61] dac_config_4
+ row_on_detect_top[49] dac_config_0 dac_config_1 row_off_detect_top[48] x1_net5
+ dac_config_2 vdda1 vssa1 vssc1 col_event_rst_top_left[60] x1_net6 row_on_detect_top[48]
+ row_off_detect_top[49] openDVS_pixel2x2_top
x1_x770 dac_config_3 dac_config_5 col_event_rst_top_left[59] dac_config_4
+ row_on_detect_top[49] dac_config_0 dac_config_1 row_off_detect_top[48] x1_net9
+ dac_config_2 vdda1 vssa1 vssc1 col_event_rst_top_left[58] x1_net10 row_on_detect_top[48]
+ row_off_detect_top[49] openDVS_pixel2x2_top
x1_x771 dac_config_3 dac_config_5 col_event_rst_top_left[57] dac_config_4
+ row_on_detect_top[49] dac_config_0 dac_config_1 row_off_detect_top[48] x1_net13
+ dac_config_2 vdda1 vssa1 vssc1 col_event_rst_top_left[56] x1_net14 row_on_detect_top[48]
+ row_off_detect_top[49] openDVS_pixel2x2_top
x1_x772 dac_config_3 dac_config_5 col_event_rst_top_left[55] dac_config_4
+ row_on_detect_top[49] dac_config_0 dac_config_1 row_off_detect_top[48] x1_net17
+ dac_config_2 vdda1 vssa1 vssc1 col_event_rst_top_left[54] x1_net18 row_on_detect_top[48]
+ row_off_detect_top[49] openDVS_pixel2x2_top
x1_x773 dac_config_3 dac_config_5 col_event_rst_top_left[53] dac_config_4
+ row_on_detect_top[49] dac_config_0 dac_config_1 row_off_detect_top[48] x1_net21
+ dac_config_2 vdda1 vssa1 vssc1 col_event_rst_top_left[52] x1_net22 row_on_detect_top[48]
+ row_off_detect_top[49] openDVS_pixel2x2_top
x1_x774 dac_config_3 dac_config_5 col_event_rst_top_left[51] dac_config_4
+ row_on_detect_top[49] dac_config_0 dac_config_1 row_off_detect_top[48] x1_net25
+ dac_config_2 vdda1 vssa1 vssc1 col_event_rst_top_left[50] x1_net26 row_on_detect_top[48]
+ row_off_detect_top[49] openDVS_pixel2x2_top
x1_x775 dac_config_3 dac_config_5 col_event_rst_top_left[49] dac_config_4
+ row_on_detect_top[49] dac_config_0 dac_config_1 row_off_detect_top[48] x1_net29
+ dac_config_2 vdda1 vssa1 vssc1 col_event_rst_top_left[48] x1_net30 row_on_detect_top[48]
+ row_off_detect_top[49] openDVS_pixel2x2_top
x1_x776 dac_config_3 dac_config_5 col_event_rst_top_left[47] dac_config_4
+ row_on_detect_top[49] dac_config_0 dac_config_1 row_off_detect_top[48] x1_net33
+ dac_config_2 vdda1 vssa1 vssc1 col_event_rst_top_left[46] x1_net34 row_on_detect_top[48]
+ row_off_detect_top[49] openDVS_pixel2x2_top
x1_x777 dac_config_3 dac_config_5 col_event_rst_top_left[45] dac_config_4
+ row_on_detect_top[49] dac_config_0 dac_config_1 row_off_detect_top[48] x1_net37
+ dac_config_2 vdda1 vssa1 vssc1 col_event_rst_top_left[44] x1_net38 row_on_detect_top[48]
+ row_off_detect_top[49] openDVS_pixel2x2_top
x1_x778 dac_config_3 dac_config_5 col_event_rst_top_left[43] dac_config_4
+ row_on_detect_top[49] dac_config_0 dac_config_1 row_off_detect_top[48] x1_net41
+ dac_config_2 vdda1 vssa1 vssc1 col_event_rst_top_left[42] x1_net42 row_on_detect_top[48]
+ row_off_detect_top[49] openDVS_pixel2x2_top
x1_x779 dac_config_3 dac_config_5 col_event_rst_top_left[41] dac_config_4
+ row_on_detect_top[49] dac_config_0 dac_config_1 row_off_detect_top[48] x1_net45
+ dac_config_2 vdda1 vssa1 vssc1 col_event_rst_top_left[40] x1_net46 row_on_detect_top[48]
+ row_off_detect_top[49] openDVS_pixel2x2_top
x1_x780 dac_config_3 dac_config_5 col_event_rst_top_left[39] dac_config_4
+ row_on_detect_top[49] dac_config_0 dac_config_1 row_off_detect_top[48] x1_net49
+ dac_config_2 vdda1 vssa1 vssc1 col_event_rst_top_left[38] x1_net50 row_on_detect_top[48]
+ row_off_detect_top[49] openDVS_pixel2x2_top
x1_x781 dac_config_3 dac_config_5 col_event_rst_top_left[37] dac_config_4
+ row_on_detect_top[49] dac_config_0 dac_config_1 row_off_detect_top[48] x1_net53
+ dac_config_2 vdda1 vssa1 vssc1 col_event_rst_top_left[36] x1_net54 row_on_detect_top[48]
+ row_off_detect_top[49] openDVS_pixel2x2_top
x1_x782 dac_config_3 dac_config_5 col_event_rst_top_left[35] dac_config_4
+ row_on_detect_top[49] dac_config_0 dac_config_1 row_off_detect_top[48] x1_net57
+ dac_config_2 vdda1 vssa1 vssc1 col_event_rst_top_left[34] x1_net58 row_on_detect_top[48]
+ row_off_detect_top[49] openDVS_pixel2x2_top
x1_x783 dac_config_3 dac_config_5 col_event_rst_top_left[33] dac_config_4
+ row_on_detect_top[49] dac_config_0 dac_config_1 row_off_detect_top[48] x1_net61
+ dac_config_2 vdda1 vssa1 vssc1 col_event_rst_top_left[32] x1_net62 row_on_detect_top[48]
+ row_off_detect_top[49] openDVS_pixel2x2_top
x1_x784 dac_config_3 dac_config_5 col_event_rst_top_left[31] dac_config_4
+ row_on_detect_top[49] dac_config_0 dac_config_1 row_off_detect_top[48] x1_net65
+ dac_config_2 vdda1 vssa1 vssc1 col_event_rst_top_left[30] x1_net66 row_on_detect_top[48]
+ row_off_detect_top[49] openDVS_pixel2x2_top
x1_x785 dac_config_3 dac_config_5 col_event_rst_top_left[29] dac_config_4
+ row_on_detect_top[49] dac_config_0 dac_config_1 row_off_detect_top[48] x1_net69
+ dac_config_2 vdda1 vssa1 vssc1 col_event_rst_top_left[28] x1_net70 row_on_detect_top[48]
+ row_off_detect_top[49] openDVS_pixel2x2_top
x1_x786 dac_config_3 dac_config_5 col_event_rst_top_left[27] dac_config_4
+ row_on_detect_top[49] dac_config_0 dac_config_1 row_off_detect_top[48] x1_net73
+ dac_config_2 vdda1 vssa1 vssc1 col_event_rst_top_left[26] x1_net74 row_on_detect_top[48]
+ row_off_detect_top[49] openDVS_pixel2x2_top
x1_x787 dac_config_3 dac_config_5 col_event_rst_top_left[25] dac_config_4
+ row_on_detect_top[49] dac_config_0 dac_config_1 row_off_detect_top[48] x1_net77
+ dac_config_2 vdda1 vssa1 vssc1 col_event_rst_top_left[24] x1_net78 row_on_detect_top[48]
+ row_off_detect_top[49] openDVS_pixel2x2_top
x1_x788 dac_config_3 dac_config_5 col_event_rst_top_left[23] dac_config_4
+ row_on_detect_top[49] dac_config_0 dac_config_1 row_off_detect_top[48] x1_net81
+ dac_config_2 vdda1 vssa1 vssc1 col_event_rst_top_left[22] x1_net82 row_on_detect_top[48]
+ row_off_detect_top[49] openDVS_pixel2x2_top
x1_x789 dac_config_3 dac_config_5 col_event_rst_top_left[21] dac_config_4
+ row_on_detect_top[49] dac_config_0 dac_config_1 row_off_detect_top[48] x1_net85
+ dac_config_2 vdda1 vssa1 vssc1 col_event_rst_top_left[20] x1_net86 row_on_detect_top[48]
+ row_off_detect_top[49] openDVS_pixel2x2_top
x1_x790 dac_config_3 dac_config_5 col_event_rst_top_left[19] dac_config_4
+ row_on_detect_top[49] dac_config_0 dac_config_1 row_off_detect_top[48] x1_net89
+ dac_config_2 vdda1 vssa1 vssc1 col_event_rst_top_left[18] x1_net90 row_on_detect_top[48]
+ row_off_detect_top[49] openDVS_pixel2x2_top
x1_x791 dac_config_3 dac_config_5 col_event_rst_top_left[17] dac_config_4
+ row_on_detect_top[49] dac_config_0 dac_config_1 row_off_detect_top[48] x1_net93
+ dac_config_2 vdda1 vssa1 vssc1 col_event_rst_top_left[16] x1_net94 row_on_detect_top[48]
+ row_off_detect_top[49] openDVS_pixel2x2_top
x1_x792 dac_config_3 dac_config_5 col_event_rst_top_left[15] dac_config_4
+ row_on_detect_top[49] dac_config_0 dac_config_1 row_off_detect_top[48] x1_net97
+ dac_config_2 vdda1 vssa1 vssc1 col_event_rst_top_left[14] x1_net98 row_on_detect_top[48]
+ row_off_detect_top[49] openDVS_pixel2x2_top
x1_x793 dac_config_3 dac_config_5 col_event_rst_top_left[13] dac_config_4
+ row_on_detect_top[49] dac_config_0 dac_config_1 row_off_detect_top[48] x1_net101
+ dac_config_2 vdda1 vssa1 vssc1 col_event_rst_top_left[12] x1_net102
+ row_on_detect_top[48] row_off_detect_top[49] openDVS_pixel2x2_top
x1_x794 dac_config_3 dac_config_5 col_event_rst_top_left[11] dac_config_4
+ row_on_detect_top[49] dac_config_0 dac_config_1 row_off_detect_top[48] x1_net105
+ dac_config_2 vdda1 vssa1 vssc1 col_event_rst_top_left[10] x1_net106
+ row_on_detect_top[48] row_off_detect_top[49] openDVS_pixel2x2_top
x1_x795 dac_config_3 dac_config_5 col_event_rst_top_left[9] dac_config_4
+ row_on_detect_top[49] dac_config_0 dac_config_1 row_off_detect_top[48] x1_net109
+ dac_config_2 vdda1 vssa1 vssc1 col_event_rst_top_left[8] x1_net110 row_on_detect_top[48]
+ row_off_detect_top[49] openDVS_pixel2x2_top
x1_x796 dac_config_3 dac_config_5 col_event_rst_top_left[7] dac_config_4
+ row_on_detect_top[49] dac_config_0 dac_config_1 row_off_detect_top[48] x1_net113
+ dac_config_2 vdda1 vssa1 vssc1 col_event_rst_top_left[6] x1_net114 row_on_detect_top[48]
+ row_off_detect_top[49] openDVS_pixel2x2_top
x1_x797 dac_config_3 dac_config_5 col_event_rst_top_left[5] dac_config_4
+ row_on_detect_top[49] dac_config_0 dac_config_1 row_off_detect_top[48] x1_net117
+ dac_config_2 vdda1 vssa1 vssc1 col_event_rst_top_left[4] x1_net118 row_on_detect_top[48]
+ row_off_detect_top[49] openDVS_pixel2x2_top
x1_x798 dac_config_3 dac_config_5 col_event_rst_top_left[3] dac_config_4
+ row_on_detect_top[49] dac_config_0 dac_config_1 row_off_detect_top[48] x1_net121
+ dac_config_2 vdda1 vssa1 vssc1 col_event_rst_top_left[2] x1_net122 row_on_detect_top[48]
+ row_off_detect_top[49] openDVS_pixel2x2_top
x1_x799 dac_config_3 dac_config_5 col_event_rst_top_left[1] dac_config_4
+ row_on_detect_top[49] dac_config_0 dac_config_1 row_off_detect_top[48] x1_net125
+ dac_config_2 vdda1 vssa1 vssc1 col_event_rst_top_left[0] x1_net126 row_on_detect_top[48]
+ row_off_detect_top[49] openDVS_pixel2x2_top
x1_x800 dac_config_3 dac_config_5 col_event_rst_top_left[63] dac_config_4
+ row_on_detect_top[51] dac_config_0 dac_config_1 row_off_detect_top[50] x1_net1
+ dac_config_2 vdda1 vssa1 vssc1 col_event_rst_top_left[62] x1_net2 row_on_detect_top[50]
+ row_off_detect_top[51] openDVS_pixel2x2_top
x1_x801 dac_config_3 dac_config_5 col_event_rst_top_left[61] dac_config_4
+ row_on_detect_top[51] dac_config_0 dac_config_1 row_off_detect_top[50] x1_net5
+ dac_config_2 vdda1 vssa1 vssc1 col_event_rst_top_left[60] x1_net6 row_on_detect_top[50]
+ row_off_detect_top[51] openDVS_pixel2x2_top
x1_x802 dac_config_3 dac_config_5 col_event_rst_top_left[59] dac_config_4
+ row_on_detect_top[51] dac_config_0 dac_config_1 row_off_detect_top[50] x1_net9
+ dac_config_2 vdda1 vssa1 vssc1 col_event_rst_top_left[58] x1_net10 row_on_detect_top[50]
+ row_off_detect_top[51] openDVS_pixel2x2_top
x1_x803 dac_config_3 dac_config_5 col_event_rst_top_left[57] dac_config_4
+ row_on_detect_top[51] dac_config_0 dac_config_1 row_off_detect_top[50] x1_net13
+ dac_config_2 vdda1 vssa1 vssc1 col_event_rst_top_left[56] x1_net14 row_on_detect_top[50]
+ row_off_detect_top[51] openDVS_pixel2x2_top
x1_x804 dac_config_3 dac_config_5 col_event_rst_top_left[55] dac_config_4
+ row_on_detect_top[51] dac_config_0 dac_config_1 row_off_detect_top[50] x1_net17
+ dac_config_2 vdda1 vssa1 vssc1 col_event_rst_top_left[54] x1_net18 row_on_detect_top[50]
+ row_off_detect_top[51] openDVS_pixel2x2_top
x1_x805 dac_config_3 dac_config_5 col_event_rst_top_left[53] dac_config_4
+ row_on_detect_top[51] dac_config_0 dac_config_1 row_off_detect_top[50] x1_net21
+ dac_config_2 vdda1 vssa1 vssc1 col_event_rst_top_left[52] x1_net22 row_on_detect_top[50]
+ row_off_detect_top[51] openDVS_pixel2x2_top
x1_x806 dac_config_3 dac_config_5 col_event_rst_top_left[51] dac_config_4
+ row_on_detect_top[51] dac_config_0 dac_config_1 row_off_detect_top[50] x1_net25
+ dac_config_2 vdda1 vssa1 vssc1 col_event_rst_top_left[50] x1_net26 row_on_detect_top[50]
+ row_off_detect_top[51] openDVS_pixel2x2_top
x1_x807 dac_config_3 dac_config_5 col_event_rst_top_left[49] dac_config_4
+ row_on_detect_top[51] dac_config_0 dac_config_1 row_off_detect_top[50] x1_net29
+ dac_config_2 vdda1 vssa1 vssc1 col_event_rst_top_left[48] x1_net30 row_on_detect_top[50]
+ row_off_detect_top[51] openDVS_pixel2x2_top
x1_x808 dac_config_3 dac_config_5 col_event_rst_top_left[47] dac_config_4
+ row_on_detect_top[51] dac_config_0 dac_config_1 row_off_detect_top[50] x1_net33
+ dac_config_2 vdda1 vssa1 vssc1 col_event_rst_top_left[46] x1_net34 row_on_detect_top[50]
+ row_off_detect_top[51] openDVS_pixel2x2_top
x1_x809 dac_config_3 dac_config_5 col_event_rst_top_left[45] dac_config_4
+ row_on_detect_top[51] dac_config_0 dac_config_1 row_off_detect_top[50] x1_net37
+ dac_config_2 vdda1 vssa1 vssc1 col_event_rst_top_left[44] x1_net38 row_on_detect_top[50]
+ row_off_detect_top[51] openDVS_pixel2x2_top
x1_x810 dac_config_3 dac_config_5 col_event_rst_top_left[43] dac_config_4
+ row_on_detect_top[51] dac_config_0 dac_config_1 row_off_detect_top[50] x1_net41
+ dac_config_2 vdda1 vssa1 vssc1 col_event_rst_top_left[42] x1_net42 row_on_detect_top[50]
+ row_off_detect_top[51] openDVS_pixel2x2_top
x1_x811 dac_config_3 dac_config_5 col_event_rst_top_left[41] dac_config_4
+ row_on_detect_top[51] dac_config_0 dac_config_1 row_off_detect_top[50] x1_net45
+ dac_config_2 vdda1 vssa1 vssc1 col_event_rst_top_left[40] x1_net46 row_on_detect_top[50]
+ row_off_detect_top[51] openDVS_pixel2x2_top
x1_x812 dac_config_3 dac_config_5 col_event_rst_top_left[39] dac_config_4
+ row_on_detect_top[51] dac_config_0 dac_config_1 row_off_detect_top[50] x1_net49
+ dac_config_2 vdda1 vssa1 vssc1 col_event_rst_top_left[38] x1_net50 row_on_detect_top[50]
+ row_off_detect_top[51] openDVS_pixel2x2_top
x1_x813 dac_config_3 dac_config_5 col_event_rst_top_left[37] dac_config_4
+ row_on_detect_top[51] dac_config_0 dac_config_1 row_off_detect_top[50] x1_net53
+ dac_config_2 vdda1 vssa1 vssc1 col_event_rst_top_left[36] x1_net54 row_on_detect_top[50]
+ row_off_detect_top[51] openDVS_pixel2x2_top
x1_x814 dac_config_3 dac_config_5 col_event_rst_top_left[35] dac_config_4
+ row_on_detect_top[51] dac_config_0 dac_config_1 row_off_detect_top[50] x1_net57
+ dac_config_2 vdda1 vssa1 vssc1 col_event_rst_top_left[34] x1_net58 row_on_detect_top[50]
+ row_off_detect_top[51] openDVS_pixel2x2_top
x1_x815 dac_config_3 dac_config_5 col_event_rst_top_left[33] dac_config_4
+ row_on_detect_top[51] dac_config_0 dac_config_1 row_off_detect_top[50] x1_net61
+ dac_config_2 vdda1 vssa1 vssc1 col_event_rst_top_left[32] x1_net62 row_on_detect_top[50]
+ row_off_detect_top[51] openDVS_pixel2x2_top
x1_x816 dac_config_3 dac_config_5 col_event_rst_top_left[31] dac_config_4
+ row_on_detect_top[51] dac_config_0 dac_config_1 row_off_detect_top[50] x1_net65
+ dac_config_2 vdda1 vssa1 vssc1 col_event_rst_top_left[30] x1_net66 row_on_detect_top[50]
+ row_off_detect_top[51] openDVS_pixel2x2_top
x1_x817 dac_config_3 dac_config_5 col_event_rst_top_left[29] dac_config_4
+ row_on_detect_top[51] dac_config_0 dac_config_1 row_off_detect_top[50] x1_net69
+ dac_config_2 vdda1 vssa1 vssc1 col_event_rst_top_left[28] x1_net70 row_on_detect_top[50]
+ row_off_detect_top[51] openDVS_pixel2x2_top
x1_x818 dac_config_3 dac_config_5 col_event_rst_top_left[27] dac_config_4
+ row_on_detect_top[51] dac_config_0 dac_config_1 row_off_detect_top[50] x1_net73
+ dac_config_2 vdda1 vssa1 vssc1 col_event_rst_top_left[26] x1_net74 row_on_detect_top[50]
+ row_off_detect_top[51] openDVS_pixel2x2_top
x1_x819 dac_config_3 dac_config_5 col_event_rst_top_left[25] dac_config_4
+ row_on_detect_top[51] dac_config_0 dac_config_1 row_off_detect_top[50] x1_net77
+ dac_config_2 vdda1 vssa1 vssc1 col_event_rst_top_left[24] x1_net78 row_on_detect_top[50]
+ row_off_detect_top[51] openDVS_pixel2x2_top
x1_x820 dac_config_3 dac_config_5 col_event_rst_top_left[23] dac_config_4
+ row_on_detect_top[51] dac_config_0 dac_config_1 row_off_detect_top[50] x1_net81
+ dac_config_2 vdda1 vssa1 vssc1 col_event_rst_top_left[22] x1_net82 row_on_detect_top[50]
+ row_off_detect_top[51] openDVS_pixel2x2_top
x1_x821 dac_config_3 dac_config_5 col_event_rst_top_left[21] dac_config_4
+ row_on_detect_top[51] dac_config_0 dac_config_1 row_off_detect_top[50] x1_net85
+ dac_config_2 vdda1 vssa1 vssc1 col_event_rst_top_left[20] x1_net86 row_on_detect_top[50]
+ row_off_detect_top[51] openDVS_pixel2x2_top
x1_x822 dac_config_3 dac_config_5 col_event_rst_top_left[19] dac_config_4
+ row_on_detect_top[51] dac_config_0 dac_config_1 row_off_detect_top[50] x1_net89
+ dac_config_2 vdda1 vssa1 vssc1 col_event_rst_top_left[18] x1_net90 row_on_detect_top[50]
+ row_off_detect_top[51] openDVS_pixel2x2_top
x1_x823 dac_config_3 dac_config_5 col_event_rst_top_left[17] dac_config_4
+ row_on_detect_top[51] dac_config_0 dac_config_1 row_off_detect_top[50] x1_net93
+ dac_config_2 vdda1 vssa1 vssc1 col_event_rst_top_left[16] x1_net94 row_on_detect_top[50]
+ row_off_detect_top[51] openDVS_pixel2x2_top
x1_x824 dac_config_3 dac_config_5 col_event_rst_top_left[15] dac_config_4
+ row_on_detect_top[51] dac_config_0 dac_config_1 row_off_detect_top[50] x1_net97
+ dac_config_2 vdda1 vssa1 vssc1 col_event_rst_top_left[14] x1_net98 row_on_detect_top[50]
+ row_off_detect_top[51] openDVS_pixel2x2_top
x1_x825 dac_config_3 dac_config_5 col_event_rst_top_left[13] dac_config_4
+ row_on_detect_top[51] dac_config_0 dac_config_1 row_off_detect_top[50] x1_net101
+ dac_config_2 vdda1 vssa1 vssc1 col_event_rst_top_left[12] x1_net102
+ row_on_detect_top[50] row_off_detect_top[51] openDVS_pixel2x2_top
x1_x826 dac_config_3 dac_config_5 col_event_rst_top_left[11] dac_config_4
+ row_on_detect_top[51] dac_config_0 dac_config_1 row_off_detect_top[50] x1_net105
+ dac_config_2 vdda1 vssa1 vssc1 col_event_rst_top_left[10] x1_net106
+ row_on_detect_top[50] row_off_detect_top[51] openDVS_pixel2x2_top
x1_x827 dac_config_3 dac_config_5 col_event_rst_top_left[9] dac_config_4
+ row_on_detect_top[51] dac_config_0 dac_config_1 row_off_detect_top[50] x1_net109
+ dac_config_2 vdda1 vssa1 vssc1 col_event_rst_top_left[8] x1_net110 row_on_detect_top[50]
+ row_off_detect_top[51] openDVS_pixel2x2_top
x1_x828 dac_config_3 dac_config_5 col_event_rst_top_left[7] dac_config_4
+ row_on_detect_top[51] dac_config_0 dac_config_1 row_off_detect_top[50] x1_net113
+ dac_config_2 vdda1 vssa1 vssc1 col_event_rst_top_left[6] x1_net114 row_on_detect_top[50]
+ row_off_detect_top[51] openDVS_pixel2x2_top
x1_x829 dac_config_3 dac_config_5 col_event_rst_top_left[5] dac_config_4
+ row_on_detect_top[51] dac_config_0 dac_config_1 row_off_detect_top[50] x1_net117
+ dac_config_2 vdda1 vssa1 vssc1 col_event_rst_top_left[4] x1_net118 row_on_detect_top[50]
+ row_off_detect_top[51] openDVS_pixel2x2_top
x1_x830 dac_config_3 dac_config_5 col_event_rst_top_left[3] dac_config_4
+ row_on_detect_top[51] dac_config_0 dac_config_1 row_off_detect_top[50] x1_net121
+ dac_config_2 vdda1 vssa1 vssc1 col_event_rst_top_left[2] x1_net122 row_on_detect_top[50]
+ row_off_detect_top[51] openDVS_pixel2x2_top
x1_x831 dac_config_3 dac_config_5 col_event_rst_top_left[1] dac_config_4
+ row_on_detect_top[51] dac_config_0 dac_config_1 row_off_detect_top[50] x1_net125
+ dac_config_2 vdda1 vssa1 vssc1 col_event_rst_top_left[0] x1_net126 row_on_detect_top[50]
+ row_off_detect_top[51] openDVS_pixel2x2_top
x1_x832 dac_config_3 dac_config_5 col_event_rst_top_left[63] dac_config_4
+ row_on_detect_top[53] dac_config_0 dac_config_1 row_off_detect_top[52] x1_net1
+ dac_config_2 vdda1 vssa1 vssc1 col_event_rst_top_left[62] x1_net2 row_on_detect_top[52]
+ row_off_detect_top[53] openDVS_pixel2x2_top
x1_x833 dac_config_3 dac_config_5 col_event_rst_top_left[61] dac_config_4
+ row_on_detect_top[53] dac_config_0 dac_config_1 row_off_detect_top[52] x1_net5
+ dac_config_2 vdda1 vssa1 vssc1 col_event_rst_top_left[60] x1_net6 row_on_detect_top[52]
+ row_off_detect_top[53] openDVS_pixel2x2_top
x1_x834 dac_config_3 dac_config_5 col_event_rst_top_left[59] dac_config_4
+ row_on_detect_top[53] dac_config_0 dac_config_1 row_off_detect_top[52] x1_net9
+ dac_config_2 vdda1 vssa1 vssc1 col_event_rst_top_left[58] x1_net10 row_on_detect_top[52]
+ row_off_detect_top[53] openDVS_pixel2x2_top
x1_x835 dac_config_3 dac_config_5 col_event_rst_top_left[57] dac_config_4
+ row_on_detect_top[53] dac_config_0 dac_config_1 row_off_detect_top[52] x1_net13
+ dac_config_2 vdda1 vssa1 vssc1 col_event_rst_top_left[56] x1_net14 row_on_detect_top[52]
+ row_off_detect_top[53] openDVS_pixel2x2_top
x1_x836 dac_config_3 dac_config_5 col_event_rst_top_left[55] dac_config_4
+ row_on_detect_top[53] dac_config_0 dac_config_1 row_off_detect_top[52] x1_net17
+ dac_config_2 vdda1 vssa1 vssc1 col_event_rst_top_left[54] x1_net18 row_on_detect_top[52]
+ row_off_detect_top[53] openDVS_pixel2x2_top
x1_x837 dac_config_3 dac_config_5 col_event_rst_top_left[53] dac_config_4
+ row_on_detect_top[53] dac_config_0 dac_config_1 row_off_detect_top[52] x1_net21
+ dac_config_2 vdda1 vssa1 vssc1 col_event_rst_top_left[52] x1_net22 row_on_detect_top[52]
+ row_off_detect_top[53] openDVS_pixel2x2_top
x1_x838 dac_config_3 dac_config_5 col_event_rst_top_left[51] dac_config_4
+ row_on_detect_top[53] dac_config_0 dac_config_1 row_off_detect_top[52] x1_net25
+ dac_config_2 vdda1 vssa1 vssc1 col_event_rst_top_left[50] x1_net26 row_on_detect_top[52]
+ row_off_detect_top[53] openDVS_pixel2x2_top
x1_x839 dac_config_3 dac_config_5 col_event_rst_top_left[49] dac_config_4
+ row_on_detect_top[53] dac_config_0 dac_config_1 row_off_detect_top[52] x1_net29
+ dac_config_2 vdda1 vssa1 vssc1 col_event_rst_top_left[48] x1_net30 row_on_detect_top[52]
+ row_off_detect_top[53] openDVS_pixel2x2_top
x1_x840 dac_config_3 dac_config_5 col_event_rst_top_left[47] dac_config_4
+ row_on_detect_top[53] dac_config_0 dac_config_1 row_off_detect_top[52] x1_net33
+ dac_config_2 vdda1 vssa1 vssc1 col_event_rst_top_left[46] x1_net34 row_on_detect_top[52]
+ row_off_detect_top[53] openDVS_pixel2x2_top
x1_x841 dac_config_3 dac_config_5 col_event_rst_top_left[45] dac_config_4
+ row_on_detect_top[53] dac_config_0 dac_config_1 row_off_detect_top[52] x1_net37
+ dac_config_2 vdda1 vssa1 vssc1 col_event_rst_top_left[44] x1_net38 row_on_detect_top[52]
+ row_off_detect_top[53] openDVS_pixel2x2_top
x1_x842 dac_config_3 dac_config_5 col_event_rst_top_left[43] dac_config_4
+ row_on_detect_top[53] dac_config_0 dac_config_1 row_off_detect_top[52] x1_net41
+ dac_config_2 vdda1 vssa1 vssc1 col_event_rst_top_left[42] x1_net42 row_on_detect_top[52]
+ row_off_detect_top[53] openDVS_pixel2x2_top
x1_x843 dac_config_3 dac_config_5 col_event_rst_top_left[41] dac_config_4
+ row_on_detect_top[53] dac_config_0 dac_config_1 row_off_detect_top[52] x1_net45
+ dac_config_2 vdda1 vssa1 vssc1 col_event_rst_top_left[40] x1_net46 row_on_detect_top[52]
+ row_off_detect_top[53] openDVS_pixel2x2_top
x1_x844 dac_config_3 dac_config_5 col_event_rst_top_left[39] dac_config_4
+ row_on_detect_top[53] dac_config_0 dac_config_1 row_off_detect_top[52] x1_net49
+ dac_config_2 vdda1 vssa1 vssc1 col_event_rst_top_left[38] x1_net50 row_on_detect_top[52]
+ row_off_detect_top[53] openDVS_pixel2x2_top
x1_x845 dac_config_3 dac_config_5 col_event_rst_top_left[37] dac_config_4
+ row_on_detect_top[53] dac_config_0 dac_config_1 row_off_detect_top[52] x1_net53
+ dac_config_2 vdda1 vssa1 vssc1 col_event_rst_top_left[36] x1_net54 row_on_detect_top[52]
+ row_off_detect_top[53] openDVS_pixel2x2_top
x1_x846 dac_config_3 dac_config_5 col_event_rst_top_left[35] dac_config_4
+ row_on_detect_top[53] dac_config_0 dac_config_1 row_off_detect_top[52] x1_net57
+ dac_config_2 vdda1 vssa1 vssc1 col_event_rst_top_left[34] x1_net58 row_on_detect_top[52]
+ row_off_detect_top[53] openDVS_pixel2x2_top
x1_x847 dac_config_3 dac_config_5 col_event_rst_top_left[33] dac_config_4
+ row_on_detect_top[53] dac_config_0 dac_config_1 row_off_detect_top[52] x1_net61
+ dac_config_2 vdda1 vssa1 vssc1 col_event_rst_top_left[32] x1_net62 row_on_detect_top[52]
+ row_off_detect_top[53] openDVS_pixel2x2_top
x1_x848 dac_config_3 dac_config_5 col_event_rst_top_left[31] dac_config_4
+ row_on_detect_top[53] dac_config_0 dac_config_1 row_off_detect_top[52] x1_net65
+ dac_config_2 vdda1 vssa1 vssc1 col_event_rst_top_left[30] x1_net66 row_on_detect_top[52]
+ row_off_detect_top[53] openDVS_pixel2x2_top
x1_x849 dac_config_3 dac_config_5 col_event_rst_top_left[29] dac_config_4
+ row_on_detect_top[53] dac_config_0 dac_config_1 row_off_detect_top[52] x1_net69
+ dac_config_2 vdda1 vssa1 vssc1 col_event_rst_top_left[28] x1_net70 row_on_detect_top[52]
+ row_off_detect_top[53] openDVS_pixel2x2_top
x1_x850 dac_config_3 dac_config_5 col_event_rst_top_left[27] dac_config_4
+ row_on_detect_top[53] dac_config_0 dac_config_1 row_off_detect_top[52] x1_net73
+ dac_config_2 vdda1 vssa1 vssc1 col_event_rst_top_left[26] x1_net74 row_on_detect_top[52]
+ row_off_detect_top[53] openDVS_pixel2x2_top
x1_x851 dac_config_3 dac_config_5 col_event_rst_top_left[25] dac_config_4
+ row_on_detect_top[53] dac_config_0 dac_config_1 row_off_detect_top[52] x1_net77
+ dac_config_2 vdda1 vssa1 vssc1 col_event_rst_top_left[24] x1_net78 row_on_detect_top[52]
+ row_off_detect_top[53] openDVS_pixel2x2_top
x1_x852 dac_config_3 dac_config_5 col_event_rst_top_left[23] dac_config_4
+ row_on_detect_top[53] dac_config_0 dac_config_1 row_off_detect_top[52] x1_net81
+ dac_config_2 vdda1 vssa1 vssc1 col_event_rst_top_left[22] x1_net82 row_on_detect_top[52]
+ row_off_detect_top[53] openDVS_pixel2x2_top
x1_x853 dac_config_3 dac_config_5 col_event_rst_top_left[21] dac_config_4
+ row_on_detect_top[53] dac_config_0 dac_config_1 row_off_detect_top[52] x1_net85
+ dac_config_2 vdda1 vssa1 vssc1 col_event_rst_top_left[20] x1_net86 row_on_detect_top[52]
+ row_off_detect_top[53] openDVS_pixel2x2_top
x1_x854 dac_config_3 dac_config_5 col_event_rst_top_left[19] dac_config_4
+ row_on_detect_top[53] dac_config_0 dac_config_1 row_off_detect_top[52] x1_net89
+ dac_config_2 vdda1 vssa1 vssc1 col_event_rst_top_left[18] x1_net90 row_on_detect_top[52]
+ row_off_detect_top[53] openDVS_pixel2x2_top
x1_x855 dac_config_3 dac_config_5 col_event_rst_top_left[17] dac_config_4
+ row_on_detect_top[53] dac_config_0 dac_config_1 row_off_detect_top[52] x1_net93
+ dac_config_2 vdda1 vssa1 vssc1 col_event_rst_top_left[16] x1_net94 row_on_detect_top[52]
+ row_off_detect_top[53] openDVS_pixel2x2_top
x1_x856 dac_config_3 dac_config_5 col_event_rst_top_left[15] dac_config_4
+ row_on_detect_top[53] dac_config_0 dac_config_1 row_off_detect_top[52] x1_net97
+ dac_config_2 vdda1 vssa1 vssc1 col_event_rst_top_left[14] x1_net98 row_on_detect_top[52]
+ row_off_detect_top[53] openDVS_pixel2x2_top
x1_x857 dac_config_3 dac_config_5 col_event_rst_top_left[13] dac_config_4
+ row_on_detect_top[53] dac_config_0 dac_config_1 row_off_detect_top[52] x1_net101
+ dac_config_2 vdda1 vssa1 vssc1 col_event_rst_top_left[12] x1_net102
+ row_on_detect_top[52] row_off_detect_top[53] openDVS_pixel2x2_top
x1_x858 dac_config_3 dac_config_5 col_event_rst_top_left[11] dac_config_4
+ row_on_detect_top[53] dac_config_0 dac_config_1 row_off_detect_top[52] x1_net105
+ dac_config_2 vdda1 vssa1 vssc1 col_event_rst_top_left[10] x1_net106
+ row_on_detect_top[52] row_off_detect_top[53] openDVS_pixel2x2_top
x1_x859 dac_config_3 dac_config_5 col_event_rst_top_left[9] dac_config_4
+ row_on_detect_top[53] dac_config_0 dac_config_1 row_off_detect_top[52] x1_net109
+ dac_config_2 vdda1 vssa1 vssc1 col_event_rst_top_left[8] x1_net110 row_on_detect_top[52]
+ row_off_detect_top[53] openDVS_pixel2x2_top
x1_x860 dac_config_3 dac_config_5 col_event_rst_top_left[7] dac_config_4
+ row_on_detect_top[53] dac_config_0 dac_config_1 row_off_detect_top[52] x1_net113
+ dac_config_2 vdda1 vssa1 vssc1 col_event_rst_top_left[6] x1_net114 row_on_detect_top[52]
+ row_off_detect_top[53] openDVS_pixel2x2_top
x1_x861 dac_config_3 dac_config_5 col_event_rst_top_left[5] dac_config_4
+ row_on_detect_top[53] dac_config_0 dac_config_1 row_off_detect_top[52] x1_net117
+ dac_config_2 vdda1 vssa1 vssc1 col_event_rst_top_left[4] x1_net118 row_on_detect_top[52]
+ row_off_detect_top[53] openDVS_pixel2x2_top
x1_x862 dac_config_3 dac_config_5 col_event_rst_top_left[3] dac_config_4
+ row_on_detect_top[53] dac_config_0 dac_config_1 row_off_detect_top[52] x1_net121
+ dac_config_2 vdda1 vssa1 vssc1 col_event_rst_top_left[2] x1_net122 row_on_detect_top[52]
+ row_off_detect_top[53] openDVS_pixel2x2_top
x1_x863 dac_config_3 dac_config_5 col_event_rst_top_left[1] dac_config_4
+ row_on_detect_top[53] dac_config_0 dac_config_1 row_off_detect_top[52] x1_net125
+ dac_config_2 vdda1 vssa1 vssc1 col_event_rst_top_left[0] x1_net126 row_on_detect_top[52]
+ row_off_detect_top[53] openDVS_pixel2x2_top
x1_x864 dac_config_3 dac_config_5 col_event_rst_top_left[63] dac_config_4
+ row_on_detect_top[55] dac_config_0 dac_config_1 row_off_detect_top[54] x1_net1
+ dac_config_2 vdda1 vssa1 vssc1 col_event_rst_top_left[62] x1_net2 row_on_detect_top[54]
+ row_off_detect_top[55] openDVS_pixel2x2_top
x1_x865 dac_config_3 dac_config_5 col_event_rst_top_left[61] dac_config_4
+ row_on_detect_top[55] dac_config_0 dac_config_1 row_off_detect_top[54] x1_net5
+ dac_config_2 vdda1 vssa1 vssc1 col_event_rst_top_left[60] x1_net6 row_on_detect_top[54]
+ row_off_detect_top[55] openDVS_pixel2x2_top
x1_x866 dac_config_3 dac_config_5 col_event_rst_top_left[59] dac_config_4
+ row_on_detect_top[55] dac_config_0 dac_config_1 row_off_detect_top[54] x1_net9
+ dac_config_2 vdda1 vssa1 vssc1 col_event_rst_top_left[58] x1_net10 row_on_detect_top[54]
+ row_off_detect_top[55] openDVS_pixel2x2_top
x1_x867 dac_config_3 dac_config_5 col_event_rst_top_left[57] dac_config_4
+ row_on_detect_top[55] dac_config_0 dac_config_1 row_off_detect_top[54] x1_net13
+ dac_config_2 vdda1 vssa1 vssc1 col_event_rst_top_left[56] x1_net14 row_on_detect_top[54]
+ row_off_detect_top[55] openDVS_pixel2x2_top
x1_x868 dac_config_3 dac_config_5 col_event_rst_top_left[55] dac_config_4
+ row_on_detect_top[55] dac_config_0 dac_config_1 row_off_detect_top[54] x1_net17
+ dac_config_2 vdda1 vssa1 vssc1 col_event_rst_top_left[54] x1_net18 row_on_detect_top[54]
+ row_off_detect_top[55] openDVS_pixel2x2_top
x1_x869 dac_config_3 dac_config_5 col_event_rst_top_left[53] dac_config_4
+ row_on_detect_top[55] dac_config_0 dac_config_1 row_off_detect_top[54] x1_net21
+ dac_config_2 vdda1 vssa1 vssc1 col_event_rst_top_left[52] x1_net22 row_on_detect_top[54]
+ row_off_detect_top[55] openDVS_pixel2x2_top
x1_x870 dac_config_3 dac_config_5 col_event_rst_top_left[51] dac_config_4
+ row_on_detect_top[55] dac_config_0 dac_config_1 row_off_detect_top[54] x1_net25
+ dac_config_2 vdda1 vssa1 vssc1 col_event_rst_top_left[50] x1_net26 row_on_detect_top[54]
+ row_off_detect_top[55] openDVS_pixel2x2_top
x1_x871 dac_config_3 dac_config_5 col_event_rst_top_left[49] dac_config_4
+ row_on_detect_top[55] dac_config_0 dac_config_1 row_off_detect_top[54] x1_net29
+ dac_config_2 vdda1 vssa1 vssc1 col_event_rst_top_left[48] x1_net30 row_on_detect_top[54]
+ row_off_detect_top[55] openDVS_pixel2x2_top
x1_x872 dac_config_3 dac_config_5 col_event_rst_top_left[47] dac_config_4
+ row_on_detect_top[55] dac_config_0 dac_config_1 row_off_detect_top[54] x1_net33
+ dac_config_2 vdda1 vssa1 vssc1 col_event_rst_top_left[46] x1_net34 row_on_detect_top[54]
+ row_off_detect_top[55] openDVS_pixel2x2_top
x1_x873 dac_config_3 dac_config_5 col_event_rst_top_left[45] dac_config_4
+ row_on_detect_top[55] dac_config_0 dac_config_1 row_off_detect_top[54] x1_net37
+ dac_config_2 vdda1 vssa1 vssc1 col_event_rst_top_left[44] x1_net38 row_on_detect_top[54]
+ row_off_detect_top[55] openDVS_pixel2x2_top
x1_x874 dac_config_3 dac_config_5 col_event_rst_top_left[43] dac_config_4
+ row_on_detect_top[55] dac_config_0 dac_config_1 row_off_detect_top[54] x1_net41
+ dac_config_2 vdda1 vssa1 vssc1 col_event_rst_top_left[42] x1_net42 row_on_detect_top[54]
+ row_off_detect_top[55] openDVS_pixel2x2_top
x1_x875 dac_config_3 dac_config_5 col_event_rst_top_left[41] dac_config_4
+ row_on_detect_top[55] dac_config_0 dac_config_1 row_off_detect_top[54] x1_net45
+ dac_config_2 vdda1 vssa1 vssc1 col_event_rst_top_left[40] x1_net46 row_on_detect_top[54]
+ row_off_detect_top[55] openDVS_pixel2x2_top
x1_x876 dac_config_3 dac_config_5 col_event_rst_top_left[39] dac_config_4
+ row_on_detect_top[55] dac_config_0 dac_config_1 row_off_detect_top[54] x1_net49
+ dac_config_2 vdda1 vssa1 vssc1 col_event_rst_top_left[38] x1_net50 row_on_detect_top[54]
+ row_off_detect_top[55] openDVS_pixel2x2_top
x1_x877 dac_config_3 dac_config_5 col_event_rst_top_left[37] dac_config_4
+ row_on_detect_top[55] dac_config_0 dac_config_1 row_off_detect_top[54] x1_net53
+ dac_config_2 vdda1 vssa1 vssc1 col_event_rst_top_left[36] x1_net54 row_on_detect_top[54]
+ row_off_detect_top[55] openDVS_pixel2x2_top
x1_x878 dac_config_3 dac_config_5 col_event_rst_top_left[35] dac_config_4
+ row_on_detect_top[55] dac_config_0 dac_config_1 row_off_detect_top[54] x1_net57
+ dac_config_2 vdda1 vssa1 vssc1 col_event_rst_top_left[34] x1_net58 row_on_detect_top[54]
+ row_off_detect_top[55] openDVS_pixel2x2_top
x1_x879 dac_config_3 dac_config_5 col_event_rst_top_left[33] dac_config_4
+ row_on_detect_top[55] dac_config_0 dac_config_1 row_off_detect_top[54] x1_net61
+ dac_config_2 vdda1 vssa1 vssc1 col_event_rst_top_left[32] x1_net62 row_on_detect_top[54]
+ row_off_detect_top[55] openDVS_pixel2x2_top
x1_x880 dac_config_3 dac_config_5 col_event_rst_top_left[31] dac_config_4
+ row_on_detect_top[55] dac_config_0 dac_config_1 row_off_detect_top[54] x1_net65
+ dac_config_2 vdda1 vssa1 vssc1 col_event_rst_top_left[30] x1_net66 row_on_detect_top[54]
+ row_off_detect_top[55] openDVS_pixel2x2_top
x1_x881 dac_config_3 dac_config_5 col_event_rst_top_left[29] dac_config_4
+ row_on_detect_top[55] dac_config_0 dac_config_1 row_off_detect_top[54] x1_net69
+ dac_config_2 vdda1 vssa1 vssc1 col_event_rst_top_left[28] x1_net70 row_on_detect_top[54]
+ row_off_detect_top[55] openDVS_pixel2x2_top
x1_x882 dac_config_3 dac_config_5 col_event_rst_top_left[27] dac_config_4
+ row_on_detect_top[55] dac_config_0 dac_config_1 row_off_detect_top[54] x1_net73
+ dac_config_2 vdda1 vssa1 vssc1 col_event_rst_top_left[26] x1_net74 row_on_detect_top[54]
+ row_off_detect_top[55] openDVS_pixel2x2_top
x1_x883 dac_config_3 dac_config_5 col_event_rst_top_left[25] dac_config_4
+ row_on_detect_top[55] dac_config_0 dac_config_1 row_off_detect_top[54] x1_net77
+ dac_config_2 vdda1 vssa1 vssc1 col_event_rst_top_left[24] x1_net78 row_on_detect_top[54]
+ row_off_detect_top[55] openDVS_pixel2x2_top
x1_x884 dac_config_3 dac_config_5 col_event_rst_top_left[23] dac_config_4
+ row_on_detect_top[55] dac_config_0 dac_config_1 row_off_detect_top[54] x1_net81
+ dac_config_2 vdda1 vssa1 vssc1 col_event_rst_top_left[22] x1_net82 row_on_detect_top[54]
+ row_off_detect_top[55] openDVS_pixel2x2_top
x1_x885 dac_config_3 dac_config_5 col_event_rst_top_left[21] dac_config_4
+ row_on_detect_top[55] dac_config_0 dac_config_1 row_off_detect_top[54] x1_net85
+ dac_config_2 vdda1 vssa1 vssc1 col_event_rst_top_left[20] x1_net86 row_on_detect_top[54]
+ row_off_detect_top[55] openDVS_pixel2x2_top
x1_x886 dac_config_3 dac_config_5 col_event_rst_top_left[19] dac_config_4
+ row_on_detect_top[55] dac_config_0 dac_config_1 row_off_detect_top[54] x1_net89
+ dac_config_2 vdda1 vssa1 vssc1 col_event_rst_top_left[18] x1_net90 row_on_detect_top[54]
+ row_off_detect_top[55] openDVS_pixel2x2_top
x1_x887 dac_config_3 dac_config_5 col_event_rst_top_left[17] dac_config_4
+ row_on_detect_top[55] dac_config_0 dac_config_1 row_off_detect_top[54] x1_net93
+ dac_config_2 vdda1 vssa1 vssc1 col_event_rst_top_left[16] x1_net94 row_on_detect_top[54]
+ row_off_detect_top[55] openDVS_pixel2x2_top
x1_x888 dac_config_3 dac_config_5 col_event_rst_top_left[15] dac_config_4
+ row_on_detect_top[55] dac_config_0 dac_config_1 row_off_detect_top[54] x1_net97
+ dac_config_2 vdda1 vssa1 vssc1 col_event_rst_top_left[14] x1_net98 row_on_detect_top[54]
+ row_off_detect_top[55] openDVS_pixel2x2_top
x1_x889 dac_config_3 dac_config_5 col_event_rst_top_left[13] dac_config_4
+ row_on_detect_top[55] dac_config_0 dac_config_1 row_off_detect_top[54] x1_net101
+ dac_config_2 vdda1 vssa1 vssc1 col_event_rst_top_left[12] x1_net102
+ row_on_detect_top[54] row_off_detect_top[55] openDVS_pixel2x2_top
x1_x890 dac_config_3 dac_config_5 col_event_rst_top_left[11] dac_config_4
+ row_on_detect_top[55] dac_config_0 dac_config_1 row_off_detect_top[54] x1_net105
+ dac_config_2 vdda1 vssa1 vssc1 col_event_rst_top_left[10] x1_net106
+ row_on_detect_top[54] row_off_detect_top[55] openDVS_pixel2x2_top
x1_x891 dac_config_3 dac_config_5 col_event_rst_top_left[9] dac_config_4
+ row_on_detect_top[55] dac_config_0 dac_config_1 row_off_detect_top[54] x1_net109
+ dac_config_2 vdda1 vssa1 vssc1 col_event_rst_top_left[8] x1_net110 row_on_detect_top[54]
+ row_off_detect_top[55] openDVS_pixel2x2_top
x1_x892 dac_config_3 dac_config_5 col_event_rst_top_left[7] dac_config_4
+ row_on_detect_top[55] dac_config_0 dac_config_1 row_off_detect_top[54] x1_net113
+ dac_config_2 vdda1 vssa1 vssc1 col_event_rst_top_left[6] x1_net114 row_on_detect_top[54]
+ row_off_detect_top[55] openDVS_pixel2x2_top
x1_x893 dac_config_3 dac_config_5 col_event_rst_top_left[5] dac_config_4
+ row_on_detect_top[55] dac_config_0 dac_config_1 row_off_detect_top[54] x1_net117
+ dac_config_2 vdda1 vssa1 vssc1 col_event_rst_top_left[4] x1_net118 row_on_detect_top[54]
+ row_off_detect_top[55] openDVS_pixel2x2_top
x1_x894 dac_config_3 dac_config_5 col_event_rst_top_left[3] dac_config_4
+ row_on_detect_top[55] dac_config_0 dac_config_1 row_off_detect_top[54] x1_net121
+ dac_config_2 vdda1 vssa1 vssc1 col_event_rst_top_left[2] x1_net122 row_on_detect_top[54]
+ row_off_detect_top[55] openDVS_pixel2x2_top
x1_x895 dac_config_3 dac_config_5 col_event_rst_top_left[1] dac_config_4
+ row_on_detect_top[55] dac_config_0 dac_config_1 row_off_detect_top[54] x1_net125
+ dac_config_2 vdda1 vssa1 vssc1 col_event_rst_top_left[0] x1_net126 row_on_detect_top[54]
+ row_off_detect_top[55] openDVS_pixel2x2_top
x1_x896 dac_config_3 dac_config_5 col_event_rst_top_left[63] dac_config_4
+ row_on_detect_top[57] dac_config_0 dac_config_1 row_off_detect_top[56] x1_net1
+ dac_config_2 vdda1 vssa1 vssc1 col_event_rst_top_left[62] x1_net2 row_on_detect_top[56]
+ row_off_detect_top[57] openDVS_pixel2x2_top
x1_x897 dac_config_3 dac_config_5 col_event_rst_top_left[61] dac_config_4
+ row_on_detect_top[57] dac_config_0 dac_config_1 row_off_detect_top[56] x1_net5
+ dac_config_2 vdda1 vssa1 vssc1 col_event_rst_top_left[60] x1_net6 row_on_detect_top[56]
+ row_off_detect_top[57] openDVS_pixel2x2_top
x1_x898 dac_config_3 dac_config_5 col_event_rst_top_left[59] dac_config_4
+ row_on_detect_top[57] dac_config_0 dac_config_1 row_off_detect_top[56] x1_net9
+ dac_config_2 vdda1 vssa1 vssc1 col_event_rst_top_left[58] x1_net10 row_on_detect_top[56]
+ row_off_detect_top[57] openDVS_pixel2x2_top
x1_x899 dac_config_3 dac_config_5 col_event_rst_top_left[57] dac_config_4
+ row_on_detect_top[57] dac_config_0 dac_config_1 row_off_detect_top[56] x1_net13
+ dac_config_2 vdda1 vssa1 vssc1 col_event_rst_top_left[56] x1_net14 row_on_detect_top[56]
+ row_off_detect_top[57] openDVS_pixel2x2_top
x1_x900 dac_config_3 dac_config_5 col_event_rst_top_left[55] dac_config_4
+ row_on_detect_top[57] dac_config_0 dac_config_1 row_off_detect_top[56] x1_net17
+ dac_config_2 vdda1 vssa1 vssc1 col_event_rst_top_left[54] x1_net18 row_on_detect_top[56]
+ row_off_detect_top[57] openDVS_pixel2x2_top
x1_x901 dac_config_3 dac_config_5 col_event_rst_top_left[53] dac_config_4
+ row_on_detect_top[57] dac_config_0 dac_config_1 row_off_detect_top[56] x1_net21
+ dac_config_2 vdda1 vssa1 vssc1 col_event_rst_top_left[52] x1_net22 row_on_detect_top[56]
+ row_off_detect_top[57] openDVS_pixel2x2_top
x1_x902 dac_config_3 dac_config_5 col_event_rst_top_left[51] dac_config_4
+ row_on_detect_top[57] dac_config_0 dac_config_1 row_off_detect_top[56] x1_net25
+ dac_config_2 vdda1 vssa1 vssc1 col_event_rst_top_left[50] x1_net26 row_on_detect_top[56]
+ row_off_detect_top[57] openDVS_pixel2x2_top
x1_x903 dac_config_3 dac_config_5 col_event_rst_top_left[49] dac_config_4
+ row_on_detect_top[57] dac_config_0 dac_config_1 row_off_detect_top[56] x1_net29
+ dac_config_2 vdda1 vssa1 vssc1 col_event_rst_top_left[48] x1_net30 row_on_detect_top[56]
+ row_off_detect_top[57] openDVS_pixel2x2_top
x1_x904 dac_config_3 dac_config_5 col_event_rst_top_left[47] dac_config_4
+ row_on_detect_top[57] dac_config_0 dac_config_1 row_off_detect_top[56] x1_net33
+ dac_config_2 vdda1 vssa1 vssc1 col_event_rst_top_left[46] x1_net34 row_on_detect_top[56]
+ row_off_detect_top[57] openDVS_pixel2x2_top
x1_x905 dac_config_3 dac_config_5 col_event_rst_top_left[45] dac_config_4
+ row_on_detect_top[57] dac_config_0 dac_config_1 row_off_detect_top[56] x1_net37
+ dac_config_2 vdda1 vssa1 vssc1 col_event_rst_top_left[44] x1_net38 row_on_detect_top[56]
+ row_off_detect_top[57] openDVS_pixel2x2_top
x1_x906 dac_config_3 dac_config_5 col_event_rst_top_left[43] dac_config_4
+ row_on_detect_top[57] dac_config_0 dac_config_1 row_off_detect_top[56] x1_net41
+ dac_config_2 vdda1 vssa1 vssc1 col_event_rst_top_left[42] x1_net42 row_on_detect_top[56]
+ row_off_detect_top[57] openDVS_pixel2x2_top
x1_x907 dac_config_3 dac_config_5 col_event_rst_top_left[41] dac_config_4
+ row_on_detect_top[57] dac_config_0 dac_config_1 row_off_detect_top[56] x1_net45
+ dac_config_2 vdda1 vssa1 vssc1 col_event_rst_top_left[40] x1_net46 row_on_detect_top[56]
+ row_off_detect_top[57] openDVS_pixel2x2_top
x1_x908 dac_config_3 dac_config_5 col_event_rst_top_left[39] dac_config_4
+ row_on_detect_top[57] dac_config_0 dac_config_1 row_off_detect_top[56] x1_net49
+ dac_config_2 vdda1 vssa1 vssc1 col_event_rst_top_left[38] x1_net50 row_on_detect_top[56]
+ row_off_detect_top[57] openDVS_pixel2x2_top
x1_x909 dac_config_3 dac_config_5 col_event_rst_top_left[37] dac_config_4
+ row_on_detect_top[57] dac_config_0 dac_config_1 row_off_detect_top[56] x1_net53
+ dac_config_2 vdda1 vssa1 vssc1 col_event_rst_top_left[36] x1_net54 row_on_detect_top[56]
+ row_off_detect_top[57] openDVS_pixel2x2_top
x1_x910 dac_config_3 dac_config_5 col_event_rst_top_left[35] dac_config_4
+ row_on_detect_top[57] dac_config_0 dac_config_1 row_off_detect_top[56] x1_net57
+ dac_config_2 vdda1 vssa1 vssc1 col_event_rst_top_left[34] x1_net58 row_on_detect_top[56]
+ row_off_detect_top[57] openDVS_pixel2x2_top
x1_x911 dac_config_3 dac_config_5 col_event_rst_top_left[33] dac_config_4
+ row_on_detect_top[57] dac_config_0 dac_config_1 row_off_detect_top[56] x1_net61
+ dac_config_2 vdda1 vssa1 vssc1 col_event_rst_top_left[32] x1_net62 row_on_detect_top[56]
+ row_off_detect_top[57] openDVS_pixel2x2_top
x1_x912 dac_config_3 dac_config_5 col_event_rst_top_left[31] dac_config_4
+ row_on_detect_top[57] dac_config_0 dac_config_1 row_off_detect_top[56] x1_net65
+ dac_config_2 vdda1 vssa1 vssc1 col_event_rst_top_left[30] x1_net66 row_on_detect_top[56]
+ row_off_detect_top[57] openDVS_pixel2x2_top
x1_x913 dac_config_3 dac_config_5 col_event_rst_top_left[29] dac_config_4
+ row_on_detect_top[57] dac_config_0 dac_config_1 row_off_detect_top[56] x1_net69
+ dac_config_2 vdda1 vssa1 vssc1 col_event_rst_top_left[28] x1_net70 row_on_detect_top[56]
+ row_off_detect_top[57] openDVS_pixel2x2_top
x1_x914 dac_config_3 dac_config_5 col_event_rst_top_left[27] dac_config_4
+ row_on_detect_top[57] dac_config_0 dac_config_1 row_off_detect_top[56] x1_net73
+ dac_config_2 vdda1 vssa1 vssc1 col_event_rst_top_left[26] x1_net74 row_on_detect_top[56]
+ row_off_detect_top[57] openDVS_pixel2x2_top
x1_x915 dac_config_3 dac_config_5 col_event_rst_top_left[25] dac_config_4
+ row_on_detect_top[57] dac_config_0 dac_config_1 row_off_detect_top[56] x1_net77
+ dac_config_2 vdda1 vssa1 vssc1 col_event_rst_top_left[24] x1_net78 row_on_detect_top[56]
+ row_off_detect_top[57] openDVS_pixel2x2_top
x1_x916 dac_config_3 dac_config_5 col_event_rst_top_left[23] dac_config_4
+ row_on_detect_top[57] dac_config_0 dac_config_1 row_off_detect_top[56] x1_net81
+ dac_config_2 vdda1 vssa1 vssc1 col_event_rst_top_left[22] x1_net82 row_on_detect_top[56]
+ row_off_detect_top[57] openDVS_pixel2x2_top
x1_x917 dac_config_3 dac_config_5 col_event_rst_top_left[21] dac_config_4
+ row_on_detect_top[57] dac_config_0 dac_config_1 row_off_detect_top[56] x1_net85
+ dac_config_2 vdda1 vssa1 vssc1 col_event_rst_top_left[20] x1_net86 row_on_detect_top[56]
+ row_off_detect_top[57] openDVS_pixel2x2_top
x1_x918 dac_config_3 dac_config_5 col_event_rst_top_left[19] dac_config_4
+ row_on_detect_top[57] dac_config_0 dac_config_1 row_off_detect_top[56] x1_net89
+ dac_config_2 vdda1 vssa1 vssc1 col_event_rst_top_left[18] x1_net90 row_on_detect_top[56]
+ row_off_detect_top[57] openDVS_pixel2x2_top
x1_x919 dac_config_3 dac_config_5 col_event_rst_top_left[17] dac_config_4
+ row_on_detect_top[57] dac_config_0 dac_config_1 row_off_detect_top[56] x1_net93
+ dac_config_2 vdda1 vssa1 vssc1 col_event_rst_top_left[16] x1_net94 row_on_detect_top[56]
+ row_off_detect_top[57] openDVS_pixel2x2_top
x1_x920 dac_config_3 dac_config_5 col_event_rst_top_left[15] dac_config_4
+ row_on_detect_top[57] dac_config_0 dac_config_1 row_off_detect_top[56] x1_net97
+ dac_config_2 vdda1 vssa1 vssc1 col_event_rst_top_left[14] x1_net98 row_on_detect_top[56]
+ row_off_detect_top[57] openDVS_pixel2x2_top
x1_x921 dac_config_3 dac_config_5 col_event_rst_top_left[13] dac_config_4
+ row_on_detect_top[57] dac_config_0 dac_config_1 row_off_detect_top[56] x1_net101
+ dac_config_2 vdda1 vssa1 vssc1 col_event_rst_top_left[12] x1_net102
+ row_on_detect_top[56] row_off_detect_top[57] openDVS_pixel2x2_top
x1_x922 dac_config_3 dac_config_5 col_event_rst_top_left[11] dac_config_4
+ row_on_detect_top[57] dac_config_0 dac_config_1 row_off_detect_top[56] x1_net105
+ dac_config_2 vdda1 vssa1 vssc1 col_event_rst_top_left[10] x1_net106
+ row_on_detect_top[56] row_off_detect_top[57] openDVS_pixel2x2_top
x1_x923 dac_config_3 dac_config_5 col_event_rst_top_left[9] dac_config_4
+ row_on_detect_top[57] dac_config_0 dac_config_1 row_off_detect_top[56] x1_net109
+ dac_config_2 vdda1 vssa1 vssc1 col_event_rst_top_left[8] x1_net110 row_on_detect_top[56]
+ row_off_detect_top[57] openDVS_pixel2x2_top
x1_x924 dac_config_3 dac_config_5 col_event_rst_top_left[7] dac_config_4
+ row_on_detect_top[57] dac_config_0 dac_config_1 row_off_detect_top[56] x1_net113
+ dac_config_2 vdda1 vssa1 vssc1 col_event_rst_top_left[6] x1_net114 row_on_detect_top[56]
+ row_off_detect_top[57] openDVS_pixel2x2_top
x1_x925 dac_config_3 dac_config_5 col_event_rst_top_left[5] dac_config_4
+ row_on_detect_top[57] dac_config_0 dac_config_1 row_off_detect_top[56] x1_net117
+ dac_config_2 vdda1 vssa1 vssc1 col_event_rst_top_left[4] x1_net118 row_on_detect_top[56]
+ row_off_detect_top[57] openDVS_pixel2x2_top
x1_x926 dac_config_3 dac_config_5 col_event_rst_top_left[3] dac_config_4
+ row_on_detect_top[57] dac_config_0 dac_config_1 row_off_detect_top[56] x1_net121
+ dac_config_2 vdda1 vssa1 vssc1 col_event_rst_top_left[2] x1_net122 row_on_detect_top[56]
+ row_off_detect_top[57] openDVS_pixel2x2_top
x1_x927 dac_config_3 dac_config_5 col_event_rst_top_left[1] dac_config_4
+ row_on_detect_top[57] dac_config_0 dac_config_1 row_off_detect_top[56] x1_net125
+ dac_config_2 vdda1 vssa1 vssc1 col_event_rst_top_left[0] x1_net126 row_on_detect_top[56]
+ row_off_detect_top[57] openDVS_pixel2x2_top
x1_x928 dac_config_3 dac_config_5 col_event_rst_top_left[63] dac_config_4
+ row_on_detect_top[59] dac_config_0 dac_config_1 row_off_detect_top[58] x1_net1
+ dac_config_2 vdda1 vssa1 vssc1 col_event_rst_top_left[62] x1_net2 row_on_detect_top[58]
+ row_off_detect_top[59] openDVS_pixel2x2_top
x1_x929 dac_config_3 dac_config_5 col_event_rst_top_left[61] dac_config_4
+ row_on_detect_top[59] dac_config_0 dac_config_1 row_off_detect_top[58] x1_net5
+ dac_config_2 vdda1 vssa1 vssc1 col_event_rst_top_left[60] x1_net6 row_on_detect_top[58]
+ row_off_detect_top[59] openDVS_pixel2x2_top
x1_x930 dac_config_3 dac_config_5 col_event_rst_top_left[59] dac_config_4
+ row_on_detect_top[59] dac_config_0 dac_config_1 row_off_detect_top[58] x1_net9
+ dac_config_2 vdda1 vssa1 vssc1 col_event_rst_top_left[58] x1_net10 row_on_detect_top[58]
+ row_off_detect_top[59] openDVS_pixel2x2_top
x1_x931 dac_config_3 dac_config_5 col_event_rst_top_left[57] dac_config_4
+ row_on_detect_top[59] dac_config_0 dac_config_1 row_off_detect_top[58] x1_net13
+ dac_config_2 vdda1 vssa1 vssc1 col_event_rst_top_left[56] x1_net14 row_on_detect_top[58]
+ row_off_detect_top[59] openDVS_pixel2x2_top
x1_x932 dac_config_3 dac_config_5 col_event_rst_top_left[55] dac_config_4
+ row_on_detect_top[59] dac_config_0 dac_config_1 row_off_detect_top[58] x1_net17
+ dac_config_2 vdda1 vssa1 vssc1 col_event_rst_top_left[54] x1_net18 row_on_detect_top[58]
+ row_off_detect_top[59] openDVS_pixel2x2_top
x1_x933 dac_config_3 dac_config_5 col_event_rst_top_left[53] dac_config_4
+ row_on_detect_top[59] dac_config_0 dac_config_1 row_off_detect_top[58] x1_net21
+ dac_config_2 vdda1 vssa1 vssc1 col_event_rst_top_left[52] x1_net22 row_on_detect_top[58]
+ row_off_detect_top[59] openDVS_pixel2x2_top
x1_x934 dac_config_3 dac_config_5 col_event_rst_top_left[51] dac_config_4
+ row_on_detect_top[59] dac_config_0 dac_config_1 row_off_detect_top[58] x1_net25
+ dac_config_2 vdda1 vssa1 vssc1 col_event_rst_top_left[50] x1_net26 row_on_detect_top[58]
+ row_off_detect_top[59] openDVS_pixel2x2_top
x1_x935 dac_config_3 dac_config_5 col_event_rst_top_left[49] dac_config_4
+ row_on_detect_top[59] dac_config_0 dac_config_1 row_off_detect_top[58] x1_net29
+ dac_config_2 vdda1 vssa1 vssc1 col_event_rst_top_left[48] x1_net30 row_on_detect_top[58]
+ row_off_detect_top[59] openDVS_pixel2x2_top
x1_x936 dac_config_3 dac_config_5 col_event_rst_top_left[47] dac_config_4
+ row_on_detect_top[59] dac_config_0 dac_config_1 row_off_detect_top[58] x1_net33
+ dac_config_2 vdda1 vssa1 vssc1 col_event_rst_top_left[46] x1_net34 row_on_detect_top[58]
+ row_off_detect_top[59] openDVS_pixel2x2_top
x1_x937 dac_config_3 dac_config_5 col_event_rst_top_left[45] dac_config_4
+ row_on_detect_top[59] dac_config_0 dac_config_1 row_off_detect_top[58] x1_net37
+ dac_config_2 vdda1 vssa1 vssc1 col_event_rst_top_left[44] x1_net38 row_on_detect_top[58]
+ row_off_detect_top[59] openDVS_pixel2x2_top
x1_x938 dac_config_3 dac_config_5 col_event_rst_top_left[43] dac_config_4
+ row_on_detect_top[59] dac_config_0 dac_config_1 row_off_detect_top[58] x1_net41
+ dac_config_2 vdda1 vssa1 vssc1 col_event_rst_top_left[42] x1_net42 row_on_detect_top[58]
+ row_off_detect_top[59] openDVS_pixel2x2_top
x1_x939 dac_config_3 dac_config_5 col_event_rst_top_left[41] dac_config_4
+ row_on_detect_top[59] dac_config_0 dac_config_1 row_off_detect_top[58] x1_net45
+ dac_config_2 vdda1 vssa1 vssc1 col_event_rst_top_left[40] x1_net46 row_on_detect_top[58]
+ row_off_detect_top[59] openDVS_pixel2x2_top
x1_x940 dac_config_3 dac_config_5 col_event_rst_top_left[39] dac_config_4
+ row_on_detect_top[59] dac_config_0 dac_config_1 row_off_detect_top[58] x1_net49
+ dac_config_2 vdda1 vssa1 vssc1 col_event_rst_top_left[38] x1_net50 row_on_detect_top[58]
+ row_off_detect_top[59] openDVS_pixel2x2_top
x1_x941 dac_config_3 dac_config_5 col_event_rst_top_left[37] dac_config_4
+ row_on_detect_top[59] dac_config_0 dac_config_1 row_off_detect_top[58] x1_net53
+ dac_config_2 vdda1 vssa1 vssc1 col_event_rst_top_left[36] x1_net54 row_on_detect_top[58]
+ row_off_detect_top[59] openDVS_pixel2x2_top
x1_x942 dac_config_3 dac_config_5 col_event_rst_top_left[35] dac_config_4
+ row_on_detect_top[59] dac_config_0 dac_config_1 row_off_detect_top[58] x1_net57
+ dac_config_2 vdda1 vssa1 vssc1 col_event_rst_top_left[34] x1_net58 row_on_detect_top[58]
+ row_off_detect_top[59] openDVS_pixel2x2_top
x1_x943 dac_config_3 dac_config_5 col_event_rst_top_left[33] dac_config_4
+ row_on_detect_top[59] dac_config_0 dac_config_1 row_off_detect_top[58] x1_net61
+ dac_config_2 vdda1 vssa1 vssc1 col_event_rst_top_left[32] x1_net62 row_on_detect_top[58]
+ row_off_detect_top[59] openDVS_pixel2x2_top
x1_x944 dac_config_3 dac_config_5 col_event_rst_top_left[31] dac_config_4
+ row_on_detect_top[59] dac_config_0 dac_config_1 row_off_detect_top[58] x1_net65
+ dac_config_2 vdda1 vssa1 vssc1 col_event_rst_top_left[30] x1_net66 row_on_detect_top[58]
+ row_off_detect_top[59] openDVS_pixel2x2_top
x1_x945 dac_config_3 dac_config_5 col_event_rst_top_left[29] dac_config_4
+ row_on_detect_top[59] dac_config_0 dac_config_1 row_off_detect_top[58] x1_net69
+ dac_config_2 vdda1 vssa1 vssc1 col_event_rst_top_left[28] x1_net70 row_on_detect_top[58]
+ row_off_detect_top[59] openDVS_pixel2x2_top
x1_x946 dac_config_3 dac_config_5 col_event_rst_top_left[27] dac_config_4
+ row_on_detect_top[59] dac_config_0 dac_config_1 row_off_detect_top[58] x1_net73
+ dac_config_2 vdda1 vssa1 vssc1 col_event_rst_top_left[26] x1_net74 row_on_detect_top[58]
+ row_off_detect_top[59] openDVS_pixel2x2_top
x1_x947 dac_config_3 dac_config_5 col_event_rst_top_left[25] dac_config_4
+ row_on_detect_top[59] dac_config_0 dac_config_1 row_off_detect_top[58] x1_net77
+ dac_config_2 vdda1 vssa1 vssc1 col_event_rst_top_left[24] x1_net78 row_on_detect_top[58]
+ row_off_detect_top[59] openDVS_pixel2x2_top
x1_x948 dac_config_3 dac_config_5 col_event_rst_top_left[23] dac_config_4
+ row_on_detect_top[59] dac_config_0 dac_config_1 row_off_detect_top[58] x1_net81
+ dac_config_2 vdda1 vssa1 vssc1 col_event_rst_top_left[22] x1_net82 row_on_detect_top[58]
+ row_off_detect_top[59] openDVS_pixel2x2_top
x1_x949 dac_config_3 dac_config_5 col_event_rst_top_left[21] dac_config_4
+ row_on_detect_top[59] dac_config_0 dac_config_1 row_off_detect_top[58] x1_net85
+ dac_config_2 vdda1 vssa1 vssc1 col_event_rst_top_left[20] x1_net86 row_on_detect_top[58]
+ row_off_detect_top[59] openDVS_pixel2x2_top
x1_x950 dac_config_3 dac_config_5 col_event_rst_top_left[19] dac_config_4
+ row_on_detect_top[59] dac_config_0 dac_config_1 row_off_detect_top[58] x1_net89
+ dac_config_2 vdda1 vssa1 vssc1 col_event_rst_top_left[18] x1_net90 row_on_detect_top[58]
+ row_off_detect_top[59] openDVS_pixel2x2_top
x1_x951 dac_config_3 dac_config_5 col_event_rst_top_left[17] dac_config_4
+ row_on_detect_top[59] dac_config_0 dac_config_1 row_off_detect_top[58] x1_net93
+ dac_config_2 vdda1 vssa1 vssc1 col_event_rst_top_left[16] x1_net94 row_on_detect_top[58]
+ row_off_detect_top[59] openDVS_pixel2x2_top
x1_x952 dac_config_3 dac_config_5 col_event_rst_top_left[15] dac_config_4
+ row_on_detect_top[59] dac_config_0 dac_config_1 row_off_detect_top[58] x1_net97
+ dac_config_2 vdda1 vssa1 vssc1 col_event_rst_top_left[14] x1_net98 row_on_detect_top[58]
+ row_off_detect_top[59] openDVS_pixel2x2_top
x1_x953 dac_config_3 dac_config_5 col_event_rst_top_left[13] dac_config_4
+ row_on_detect_top[59] dac_config_0 dac_config_1 row_off_detect_top[58] x1_net101
+ dac_config_2 vdda1 vssa1 vssc1 col_event_rst_top_left[12] x1_net102
+ row_on_detect_top[58] row_off_detect_top[59] openDVS_pixel2x2_top
x1_x954 dac_config_3 dac_config_5 col_event_rst_top_left[11] dac_config_4
+ row_on_detect_top[59] dac_config_0 dac_config_1 row_off_detect_top[58] x1_net105
+ dac_config_2 vdda1 vssa1 vssc1 col_event_rst_top_left[10] x1_net106
+ row_on_detect_top[58] row_off_detect_top[59] openDVS_pixel2x2_top
x1_x955 dac_config_3 dac_config_5 col_event_rst_top_left[9] dac_config_4
+ row_on_detect_top[59] dac_config_0 dac_config_1 row_off_detect_top[58] x1_net109
+ dac_config_2 vdda1 vssa1 vssc1 col_event_rst_top_left[8] x1_net110 row_on_detect_top[58]
+ row_off_detect_top[59] openDVS_pixel2x2_top
x1_x956 dac_config_3 dac_config_5 col_event_rst_top_left[7] dac_config_4
+ row_on_detect_top[59] dac_config_0 dac_config_1 row_off_detect_top[58] x1_net113
+ dac_config_2 vdda1 vssa1 vssc1 col_event_rst_top_left[6] x1_net114 row_on_detect_top[58]
+ row_off_detect_top[59] openDVS_pixel2x2_top
x1_x957 dac_config_3 dac_config_5 col_event_rst_top_left[5] dac_config_4
+ row_on_detect_top[59] dac_config_0 dac_config_1 row_off_detect_top[58] x1_net117
+ dac_config_2 vdda1 vssa1 vssc1 col_event_rst_top_left[4] x1_net118 row_on_detect_top[58]
+ row_off_detect_top[59] openDVS_pixel2x2_top
x1_x958 dac_config_3 dac_config_5 col_event_rst_top_left[3] dac_config_4
+ row_on_detect_top[59] dac_config_0 dac_config_1 row_off_detect_top[58] x1_net121
+ dac_config_2 vdda1 vssa1 vssc1 col_event_rst_top_left[2] x1_net122 row_on_detect_top[58]
+ row_off_detect_top[59] openDVS_pixel2x2_top
x1_x959 dac_config_3 dac_config_5 col_event_rst_top_left[1] dac_config_4
+ row_on_detect_top[59] dac_config_0 dac_config_1 row_off_detect_top[58] x1_net125
+ dac_config_2 vdda1 vssa1 vssc1 col_event_rst_top_left[0] x1_net126 row_on_detect_top[58]
+ row_off_detect_top[59] openDVS_pixel2x2_top
x1_x960 dac_config_3 dac_config_5 col_event_rst_top_left[63] dac_config_4
+ row_on_detect_top[61] dac_config_0 dac_config_1 row_off_detect_top[60] x1_net1
+ dac_config_2 vdda1 vssa1 vssc1 col_event_rst_top_left[62] x1_net2 row_on_detect_top[60]
+ row_off_detect_top[61] openDVS_pixel2x2_top
x1_x961 dac_config_3 dac_config_5 col_event_rst_top_left[61] dac_config_4
+ row_on_detect_top[61] dac_config_0 dac_config_1 row_off_detect_top[60] x1_net5
+ dac_config_2 vdda1 vssa1 vssc1 col_event_rst_top_left[60] x1_net6 row_on_detect_top[60]
+ row_off_detect_top[61] openDVS_pixel2x2_top
x1_x962 dac_config_3 dac_config_5 col_event_rst_top_left[59] dac_config_4
+ row_on_detect_top[61] dac_config_0 dac_config_1 row_off_detect_top[60] x1_net9
+ dac_config_2 vdda1 vssa1 vssc1 col_event_rst_top_left[58] x1_net10 row_on_detect_top[60]
+ row_off_detect_top[61] openDVS_pixel2x2_top
x1_x963 dac_config_3 dac_config_5 col_event_rst_top_left[57] dac_config_4
+ row_on_detect_top[61] dac_config_0 dac_config_1 row_off_detect_top[60] x1_net13
+ dac_config_2 vdda1 vssa1 vssc1 col_event_rst_top_left[56] x1_net14 row_on_detect_top[60]
+ row_off_detect_top[61] openDVS_pixel2x2_top
x1_x964 dac_config_3 dac_config_5 col_event_rst_top_left[55] dac_config_4
+ row_on_detect_top[61] dac_config_0 dac_config_1 row_off_detect_top[60] x1_net17
+ dac_config_2 vdda1 vssa1 vssc1 col_event_rst_top_left[54] x1_net18 row_on_detect_top[60]
+ row_off_detect_top[61] openDVS_pixel2x2_top
x1_x965 dac_config_3 dac_config_5 col_event_rst_top_left[53] dac_config_4
+ row_on_detect_top[61] dac_config_0 dac_config_1 row_off_detect_top[60] x1_net21
+ dac_config_2 vdda1 vssa1 vssc1 col_event_rst_top_left[52] x1_net22 row_on_detect_top[60]
+ row_off_detect_top[61] openDVS_pixel2x2_top
x1_x966 dac_config_3 dac_config_5 col_event_rst_top_left[51] dac_config_4
+ row_on_detect_top[61] dac_config_0 dac_config_1 row_off_detect_top[60] x1_net25
+ dac_config_2 vdda1 vssa1 vssc1 col_event_rst_top_left[50] x1_net26 row_on_detect_top[60]
+ row_off_detect_top[61] openDVS_pixel2x2_top
x1_x967 dac_config_3 dac_config_5 col_event_rst_top_left[49] dac_config_4
+ row_on_detect_top[61] dac_config_0 dac_config_1 row_off_detect_top[60] x1_net29
+ dac_config_2 vdda1 vssa1 vssc1 col_event_rst_top_left[48] x1_net30 row_on_detect_top[60]
+ row_off_detect_top[61] openDVS_pixel2x2_top
x1_x968 dac_config_3 dac_config_5 col_event_rst_top_left[47] dac_config_4
+ row_on_detect_top[61] dac_config_0 dac_config_1 row_off_detect_top[60] x1_net33
+ dac_config_2 vdda1 vssa1 vssc1 col_event_rst_top_left[46] x1_net34 row_on_detect_top[60]
+ row_off_detect_top[61] openDVS_pixel2x2_top
x1_x969 dac_config_3 dac_config_5 col_event_rst_top_left[45] dac_config_4
+ row_on_detect_top[61] dac_config_0 dac_config_1 row_off_detect_top[60] x1_net37
+ dac_config_2 vdda1 vssa1 vssc1 col_event_rst_top_left[44] x1_net38 row_on_detect_top[60]
+ row_off_detect_top[61] openDVS_pixel2x2_top
x1_x970 dac_config_3 dac_config_5 col_event_rst_top_left[43] dac_config_4
+ row_on_detect_top[61] dac_config_0 dac_config_1 row_off_detect_top[60] x1_net41
+ dac_config_2 vdda1 vssa1 vssc1 col_event_rst_top_left[42] x1_net42 row_on_detect_top[60]
+ row_off_detect_top[61] openDVS_pixel2x2_top
x1_x971 dac_config_3 dac_config_5 col_event_rst_top_left[41] dac_config_4
+ row_on_detect_top[61] dac_config_0 dac_config_1 row_off_detect_top[60] x1_net45
+ dac_config_2 vdda1 vssa1 vssc1 col_event_rst_top_left[40] x1_net46 row_on_detect_top[60]
+ row_off_detect_top[61] openDVS_pixel2x2_top
x1_x972 dac_config_3 dac_config_5 col_event_rst_top_left[39] dac_config_4
+ row_on_detect_top[61] dac_config_0 dac_config_1 row_off_detect_top[60] x1_net49
+ dac_config_2 vdda1 vssa1 vssc1 col_event_rst_top_left[38] x1_net50 row_on_detect_top[60]
+ row_off_detect_top[61] openDVS_pixel2x2_top
x1_x973 dac_config_3 dac_config_5 col_event_rst_top_left[37] dac_config_4
+ row_on_detect_top[61] dac_config_0 dac_config_1 row_off_detect_top[60] x1_net53
+ dac_config_2 vdda1 vssa1 vssc1 col_event_rst_top_left[36] x1_net54 row_on_detect_top[60]
+ row_off_detect_top[61] openDVS_pixel2x2_top
x1_x974 dac_config_3 dac_config_5 col_event_rst_top_left[35] dac_config_4
+ row_on_detect_top[61] dac_config_0 dac_config_1 row_off_detect_top[60] x1_net57
+ dac_config_2 vdda1 vssa1 vssc1 col_event_rst_top_left[34] x1_net58 row_on_detect_top[60]
+ row_off_detect_top[61] openDVS_pixel2x2_top
x1_x975 dac_config_3 dac_config_5 col_event_rst_top_left[33] dac_config_4
+ row_on_detect_top[61] dac_config_0 dac_config_1 row_off_detect_top[60] x1_net61
+ dac_config_2 vdda1 vssa1 vssc1 col_event_rst_top_left[32] x1_net62 row_on_detect_top[60]
+ row_off_detect_top[61] openDVS_pixel2x2_top
x1_x976 dac_config_3 dac_config_5 col_event_rst_top_left[31] dac_config_4
+ row_on_detect_top[61] dac_config_0 dac_config_1 row_off_detect_top[60] x1_net65
+ dac_config_2 vdda1 vssa1 vssc1 col_event_rst_top_left[30] x1_net66 row_on_detect_top[60]
+ row_off_detect_top[61] openDVS_pixel2x2_top
x1_x977 dac_config_3 dac_config_5 col_event_rst_top_left[29] dac_config_4
+ row_on_detect_top[61] dac_config_0 dac_config_1 row_off_detect_top[60] x1_net69
+ dac_config_2 vdda1 vssa1 vssc1 col_event_rst_top_left[28] x1_net70 row_on_detect_top[60]
+ row_off_detect_top[61] openDVS_pixel2x2_top
x1_x978 dac_config_3 dac_config_5 col_event_rst_top_left[27] dac_config_4
+ row_on_detect_top[61] dac_config_0 dac_config_1 row_off_detect_top[60] x1_net73
+ dac_config_2 vdda1 vssa1 vssc1 col_event_rst_top_left[26] x1_net74 row_on_detect_top[60]
+ row_off_detect_top[61] openDVS_pixel2x2_top
x1_x979 dac_config_3 dac_config_5 col_event_rst_top_left[25] dac_config_4
+ row_on_detect_top[61] dac_config_0 dac_config_1 row_off_detect_top[60] x1_net77
+ dac_config_2 vdda1 vssa1 vssc1 col_event_rst_top_left[24] x1_net78 row_on_detect_top[60]
+ row_off_detect_top[61] openDVS_pixel2x2_top
x1_x980 dac_config_3 dac_config_5 col_event_rst_top_left[23] dac_config_4
+ row_on_detect_top[61] dac_config_0 dac_config_1 row_off_detect_top[60] x1_net81
+ dac_config_2 vdda1 vssa1 vssc1 col_event_rst_top_left[22] x1_net82 row_on_detect_top[60]
+ row_off_detect_top[61] openDVS_pixel2x2_top
x1_x981 dac_config_3 dac_config_5 col_event_rst_top_left[21] dac_config_4
+ row_on_detect_top[61] dac_config_0 dac_config_1 row_off_detect_top[60] x1_net85
+ dac_config_2 vdda1 vssa1 vssc1 col_event_rst_top_left[20] x1_net86 row_on_detect_top[60]
+ row_off_detect_top[61] openDVS_pixel2x2_top
x1_x982 dac_config_3 dac_config_5 col_event_rst_top_left[19] dac_config_4
+ row_on_detect_top[61] dac_config_0 dac_config_1 row_off_detect_top[60] x1_net89
+ dac_config_2 vdda1 vssa1 vssc1 col_event_rst_top_left[18] x1_net90 row_on_detect_top[60]
+ row_off_detect_top[61] openDVS_pixel2x2_top
x1_x983 dac_config_3 dac_config_5 col_event_rst_top_left[17] dac_config_4
+ row_on_detect_top[61] dac_config_0 dac_config_1 row_off_detect_top[60] x1_net93
+ dac_config_2 vdda1 vssa1 vssc1 col_event_rst_top_left[16] x1_net94 row_on_detect_top[60]
+ row_off_detect_top[61] openDVS_pixel2x2_top
x1_x984 dac_config_3 dac_config_5 col_event_rst_top_left[15] dac_config_4
+ row_on_detect_top[61] dac_config_0 dac_config_1 row_off_detect_top[60] x1_net97
+ dac_config_2 vdda1 vssa1 vssc1 col_event_rst_top_left[14] x1_net98 row_on_detect_top[60]
+ row_off_detect_top[61] openDVS_pixel2x2_top
x1_x985 dac_config_3 dac_config_5 col_event_rst_top_left[13] dac_config_4
+ row_on_detect_top[61] dac_config_0 dac_config_1 row_off_detect_top[60] x1_net101
+ dac_config_2 vdda1 vssa1 vssc1 col_event_rst_top_left[12] x1_net102
+ row_on_detect_top[60] row_off_detect_top[61] openDVS_pixel2x2_top
x1_x986 dac_config_3 dac_config_5 col_event_rst_top_left[11] dac_config_4
+ row_on_detect_top[61] dac_config_0 dac_config_1 row_off_detect_top[60] x1_net105
+ dac_config_2 vdda1 vssa1 vssc1 col_event_rst_top_left[10] x1_net106
+ row_on_detect_top[60] row_off_detect_top[61] openDVS_pixel2x2_top
x1_x987 dac_config_3 dac_config_5 col_event_rst_top_left[9] dac_config_4
+ row_on_detect_top[61] dac_config_0 dac_config_1 row_off_detect_top[60] x1_net109
+ dac_config_2 vdda1 vssa1 vssc1 col_event_rst_top_left[8] x1_net110 row_on_detect_top[60]
+ row_off_detect_top[61] openDVS_pixel2x2_top
x1_x988 dac_config_3 dac_config_5 col_event_rst_top_left[7] dac_config_4
+ row_on_detect_top[61] dac_config_0 dac_config_1 row_off_detect_top[60] x1_net113
+ dac_config_2 vdda1 vssa1 vssc1 col_event_rst_top_left[6] x1_net114 row_on_detect_top[60]
+ row_off_detect_top[61] openDVS_pixel2x2_top
x1_x989 dac_config_3 dac_config_5 col_event_rst_top_left[5] dac_config_4
+ row_on_detect_top[61] dac_config_0 dac_config_1 row_off_detect_top[60] x1_net117
+ dac_config_2 vdda1 vssa1 vssc1 col_event_rst_top_left[4] x1_net118 row_on_detect_top[60]
+ row_off_detect_top[61] openDVS_pixel2x2_top
x1_x990 dac_config_3 dac_config_5 col_event_rst_top_left[3] dac_config_4
+ row_on_detect_top[61] dac_config_0 dac_config_1 row_off_detect_top[60] x1_net121
+ dac_config_2 vdda1 vssa1 vssc1 col_event_rst_top_left[2] x1_net122 row_on_detect_top[60]
+ row_off_detect_top[61] openDVS_pixel2x2_top
x1_x991 dac_config_3 dac_config_5 col_event_rst_top_left[1] dac_config_4
+ row_on_detect_top[61] dac_config_0 dac_config_1 row_off_detect_top[60] x1_net125
+ dac_config_2 vdda1 vssa1 vssc1 col_event_rst_top_left[0] x1_net126 row_on_detect_top[60]
+ row_off_detect_top[61] openDVS_pixel2x2_top
x1_x992 dac_config_3 dac_config_5 col_event_rst_top_left[63] dac_config_4
+ row_on_detect_top[63] dac_config_0 dac_config_1 row_off_detect_top[62] x1_net1
+ dac_config_2 vdda1 vssa1 vssc1 col_event_rst_top_left[62] x1_net2 row_on_detect_top[62]
+ row_off_detect_top[63] openDVS_pixel2x2_top
x1_x993 dac_config_3 dac_config_5 col_event_rst_top_left[61] dac_config_4
+ row_on_detect_top[63] dac_config_0 dac_config_1 row_off_detect_top[62] x1_net5
+ dac_config_2 vdda1 vssa1 vssc1 col_event_rst_top_left[60] x1_net6 row_on_detect_top[62]
+ row_off_detect_top[63] openDVS_pixel2x2_top
x1_x994 dac_config_3 dac_config_5 col_event_rst_top_left[59] dac_config_4
+ row_on_detect_top[63] dac_config_0 dac_config_1 row_off_detect_top[62] x1_net9
+ dac_config_2 vdda1 vssa1 vssc1 col_event_rst_top_left[58] x1_net10 row_on_detect_top[62]
+ row_off_detect_top[63] openDVS_pixel2x2_top
x1_x995 dac_config_3 dac_config_5 col_event_rst_top_left[57] dac_config_4
+ row_on_detect_top[63] dac_config_0 dac_config_1 row_off_detect_top[62] x1_net13
+ dac_config_2 vdda1 vssa1 vssc1 col_event_rst_top_left[56] x1_net14 row_on_detect_top[62]
+ row_off_detect_top[63] openDVS_pixel2x2_top
x1_x996 dac_config_3 dac_config_5 col_event_rst_top_left[55] dac_config_4
+ row_on_detect_top[63] dac_config_0 dac_config_1 row_off_detect_top[62] x1_net17
+ dac_config_2 vdda1 vssa1 vssc1 col_event_rst_top_left[54] x1_net18 row_on_detect_top[62]
+ row_off_detect_top[63] openDVS_pixel2x2_top
x1_x997 dac_config_3 dac_config_5 col_event_rst_top_left[53] dac_config_4
+ row_on_detect_top[63] dac_config_0 dac_config_1 row_off_detect_top[62] x1_net21
+ dac_config_2 vdda1 vssa1 vssc1 col_event_rst_top_left[52] x1_net22 row_on_detect_top[62]
+ row_off_detect_top[63] openDVS_pixel2x2_top
x1_x998 dac_config_3 dac_config_5 col_event_rst_top_left[51] dac_config_4
+ row_on_detect_top[63] dac_config_0 dac_config_1 row_off_detect_top[62] x1_net25
+ dac_config_2 vdda1 vssa1 vssc1 col_event_rst_top_left[50] x1_net26 row_on_detect_top[62]
+ row_off_detect_top[63] openDVS_pixel2x2_top
x1_x999 dac_config_3 dac_config_5 col_event_rst_top_left[49] dac_config_4
+ row_on_detect_top[63] dac_config_0 dac_config_1 row_off_detect_top[62] x1_net29
+ dac_config_2 vdda1 vssa1 vssc1 col_event_rst_top_left[48] x1_net30 row_on_detect_top[62]
+ row_off_detect_top[63] openDVS_pixel2x2_top
x1_x1000 dac_config_3 dac_config_5 col_event_rst_top_left[47] dac_config_4
+ row_on_detect_top[63] dac_config_0 dac_config_1 row_off_detect_top[62] x1_net33
+ dac_config_2 vdda1 vssa1 vssc1 col_event_rst_top_left[46] x1_net34 row_on_detect_top[62]
+ row_off_detect_top[63] openDVS_pixel2x2_top
x1_x1001 dac_config_3 dac_config_5 col_event_rst_top_left[45] dac_config_4
+ row_on_detect_top[63] dac_config_0 dac_config_1 row_off_detect_top[62] x1_net37
+ dac_config_2 vdda1 vssa1 vssc1 col_event_rst_top_left[44] x1_net38 row_on_detect_top[62]
+ row_off_detect_top[63] openDVS_pixel2x2_top
x1_x1002 dac_config_3 dac_config_5 col_event_rst_top_left[43] dac_config_4
+ row_on_detect_top[63] dac_config_0 dac_config_1 row_off_detect_top[62] x1_net41
+ dac_config_2 vdda1 vssa1 vssc1 col_event_rst_top_left[42] x1_net42 row_on_detect_top[62]
+ row_off_detect_top[63] openDVS_pixel2x2_top
x1_x1003 dac_config_3 dac_config_5 col_event_rst_top_left[41] dac_config_4
+ row_on_detect_top[63] dac_config_0 dac_config_1 row_off_detect_top[62] x1_net45
+ dac_config_2 vdda1 vssa1 vssc1 col_event_rst_top_left[40] x1_net46 row_on_detect_top[62]
+ row_off_detect_top[63] openDVS_pixel2x2_top
x1_x1004 dac_config_3 dac_config_5 col_event_rst_top_left[39] dac_config_4
+ row_on_detect_top[63] dac_config_0 dac_config_1 row_off_detect_top[62] x1_net49
+ dac_config_2 vdda1 vssa1 vssc1 col_event_rst_top_left[38] x1_net50 row_on_detect_top[62]
+ row_off_detect_top[63] openDVS_pixel2x2_top
x1_x1005 dac_config_3 dac_config_5 col_event_rst_top_left[37] dac_config_4
+ row_on_detect_top[63] dac_config_0 dac_config_1 row_off_detect_top[62] x1_net53
+ dac_config_2 vdda1 vssa1 vssc1 col_event_rst_top_left[36] x1_net54 row_on_detect_top[62]
+ row_off_detect_top[63] openDVS_pixel2x2_top
x1_x1006 dac_config_3 dac_config_5 col_event_rst_top_left[35] dac_config_4
+ row_on_detect_top[63] dac_config_0 dac_config_1 row_off_detect_top[62] x1_net57
+ dac_config_2 vdda1 vssa1 vssc1 col_event_rst_top_left[34] x1_net58 row_on_detect_top[62]
+ row_off_detect_top[63] openDVS_pixel2x2_top
x1_x1007 dac_config_3 dac_config_5 col_event_rst_top_left[33] dac_config_4
+ row_on_detect_top[63] dac_config_0 dac_config_1 row_off_detect_top[62] x1_net61
+ dac_config_2 vdda1 vssa1 vssc1 col_event_rst_top_left[32] x1_net62 row_on_detect_top[62]
+ row_off_detect_top[63] openDVS_pixel2x2_top
x1_x1008 dac_config_3 dac_config_5 col_event_rst_top_left[31] dac_config_4
+ row_on_detect_top[63] dac_config_0 dac_config_1 row_off_detect_top[62] x1_net65
+ dac_config_2 vdda1 vssa1 vssc1 col_event_rst_top_left[30] x1_net66 row_on_detect_top[62]
+ row_off_detect_top[63] openDVS_pixel2x2_top
x1_x1009 dac_config_3 dac_config_5 col_event_rst_top_left[29] dac_config_4
+ row_on_detect_top[63] dac_config_0 dac_config_1 row_off_detect_top[62] x1_net69
+ dac_config_2 vdda1 vssa1 vssc1 col_event_rst_top_left[28] x1_net70 row_on_detect_top[62]
+ row_off_detect_top[63] openDVS_pixel2x2_top
x1_x1010 dac_config_3 dac_config_5 col_event_rst_top_left[27] dac_config_4
+ row_on_detect_top[63] dac_config_0 dac_config_1 row_off_detect_top[62] x1_net73
+ dac_config_2 vdda1 vssa1 vssc1 col_event_rst_top_left[26] x1_net74 row_on_detect_top[62]
+ row_off_detect_top[63] openDVS_pixel2x2_top
x1_x1011 dac_config_3 dac_config_5 col_event_rst_top_left[25] dac_config_4
+ row_on_detect_top[63] dac_config_0 dac_config_1 row_off_detect_top[62] x1_net77
+ dac_config_2 vdda1 vssa1 vssc1 col_event_rst_top_left[24] x1_net78 row_on_detect_top[62]
+ row_off_detect_top[63] openDVS_pixel2x2_top
x1_x1012 dac_config_3 dac_config_5 col_event_rst_top_left[23] dac_config_4
+ row_on_detect_top[63] dac_config_0 dac_config_1 row_off_detect_top[62] x1_net81
+ dac_config_2 vdda1 vssa1 vssc1 col_event_rst_top_left[22] x1_net82 row_on_detect_top[62]
+ row_off_detect_top[63] openDVS_pixel2x2_top
x1_x1013 dac_config_3 dac_config_5 col_event_rst_top_left[21] dac_config_4
+ row_on_detect_top[63] dac_config_0 dac_config_1 row_off_detect_top[62] x1_net85
+ dac_config_2 vdda1 vssa1 vssc1 col_event_rst_top_left[20] x1_net86 row_on_detect_top[62]
+ row_off_detect_top[63] openDVS_pixel2x2_top
x1_x1014 dac_config_3 dac_config_5 col_event_rst_top_left[19] dac_config_4
+ row_on_detect_top[63] dac_config_0 dac_config_1 row_off_detect_top[62] x1_net89
+ dac_config_2 vdda1 vssa1 vssc1 col_event_rst_top_left[18] x1_net90 row_on_detect_top[62]
+ row_off_detect_top[63] openDVS_pixel2x2_top
x1_x1015 dac_config_3 dac_config_5 col_event_rst_top_left[17] dac_config_4
+ row_on_detect_top[63] dac_config_0 dac_config_1 row_off_detect_top[62] x1_net93
+ dac_config_2 vdda1 vssa1 vssc1 col_event_rst_top_left[16] x1_net94 row_on_detect_top[62]
+ row_off_detect_top[63] openDVS_pixel2x2_top
x1_x1016 dac_config_3 dac_config_5 col_event_rst_top_left[15] dac_config_4
+ row_on_detect_top[63] dac_config_0 dac_config_1 row_off_detect_top[62] x1_net97
+ dac_config_2 vdda1 vssa1 vssc1 col_event_rst_top_left[14] x1_net98 row_on_detect_top[62]
+ row_off_detect_top[63] openDVS_pixel2x2_top
x1_x1017 dac_config_3 dac_config_5 col_event_rst_top_left[13] dac_config_4
+ row_on_detect_top[63] dac_config_0 dac_config_1 row_off_detect_top[62] x1_net101
+ dac_config_2 vdda1 vssa1 vssc1 col_event_rst_top_left[12] x1_net102
+ row_on_detect_top[62] row_off_detect_top[63] openDVS_pixel2x2_top
x1_x1018 dac_config_3 dac_config_5 col_event_rst_top_left[11] dac_config_4
+ row_on_detect_top[63] dac_config_0 dac_config_1 row_off_detect_top[62] x1_net105
+ dac_config_2 vdda1 vssa1 vssc1 col_event_rst_top_left[10] x1_net106
+ row_on_detect_top[62] row_off_detect_top[63] openDVS_pixel2x2_top
x1_x1019 dac_config_3 dac_config_5 col_event_rst_top_left[9] dac_config_4
+ row_on_detect_top[63] dac_config_0 dac_config_1 row_off_detect_top[62] x1_net109
+ dac_config_2 vdda1 vssa1 vssc1 col_event_rst_top_left[8] x1_net110 row_on_detect_top[62]
+ row_off_detect_top[63] openDVS_pixel2x2_top
x1_x1020 dac_config_3 dac_config_5 col_event_rst_top_left[7] dac_config_4
+ row_on_detect_top[63] dac_config_0 dac_config_1 row_off_detect_top[62] x1_net113
+ dac_config_2 vdda1 vssa1 vssc1 col_event_rst_top_left[6] x1_net114 row_on_detect_top[62]
+ row_off_detect_top[63] openDVS_pixel2x2_top
x1_x1021 dac_config_3 dac_config_5 col_event_rst_top_left[5] dac_config_4
+ row_on_detect_top[63] dac_config_0 dac_config_1 row_off_detect_top[62] x1_net117
+ dac_config_2 vdda1 vssa1 vssc1 col_event_rst_top_left[4] x1_net118 row_on_detect_top[62]
+ row_off_detect_top[63] openDVS_pixel2x2_top
x1_x1022 dac_config_3 dac_config_5 col_event_rst_top_left[3] dac_config_4
+ row_on_detect_top[63] dac_config_0 dac_config_1 row_off_detect_top[62] x1_net121
+ dac_config_2 vdda1 vssa1 vssc1 col_event_rst_top_left[2] x1_net122 row_on_detect_top[62]
+ row_off_detect_top[63] openDVS_pixel2x2_top
x1_x1023 dac_config_3 dac_config_5 col_event_rst_top_left[1] dac_config_4
+ row_on_detect_top[63] dac_config_0 dac_config_1 row_off_detect_top[62] x1_net125
+ dac_config_2 vdda1 vssa1 vssc1 col_event_rst_top_left[0] x1_net126 row_on_detect_top[62]
+ row_off_detect_top[63] openDVS_pixel2x2_top
x1_x1088 detect_pulse_global_top_left ndetect_pulse_global_top_left dac_config_6
+ pre_charge_global_top_left vdda1 vssa1 x1_net1 x1_net2 array_col_top_left[63]
+ array_col_top_left[62] col_event_rst_top_left[62] col_event_rst_top_left[63] col_amp_2x1
x1_x1089 detect_pulse_global_top_left ndetect_pulse_global_top_left dac_config_6
+ pre_charge_global_top_left vdda1 vssa1 x1_net5 x1_net6 array_col_top_left[61]
+ array_col_top_left[60] col_event_rst_top_left[60] col_event_rst_top_left[61] col_amp_2x1
x1_x1090 detect_pulse_global_top_left ndetect_pulse_global_top_left dac_config_6
+ pre_charge_global_top_left vdda1 vssa1 x1_net9 x1_net10 array_col_top_left[59]
+ array_col_top_left[58] col_event_rst_top_left[58] col_event_rst_top_left[59] col_amp_2x1
x1_x1091 detect_pulse_global_top_left ndetect_pulse_global_top_left dac_config_6
+ pre_charge_global_top_left vdda1 vssa1 x1_net13 x1_net14 array_col_top_left[57]
+ array_col_top_left[56] col_event_rst_top_left[56] col_event_rst_top_left[57] col_amp_2x1
x1_x1092 detect_pulse_global_top_left ndetect_pulse_global_top_left dac_config_6
+ pre_charge_global_top_left vdda1 vssa1 x1_net17 x1_net18 array_col_top_left[55]
+ array_col_top_left[54] col_event_rst_top_left[54] col_event_rst_top_left[55] col_amp_2x1
x1_x1093 detect_pulse_global_top_left ndetect_pulse_global_top_left dac_config_6
+ pre_charge_global_top_left vdda1 vssa1 x1_net21 x1_net22 array_col_top_left[53]
+ array_col_top_left[52] col_event_rst_top_left[52] col_event_rst_top_left[53] col_amp_2x1
x1_x1094 detect_pulse_global_top_left ndetect_pulse_global_top_left dac_config_6
+ pre_charge_global_top_left vdda1 vssa1 x1_net25 x1_net26 array_col_top_left[51]
+ array_col_top_left[50] col_event_rst_top_left[50] col_event_rst_top_left[51] col_amp_2x1
x1_x1095 detect_pulse_global_top_left ndetect_pulse_global_top_left dac_config_6
+ pre_charge_global_top_left vdda1 vssa1 x1_net29 x1_net30 array_col_top_left[49]
+ array_col_top_left[48] col_event_rst_top_left[48] col_event_rst_top_left[49] col_amp_2x1
x1_x1096 detect_pulse_global_top_left ndetect_pulse_global_top_left dac_config_6
+ pre_charge_global_top_left vdda1 vssa1 x1_net33 x1_net34 array_col_top_left[47]
+ array_col_top_left[46] col_event_rst_top_left[46] col_event_rst_top_left[47] col_amp_2x1
x1_x1097 detect_pulse_global_top_left ndetect_pulse_global_top_left dac_config_6
+ pre_charge_global_top_left vdda1 vssa1 x1_net37 x1_net38 array_col_top_left[45]
+ array_col_top_left[44] col_event_rst_top_left[44] col_event_rst_top_left[45] col_amp_2x1
x1_x1098 detect_pulse_global_top_left ndetect_pulse_global_top_left dac_config_6
+ pre_charge_global_top_left vdda1 vssa1 x1_net41 x1_net42 array_col_top_left[43]
+ array_col_top_left[42] col_event_rst_top_left[42] col_event_rst_top_left[43] col_amp_2x1
x1_x1099 detect_pulse_global_top_left ndetect_pulse_global_top_left dac_config_6
+ pre_charge_global_top_left vdda1 vssa1 x1_net45 x1_net46 array_col_top_left[41]
+ array_col_top_left[40] col_event_rst_top_left[40] col_event_rst_top_left[41] col_amp_2x1
x1_x1100 detect_pulse_global_top_left ndetect_pulse_global_top_left dac_config_6
+ pre_charge_global_top_left vdda1 vssa1 x1_net49 x1_net50 array_col_top_left[39]
+ array_col_top_left[38] col_event_rst_top_left[38] col_event_rst_top_left[39] col_amp_2x1
x1_x1101 detect_pulse_global_top_left ndetect_pulse_global_top_left dac_config_6
+ pre_charge_global_top_left vdda1 vssa1 x1_net53 x1_net54 array_col_top_left[37]
+ array_col_top_left[36] col_event_rst_top_left[36] col_event_rst_top_left[37] col_amp_2x1
x1_x1102 detect_pulse_global_top_left ndetect_pulse_global_top_left dac_config_6
+ pre_charge_global_top_left vdda1 vssa1 x1_net57 x1_net58 array_col_top_left[35]
+ array_col_top_left[34] col_event_rst_top_left[34] col_event_rst_top_left[35] col_amp_2x1
x1_x1103 detect_pulse_global_top_left ndetect_pulse_global_top_left dac_config_6
+ pre_charge_global_top_left vdda1 vssa1 x1_net61 x1_net62 array_col_top_left[33]
+ array_col_top_left[32] col_event_rst_top_left[32] col_event_rst_top_left[33] col_amp_2x1
x1_x1104 detect_pulse_global_top_left ndetect_pulse_global_top_left dac_config_6
+ pre_charge_global_top_left vdda1 vssa1 x1_net65 x1_net66 array_col_top_left[31]
+ array_col_top_left[30] col_event_rst_top_left[30] col_event_rst_top_left[31] col_amp_2x1
x1_x1105 detect_pulse_global_top_left ndetect_pulse_global_top_left dac_config_6
+ pre_charge_global_top_left vdda1 vssa1 x1_net69 x1_net70 array_col_top_left[29]
+ array_col_top_left[28] col_event_rst_top_left[28] col_event_rst_top_left[29] col_amp_2x1
x1_x1106 detect_pulse_global_top_left ndetect_pulse_global_top_left dac_config_6
+ pre_charge_global_top_left vdda1 vssa1 x1_net73 x1_net74 array_col_top_left[27]
+ array_col_top_left[26] col_event_rst_top_left[26] col_event_rst_top_left[27] col_amp_2x1
x1_x1107 detect_pulse_global_top_left ndetect_pulse_global_top_left dac_config_6
+ pre_charge_global_top_left vdda1 vssa1 x1_net77 x1_net78 array_col_top_left[25]
+ array_col_top_left[24] col_event_rst_top_left[24] col_event_rst_top_left[25] col_amp_2x1
x1_x1108 detect_pulse_global_top_left ndetect_pulse_global_top_left dac_config_6
+ pre_charge_global_top_left vdda1 vssa1 x1_net81 x1_net82 array_col_top_left[23]
+ array_col_top_left[22] col_event_rst_top_left[22] col_event_rst_top_left[23] col_amp_2x1
x1_x1109 detect_pulse_global_top_left ndetect_pulse_global_top_left dac_config_6
+ pre_charge_global_top_left vdda1 vssa1 x1_net85 x1_net86 array_col_top_left[21]
+ array_col_top_left[20] col_event_rst_top_left[20] col_event_rst_top_left[21] col_amp_2x1
x1_x1110 detect_pulse_global_top_left ndetect_pulse_global_top_left dac_config_6
+ pre_charge_global_top_left vdda1 vssa1 x1_net89 x1_net90 array_col_top_left[19]
+ array_col_top_left[18] col_event_rst_top_left[18] col_event_rst_top_left[19] col_amp_2x1
x1_x1111 detect_pulse_global_top_left ndetect_pulse_global_top_left dac_config_6
+ pre_charge_global_top_left vdda1 vssa1 x1_net93 x1_net94 array_col_top_left[17]
+ array_col_top_left[16] col_event_rst_top_left[16] col_event_rst_top_left[17] col_amp_2x1
x1_x1112 detect_pulse_global_top_left ndetect_pulse_global_top_left dac_config_6
+ pre_charge_global_top_left vdda1 vssa1 x1_net97 x1_net98 array_col_top_left[15]
+ array_col_top_left[14] col_event_rst_top_left[14] col_event_rst_top_left[15] col_amp_2x1
x1_x1113 detect_pulse_global_top_left ndetect_pulse_global_top_left dac_config_6
+ pre_charge_global_top_left vdda1 vssa1 x1_net101 x1_net102 array_col_top_left[13]
+ array_col_top_left[12] col_event_rst_top_left[12] col_event_rst_top_left[13] col_amp_2x1
x1_x1114 detect_pulse_global_top_left ndetect_pulse_global_top_left dac_config_6
+ pre_charge_global_top_left vdda1 vssa1 x1_net105 x1_net106 array_col_top_left[11]
+ array_col_top_left[10] col_event_rst_top_left[10] col_event_rst_top_left[11] col_amp_2x1
x1_x1115 detect_pulse_global_top_left ndetect_pulse_global_top_left dac_config_6
+ pre_charge_global_top_left vdda1 vssa1 x1_net109 x1_net110 array_col_top_left[9]
+ array_col_top_left[8] col_event_rst_top_left[8] col_event_rst_top_left[9] col_amp_2x1
x1_x1116 detect_pulse_global_top_left ndetect_pulse_global_top_left dac_config_6
+ pre_charge_global_top_left vdda1 vssa1 x1_net113 x1_net114 array_col_top_left[7]
+ array_col_top_left[6] col_event_rst_top_left[6] col_event_rst_top_left[7] col_amp_2x1
x1_x1117 detect_pulse_global_top_left ndetect_pulse_global_top_left dac_config_6
+ pre_charge_global_top_left vdda1 vssa1 x1_net117 x1_net118 array_col_top_left[5]
+ array_col_top_left[4] col_event_rst_top_left[4] col_event_rst_top_left[5] col_amp_2x1
x1_x1118 detect_pulse_global_top_left ndetect_pulse_global_top_left dac_config_6
+ pre_charge_global_top_left vdda1 vssa1 x1_net121 x1_net122 array_col_top_left[3]
+ array_col_top_left[2] col_event_rst_top_left[2] col_event_rst_top_left[3] col_amp_2x1
x1_x1119 detect_pulse_global_top_left ndetect_pulse_global_top_left dac_config_6
+ pre_charge_global_top_left vdda1 vssa1 x1_net125 x1_net126 array_col_top_left[1]
+ array_col_top_left[0] col_event_rst_top_left[0] col_event_rst_top_left[1] col_amp_2x1
x2_x0 dac_config_3 dac_config_5 col_event_rst_top_right[63] dac_config_4
+ row_on_detect_top[1] dac_config_0 dac_config_1 row_off_detect_top[0] x2_net1
+ dac_config_2 vdda1 vssa1 vssc1 col_event_rst_top_right[62] x2_net2 row_on_detect_top[0]
+ row_off_detect_top[1] openDVS_pixel2x2_top
x2_x1 dac_config_3 dac_config_5 col_event_rst_top_right[61] dac_config_4
+ row_on_detect_top[1] dac_config_0 dac_config_1 row_off_detect_top[0] x2_net5
+ dac_config_2 vdda1 vssa1 vssc1 col_event_rst_top_right[60] x2_net6 row_on_detect_top[0]
+ row_off_detect_top[1] openDVS_pixel2x2_top
x2_x2 dac_config_3 dac_config_5 col_event_rst_top_right[59] dac_config_4
+ row_on_detect_top[1] dac_config_0 dac_config_1 row_off_detect_top[0] x2_net9
+ dac_config_2 vdda1 vssa1 vssc1 col_event_rst_top_right[58] x2_net10 row_on_detect_top[0]
+ row_off_detect_top[1] openDVS_pixel2x2_top
x2_x3 dac_config_3 dac_config_5 col_event_rst_top_right[57] dac_config_4
+ row_on_detect_top[1] dac_config_0 dac_config_1 row_off_detect_top[0] x2_net13
+ dac_config_2 vdda1 vssa1 vssc1 col_event_rst_top_right[56] x2_net14 row_on_detect_top[0]
+ row_off_detect_top[1] openDVS_pixel2x2_top
x2_x4 dac_config_3 dac_config_5 col_event_rst_top_right[55] dac_config_4
+ row_on_detect_top[1] dac_config_0 dac_config_1 row_off_detect_top[0] x2_net17
+ dac_config_2 vdda1 vssa1 vssc1 col_event_rst_top_right[54] x2_net18 row_on_detect_top[0]
+ row_off_detect_top[1] openDVS_pixel2x2_top
x2_x5 dac_config_3 dac_config_5 col_event_rst_top_right[53] dac_config_4
+ row_on_detect_top[1] dac_config_0 dac_config_1 row_off_detect_top[0] x2_net21
+ dac_config_2 vdda1 vssa1 vssc1 col_event_rst_top_right[52] x2_net22 row_on_detect_top[0]
+ row_off_detect_top[1] openDVS_pixel2x2_top
x2_x6 dac_config_3 dac_config_5 col_event_rst_top_right[51] dac_config_4
+ row_on_detect_top[1] dac_config_0 dac_config_1 row_off_detect_top[0] x2_net25
+ dac_config_2 vdda1 vssa1 vssc1 col_event_rst_top_right[50] x2_net26 row_on_detect_top[0]
+ row_off_detect_top[1] openDVS_pixel2x2_top
x2_x7 dac_config_3 dac_config_5 col_event_rst_top_right[49] dac_config_4
+ row_on_detect_top[1] dac_config_0 dac_config_1 row_off_detect_top[0] x2_net29
+ dac_config_2 vdda1 vssa1 vssc1 col_event_rst_top_right[48] x2_net30 row_on_detect_top[0]
+ row_off_detect_top[1] openDVS_pixel2x2_top
x2_x8 dac_config_3 dac_config_5 col_event_rst_top_right[47] dac_config_4
+ row_on_detect_top[1] dac_config_0 dac_config_1 row_off_detect_top[0] x2_net33
+ dac_config_2 vdda1 vssa1 vssc1 col_event_rst_top_right[46] x2_net34 row_on_detect_top[0]
+ row_off_detect_top[1] openDVS_pixel2x2_top
x2_x9 dac_config_3 dac_config_5 col_event_rst_top_right[45] dac_config_4
+ row_on_detect_top[1] dac_config_0 dac_config_1 row_off_detect_top[0] x2_net37
+ dac_config_2 vdda1 vssa1 vssc1 col_event_rst_top_right[44] x2_net38 row_on_detect_top[0]
+ row_off_detect_top[1] openDVS_pixel2x2_top
x2_x10 dac_config_3 dac_config_5 col_event_rst_top_right[43] dac_config_4
+ row_on_detect_top[1] dac_config_0 dac_config_1 row_off_detect_top[0] x2_net41
+ dac_config_2 vdda1 vssa1 vssc1 col_event_rst_top_right[42] x2_net42 row_on_detect_top[0]
+ row_off_detect_top[1] openDVS_pixel2x2_top
x2_x11 dac_config_3 dac_config_5 col_event_rst_top_right[41] dac_config_4
+ row_on_detect_top[1] dac_config_0 dac_config_1 row_off_detect_top[0] x2_net45
+ dac_config_2 vdda1 vssa1 vssc1 col_event_rst_top_right[40] x2_net46 row_on_detect_top[0]
+ row_off_detect_top[1] openDVS_pixel2x2_top
x2_x12 dac_config_3 dac_config_5 col_event_rst_top_right[39] dac_config_4
+ row_on_detect_top[1] dac_config_0 dac_config_1 row_off_detect_top[0] x2_net49
+ dac_config_2 vdda1 vssa1 vssc1 col_event_rst_top_right[38] x2_net50 row_on_detect_top[0]
+ row_off_detect_top[1] openDVS_pixel2x2_top
x2_x13 dac_config_3 dac_config_5 col_event_rst_top_right[37] dac_config_4
+ row_on_detect_top[1] dac_config_0 dac_config_1 row_off_detect_top[0] x2_net53
+ dac_config_2 vdda1 vssa1 vssc1 col_event_rst_top_right[36] x2_net54 row_on_detect_top[0]
+ row_off_detect_top[1] openDVS_pixel2x2_top
x2_x14 dac_config_3 dac_config_5 col_event_rst_top_right[35] dac_config_4
+ row_on_detect_top[1] dac_config_0 dac_config_1 row_off_detect_top[0] x2_net57
+ dac_config_2 vdda1 vssa1 vssc1 col_event_rst_top_right[34] x2_net58 row_on_detect_top[0]
+ row_off_detect_top[1] openDVS_pixel2x2_top
x2_x15 dac_config_3 dac_config_5 col_event_rst_top_right[33] dac_config_4
+ row_on_detect_top[1] dac_config_0 dac_config_1 row_off_detect_top[0] x2_net61
+ dac_config_2 vdda1 vssa1 vssc1 col_event_rst_top_right[32] x2_net62 row_on_detect_top[0]
+ row_off_detect_top[1] openDVS_pixel2x2_top
x2_x16 dac_config_3 dac_config_5 col_event_rst_top_right[31] dac_config_4
+ row_on_detect_top[1] dac_config_0 dac_config_1 row_off_detect_top[0] x2_net65
+ dac_config_2 vdda1 vssa1 vssc1 col_event_rst_top_right[30] x2_net66 row_on_detect_top[0]
+ row_off_detect_top[1] openDVS_pixel2x2_top
x2_x17 dac_config_3 dac_config_5 col_event_rst_top_right[29] dac_config_4
+ row_on_detect_top[1] dac_config_0 dac_config_1 row_off_detect_top[0] x2_net69
+ dac_config_2 vdda1 vssa1 vssc1 col_event_rst_top_right[28] x2_net70 row_on_detect_top[0]
+ row_off_detect_top[1] openDVS_pixel2x2_top
x2_x18 dac_config_3 dac_config_5 col_event_rst_top_right[27] dac_config_4
+ row_on_detect_top[1] dac_config_0 dac_config_1 row_off_detect_top[0] x2_net73
+ dac_config_2 vdda1 vssa1 vssc1 col_event_rst_top_right[26] x2_net74 row_on_detect_top[0]
+ row_off_detect_top[1] openDVS_pixel2x2_top
x2_x19 dac_config_3 dac_config_5 col_event_rst_top_right[25] dac_config_4
+ row_on_detect_top[1] dac_config_0 dac_config_1 row_off_detect_top[0] x2_net77
+ dac_config_2 vdda1 vssa1 vssc1 col_event_rst_top_right[24] x2_net78 row_on_detect_top[0]
+ row_off_detect_top[1] openDVS_pixel2x2_top
x2_x20 dac_config_3 dac_config_5 col_event_rst_top_right[23] dac_config_4
+ row_on_detect_top[1] dac_config_0 dac_config_1 row_off_detect_top[0] x2_net81
+ dac_config_2 vdda1 vssa1 vssc1 col_event_rst_top_right[22] x2_net82 row_on_detect_top[0]
+ row_off_detect_top[1] openDVS_pixel2x2_top
x2_x21 dac_config_3 dac_config_5 col_event_rst_top_right[21] dac_config_4
+ row_on_detect_top[1] dac_config_0 dac_config_1 row_off_detect_top[0] x2_net85
+ dac_config_2 vdda1 vssa1 vssc1 col_event_rst_top_right[20] x2_net86 row_on_detect_top[0]
+ row_off_detect_top[1] openDVS_pixel2x2_top
x2_x22 dac_config_3 dac_config_5 col_event_rst_top_right[19] dac_config_4
+ row_on_detect_top[1] dac_config_0 dac_config_1 row_off_detect_top[0] x2_net89
+ dac_config_2 vdda1 vssa1 vssc1 col_event_rst_top_right[18] x2_net90 row_on_detect_top[0]
+ row_off_detect_top[1] openDVS_pixel2x2_top
x2_x23 dac_config_3 dac_config_5 col_event_rst_top_right[17] dac_config_4
+ row_on_detect_top[1] dac_config_0 dac_config_1 row_off_detect_top[0] x2_net93
+ dac_config_2 vdda1 vssa1 vssc1 col_event_rst_top_right[16] x2_net94 row_on_detect_top[0]
+ row_off_detect_top[1] openDVS_pixel2x2_top
x2_x24 dac_config_3 dac_config_5 col_event_rst_top_right[15] dac_config_4
+ row_on_detect_top[1] dac_config_0 dac_config_1 row_off_detect_top[0] x2_net97
+ dac_config_2 vdda1 vssa1 vssc1 col_event_rst_top_right[14] x2_net98 row_on_detect_top[0]
+ row_off_detect_top[1] openDVS_pixel2x2_top
x2_x25 dac_config_3 dac_config_5 col_event_rst_top_right[13] dac_config_4
+ row_on_detect_top[1] dac_config_0 dac_config_1 row_off_detect_top[0] x2_net101
+ dac_config_2 vdda1 vssa1 vssc1 col_event_rst_top_right[12] x2_net102
+ row_on_detect_top[0] row_off_detect_top[1] openDVS_pixel2x2_top
x2_x26 dac_config_3 dac_config_5 col_event_rst_top_right[11] dac_config_4
+ row_on_detect_top[1] dac_config_0 dac_config_1 row_off_detect_top[0] x2_net105
+ dac_config_2 vdda1 vssa1 vssc1 col_event_rst_top_right[10] x2_net106
+ row_on_detect_top[0] row_off_detect_top[1] openDVS_pixel2x2_top
x2_x27 dac_config_3 dac_config_5 col_event_rst_top_right[9] dac_config_4
+ row_on_detect_top[1] dac_config_0 dac_config_1 row_off_detect_top[0] x2_net109
+ dac_config_2 vdda1 vssa1 vssc1 col_event_rst_top_right[8] x2_net110 row_on_detect_top[0]
+ row_off_detect_top[1] openDVS_pixel2x2_top
x2_x28 dac_config_3 dac_config_5 col_event_rst_top_right[7] dac_config_4
+ row_on_detect_top[1] dac_config_0 dac_config_1 row_off_detect_top[0] x2_net113
+ dac_config_2 vdda1 vssa1 vssc1 col_event_rst_top_right[6] x2_net114 row_on_detect_top[0]
+ row_off_detect_top[1] openDVS_pixel2x2_top
x2_x29 dac_config_3 dac_config_5 col_event_rst_top_right[5] dac_config_4
+ row_on_detect_top[1] dac_config_0 dac_config_1 row_off_detect_top[0] x2_net117
+ dac_config_2 vdda1 vssa1 vssc1 col_event_rst_top_right[4] x2_net118 row_on_detect_top[0]
+ row_off_detect_top[1] openDVS_pixel2x2_top
x2_x30 dac_config_3 dac_config_5 col_event_rst_top_right[3] dac_config_4
+ row_on_detect_top[1] dac_config_0 dac_config_1 row_off_detect_top[0] x2_net121
+ dac_config_2 vdda1 vssa1 vssc1 col_event_rst_top_right[2] x2_net122 row_on_detect_top[0]
+ row_off_detect_top[1] openDVS_pixel2x2_top
x2_x31 dac_config_3 dac_config_5 col_event_rst_top_right[1] dac_config_4
+ row_on_detect_top[1] dac_config_0 dac_config_1 row_off_detect_top[0] x2_net125
+ dac_config_2 vdda1 vssa1 vssc1 col_event_rst_top_right[0] x2_net126 row_on_detect_top[0]
+ row_off_detect_top[1] openDVS_pixel2x2_top
x2_x32 dac_config_3 dac_config_5 col_event_rst_top_right[63] dac_config_4
+ row_on_detect_top[3] dac_config_0 dac_config_1 row_off_detect_top[2] x2_net1
+ dac_config_2 vdda1 vssa1 vssc1 col_event_rst_top_right[62] x2_net2 row_on_detect_top[2]
+ row_off_detect_top[3] openDVS_pixel2x2_top
x2_x33 dac_config_3 dac_config_5 col_event_rst_top_right[61] dac_config_4
+ row_on_detect_top[3] dac_config_0 dac_config_1 row_off_detect_top[2] x2_net5
+ dac_config_2 vdda1 vssa1 vssc1 col_event_rst_top_right[60] x2_net6 row_on_detect_top[2]
+ row_off_detect_top[3] openDVS_pixel2x2_top
x2_x34 dac_config_3 dac_config_5 col_event_rst_top_right[59] dac_config_4
+ row_on_detect_top[3] dac_config_0 dac_config_1 row_off_detect_top[2] x2_net9
+ dac_config_2 vdda1 vssa1 vssc1 col_event_rst_top_right[58] x2_net10 row_on_detect_top[2]
+ row_off_detect_top[3] openDVS_pixel2x2_top
x2_x35 dac_config_3 dac_config_5 col_event_rst_top_right[57] dac_config_4
+ row_on_detect_top[3] dac_config_0 dac_config_1 row_off_detect_top[2] x2_net13
+ dac_config_2 vdda1 vssa1 vssc1 col_event_rst_top_right[56] x2_net14 row_on_detect_top[2]
+ row_off_detect_top[3] openDVS_pixel2x2_top
x2_x36 dac_config_3 dac_config_5 col_event_rst_top_right[55] dac_config_4
+ row_on_detect_top[3] dac_config_0 dac_config_1 row_off_detect_top[2] x2_net17
+ dac_config_2 vdda1 vssa1 vssc1 col_event_rst_top_right[54] x2_net18 row_on_detect_top[2]
+ row_off_detect_top[3] openDVS_pixel2x2_top
x2_x37 dac_config_3 dac_config_5 col_event_rst_top_right[53] dac_config_4
+ row_on_detect_top[3] dac_config_0 dac_config_1 row_off_detect_top[2] x2_net21
+ dac_config_2 vdda1 vssa1 vssc1 col_event_rst_top_right[52] x2_net22 row_on_detect_top[2]
+ row_off_detect_top[3] openDVS_pixel2x2_top
x2_x38 dac_config_3 dac_config_5 col_event_rst_top_right[51] dac_config_4
+ row_on_detect_top[3] dac_config_0 dac_config_1 row_off_detect_top[2] x2_net25
+ dac_config_2 vdda1 vssa1 vssc1 col_event_rst_top_right[50] x2_net26 row_on_detect_top[2]
+ row_off_detect_top[3] openDVS_pixel2x2_top
x2_x39 dac_config_3 dac_config_5 col_event_rst_top_right[49] dac_config_4
+ row_on_detect_top[3] dac_config_0 dac_config_1 row_off_detect_top[2] x2_net29
+ dac_config_2 vdda1 vssa1 vssc1 col_event_rst_top_right[48] x2_net30 row_on_detect_top[2]
+ row_off_detect_top[3] openDVS_pixel2x2_top
x2_x40 dac_config_3 dac_config_5 col_event_rst_top_right[47] dac_config_4
+ row_on_detect_top[3] dac_config_0 dac_config_1 row_off_detect_top[2] x2_net33
+ dac_config_2 vdda1 vssa1 vssc1 col_event_rst_top_right[46] x2_net34 row_on_detect_top[2]
+ row_off_detect_top[3] openDVS_pixel2x2_top
x2_x41 dac_config_3 dac_config_5 col_event_rst_top_right[45] dac_config_4
+ row_on_detect_top[3] dac_config_0 dac_config_1 row_off_detect_top[2] x2_net37
+ dac_config_2 vdda1 vssa1 vssc1 col_event_rst_top_right[44] x2_net38 row_on_detect_top[2]
+ row_off_detect_top[3] openDVS_pixel2x2_top
x2_x42 dac_config_3 dac_config_5 col_event_rst_top_right[43] dac_config_4
+ row_on_detect_top[3] dac_config_0 dac_config_1 row_off_detect_top[2] x2_net41
+ dac_config_2 vdda1 vssa1 vssc1 col_event_rst_top_right[42] x2_net42 row_on_detect_top[2]
+ row_off_detect_top[3] openDVS_pixel2x2_top
x2_x43 dac_config_3 dac_config_5 col_event_rst_top_right[41] dac_config_4
+ row_on_detect_top[3] dac_config_0 dac_config_1 row_off_detect_top[2] x2_net45
+ dac_config_2 vdda1 vssa1 vssc1 col_event_rst_top_right[40] x2_net46 row_on_detect_top[2]
+ row_off_detect_top[3] openDVS_pixel2x2_top
x2_x44 dac_config_3 dac_config_5 col_event_rst_top_right[39] dac_config_4
+ row_on_detect_top[3] dac_config_0 dac_config_1 row_off_detect_top[2] x2_net49
+ dac_config_2 vdda1 vssa1 vssc1 col_event_rst_top_right[38] x2_net50 row_on_detect_top[2]
+ row_off_detect_top[3] openDVS_pixel2x2_top
x2_x45 dac_config_3 dac_config_5 col_event_rst_top_right[37] dac_config_4
+ row_on_detect_top[3] dac_config_0 dac_config_1 row_off_detect_top[2] x2_net53
+ dac_config_2 vdda1 vssa1 vssc1 col_event_rst_top_right[36] x2_net54 row_on_detect_top[2]
+ row_off_detect_top[3] openDVS_pixel2x2_top
x2_x46 dac_config_3 dac_config_5 col_event_rst_top_right[35] dac_config_4
+ row_on_detect_top[3] dac_config_0 dac_config_1 row_off_detect_top[2] x2_net57
+ dac_config_2 vdda1 vssa1 vssc1 col_event_rst_top_right[34] x2_net58 row_on_detect_top[2]
+ row_off_detect_top[3] openDVS_pixel2x2_top
x2_x47 dac_config_3 dac_config_5 col_event_rst_top_right[33] dac_config_4
+ row_on_detect_top[3] dac_config_0 dac_config_1 row_off_detect_top[2] x2_net61
+ dac_config_2 vdda1 vssa1 vssc1 col_event_rst_top_right[32] x2_net62 row_on_detect_top[2]
+ row_off_detect_top[3] openDVS_pixel2x2_top
x2_x48 dac_config_3 dac_config_5 col_event_rst_top_right[31] dac_config_4
+ row_on_detect_top[3] dac_config_0 dac_config_1 row_off_detect_top[2] x2_net65
+ dac_config_2 vdda1 vssa1 vssc1 col_event_rst_top_right[30] x2_net66 row_on_detect_top[2]
+ row_off_detect_top[3] openDVS_pixel2x2_top
x2_x49 dac_config_3 dac_config_5 col_event_rst_top_right[29] dac_config_4
+ row_on_detect_top[3] dac_config_0 dac_config_1 row_off_detect_top[2] x2_net69
+ dac_config_2 vdda1 vssa1 vssc1 col_event_rst_top_right[28] x2_net70 row_on_detect_top[2]
+ row_off_detect_top[3] openDVS_pixel2x2_top
x2_x50 dac_config_3 dac_config_5 col_event_rst_top_right[27] dac_config_4
+ row_on_detect_top[3] dac_config_0 dac_config_1 row_off_detect_top[2] x2_net73
+ dac_config_2 vdda1 vssa1 vssc1 col_event_rst_top_right[26] x2_net74 row_on_detect_top[2]
+ row_off_detect_top[3] openDVS_pixel2x2_top
x2_x51 dac_config_3 dac_config_5 col_event_rst_top_right[25] dac_config_4
+ row_on_detect_top[3] dac_config_0 dac_config_1 row_off_detect_top[2] x2_net77
+ dac_config_2 vdda1 vssa1 vssc1 col_event_rst_top_right[24] x2_net78 row_on_detect_top[2]
+ row_off_detect_top[3] openDVS_pixel2x2_top
x2_x52 dac_config_3 dac_config_5 col_event_rst_top_right[23] dac_config_4
+ row_on_detect_top[3] dac_config_0 dac_config_1 row_off_detect_top[2] x2_net81
+ dac_config_2 vdda1 vssa1 vssc1 col_event_rst_top_right[22] x2_net82 row_on_detect_top[2]
+ row_off_detect_top[3] openDVS_pixel2x2_top
x2_x53 dac_config_3 dac_config_5 col_event_rst_top_right[21] dac_config_4
+ row_on_detect_top[3] dac_config_0 dac_config_1 row_off_detect_top[2] x2_net85
+ dac_config_2 vdda1 vssa1 vssc1 col_event_rst_top_right[20] x2_net86 row_on_detect_top[2]
+ row_off_detect_top[3] openDVS_pixel2x2_top
x2_x54 dac_config_3 dac_config_5 col_event_rst_top_right[19] dac_config_4
+ row_on_detect_top[3] dac_config_0 dac_config_1 row_off_detect_top[2] x2_net89
+ dac_config_2 vdda1 vssa1 vssc1 col_event_rst_top_right[18] x2_net90 row_on_detect_top[2]
+ row_off_detect_top[3] openDVS_pixel2x2_top
x2_x55 dac_config_3 dac_config_5 col_event_rst_top_right[17] dac_config_4
+ row_on_detect_top[3] dac_config_0 dac_config_1 row_off_detect_top[2] x2_net93
+ dac_config_2 vdda1 vssa1 vssc1 col_event_rst_top_right[16] x2_net94 row_on_detect_top[2]
+ row_off_detect_top[3] openDVS_pixel2x2_top
x2_x56 dac_config_3 dac_config_5 col_event_rst_top_right[15] dac_config_4
+ row_on_detect_top[3] dac_config_0 dac_config_1 row_off_detect_top[2] x2_net97
+ dac_config_2 vdda1 vssa1 vssc1 col_event_rst_top_right[14] x2_net98 row_on_detect_top[2]
+ row_off_detect_top[3] openDVS_pixel2x2_top
x2_x57 dac_config_3 dac_config_5 col_event_rst_top_right[13] dac_config_4
+ row_on_detect_top[3] dac_config_0 dac_config_1 row_off_detect_top[2] x2_net101
+ dac_config_2 vdda1 vssa1 vssc1 col_event_rst_top_right[12] x2_net102
+ row_on_detect_top[2] row_off_detect_top[3] openDVS_pixel2x2_top
x2_x58 dac_config_3 dac_config_5 col_event_rst_top_right[11] dac_config_4
+ row_on_detect_top[3] dac_config_0 dac_config_1 row_off_detect_top[2] x2_net105
+ dac_config_2 vdda1 vssa1 vssc1 col_event_rst_top_right[10] x2_net106
+ row_on_detect_top[2] row_off_detect_top[3] openDVS_pixel2x2_top
x2_x59 dac_config_3 dac_config_5 col_event_rst_top_right[9] dac_config_4
+ row_on_detect_top[3] dac_config_0 dac_config_1 row_off_detect_top[2] x2_net109
+ dac_config_2 vdda1 vssa1 vssc1 col_event_rst_top_right[8] x2_net110 row_on_detect_top[2]
+ row_off_detect_top[3] openDVS_pixel2x2_top
x2_x60 dac_config_3 dac_config_5 col_event_rst_top_right[7] dac_config_4
+ row_on_detect_top[3] dac_config_0 dac_config_1 row_off_detect_top[2] x2_net113
+ dac_config_2 vdda1 vssa1 vssc1 col_event_rst_top_right[6] x2_net114 row_on_detect_top[2]
+ row_off_detect_top[3] openDVS_pixel2x2_top
x2_x61 dac_config_3 dac_config_5 col_event_rst_top_right[5] dac_config_4
+ row_on_detect_top[3] dac_config_0 dac_config_1 row_off_detect_top[2] x2_net117
+ dac_config_2 vdda1 vssa1 vssc1 col_event_rst_top_right[4] x2_net118 row_on_detect_top[2]
+ row_off_detect_top[3] openDVS_pixel2x2_top
x2_x62 dac_config_3 dac_config_5 col_event_rst_top_right[3] dac_config_4
+ row_on_detect_top[3] dac_config_0 dac_config_1 row_off_detect_top[2] x2_net121
+ dac_config_2 vdda1 vssa1 vssc1 col_event_rst_top_right[2] x2_net122 row_on_detect_top[2]
+ row_off_detect_top[3] openDVS_pixel2x2_top
x2_x63 dac_config_3 dac_config_5 col_event_rst_top_right[1] dac_config_4
+ row_on_detect_top[3] dac_config_0 dac_config_1 row_off_detect_top[2] x2_net125
+ dac_config_2 vdda1 vssa1 vssc1 col_event_rst_top_right[0] x2_net126 row_on_detect_top[2]
+ row_off_detect_top[3] openDVS_pixel2x2_top
x2_x64 dac_config_3 dac_config_5 col_event_rst_top_right[63] dac_config_4
+ row_on_detect_top[5] dac_config_0 dac_config_1 row_off_detect_top[4] x2_net1
+ dac_config_2 vdda1 vssa1 vssc1 col_event_rst_top_right[62] x2_net2 row_on_detect_top[4]
+ row_off_detect_top[5] openDVS_pixel2x2_top
x2_x65 dac_config_3 dac_config_5 col_event_rst_top_right[61] dac_config_4
+ row_on_detect_top[5] dac_config_0 dac_config_1 row_off_detect_top[4] x2_net5
+ dac_config_2 vdda1 vssa1 vssc1 col_event_rst_top_right[60] x2_net6 row_on_detect_top[4]
+ row_off_detect_top[5] openDVS_pixel2x2_top
x2_x66 dac_config_3 dac_config_5 col_event_rst_top_right[59] dac_config_4
+ row_on_detect_top[5] dac_config_0 dac_config_1 row_off_detect_top[4] x2_net9
+ dac_config_2 vdda1 vssa1 vssc1 col_event_rst_top_right[58] x2_net10 row_on_detect_top[4]
+ row_off_detect_top[5] openDVS_pixel2x2_top
x2_x67 dac_config_3 dac_config_5 col_event_rst_top_right[57] dac_config_4
+ row_on_detect_top[5] dac_config_0 dac_config_1 row_off_detect_top[4] x2_net13
+ dac_config_2 vdda1 vssa1 vssc1 col_event_rst_top_right[56] x2_net14 row_on_detect_top[4]
+ row_off_detect_top[5] openDVS_pixel2x2_top
x2_x68 dac_config_3 dac_config_5 col_event_rst_top_right[55] dac_config_4
+ row_on_detect_top[5] dac_config_0 dac_config_1 row_off_detect_top[4] x2_net17
+ dac_config_2 vdda1 vssa1 vssc1 col_event_rst_top_right[54] x2_net18 row_on_detect_top[4]
+ row_off_detect_top[5] openDVS_pixel2x2_top
x2_x69 dac_config_3 dac_config_5 col_event_rst_top_right[53] dac_config_4
+ row_on_detect_top[5] dac_config_0 dac_config_1 row_off_detect_top[4] x2_net21
+ dac_config_2 vdda1 vssa1 vssc1 col_event_rst_top_right[52] x2_net22 row_on_detect_top[4]
+ row_off_detect_top[5] openDVS_pixel2x2_top
x2_x70 dac_config_3 dac_config_5 col_event_rst_top_right[51] dac_config_4
+ row_on_detect_top[5] dac_config_0 dac_config_1 row_off_detect_top[4] x2_net25
+ dac_config_2 vdda1 vssa1 vssc1 col_event_rst_top_right[50] x2_net26 row_on_detect_top[4]
+ row_off_detect_top[5] openDVS_pixel2x2_top
x2_x71 dac_config_3 dac_config_5 col_event_rst_top_right[49] dac_config_4
+ row_on_detect_top[5] dac_config_0 dac_config_1 row_off_detect_top[4] x2_net29
+ dac_config_2 vdda1 vssa1 vssc1 col_event_rst_top_right[48] x2_net30 row_on_detect_top[4]
+ row_off_detect_top[5] openDVS_pixel2x2_top
x2_x72 dac_config_3 dac_config_5 col_event_rst_top_right[47] dac_config_4
+ row_on_detect_top[5] dac_config_0 dac_config_1 row_off_detect_top[4] x2_net33
+ dac_config_2 vdda1 vssa1 vssc1 col_event_rst_top_right[46] x2_net34 row_on_detect_top[4]
+ row_off_detect_top[5] openDVS_pixel2x2_top
x2_x73 dac_config_3 dac_config_5 col_event_rst_top_right[45] dac_config_4
+ row_on_detect_top[5] dac_config_0 dac_config_1 row_off_detect_top[4] x2_net37
+ dac_config_2 vdda1 vssa1 vssc1 col_event_rst_top_right[44] x2_net38 row_on_detect_top[4]
+ row_off_detect_top[5] openDVS_pixel2x2_top
x2_x74 dac_config_3 dac_config_5 col_event_rst_top_right[43] dac_config_4
+ row_on_detect_top[5] dac_config_0 dac_config_1 row_off_detect_top[4] x2_net41
+ dac_config_2 vdda1 vssa1 vssc1 col_event_rst_top_right[42] x2_net42 row_on_detect_top[4]
+ row_off_detect_top[5] openDVS_pixel2x2_top
x2_x75 dac_config_3 dac_config_5 col_event_rst_top_right[41] dac_config_4
+ row_on_detect_top[5] dac_config_0 dac_config_1 row_off_detect_top[4] x2_net45
+ dac_config_2 vdda1 vssa1 vssc1 col_event_rst_top_right[40] x2_net46 row_on_detect_top[4]
+ row_off_detect_top[5] openDVS_pixel2x2_top
x2_x76 dac_config_3 dac_config_5 col_event_rst_top_right[39] dac_config_4
+ row_on_detect_top[5] dac_config_0 dac_config_1 row_off_detect_top[4] x2_net49
+ dac_config_2 vdda1 vssa1 vssc1 col_event_rst_top_right[38] x2_net50 row_on_detect_top[4]
+ row_off_detect_top[5] openDVS_pixel2x2_top
x2_x77 dac_config_3 dac_config_5 col_event_rst_top_right[37] dac_config_4
+ row_on_detect_top[5] dac_config_0 dac_config_1 row_off_detect_top[4] x2_net53
+ dac_config_2 vdda1 vssa1 vssc1 col_event_rst_top_right[36] x2_net54 row_on_detect_top[4]
+ row_off_detect_top[5] openDVS_pixel2x2_top
x2_x78 dac_config_3 dac_config_5 col_event_rst_top_right[35] dac_config_4
+ row_on_detect_top[5] dac_config_0 dac_config_1 row_off_detect_top[4] x2_net57
+ dac_config_2 vdda1 vssa1 vssc1 col_event_rst_top_right[34] x2_net58 row_on_detect_top[4]
+ row_off_detect_top[5] openDVS_pixel2x2_top
x2_x79 dac_config_3 dac_config_5 col_event_rst_top_right[33] dac_config_4
+ row_on_detect_top[5] dac_config_0 dac_config_1 row_off_detect_top[4] x2_net61
+ dac_config_2 vdda1 vssa1 vssc1 col_event_rst_top_right[32] x2_net62 row_on_detect_top[4]
+ row_off_detect_top[5] openDVS_pixel2x2_top
x2_x80 dac_config_3 dac_config_5 col_event_rst_top_right[31] dac_config_4
+ row_on_detect_top[5] dac_config_0 dac_config_1 row_off_detect_top[4] x2_net65
+ dac_config_2 vdda1 vssa1 vssc1 col_event_rst_top_right[30] x2_net66 row_on_detect_top[4]
+ row_off_detect_top[5] openDVS_pixel2x2_top
x2_x81 dac_config_3 dac_config_5 col_event_rst_top_right[29] dac_config_4
+ row_on_detect_top[5] dac_config_0 dac_config_1 row_off_detect_top[4] x2_net69
+ dac_config_2 vdda1 vssa1 vssc1 col_event_rst_top_right[28] x2_net70 row_on_detect_top[4]
+ row_off_detect_top[5] openDVS_pixel2x2_top
x2_x82 dac_config_3 dac_config_5 col_event_rst_top_right[27] dac_config_4
+ row_on_detect_top[5] dac_config_0 dac_config_1 row_off_detect_top[4] x2_net73
+ dac_config_2 vdda1 vssa1 vssc1 col_event_rst_top_right[26] x2_net74 row_on_detect_top[4]
+ row_off_detect_top[5] openDVS_pixel2x2_top
x2_x83 dac_config_3 dac_config_5 col_event_rst_top_right[25] dac_config_4
+ row_on_detect_top[5] dac_config_0 dac_config_1 row_off_detect_top[4] x2_net77
+ dac_config_2 vdda1 vssa1 vssc1 col_event_rst_top_right[24] x2_net78 row_on_detect_top[4]
+ row_off_detect_top[5] openDVS_pixel2x2_top
x2_x84 dac_config_3 dac_config_5 col_event_rst_top_right[23] dac_config_4
+ row_on_detect_top[5] dac_config_0 dac_config_1 row_off_detect_top[4] x2_net81
+ dac_config_2 vdda1 vssa1 vssc1 col_event_rst_top_right[22] x2_net82 row_on_detect_top[4]
+ row_off_detect_top[5] openDVS_pixel2x2_top
x2_x85 dac_config_3 dac_config_5 col_event_rst_top_right[21] dac_config_4
+ row_on_detect_top[5] dac_config_0 dac_config_1 row_off_detect_top[4] x2_net85
+ dac_config_2 vdda1 vssa1 vssc1 col_event_rst_top_right[20] x2_net86 row_on_detect_top[4]
+ row_off_detect_top[5] openDVS_pixel2x2_top
x2_x86 dac_config_3 dac_config_5 col_event_rst_top_right[19] dac_config_4
+ row_on_detect_top[5] dac_config_0 dac_config_1 row_off_detect_top[4] x2_net89
+ dac_config_2 vdda1 vssa1 vssc1 col_event_rst_top_right[18] x2_net90 row_on_detect_top[4]
+ row_off_detect_top[5] openDVS_pixel2x2_top
x2_x87 dac_config_3 dac_config_5 col_event_rst_top_right[17] dac_config_4
+ row_on_detect_top[5] dac_config_0 dac_config_1 row_off_detect_top[4] x2_net93
+ dac_config_2 vdda1 vssa1 vssc1 col_event_rst_top_right[16] x2_net94 row_on_detect_top[4]
+ row_off_detect_top[5] openDVS_pixel2x2_top
x2_x88 dac_config_3 dac_config_5 col_event_rst_top_right[15] dac_config_4
+ row_on_detect_top[5] dac_config_0 dac_config_1 row_off_detect_top[4] x2_net97
+ dac_config_2 vdda1 vssa1 vssc1 col_event_rst_top_right[14] x2_net98 row_on_detect_top[4]
+ row_off_detect_top[5] openDVS_pixel2x2_top
x2_x89 dac_config_3 dac_config_5 col_event_rst_top_right[13] dac_config_4
+ row_on_detect_top[5] dac_config_0 dac_config_1 row_off_detect_top[4] x2_net101
+ dac_config_2 vdda1 vssa1 vssc1 col_event_rst_top_right[12] x2_net102
+ row_on_detect_top[4] row_off_detect_top[5] openDVS_pixel2x2_top
x2_x90 dac_config_3 dac_config_5 col_event_rst_top_right[11] dac_config_4
+ row_on_detect_top[5] dac_config_0 dac_config_1 row_off_detect_top[4] x2_net105
+ dac_config_2 vdda1 vssa1 vssc1 col_event_rst_top_right[10] x2_net106
+ row_on_detect_top[4] row_off_detect_top[5] openDVS_pixel2x2_top
x2_x91 dac_config_3 dac_config_5 col_event_rst_top_right[9] dac_config_4
+ row_on_detect_top[5] dac_config_0 dac_config_1 row_off_detect_top[4] x2_net109
+ dac_config_2 vdda1 vssa1 vssc1 col_event_rst_top_right[8] x2_net110 row_on_detect_top[4]
+ row_off_detect_top[5] openDVS_pixel2x2_top
x2_x92 dac_config_3 dac_config_5 col_event_rst_top_right[7] dac_config_4
+ row_on_detect_top[5] dac_config_0 dac_config_1 row_off_detect_top[4] x2_net113
+ dac_config_2 vdda1 vssa1 vssc1 col_event_rst_top_right[6] x2_net114 row_on_detect_top[4]
+ row_off_detect_top[5] openDVS_pixel2x2_top
x2_x93 dac_config_3 dac_config_5 col_event_rst_top_right[5] dac_config_4
+ row_on_detect_top[5] dac_config_0 dac_config_1 row_off_detect_top[4] x2_net117
+ dac_config_2 vdda1 vssa1 vssc1 col_event_rst_top_right[4] x2_net118 row_on_detect_top[4]
+ row_off_detect_top[5] openDVS_pixel2x2_top
x2_x94 dac_config_3 dac_config_5 col_event_rst_top_right[3] dac_config_4
+ row_on_detect_top[5] dac_config_0 dac_config_1 row_off_detect_top[4] x2_net121
+ dac_config_2 vdda1 vssa1 vssc1 col_event_rst_top_right[2] x2_net122 row_on_detect_top[4]
+ row_off_detect_top[5] openDVS_pixel2x2_top
x2_x95 dac_config_3 dac_config_5 col_event_rst_top_right[1] dac_config_4
+ row_on_detect_top[5] dac_config_0 dac_config_1 row_off_detect_top[4] x2_net125
+ dac_config_2 vdda1 vssa1 vssc1 col_event_rst_top_right[0] x2_net126 row_on_detect_top[4]
+ row_off_detect_top[5] openDVS_pixel2x2_top
x2_x96 dac_config_3 dac_config_5 col_event_rst_top_right[63] dac_config_4
+ row_on_detect_top[7] dac_config_0 dac_config_1 row_off_detect_top[6] x2_net1
+ dac_config_2 vdda1 vssa1 vssc1 col_event_rst_top_right[62] x2_net2 row_on_detect_top[6]
+ row_off_detect_top[7] openDVS_pixel2x2_top
x2_x97 dac_config_3 dac_config_5 col_event_rst_top_right[61] dac_config_4
+ row_on_detect_top[7] dac_config_0 dac_config_1 row_off_detect_top[6] x2_net5
+ dac_config_2 vdda1 vssa1 vssc1 col_event_rst_top_right[60] x2_net6 row_on_detect_top[6]
+ row_off_detect_top[7] openDVS_pixel2x2_top
x2_x98 dac_config_3 dac_config_5 col_event_rst_top_right[59] dac_config_4
+ row_on_detect_top[7] dac_config_0 dac_config_1 row_off_detect_top[6] x2_net9
+ dac_config_2 vdda1 vssa1 vssc1 col_event_rst_top_right[58] x2_net10 row_on_detect_top[6]
+ row_off_detect_top[7] openDVS_pixel2x2_top
x2_x99 dac_config_3 dac_config_5 col_event_rst_top_right[57] dac_config_4
+ row_on_detect_top[7] dac_config_0 dac_config_1 row_off_detect_top[6] x2_net13
+ dac_config_2 vdda1 vssa1 vssc1 col_event_rst_top_right[56] x2_net14 row_on_detect_top[6]
+ row_off_detect_top[7] openDVS_pixel2x2_top
x2_x100 dac_config_3 dac_config_5 col_event_rst_top_right[55] dac_config_4
+ row_on_detect_top[7] dac_config_0 dac_config_1 row_off_detect_top[6] x2_net17
+ dac_config_2 vdda1 vssa1 vssc1 col_event_rst_top_right[54] x2_net18 row_on_detect_top[6]
+ row_off_detect_top[7] openDVS_pixel2x2_top
x2_x101 dac_config_3 dac_config_5 col_event_rst_top_right[53] dac_config_4
+ row_on_detect_top[7] dac_config_0 dac_config_1 row_off_detect_top[6] x2_net21
+ dac_config_2 vdda1 vssa1 vssc1 col_event_rst_top_right[52] x2_net22 row_on_detect_top[6]
+ row_off_detect_top[7] openDVS_pixel2x2_top
x2_x102 dac_config_3 dac_config_5 col_event_rst_top_right[51] dac_config_4
+ row_on_detect_top[7] dac_config_0 dac_config_1 row_off_detect_top[6] x2_net25
+ dac_config_2 vdda1 vssa1 vssc1 col_event_rst_top_right[50] x2_net26 row_on_detect_top[6]
+ row_off_detect_top[7] openDVS_pixel2x2_top
x2_x103 dac_config_3 dac_config_5 col_event_rst_top_right[49] dac_config_4
+ row_on_detect_top[7] dac_config_0 dac_config_1 row_off_detect_top[6] x2_net29
+ dac_config_2 vdda1 vssa1 vssc1 col_event_rst_top_right[48] x2_net30 row_on_detect_top[6]
+ row_off_detect_top[7] openDVS_pixel2x2_top
x2_x104 dac_config_3 dac_config_5 col_event_rst_top_right[47] dac_config_4
+ row_on_detect_top[7] dac_config_0 dac_config_1 row_off_detect_top[6] x2_net33
+ dac_config_2 vdda1 vssa1 vssc1 col_event_rst_top_right[46] x2_net34 row_on_detect_top[6]
+ row_off_detect_top[7] openDVS_pixel2x2_top
x2_x105 dac_config_3 dac_config_5 col_event_rst_top_right[45] dac_config_4
+ row_on_detect_top[7] dac_config_0 dac_config_1 row_off_detect_top[6] x2_net37
+ dac_config_2 vdda1 vssa1 vssc1 col_event_rst_top_right[44] x2_net38 row_on_detect_top[6]
+ row_off_detect_top[7] openDVS_pixel2x2_top
x2_x106 dac_config_3 dac_config_5 col_event_rst_top_right[43] dac_config_4
+ row_on_detect_top[7] dac_config_0 dac_config_1 row_off_detect_top[6] x2_net41
+ dac_config_2 vdda1 vssa1 vssc1 col_event_rst_top_right[42] x2_net42 row_on_detect_top[6]
+ row_off_detect_top[7] openDVS_pixel2x2_top
x2_x107 dac_config_3 dac_config_5 col_event_rst_top_right[41] dac_config_4
+ row_on_detect_top[7] dac_config_0 dac_config_1 row_off_detect_top[6] x2_net45
+ dac_config_2 vdda1 vssa1 vssc1 col_event_rst_top_right[40] x2_net46 row_on_detect_top[6]
+ row_off_detect_top[7] openDVS_pixel2x2_top
x2_x108 dac_config_3 dac_config_5 col_event_rst_top_right[39] dac_config_4
+ row_on_detect_top[7] dac_config_0 dac_config_1 row_off_detect_top[6] x2_net49
+ dac_config_2 vdda1 vssa1 vssc1 col_event_rst_top_right[38] x2_net50 row_on_detect_top[6]
+ row_off_detect_top[7] openDVS_pixel2x2_top
x2_x109 dac_config_3 dac_config_5 col_event_rst_top_right[37] dac_config_4
+ row_on_detect_top[7] dac_config_0 dac_config_1 row_off_detect_top[6] x2_net53
+ dac_config_2 vdda1 vssa1 vssc1 col_event_rst_top_right[36] x2_net54 row_on_detect_top[6]
+ row_off_detect_top[7] openDVS_pixel2x2_top
x2_x110 dac_config_3 dac_config_5 col_event_rst_top_right[35] dac_config_4
+ row_on_detect_top[7] dac_config_0 dac_config_1 row_off_detect_top[6] x2_net57
+ dac_config_2 vdda1 vssa1 vssc1 col_event_rst_top_right[34] x2_net58 row_on_detect_top[6]
+ row_off_detect_top[7] openDVS_pixel2x2_top
x2_x111 dac_config_3 dac_config_5 col_event_rst_top_right[33] dac_config_4
+ row_on_detect_top[7] dac_config_0 dac_config_1 row_off_detect_top[6] x2_net61
+ dac_config_2 vdda1 vssa1 vssc1 col_event_rst_top_right[32] x2_net62 row_on_detect_top[6]
+ row_off_detect_top[7] openDVS_pixel2x2_top
x2_x112 dac_config_3 dac_config_5 col_event_rst_top_right[31] dac_config_4
+ row_on_detect_top[7] dac_config_0 dac_config_1 row_off_detect_top[6] x2_net65
+ dac_config_2 vdda1 vssa1 vssc1 col_event_rst_top_right[30] x2_net66 row_on_detect_top[6]
+ row_off_detect_top[7] openDVS_pixel2x2_top
x2_x113 dac_config_3 dac_config_5 col_event_rst_top_right[29] dac_config_4
+ row_on_detect_top[7] dac_config_0 dac_config_1 row_off_detect_top[6] x2_net69
+ dac_config_2 vdda1 vssa1 vssc1 col_event_rst_top_right[28] x2_net70 row_on_detect_top[6]
+ row_off_detect_top[7] openDVS_pixel2x2_top
x2_x114 dac_config_3 dac_config_5 col_event_rst_top_right[27] dac_config_4
+ row_on_detect_top[7] dac_config_0 dac_config_1 row_off_detect_top[6] x2_net73
+ dac_config_2 vdda1 vssa1 vssc1 col_event_rst_top_right[26] x2_net74 row_on_detect_top[6]
+ row_off_detect_top[7] openDVS_pixel2x2_top
x2_x115 dac_config_3 dac_config_5 col_event_rst_top_right[25] dac_config_4
+ row_on_detect_top[7] dac_config_0 dac_config_1 row_off_detect_top[6] x2_net77
+ dac_config_2 vdda1 vssa1 vssc1 col_event_rst_top_right[24] x2_net78 row_on_detect_top[6]
+ row_off_detect_top[7] openDVS_pixel2x2_top
x2_x116 dac_config_3 dac_config_5 col_event_rst_top_right[23] dac_config_4
+ row_on_detect_top[7] dac_config_0 dac_config_1 row_off_detect_top[6] x2_net81
+ dac_config_2 vdda1 vssa1 vssc1 col_event_rst_top_right[22] x2_net82 row_on_detect_top[6]
+ row_off_detect_top[7] openDVS_pixel2x2_top
x2_x117 dac_config_3 dac_config_5 col_event_rst_top_right[21] dac_config_4
+ row_on_detect_top[7] dac_config_0 dac_config_1 row_off_detect_top[6] x2_net85
+ dac_config_2 vdda1 vssa1 vssc1 col_event_rst_top_right[20] x2_net86 row_on_detect_top[6]
+ row_off_detect_top[7] openDVS_pixel2x2_top
x2_x118 dac_config_3 dac_config_5 col_event_rst_top_right[19] dac_config_4
+ row_on_detect_top[7] dac_config_0 dac_config_1 row_off_detect_top[6] x2_net89
+ dac_config_2 vdda1 vssa1 vssc1 col_event_rst_top_right[18] x2_net90 row_on_detect_top[6]
+ row_off_detect_top[7] openDVS_pixel2x2_top
x2_x119 dac_config_3 dac_config_5 col_event_rst_top_right[17] dac_config_4
+ row_on_detect_top[7] dac_config_0 dac_config_1 row_off_detect_top[6] x2_net93
+ dac_config_2 vdda1 vssa1 vssc1 col_event_rst_top_right[16] x2_net94 row_on_detect_top[6]
+ row_off_detect_top[7] openDVS_pixel2x2_top
x2_x120 dac_config_3 dac_config_5 col_event_rst_top_right[15] dac_config_4
+ row_on_detect_top[7] dac_config_0 dac_config_1 row_off_detect_top[6] x2_net97
+ dac_config_2 vdda1 vssa1 vssc1 col_event_rst_top_right[14] x2_net98 row_on_detect_top[6]
+ row_off_detect_top[7] openDVS_pixel2x2_top
x2_x121 dac_config_3 dac_config_5 col_event_rst_top_right[13] dac_config_4
+ row_on_detect_top[7] dac_config_0 dac_config_1 row_off_detect_top[6] x2_net101
+ dac_config_2 vdda1 vssa1 vssc1 col_event_rst_top_right[12] x2_net102
+ row_on_detect_top[6] row_off_detect_top[7] openDVS_pixel2x2_top
x2_x122 dac_config_3 dac_config_5 col_event_rst_top_right[11] dac_config_4
+ row_on_detect_top[7] dac_config_0 dac_config_1 row_off_detect_top[6] x2_net105
+ dac_config_2 vdda1 vssa1 vssc1 col_event_rst_top_right[10] x2_net106
+ row_on_detect_top[6] row_off_detect_top[7] openDVS_pixel2x2_top
x2_x123 dac_config_3 dac_config_5 col_event_rst_top_right[9] dac_config_4
+ row_on_detect_top[7] dac_config_0 dac_config_1 row_off_detect_top[6] x2_net109
+ dac_config_2 vdda1 vssa1 vssc1 col_event_rst_top_right[8] x2_net110 row_on_detect_top[6]
+ row_off_detect_top[7] openDVS_pixel2x2_top
x2_x124 dac_config_3 dac_config_5 col_event_rst_top_right[7] dac_config_4
+ row_on_detect_top[7] dac_config_0 dac_config_1 row_off_detect_top[6] x2_net113
+ dac_config_2 vdda1 vssa1 vssc1 col_event_rst_top_right[6] x2_net114 row_on_detect_top[6]
+ row_off_detect_top[7] openDVS_pixel2x2_top
x2_x125 dac_config_3 dac_config_5 col_event_rst_top_right[5] dac_config_4
+ row_on_detect_top[7] dac_config_0 dac_config_1 row_off_detect_top[6] x2_net117
+ dac_config_2 vdda1 vssa1 vssc1 col_event_rst_top_right[4] x2_net118 row_on_detect_top[6]
+ row_off_detect_top[7] openDVS_pixel2x2_top
x2_x126 dac_config_3 dac_config_5 col_event_rst_top_right[3] dac_config_4
+ row_on_detect_top[7] dac_config_0 dac_config_1 row_off_detect_top[6] x2_net121
+ dac_config_2 vdda1 vssa1 vssc1 col_event_rst_top_right[2] x2_net122 row_on_detect_top[6]
+ row_off_detect_top[7] openDVS_pixel2x2_top
x2_x127 dac_config_3 dac_config_5 col_event_rst_top_right[1] dac_config_4
+ row_on_detect_top[7] dac_config_0 dac_config_1 row_off_detect_top[6] x2_net125
+ dac_config_2 vdda1 vssa1 vssc1 col_event_rst_top_right[0] x2_net126 row_on_detect_top[6]
+ row_off_detect_top[7] openDVS_pixel2x2_top
x2_x128 dac_config_3 dac_config_5 col_event_rst_top_right[63] dac_config_4
+ row_on_detect_top[9] dac_config_0 dac_config_1 row_off_detect_top[8] x2_net1
+ dac_config_2 vdda1 vssa1 vssc1 col_event_rst_top_right[62] x2_net2 row_on_detect_top[8]
+ row_off_detect_top[9] openDVS_pixel2x2_top
x2_x129 dac_config_3 dac_config_5 col_event_rst_top_right[61] dac_config_4
+ row_on_detect_top[9] dac_config_0 dac_config_1 row_off_detect_top[8] x2_net5
+ dac_config_2 vdda1 vssa1 vssc1 col_event_rst_top_right[60] x2_net6 row_on_detect_top[8]
+ row_off_detect_top[9] openDVS_pixel2x2_top
x2_x130 dac_config_3 dac_config_5 col_event_rst_top_right[59] dac_config_4
+ row_on_detect_top[9] dac_config_0 dac_config_1 row_off_detect_top[8] x2_net9
+ dac_config_2 vdda1 vssa1 vssc1 col_event_rst_top_right[58] x2_net10 row_on_detect_top[8]
+ row_off_detect_top[9] openDVS_pixel2x2_top
x2_x131 dac_config_3 dac_config_5 col_event_rst_top_right[57] dac_config_4
+ row_on_detect_top[9] dac_config_0 dac_config_1 row_off_detect_top[8] x2_net13
+ dac_config_2 vdda1 vssa1 vssc1 col_event_rst_top_right[56] x2_net14 row_on_detect_top[8]
+ row_off_detect_top[9] openDVS_pixel2x2_top
x2_x132 dac_config_3 dac_config_5 col_event_rst_top_right[55] dac_config_4
+ row_on_detect_top[9] dac_config_0 dac_config_1 row_off_detect_top[8] x2_net17
+ dac_config_2 vdda1 vssa1 vssc1 col_event_rst_top_right[54] x2_net18 row_on_detect_top[8]
+ row_off_detect_top[9] openDVS_pixel2x2_top
x2_x133 dac_config_3 dac_config_5 col_event_rst_top_right[53] dac_config_4
+ row_on_detect_top[9] dac_config_0 dac_config_1 row_off_detect_top[8] x2_net21
+ dac_config_2 vdda1 vssa1 vssc1 col_event_rst_top_right[52] x2_net22 row_on_detect_top[8]
+ row_off_detect_top[9] openDVS_pixel2x2_top
x2_x134 dac_config_3 dac_config_5 col_event_rst_top_right[51] dac_config_4
+ row_on_detect_top[9] dac_config_0 dac_config_1 row_off_detect_top[8] x2_net25
+ dac_config_2 vdda1 vssa1 vssc1 col_event_rst_top_right[50] x2_net26 row_on_detect_top[8]
+ row_off_detect_top[9] openDVS_pixel2x2_top
x2_x135 dac_config_3 dac_config_5 col_event_rst_top_right[49] dac_config_4
+ row_on_detect_top[9] dac_config_0 dac_config_1 row_off_detect_top[8] x2_net29
+ dac_config_2 vdda1 vssa1 vssc1 col_event_rst_top_right[48] x2_net30 row_on_detect_top[8]
+ row_off_detect_top[9] openDVS_pixel2x2_top
x2_x136 dac_config_3 dac_config_5 col_event_rst_top_right[47] dac_config_4
+ row_on_detect_top[9] dac_config_0 dac_config_1 row_off_detect_top[8] x2_net33
+ dac_config_2 vdda1 vssa1 vssc1 col_event_rst_top_right[46] x2_net34 row_on_detect_top[8]
+ row_off_detect_top[9] openDVS_pixel2x2_top
x2_x137 dac_config_3 dac_config_5 col_event_rst_top_right[45] dac_config_4
+ row_on_detect_top[9] dac_config_0 dac_config_1 row_off_detect_top[8] x2_net37
+ dac_config_2 vdda1 vssa1 vssc1 col_event_rst_top_right[44] x2_net38 row_on_detect_top[8]
+ row_off_detect_top[9] openDVS_pixel2x2_top
x2_x138 dac_config_3 dac_config_5 col_event_rst_top_right[43] dac_config_4
+ row_on_detect_top[9] dac_config_0 dac_config_1 row_off_detect_top[8] x2_net41
+ dac_config_2 vdda1 vssa1 vssc1 col_event_rst_top_right[42] x2_net42 row_on_detect_top[8]
+ row_off_detect_top[9] openDVS_pixel2x2_top
x2_x139 dac_config_3 dac_config_5 col_event_rst_top_right[41] dac_config_4
+ row_on_detect_top[9] dac_config_0 dac_config_1 row_off_detect_top[8] x2_net45
+ dac_config_2 vdda1 vssa1 vssc1 col_event_rst_top_right[40] x2_net46 row_on_detect_top[8]
+ row_off_detect_top[9] openDVS_pixel2x2_top
x2_x140 dac_config_3 dac_config_5 col_event_rst_top_right[39] dac_config_4
+ row_on_detect_top[9] dac_config_0 dac_config_1 row_off_detect_top[8] x2_net49
+ dac_config_2 vdda1 vssa1 vssc1 col_event_rst_top_right[38] x2_net50 row_on_detect_top[8]
+ row_off_detect_top[9] openDVS_pixel2x2_top
x2_x141 dac_config_3 dac_config_5 col_event_rst_top_right[37] dac_config_4
+ row_on_detect_top[9] dac_config_0 dac_config_1 row_off_detect_top[8] x2_net53
+ dac_config_2 vdda1 vssa1 vssc1 col_event_rst_top_right[36] x2_net54 row_on_detect_top[8]
+ row_off_detect_top[9] openDVS_pixel2x2_top
x2_x142 dac_config_3 dac_config_5 col_event_rst_top_right[35] dac_config_4
+ row_on_detect_top[9] dac_config_0 dac_config_1 row_off_detect_top[8] x2_net57
+ dac_config_2 vdda1 vssa1 vssc1 col_event_rst_top_right[34] x2_net58 row_on_detect_top[8]
+ row_off_detect_top[9] openDVS_pixel2x2_top
x2_x143 dac_config_3 dac_config_5 col_event_rst_top_right[33] dac_config_4
+ row_on_detect_top[9] dac_config_0 dac_config_1 row_off_detect_top[8] x2_net61
+ dac_config_2 vdda1 vssa1 vssc1 col_event_rst_top_right[32] x2_net62 row_on_detect_top[8]
+ row_off_detect_top[9] openDVS_pixel2x2_top
x2_x144 dac_config_3 dac_config_5 col_event_rst_top_right[31] dac_config_4
+ row_on_detect_top[9] dac_config_0 dac_config_1 row_off_detect_top[8] x2_net65
+ dac_config_2 vdda1 vssa1 vssc1 col_event_rst_top_right[30] x2_net66 row_on_detect_top[8]
+ row_off_detect_top[9] openDVS_pixel2x2_top
x2_x145 dac_config_3 dac_config_5 col_event_rst_top_right[29] dac_config_4
+ row_on_detect_top[9] dac_config_0 dac_config_1 row_off_detect_top[8] x2_net69
+ dac_config_2 vdda1 vssa1 vssc1 col_event_rst_top_right[28] x2_net70 row_on_detect_top[8]
+ row_off_detect_top[9] openDVS_pixel2x2_top
x2_x146 dac_config_3 dac_config_5 col_event_rst_top_right[27] dac_config_4
+ row_on_detect_top[9] dac_config_0 dac_config_1 row_off_detect_top[8] x2_net73
+ dac_config_2 vdda1 vssa1 vssc1 col_event_rst_top_right[26] x2_net74 row_on_detect_top[8]
+ row_off_detect_top[9] openDVS_pixel2x2_top
x2_x147 dac_config_3 dac_config_5 col_event_rst_top_right[25] dac_config_4
+ row_on_detect_top[9] dac_config_0 dac_config_1 row_off_detect_top[8] x2_net77
+ dac_config_2 vdda1 vssa1 vssc1 col_event_rst_top_right[24] x2_net78 row_on_detect_top[8]
+ row_off_detect_top[9] openDVS_pixel2x2_top
x2_x148 dac_config_3 dac_config_5 col_event_rst_top_right[23] dac_config_4
+ row_on_detect_top[9] dac_config_0 dac_config_1 row_off_detect_top[8] x2_net81
+ dac_config_2 vdda1 vssa1 vssc1 col_event_rst_top_right[22] x2_net82 row_on_detect_top[8]
+ row_off_detect_top[9] openDVS_pixel2x2_top
x2_x149 dac_config_3 dac_config_5 col_event_rst_top_right[21] dac_config_4
+ row_on_detect_top[9] dac_config_0 dac_config_1 row_off_detect_top[8] x2_net85
+ dac_config_2 vdda1 vssa1 vssc1 col_event_rst_top_right[20] x2_net86 row_on_detect_top[8]
+ row_off_detect_top[9] openDVS_pixel2x2_top
x2_x150 dac_config_3 dac_config_5 col_event_rst_top_right[19] dac_config_4
+ row_on_detect_top[9] dac_config_0 dac_config_1 row_off_detect_top[8] x2_net89
+ dac_config_2 vdda1 vssa1 vssc1 col_event_rst_top_right[18] x2_net90 row_on_detect_top[8]
+ row_off_detect_top[9] openDVS_pixel2x2_top
x2_x151 dac_config_3 dac_config_5 col_event_rst_top_right[17] dac_config_4
+ row_on_detect_top[9] dac_config_0 dac_config_1 row_off_detect_top[8] x2_net93
+ dac_config_2 vdda1 vssa1 vssc1 col_event_rst_top_right[16] x2_net94 row_on_detect_top[8]
+ row_off_detect_top[9] openDVS_pixel2x2_top
x2_x152 dac_config_3 dac_config_5 col_event_rst_top_right[15] dac_config_4
+ row_on_detect_top[9] dac_config_0 dac_config_1 row_off_detect_top[8] x2_net97
+ dac_config_2 vdda1 vssa1 vssc1 col_event_rst_top_right[14] x2_net98 row_on_detect_top[8]
+ row_off_detect_top[9] openDVS_pixel2x2_top
x2_x153 dac_config_3 dac_config_5 col_event_rst_top_right[13] dac_config_4
+ row_on_detect_top[9] dac_config_0 dac_config_1 row_off_detect_top[8] x2_net101
+ dac_config_2 vdda1 vssa1 vssc1 col_event_rst_top_right[12] x2_net102
+ row_on_detect_top[8] row_off_detect_top[9] openDVS_pixel2x2_top
x2_x154 dac_config_3 dac_config_5 col_event_rst_top_right[11] dac_config_4
+ row_on_detect_top[9] dac_config_0 dac_config_1 row_off_detect_top[8] x2_net105
+ dac_config_2 vdda1 vssa1 vssc1 col_event_rst_top_right[10] x2_net106
+ row_on_detect_top[8] row_off_detect_top[9] openDVS_pixel2x2_top
x2_x155 dac_config_3 dac_config_5 col_event_rst_top_right[9] dac_config_4
+ row_on_detect_top[9] dac_config_0 dac_config_1 row_off_detect_top[8] x2_net109
+ dac_config_2 vdda1 vssa1 vssc1 col_event_rst_top_right[8] x2_net110 row_on_detect_top[8]
+ row_off_detect_top[9] openDVS_pixel2x2_top
x2_x156 dac_config_3 dac_config_5 col_event_rst_top_right[7] dac_config_4
+ row_on_detect_top[9] dac_config_0 dac_config_1 row_off_detect_top[8] x2_net113
+ dac_config_2 vdda1 vssa1 vssc1 col_event_rst_top_right[6] x2_net114 row_on_detect_top[8]
+ row_off_detect_top[9] openDVS_pixel2x2_top
x2_x157 dac_config_3 dac_config_5 col_event_rst_top_right[5] dac_config_4
+ row_on_detect_top[9] dac_config_0 dac_config_1 row_off_detect_top[8] x2_net117
+ dac_config_2 vdda1 vssa1 vssc1 col_event_rst_top_right[4] x2_net118 row_on_detect_top[8]
+ row_off_detect_top[9] openDVS_pixel2x2_top
x2_x158 dac_config_3 dac_config_5 col_event_rst_top_right[3] dac_config_4
+ row_on_detect_top[9] dac_config_0 dac_config_1 row_off_detect_top[8] x2_net121
+ dac_config_2 vdda1 vssa1 vssc1 col_event_rst_top_right[2] x2_net122 row_on_detect_top[8]
+ row_off_detect_top[9] openDVS_pixel2x2_top
x2_x159 dac_config_3 dac_config_5 col_event_rst_top_right[1] dac_config_4
+ row_on_detect_top[9] dac_config_0 dac_config_1 row_off_detect_top[8] x2_net125
+ dac_config_2 vdda1 vssa1 vssc1 col_event_rst_top_right[0] x2_net126 row_on_detect_top[8]
+ row_off_detect_top[9] openDVS_pixel2x2_top
x2_x160 dac_config_3 dac_config_5 col_event_rst_top_right[63] dac_config_4
+ row_on_detect_top[11] dac_config_0 dac_config_1 row_off_detect_top[10] x2_net1
+ dac_config_2 vdda1 vssa1 vssc1 col_event_rst_top_right[62] x2_net2 row_on_detect_top[10]
+ row_off_detect_top[11] openDVS_pixel2x2_top
x2_x161 dac_config_3 dac_config_5 col_event_rst_top_right[61] dac_config_4
+ row_on_detect_top[11] dac_config_0 dac_config_1 row_off_detect_top[10] x2_net5
+ dac_config_2 vdda1 vssa1 vssc1 col_event_rst_top_right[60] x2_net6 row_on_detect_top[10]
+ row_off_detect_top[11] openDVS_pixel2x2_top
x2_x162 dac_config_3 dac_config_5 col_event_rst_top_right[59] dac_config_4
+ row_on_detect_top[11] dac_config_0 dac_config_1 row_off_detect_top[10] x2_net9
+ dac_config_2 vdda1 vssa1 vssc1 col_event_rst_top_right[58] x2_net10
+ row_on_detect_top[10] row_off_detect_top[11] openDVS_pixel2x2_top
x2_x163 dac_config_3 dac_config_5 col_event_rst_top_right[57] dac_config_4
+ row_on_detect_top[11] dac_config_0 dac_config_1 row_off_detect_top[10] x2_net13
+ dac_config_2 vdda1 vssa1 vssc1 col_event_rst_top_right[56] x2_net14
+ row_on_detect_top[10] row_off_detect_top[11] openDVS_pixel2x2_top
x2_x164 dac_config_3 dac_config_5 col_event_rst_top_right[55] dac_config_4
+ row_on_detect_top[11] dac_config_0 dac_config_1 row_off_detect_top[10] x2_net17
+ dac_config_2 vdda1 vssa1 vssc1 col_event_rst_top_right[54] x2_net18
+ row_on_detect_top[10] row_off_detect_top[11] openDVS_pixel2x2_top
x2_x165 dac_config_3 dac_config_5 col_event_rst_top_right[53] dac_config_4
+ row_on_detect_top[11] dac_config_0 dac_config_1 row_off_detect_top[10] x2_net21
+ dac_config_2 vdda1 vssa1 vssc1 col_event_rst_top_right[52] x2_net22
+ row_on_detect_top[10] row_off_detect_top[11] openDVS_pixel2x2_top
x2_x166 dac_config_3 dac_config_5 col_event_rst_top_right[51] dac_config_4
+ row_on_detect_top[11] dac_config_0 dac_config_1 row_off_detect_top[10] x2_net25
+ dac_config_2 vdda1 vssa1 vssc1 col_event_rst_top_right[50] x2_net26
+ row_on_detect_top[10] row_off_detect_top[11] openDVS_pixel2x2_top
x2_x167 dac_config_3 dac_config_5 col_event_rst_top_right[49] dac_config_4
+ row_on_detect_top[11] dac_config_0 dac_config_1 row_off_detect_top[10] x2_net29
+ dac_config_2 vdda1 vssa1 vssc1 col_event_rst_top_right[48] x2_net30
+ row_on_detect_top[10] row_off_detect_top[11] openDVS_pixel2x2_top
x2_x168 dac_config_3 dac_config_5 col_event_rst_top_right[47] dac_config_4
+ row_on_detect_top[11] dac_config_0 dac_config_1 row_off_detect_top[10] x2_net33
+ dac_config_2 vdda1 vssa1 vssc1 col_event_rst_top_right[46] x2_net34
+ row_on_detect_top[10] row_off_detect_top[11] openDVS_pixel2x2_top
x2_x169 dac_config_3 dac_config_5 col_event_rst_top_right[45] dac_config_4
+ row_on_detect_top[11] dac_config_0 dac_config_1 row_off_detect_top[10] x2_net37
+ dac_config_2 vdda1 vssa1 vssc1 col_event_rst_top_right[44] x2_net38
+ row_on_detect_top[10] row_off_detect_top[11] openDVS_pixel2x2_top
x2_x170 dac_config_3 dac_config_5 col_event_rst_top_right[43] dac_config_4
+ row_on_detect_top[11] dac_config_0 dac_config_1 row_off_detect_top[10] x2_net41
+ dac_config_2 vdda1 vssa1 vssc1 col_event_rst_top_right[42] x2_net42
+ row_on_detect_top[10] row_off_detect_top[11] openDVS_pixel2x2_top
x2_x171 dac_config_3 dac_config_5 col_event_rst_top_right[41] dac_config_4
+ row_on_detect_top[11] dac_config_0 dac_config_1 row_off_detect_top[10] x2_net45
+ dac_config_2 vdda1 vssa1 vssc1 col_event_rst_top_right[40] x2_net46
+ row_on_detect_top[10] row_off_detect_top[11] openDVS_pixel2x2_top
x2_x172 dac_config_3 dac_config_5 col_event_rst_top_right[39] dac_config_4
+ row_on_detect_top[11] dac_config_0 dac_config_1 row_off_detect_top[10] x2_net49
+ dac_config_2 vdda1 vssa1 vssc1 col_event_rst_top_right[38] x2_net50
+ row_on_detect_top[10] row_off_detect_top[11] openDVS_pixel2x2_top
x2_x173 dac_config_3 dac_config_5 col_event_rst_top_right[37] dac_config_4
+ row_on_detect_top[11] dac_config_0 dac_config_1 row_off_detect_top[10] x2_net53
+ dac_config_2 vdda1 vssa1 vssc1 col_event_rst_top_right[36] x2_net54
+ row_on_detect_top[10] row_off_detect_top[11] openDVS_pixel2x2_top
x2_x174 dac_config_3 dac_config_5 col_event_rst_top_right[35] dac_config_4
+ row_on_detect_top[11] dac_config_0 dac_config_1 row_off_detect_top[10] x2_net57
+ dac_config_2 vdda1 vssa1 vssc1 col_event_rst_top_right[34] x2_net58
+ row_on_detect_top[10] row_off_detect_top[11] openDVS_pixel2x2_top
x2_x175 dac_config_3 dac_config_5 col_event_rst_top_right[33] dac_config_4
+ row_on_detect_top[11] dac_config_0 dac_config_1 row_off_detect_top[10] x2_net61
+ dac_config_2 vdda1 vssa1 vssc1 col_event_rst_top_right[32] x2_net62
+ row_on_detect_top[10] row_off_detect_top[11] openDVS_pixel2x2_top
x2_x176 dac_config_3 dac_config_5 col_event_rst_top_right[31] dac_config_4
+ row_on_detect_top[11] dac_config_0 dac_config_1 row_off_detect_top[10] x2_net65
+ dac_config_2 vdda1 vssa1 vssc1 col_event_rst_top_right[30] x2_net66
+ row_on_detect_top[10] row_off_detect_top[11] openDVS_pixel2x2_top
x2_x177 dac_config_3 dac_config_5 col_event_rst_top_right[29] dac_config_4
+ row_on_detect_top[11] dac_config_0 dac_config_1 row_off_detect_top[10] x2_net69
+ dac_config_2 vdda1 vssa1 vssc1 col_event_rst_top_right[28] x2_net70
+ row_on_detect_top[10] row_off_detect_top[11] openDVS_pixel2x2_top
x2_x178 dac_config_3 dac_config_5 col_event_rst_top_right[27] dac_config_4
+ row_on_detect_top[11] dac_config_0 dac_config_1 row_off_detect_top[10] x2_net73
+ dac_config_2 vdda1 vssa1 vssc1 col_event_rst_top_right[26] x2_net74
+ row_on_detect_top[10] row_off_detect_top[11] openDVS_pixel2x2_top
x2_x179 dac_config_3 dac_config_5 col_event_rst_top_right[25] dac_config_4
+ row_on_detect_top[11] dac_config_0 dac_config_1 row_off_detect_top[10] x2_net77
+ dac_config_2 vdda1 vssa1 vssc1 col_event_rst_top_right[24] x2_net78
+ row_on_detect_top[10] row_off_detect_top[11] openDVS_pixel2x2_top
x2_x180 dac_config_3 dac_config_5 col_event_rst_top_right[23] dac_config_4
+ row_on_detect_top[11] dac_config_0 dac_config_1 row_off_detect_top[10] x2_net81
+ dac_config_2 vdda1 vssa1 vssc1 col_event_rst_top_right[22] x2_net82
+ row_on_detect_top[10] row_off_detect_top[11] openDVS_pixel2x2_top
x2_x181 dac_config_3 dac_config_5 col_event_rst_top_right[21] dac_config_4
+ row_on_detect_top[11] dac_config_0 dac_config_1 row_off_detect_top[10] x2_net85
+ dac_config_2 vdda1 vssa1 vssc1 col_event_rst_top_right[20] x2_net86
+ row_on_detect_top[10] row_off_detect_top[11] openDVS_pixel2x2_top
x2_x182 dac_config_3 dac_config_5 col_event_rst_top_right[19] dac_config_4
+ row_on_detect_top[11] dac_config_0 dac_config_1 row_off_detect_top[10] x2_net89
+ dac_config_2 vdda1 vssa1 vssc1 col_event_rst_top_right[18] x2_net90
+ row_on_detect_top[10] row_off_detect_top[11] openDVS_pixel2x2_top
x2_x183 dac_config_3 dac_config_5 col_event_rst_top_right[17] dac_config_4
+ row_on_detect_top[11] dac_config_0 dac_config_1 row_off_detect_top[10] x2_net93
+ dac_config_2 vdda1 vssa1 vssc1 col_event_rst_top_right[16] x2_net94
+ row_on_detect_top[10] row_off_detect_top[11] openDVS_pixel2x2_top
x2_x184 dac_config_3 dac_config_5 col_event_rst_top_right[15] dac_config_4
+ row_on_detect_top[11] dac_config_0 dac_config_1 row_off_detect_top[10] x2_net97
+ dac_config_2 vdda1 vssa1 vssc1 col_event_rst_top_right[14] x2_net98
+ row_on_detect_top[10] row_off_detect_top[11] openDVS_pixel2x2_top
x2_x185 dac_config_3 dac_config_5 col_event_rst_top_right[13] dac_config_4
+ row_on_detect_top[11] dac_config_0 dac_config_1 row_off_detect_top[10] x2_net101
+ dac_config_2 vdda1 vssa1 vssc1 col_event_rst_top_right[12] x2_net102
+ row_on_detect_top[10] row_off_detect_top[11] openDVS_pixel2x2_top
x2_x186 dac_config_3 dac_config_5 col_event_rst_top_right[11] dac_config_4
+ row_on_detect_top[11] dac_config_0 dac_config_1 row_off_detect_top[10] x2_net105
+ dac_config_2 vdda1 vssa1 vssc1 col_event_rst_top_right[10] x2_net106
+ row_on_detect_top[10] row_off_detect_top[11] openDVS_pixel2x2_top
x2_x187 dac_config_3 dac_config_5 col_event_rst_top_right[9] dac_config_4
+ row_on_detect_top[11] dac_config_0 dac_config_1 row_off_detect_top[10] x2_net109
+ dac_config_2 vdda1 vssa1 vssc1 col_event_rst_top_right[8] x2_net110
+ row_on_detect_top[10] row_off_detect_top[11] openDVS_pixel2x2_top
x2_x188 dac_config_3 dac_config_5 col_event_rst_top_right[7] dac_config_4
+ row_on_detect_top[11] dac_config_0 dac_config_1 row_off_detect_top[10] x2_net113
+ dac_config_2 vdda1 vssa1 vssc1 col_event_rst_top_right[6] x2_net114
+ row_on_detect_top[10] row_off_detect_top[11] openDVS_pixel2x2_top
x2_x189 dac_config_3 dac_config_5 col_event_rst_top_right[5] dac_config_4
+ row_on_detect_top[11] dac_config_0 dac_config_1 row_off_detect_top[10] x2_net117
+ dac_config_2 vdda1 vssa1 vssc1 col_event_rst_top_right[4] x2_net118
+ row_on_detect_top[10] row_off_detect_top[11] openDVS_pixel2x2_top
x2_x190 dac_config_3 dac_config_5 col_event_rst_top_right[3] dac_config_4
+ row_on_detect_top[11] dac_config_0 dac_config_1 row_off_detect_top[10] x2_net121
+ dac_config_2 vdda1 vssa1 vssc1 col_event_rst_top_right[2] x2_net122
+ row_on_detect_top[10] row_off_detect_top[11] openDVS_pixel2x2_top
x2_x191 dac_config_3 dac_config_5 col_event_rst_top_right[1] dac_config_4
+ row_on_detect_top[11] dac_config_0 dac_config_1 row_off_detect_top[10] x2_net125
+ dac_config_2 vdda1 vssa1 vssc1 col_event_rst_top_right[0] x2_net126
+ row_on_detect_top[10] row_off_detect_top[11] openDVS_pixel2x2_top
x2_x192 dac_config_3 dac_config_5 col_event_rst_top_right[63] dac_config_4
+ row_on_detect_top[13] dac_config_0 dac_config_1 row_off_detect_top[12] x2_net1
+ dac_config_2 vdda1 vssa1 vssc1 col_event_rst_top_right[62] x2_net2 row_on_detect_top[12]
+ row_off_detect_top[13] openDVS_pixel2x2_top
x2_x193 dac_config_3 dac_config_5 col_event_rst_top_right[61] dac_config_4
+ row_on_detect_top[13] dac_config_0 dac_config_1 row_off_detect_top[12] x2_net5
+ dac_config_2 vdda1 vssa1 vssc1 col_event_rst_top_right[60] x2_net6 row_on_detect_top[12]
+ row_off_detect_top[13] openDVS_pixel2x2_top
x2_x194 dac_config_3 dac_config_5 col_event_rst_top_right[59] dac_config_4
+ row_on_detect_top[13] dac_config_0 dac_config_1 row_off_detect_top[12] x2_net9
+ dac_config_2 vdda1 vssa1 vssc1 col_event_rst_top_right[58] x2_net10
+ row_on_detect_top[12] row_off_detect_top[13] openDVS_pixel2x2_top
x2_x195 dac_config_3 dac_config_5 col_event_rst_top_right[57] dac_config_4
+ row_on_detect_top[13] dac_config_0 dac_config_1 row_off_detect_top[12] x2_net13
+ dac_config_2 vdda1 vssa1 vssc1 col_event_rst_top_right[56] x2_net14
+ row_on_detect_top[12] row_off_detect_top[13] openDVS_pixel2x2_top
x2_x196 dac_config_3 dac_config_5 col_event_rst_top_right[55] dac_config_4
+ row_on_detect_top[13] dac_config_0 dac_config_1 row_off_detect_top[12] x2_net17
+ dac_config_2 vdda1 vssa1 vssc1 col_event_rst_top_right[54] x2_net18
+ row_on_detect_top[12] row_off_detect_top[13] openDVS_pixel2x2_top
x2_x197 dac_config_3 dac_config_5 col_event_rst_top_right[53] dac_config_4
+ row_on_detect_top[13] dac_config_0 dac_config_1 row_off_detect_top[12] x2_net21
+ dac_config_2 vdda1 vssa1 vssc1 col_event_rst_top_right[52] x2_net22
+ row_on_detect_top[12] row_off_detect_top[13] openDVS_pixel2x2_top
x2_x198 dac_config_3 dac_config_5 col_event_rst_top_right[51] dac_config_4
+ row_on_detect_top[13] dac_config_0 dac_config_1 row_off_detect_top[12] x2_net25
+ dac_config_2 vdda1 vssa1 vssc1 col_event_rst_top_right[50] x2_net26
+ row_on_detect_top[12] row_off_detect_top[13] openDVS_pixel2x2_top
x2_x199 dac_config_3 dac_config_5 col_event_rst_top_right[49] dac_config_4
+ row_on_detect_top[13] dac_config_0 dac_config_1 row_off_detect_top[12] x2_net29
+ dac_config_2 vdda1 vssa1 vssc1 col_event_rst_top_right[48] x2_net30
+ row_on_detect_top[12] row_off_detect_top[13] openDVS_pixel2x2_top
x2_x200 dac_config_3 dac_config_5 col_event_rst_top_right[47] dac_config_4
+ row_on_detect_top[13] dac_config_0 dac_config_1 row_off_detect_top[12] x2_net33
+ dac_config_2 vdda1 vssa1 vssc1 col_event_rst_top_right[46] x2_net34
+ row_on_detect_top[12] row_off_detect_top[13] openDVS_pixel2x2_top
x2_x201 dac_config_3 dac_config_5 col_event_rst_top_right[45] dac_config_4
+ row_on_detect_top[13] dac_config_0 dac_config_1 row_off_detect_top[12] x2_net37
+ dac_config_2 vdda1 vssa1 vssc1 col_event_rst_top_right[44] x2_net38
+ row_on_detect_top[12] row_off_detect_top[13] openDVS_pixel2x2_top
x2_x202 dac_config_3 dac_config_5 col_event_rst_top_right[43] dac_config_4
+ row_on_detect_top[13] dac_config_0 dac_config_1 row_off_detect_top[12] x2_net41
+ dac_config_2 vdda1 vssa1 vssc1 col_event_rst_top_right[42] x2_net42
+ row_on_detect_top[12] row_off_detect_top[13] openDVS_pixel2x2_top
x2_x203 dac_config_3 dac_config_5 col_event_rst_top_right[41] dac_config_4
+ row_on_detect_top[13] dac_config_0 dac_config_1 row_off_detect_top[12] x2_net45
+ dac_config_2 vdda1 vssa1 vssc1 col_event_rst_top_right[40] x2_net46
+ row_on_detect_top[12] row_off_detect_top[13] openDVS_pixel2x2_top
x2_x204 dac_config_3 dac_config_5 col_event_rst_top_right[39] dac_config_4
+ row_on_detect_top[13] dac_config_0 dac_config_1 row_off_detect_top[12] x2_net49
+ dac_config_2 vdda1 vssa1 vssc1 col_event_rst_top_right[38] x2_net50
+ row_on_detect_top[12] row_off_detect_top[13] openDVS_pixel2x2_top
x2_x205 dac_config_3 dac_config_5 col_event_rst_top_right[37] dac_config_4
+ row_on_detect_top[13] dac_config_0 dac_config_1 row_off_detect_top[12] x2_net53
+ dac_config_2 vdda1 vssa1 vssc1 col_event_rst_top_right[36] x2_net54
+ row_on_detect_top[12] row_off_detect_top[13] openDVS_pixel2x2_top
x2_x206 dac_config_3 dac_config_5 col_event_rst_top_right[35] dac_config_4
+ row_on_detect_top[13] dac_config_0 dac_config_1 row_off_detect_top[12] x2_net57
+ dac_config_2 vdda1 vssa1 vssc1 col_event_rst_top_right[34] x2_net58
+ row_on_detect_top[12] row_off_detect_top[13] openDVS_pixel2x2_top
x2_x207 dac_config_3 dac_config_5 col_event_rst_top_right[33] dac_config_4
+ row_on_detect_top[13] dac_config_0 dac_config_1 row_off_detect_top[12] x2_net61
+ dac_config_2 vdda1 vssa1 vssc1 col_event_rst_top_right[32] x2_net62
+ row_on_detect_top[12] row_off_detect_top[13] openDVS_pixel2x2_top
x2_x208 dac_config_3 dac_config_5 col_event_rst_top_right[31] dac_config_4
+ row_on_detect_top[13] dac_config_0 dac_config_1 row_off_detect_top[12] x2_net65
+ dac_config_2 vdda1 vssa1 vssc1 col_event_rst_top_right[30] x2_net66
+ row_on_detect_top[12] row_off_detect_top[13] openDVS_pixel2x2_top
x2_x209 dac_config_3 dac_config_5 col_event_rst_top_right[29] dac_config_4
+ row_on_detect_top[13] dac_config_0 dac_config_1 row_off_detect_top[12] x2_net69
+ dac_config_2 vdda1 vssa1 vssc1 col_event_rst_top_right[28] x2_net70
+ row_on_detect_top[12] row_off_detect_top[13] openDVS_pixel2x2_top
x2_x210 dac_config_3 dac_config_5 col_event_rst_top_right[27] dac_config_4
+ row_on_detect_top[13] dac_config_0 dac_config_1 row_off_detect_top[12] x2_net73
+ dac_config_2 vdda1 vssa1 vssc1 col_event_rst_top_right[26] x2_net74
+ row_on_detect_top[12] row_off_detect_top[13] openDVS_pixel2x2_top
x2_x211 dac_config_3 dac_config_5 col_event_rst_top_right[25] dac_config_4
+ row_on_detect_top[13] dac_config_0 dac_config_1 row_off_detect_top[12] x2_net77
+ dac_config_2 vdda1 vssa1 vssc1 col_event_rst_top_right[24] x2_net78
+ row_on_detect_top[12] row_off_detect_top[13] openDVS_pixel2x2_top
x2_x212 dac_config_3 dac_config_5 col_event_rst_top_right[23] dac_config_4
+ row_on_detect_top[13] dac_config_0 dac_config_1 row_off_detect_top[12] x2_net81
+ dac_config_2 vdda1 vssa1 vssc1 col_event_rst_top_right[22] x2_net82
+ row_on_detect_top[12] row_off_detect_top[13] openDVS_pixel2x2_top
x2_x213 dac_config_3 dac_config_5 col_event_rst_top_right[21] dac_config_4
+ row_on_detect_top[13] dac_config_0 dac_config_1 row_off_detect_top[12] x2_net85
+ dac_config_2 vdda1 vssa1 vssc1 col_event_rst_top_right[20] x2_net86
+ row_on_detect_top[12] row_off_detect_top[13] openDVS_pixel2x2_top
x2_x214 dac_config_3 dac_config_5 col_event_rst_top_right[19] dac_config_4
+ row_on_detect_top[13] dac_config_0 dac_config_1 row_off_detect_top[12] x2_net89
+ dac_config_2 vdda1 vssa1 vssc1 col_event_rst_top_right[18] x2_net90
+ row_on_detect_top[12] row_off_detect_top[13] openDVS_pixel2x2_top
x2_x215 dac_config_3 dac_config_5 col_event_rst_top_right[17] dac_config_4
+ row_on_detect_top[13] dac_config_0 dac_config_1 row_off_detect_top[12] x2_net93
+ dac_config_2 vdda1 vssa1 vssc1 col_event_rst_top_right[16] x2_net94
+ row_on_detect_top[12] row_off_detect_top[13] openDVS_pixel2x2_top
x2_x216 dac_config_3 dac_config_5 col_event_rst_top_right[15] dac_config_4
+ row_on_detect_top[13] dac_config_0 dac_config_1 row_off_detect_top[12] x2_net97
+ dac_config_2 vdda1 vssa1 vssc1 col_event_rst_top_right[14] x2_net98
+ row_on_detect_top[12] row_off_detect_top[13] openDVS_pixel2x2_top
x2_x217 dac_config_3 dac_config_5 col_event_rst_top_right[13] dac_config_4
+ row_on_detect_top[13] dac_config_0 dac_config_1 row_off_detect_top[12] x2_net101
+ dac_config_2 vdda1 vssa1 vssc1 col_event_rst_top_right[12] x2_net102
+ row_on_detect_top[12] row_off_detect_top[13] openDVS_pixel2x2_top
x2_x218 dac_config_3 dac_config_5 col_event_rst_top_right[11] dac_config_4
+ row_on_detect_top[13] dac_config_0 dac_config_1 row_off_detect_top[12] x2_net105
+ dac_config_2 vdda1 vssa1 vssc1 col_event_rst_top_right[10] x2_net106
+ row_on_detect_top[12] row_off_detect_top[13] openDVS_pixel2x2_top
x2_x219 dac_config_3 dac_config_5 col_event_rst_top_right[9] dac_config_4
+ row_on_detect_top[13] dac_config_0 dac_config_1 row_off_detect_top[12] x2_net109
+ dac_config_2 vdda1 vssa1 vssc1 col_event_rst_top_right[8] x2_net110
+ row_on_detect_top[12] row_off_detect_top[13] openDVS_pixel2x2_top
x2_x220 dac_config_3 dac_config_5 col_event_rst_top_right[7] dac_config_4
+ row_on_detect_top[13] dac_config_0 dac_config_1 row_off_detect_top[12] x2_net113
+ dac_config_2 vdda1 vssa1 vssc1 col_event_rst_top_right[6] x2_net114
+ row_on_detect_top[12] row_off_detect_top[13] openDVS_pixel2x2_top
x2_x221 dac_config_3 dac_config_5 col_event_rst_top_right[5] dac_config_4
+ row_on_detect_top[13] dac_config_0 dac_config_1 row_off_detect_top[12] x2_net117
+ dac_config_2 vdda1 vssa1 vssc1 col_event_rst_top_right[4] x2_net118
+ row_on_detect_top[12] row_off_detect_top[13] openDVS_pixel2x2_top
x2_x222 dac_config_3 dac_config_5 col_event_rst_top_right[3] dac_config_4
+ row_on_detect_top[13] dac_config_0 dac_config_1 row_off_detect_top[12] x2_net121
+ dac_config_2 vdda1 vssa1 vssc1 col_event_rst_top_right[2] x2_net122
+ row_on_detect_top[12] row_off_detect_top[13] openDVS_pixel2x2_top
x2_x223 dac_config_3 dac_config_5 col_event_rst_top_right[1] dac_config_4
+ row_on_detect_top[13] dac_config_0 dac_config_1 row_off_detect_top[12] x2_net125
+ dac_config_2 vdda1 vssa1 vssc1 col_event_rst_top_right[0] x2_net126
+ row_on_detect_top[12] row_off_detect_top[13] openDVS_pixel2x2_top
x2_x224 dac_config_3 dac_config_5 col_event_rst_top_right[63] dac_config_4
+ row_on_detect_top[15] dac_config_0 dac_config_1 row_off_detect_top[14] x2_net1
+ dac_config_2 vdda1 vssa1 vssc1 col_event_rst_top_right[62] x2_net2 row_on_detect_top[14]
+ row_off_detect_top[15] openDVS_pixel2x2_top
x2_x225 dac_config_3 dac_config_5 col_event_rst_top_right[61] dac_config_4
+ row_on_detect_top[15] dac_config_0 dac_config_1 row_off_detect_top[14] x2_net5
+ dac_config_2 vdda1 vssa1 vssc1 col_event_rst_top_right[60] x2_net6 row_on_detect_top[14]
+ row_off_detect_top[15] openDVS_pixel2x2_top
x2_x226 dac_config_3 dac_config_5 col_event_rst_top_right[59] dac_config_4
+ row_on_detect_top[15] dac_config_0 dac_config_1 row_off_detect_top[14] x2_net9
+ dac_config_2 vdda1 vssa1 vssc1 col_event_rst_top_right[58] x2_net10
+ row_on_detect_top[14] row_off_detect_top[15] openDVS_pixel2x2_top
x2_x227 dac_config_3 dac_config_5 col_event_rst_top_right[57] dac_config_4
+ row_on_detect_top[15] dac_config_0 dac_config_1 row_off_detect_top[14] x2_net13
+ dac_config_2 vdda1 vssa1 vssc1 col_event_rst_top_right[56] x2_net14
+ row_on_detect_top[14] row_off_detect_top[15] openDVS_pixel2x2_top
x2_x228 dac_config_3 dac_config_5 col_event_rst_top_right[55] dac_config_4
+ row_on_detect_top[15] dac_config_0 dac_config_1 row_off_detect_top[14] x2_net17
+ dac_config_2 vdda1 vssa1 vssc1 col_event_rst_top_right[54] x2_net18
+ row_on_detect_top[14] row_off_detect_top[15] openDVS_pixel2x2_top
x2_x229 dac_config_3 dac_config_5 col_event_rst_top_right[53] dac_config_4
+ row_on_detect_top[15] dac_config_0 dac_config_1 row_off_detect_top[14] x2_net21
+ dac_config_2 vdda1 vssa1 vssc1 col_event_rst_top_right[52] x2_net22
+ row_on_detect_top[14] row_off_detect_top[15] openDVS_pixel2x2_top
x2_x230 dac_config_3 dac_config_5 col_event_rst_top_right[51] dac_config_4
+ row_on_detect_top[15] dac_config_0 dac_config_1 row_off_detect_top[14] x2_net25
+ dac_config_2 vdda1 vssa1 vssc1 col_event_rst_top_right[50] x2_net26
+ row_on_detect_top[14] row_off_detect_top[15] openDVS_pixel2x2_top
x2_x231 dac_config_3 dac_config_5 col_event_rst_top_right[49] dac_config_4
+ row_on_detect_top[15] dac_config_0 dac_config_1 row_off_detect_top[14] x2_net29
+ dac_config_2 vdda1 vssa1 vssc1 col_event_rst_top_right[48] x2_net30
+ row_on_detect_top[14] row_off_detect_top[15] openDVS_pixel2x2_top
x2_x232 dac_config_3 dac_config_5 col_event_rst_top_right[47] dac_config_4
+ row_on_detect_top[15] dac_config_0 dac_config_1 row_off_detect_top[14] x2_net33
+ dac_config_2 vdda1 vssa1 vssc1 col_event_rst_top_right[46] x2_net34
+ row_on_detect_top[14] row_off_detect_top[15] openDVS_pixel2x2_top
x2_x233 dac_config_3 dac_config_5 col_event_rst_top_right[45] dac_config_4
+ row_on_detect_top[15] dac_config_0 dac_config_1 row_off_detect_top[14] x2_net37
+ dac_config_2 vdda1 vssa1 vssc1 col_event_rst_top_right[44] x2_net38
+ row_on_detect_top[14] row_off_detect_top[15] openDVS_pixel2x2_top
x2_x234 dac_config_3 dac_config_5 col_event_rst_top_right[43] dac_config_4
+ row_on_detect_top[15] dac_config_0 dac_config_1 row_off_detect_top[14] x2_net41
+ dac_config_2 vdda1 vssa1 vssc1 col_event_rst_top_right[42] x2_net42
+ row_on_detect_top[14] row_off_detect_top[15] openDVS_pixel2x2_top
x2_x235 dac_config_3 dac_config_5 col_event_rst_top_right[41] dac_config_4
+ row_on_detect_top[15] dac_config_0 dac_config_1 row_off_detect_top[14] x2_net45
+ dac_config_2 vdda1 vssa1 vssc1 col_event_rst_top_right[40] x2_net46
+ row_on_detect_top[14] row_off_detect_top[15] openDVS_pixel2x2_top
x2_x236 dac_config_3 dac_config_5 col_event_rst_top_right[39] dac_config_4
+ row_on_detect_top[15] dac_config_0 dac_config_1 row_off_detect_top[14] x2_net49
+ dac_config_2 vdda1 vssa1 vssc1 col_event_rst_top_right[38] x2_net50
+ row_on_detect_top[14] row_off_detect_top[15] openDVS_pixel2x2_top
x2_x237 dac_config_3 dac_config_5 col_event_rst_top_right[37] dac_config_4
+ row_on_detect_top[15] dac_config_0 dac_config_1 row_off_detect_top[14] x2_net53
+ dac_config_2 vdda1 vssa1 vssc1 col_event_rst_top_right[36] x2_net54
+ row_on_detect_top[14] row_off_detect_top[15] openDVS_pixel2x2_top
x2_x238 dac_config_3 dac_config_5 col_event_rst_top_right[35] dac_config_4
+ row_on_detect_top[15] dac_config_0 dac_config_1 row_off_detect_top[14] x2_net57
+ dac_config_2 vdda1 vssa1 vssc1 col_event_rst_top_right[34] x2_net58
+ row_on_detect_top[14] row_off_detect_top[15] openDVS_pixel2x2_top
x2_x239 dac_config_3 dac_config_5 col_event_rst_top_right[33] dac_config_4
+ row_on_detect_top[15] dac_config_0 dac_config_1 row_off_detect_top[14] x2_net61
+ dac_config_2 vdda1 vssa1 vssc1 col_event_rst_top_right[32] x2_net62
+ row_on_detect_top[14] row_off_detect_top[15] openDVS_pixel2x2_top
x2_x240 dac_config_3 dac_config_5 col_event_rst_top_right[31] dac_config_4
+ row_on_detect_top[15] dac_config_0 dac_config_1 row_off_detect_top[14] x2_net65
+ dac_config_2 vdda1 vssa1 vssc1 col_event_rst_top_right[30] x2_net66
+ row_on_detect_top[14] row_off_detect_top[15] openDVS_pixel2x2_top
x2_x241 dac_config_3 dac_config_5 col_event_rst_top_right[29] dac_config_4
+ row_on_detect_top[15] dac_config_0 dac_config_1 row_off_detect_top[14] x2_net69
+ dac_config_2 vdda1 vssa1 vssc1 col_event_rst_top_right[28] x2_net70
+ row_on_detect_top[14] row_off_detect_top[15] openDVS_pixel2x2_top
x2_x242 dac_config_3 dac_config_5 col_event_rst_top_right[27] dac_config_4
+ row_on_detect_top[15] dac_config_0 dac_config_1 row_off_detect_top[14] x2_net73
+ dac_config_2 vdda1 vssa1 vssc1 col_event_rst_top_right[26] x2_net74
+ row_on_detect_top[14] row_off_detect_top[15] openDVS_pixel2x2_top
x2_x243 dac_config_3 dac_config_5 col_event_rst_top_right[25] dac_config_4
+ row_on_detect_top[15] dac_config_0 dac_config_1 row_off_detect_top[14] x2_net77
+ dac_config_2 vdda1 vssa1 vssc1 col_event_rst_top_right[24] x2_net78
+ row_on_detect_top[14] row_off_detect_top[15] openDVS_pixel2x2_top
x2_x244 dac_config_3 dac_config_5 col_event_rst_top_right[23] dac_config_4
+ row_on_detect_top[15] dac_config_0 dac_config_1 row_off_detect_top[14] x2_net81
+ dac_config_2 vdda1 vssa1 vssc1 col_event_rst_top_right[22] x2_net82
+ row_on_detect_top[14] row_off_detect_top[15] openDVS_pixel2x2_top
x2_x245 dac_config_3 dac_config_5 col_event_rst_top_right[21] dac_config_4
+ row_on_detect_top[15] dac_config_0 dac_config_1 row_off_detect_top[14] x2_net85
+ dac_config_2 vdda1 vssa1 vssc1 col_event_rst_top_right[20] x2_net86
+ row_on_detect_top[14] row_off_detect_top[15] openDVS_pixel2x2_top
x2_x246 dac_config_3 dac_config_5 col_event_rst_top_right[19] dac_config_4
+ row_on_detect_top[15] dac_config_0 dac_config_1 row_off_detect_top[14] x2_net89
+ dac_config_2 vdda1 vssa1 vssc1 col_event_rst_top_right[18] x2_net90
+ row_on_detect_top[14] row_off_detect_top[15] openDVS_pixel2x2_top
x2_x247 dac_config_3 dac_config_5 col_event_rst_top_right[17] dac_config_4
+ row_on_detect_top[15] dac_config_0 dac_config_1 row_off_detect_top[14] x2_net93
+ dac_config_2 vdda1 vssa1 vssc1 col_event_rst_top_right[16] x2_net94
+ row_on_detect_top[14] row_off_detect_top[15] openDVS_pixel2x2_top
x2_x248 dac_config_3 dac_config_5 col_event_rst_top_right[15] dac_config_4
+ row_on_detect_top[15] dac_config_0 dac_config_1 row_off_detect_top[14] x2_net97
+ dac_config_2 vdda1 vssa1 vssc1 col_event_rst_top_right[14] x2_net98
+ row_on_detect_top[14] row_off_detect_top[15] openDVS_pixel2x2_top
x2_x249 dac_config_3 dac_config_5 col_event_rst_top_right[13] dac_config_4
+ row_on_detect_top[15] dac_config_0 dac_config_1 row_off_detect_top[14] x2_net101
+ dac_config_2 vdda1 vssa1 vssc1 col_event_rst_top_right[12] x2_net102
+ row_on_detect_top[14] row_off_detect_top[15] openDVS_pixel2x2_top
x2_x250 dac_config_3 dac_config_5 col_event_rst_top_right[11] dac_config_4
+ row_on_detect_top[15] dac_config_0 dac_config_1 row_off_detect_top[14] x2_net105
+ dac_config_2 vdda1 vssa1 vssc1 col_event_rst_top_right[10] x2_net106
+ row_on_detect_top[14] row_off_detect_top[15] openDVS_pixel2x2_top
x2_x251 dac_config_3 dac_config_5 col_event_rst_top_right[9] dac_config_4
+ row_on_detect_top[15] dac_config_0 dac_config_1 row_off_detect_top[14] x2_net109
+ dac_config_2 vdda1 vssa1 vssc1 col_event_rst_top_right[8] x2_net110
+ row_on_detect_top[14] row_off_detect_top[15] openDVS_pixel2x2_top
x2_x252 dac_config_3 dac_config_5 col_event_rst_top_right[7] dac_config_4
+ row_on_detect_top[15] dac_config_0 dac_config_1 row_off_detect_top[14] x2_net113
+ dac_config_2 vdda1 vssa1 vssc1 col_event_rst_top_right[6] x2_net114
+ row_on_detect_top[14] row_off_detect_top[15] openDVS_pixel2x2_top
x2_x253 dac_config_3 dac_config_5 col_event_rst_top_right[5] dac_config_4
+ row_on_detect_top[15] dac_config_0 dac_config_1 row_off_detect_top[14] x2_net117
+ dac_config_2 vdda1 vssa1 vssc1 col_event_rst_top_right[4] x2_net118
+ row_on_detect_top[14] row_off_detect_top[15] openDVS_pixel2x2_top
x2_x254 dac_config_3 dac_config_5 col_event_rst_top_right[3] dac_config_4
+ row_on_detect_top[15] dac_config_0 dac_config_1 row_off_detect_top[14] x2_net121
+ dac_config_2 vdda1 vssa1 vssc1 col_event_rst_top_right[2] x2_net122
+ row_on_detect_top[14] row_off_detect_top[15] openDVS_pixel2x2_top
x2_x255 dac_config_3 dac_config_5 col_event_rst_top_right[1] dac_config_4
+ row_on_detect_top[15] dac_config_0 dac_config_1 row_off_detect_top[14] x2_net125
+ dac_config_2 vdda1 vssa1 vssc1 col_event_rst_top_right[0] x2_net126
+ row_on_detect_top[14] row_off_detect_top[15] openDVS_pixel2x2_top
x2_x256 dac_config_3 dac_config_5 col_event_rst_top_right[63] dac_config_4
+ row_on_detect_top[17] dac_config_0 dac_config_1 row_off_detect_top[16] x2_net1
+ dac_config_2 vdda1 vssa1 vssc1 col_event_rst_top_right[62] x2_net2 row_on_detect_top[16]
+ row_off_detect_top[17] openDVS_pixel2x2_top
x2_x257 dac_config_3 dac_config_5 col_event_rst_top_right[61] dac_config_4
+ row_on_detect_top[17] dac_config_0 dac_config_1 row_off_detect_top[16] x2_net5
+ dac_config_2 vdda1 vssa1 vssc1 col_event_rst_top_right[60] x2_net6 row_on_detect_top[16]
+ row_off_detect_top[17] openDVS_pixel2x2_top
x2_x258 dac_config_3 dac_config_5 col_event_rst_top_right[59] dac_config_4
+ row_on_detect_top[17] dac_config_0 dac_config_1 row_off_detect_top[16] x2_net9
+ dac_config_2 vdda1 vssa1 vssc1 col_event_rst_top_right[58] x2_net10
+ row_on_detect_top[16] row_off_detect_top[17] openDVS_pixel2x2_top
x2_x259 dac_config_3 dac_config_5 col_event_rst_top_right[57] dac_config_4
+ row_on_detect_top[17] dac_config_0 dac_config_1 row_off_detect_top[16] x2_net13
+ dac_config_2 vdda1 vssa1 vssc1 col_event_rst_top_right[56] x2_net14
+ row_on_detect_top[16] row_off_detect_top[17] openDVS_pixel2x2_top
x2_x260 dac_config_3 dac_config_5 col_event_rst_top_right[55] dac_config_4
+ row_on_detect_top[17] dac_config_0 dac_config_1 row_off_detect_top[16] x2_net17
+ dac_config_2 vdda1 vssa1 vssc1 col_event_rst_top_right[54] x2_net18
+ row_on_detect_top[16] row_off_detect_top[17] openDVS_pixel2x2_top
x2_x261 dac_config_3 dac_config_5 col_event_rst_top_right[53] dac_config_4
+ row_on_detect_top[17] dac_config_0 dac_config_1 row_off_detect_top[16] x2_net21
+ dac_config_2 vdda1 vssa1 vssc1 col_event_rst_top_right[52] x2_net22
+ row_on_detect_top[16] row_off_detect_top[17] openDVS_pixel2x2_top
x2_x262 dac_config_3 dac_config_5 col_event_rst_top_right[51] dac_config_4
+ row_on_detect_top[17] dac_config_0 dac_config_1 row_off_detect_top[16] x2_net25
+ dac_config_2 vdda1 vssa1 vssc1 col_event_rst_top_right[50] x2_net26
+ row_on_detect_top[16] row_off_detect_top[17] openDVS_pixel2x2_top
x2_x263 dac_config_3 dac_config_5 col_event_rst_top_right[49] dac_config_4
+ row_on_detect_top[17] dac_config_0 dac_config_1 row_off_detect_top[16] x2_net29
+ dac_config_2 vdda1 vssa1 vssc1 col_event_rst_top_right[48] x2_net30
+ row_on_detect_top[16] row_off_detect_top[17] openDVS_pixel2x2_top
x2_x264 dac_config_3 dac_config_5 col_event_rst_top_right[47] dac_config_4
+ row_on_detect_top[17] dac_config_0 dac_config_1 row_off_detect_top[16] x2_net33
+ dac_config_2 vdda1 vssa1 vssc1 col_event_rst_top_right[46] x2_net34
+ row_on_detect_top[16] row_off_detect_top[17] openDVS_pixel2x2_top
x2_x265 dac_config_3 dac_config_5 col_event_rst_top_right[45] dac_config_4
+ row_on_detect_top[17] dac_config_0 dac_config_1 row_off_detect_top[16] x2_net37
+ dac_config_2 vdda1 vssa1 vssc1 col_event_rst_top_right[44] x2_net38
+ row_on_detect_top[16] row_off_detect_top[17] openDVS_pixel2x2_top
x2_x266 dac_config_3 dac_config_5 col_event_rst_top_right[43] dac_config_4
+ row_on_detect_top[17] dac_config_0 dac_config_1 row_off_detect_top[16] x2_net41
+ dac_config_2 vdda1 vssa1 vssc1 col_event_rst_top_right[42] x2_net42
+ row_on_detect_top[16] row_off_detect_top[17] openDVS_pixel2x2_top
x2_x267 dac_config_3 dac_config_5 col_event_rst_top_right[41] dac_config_4
+ row_on_detect_top[17] dac_config_0 dac_config_1 row_off_detect_top[16] x2_net45
+ dac_config_2 vdda1 vssa1 vssc1 col_event_rst_top_right[40] x2_net46
+ row_on_detect_top[16] row_off_detect_top[17] openDVS_pixel2x2_top
x2_x268 dac_config_3 dac_config_5 col_event_rst_top_right[39] dac_config_4
+ row_on_detect_top[17] dac_config_0 dac_config_1 row_off_detect_top[16] x2_net49
+ dac_config_2 vdda1 vssa1 vssc1 col_event_rst_top_right[38] x2_net50
+ row_on_detect_top[16] row_off_detect_top[17] openDVS_pixel2x2_top
x2_x269 dac_config_3 dac_config_5 col_event_rst_top_right[37] dac_config_4
+ row_on_detect_top[17] dac_config_0 dac_config_1 row_off_detect_top[16] x2_net53
+ dac_config_2 vdda1 vssa1 vssc1 col_event_rst_top_right[36] x2_net54
+ row_on_detect_top[16] row_off_detect_top[17] openDVS_pixel2x2_top
x2_x270 dac_config_3 dac_config_5 col_event_rst_top_right[35] dac_config_4
+ row_on_detect_top[17] dac_config_0 dac_config_1 row_off_detect_top[16] x2_net57
+ dac_config_2 vdda1 vssa1 vssc1 col_event_rst_top_right[34] x2_net58
+ row_on_detect_top[16] row_off_detect_top[17] openDVS_pixel2x2_top
x2_x271 dac_config_3 dac_config_5 col_event_rst_top_right[33] dac_config_4
+ row_on_detect_top[17] dac_config_0 dac_config_1 row_off_detect_top[16] x2_net61
+ dac_config_2 vdda1 vssa1 vssc1 col_event_rst_top_right[32] x2_net62
+ row_on_detect_top[16] row_off_detect_top[17] openDVS_pixel2x2_top
x2_x272 dac_config_3 dac_config_5 col_event_rst_top_right[31] dac_config_4
+ row_on_detect_top[17] dac_config_0 dac_config_1 row_off_detect_top[16] x2_net65
+ dac_config_2 vdda1 vssa1 vssc1 col_event_rst_top_right[30] x2_net66
+ row_on_detect_top[16] row_off_detect_top[17] openDVS_pixel2x2_top
x2_x273 dac_config_3 dac_config_5 col_event_rst_top_right[29] dac_config_4
+ row_on_detect_top[17] dac_config_0 dac_config_1 row_off_detect_top[16] x2_net69
+ dac_config_2 vdda1 vssa1 vssc1 col_event_rst_top_right[28] x2_net70
+ row_on_detect_top[16] row_off_detect_top[17] openDVS_pixel2x2_top
x2_x274 dac_config_3 dac_config_5 col_event_rst_top_right[27] dac_config_4
+ row_on_detect_top[17] dac_config_0 dac_config_1 row_off_detect_top[16] x2_net73
+ dac_config_2 vdda1 vssa1 vssc1 col_event_rst_top_right[26] x2_net74
+ row_on_detect_top[16] row_off_detect_top[17] openDVS_pixel2x2_top
x2_x275 dac_config_3 dac_config_5 col_event_rst_top_right[25] dac_config_4
+ row_on_detect_top[17] dac_config_0 dac_config_1 row_off_detect_top[16] x2_net77
+ dac_config_2 vdda1 vssa1 vssc1 col_event_rst_top_right[24] x2_net78
+ row_on_detect_top[16] row_off_detect_top[17] openDVS_pixel2x2_top
x2_x276 dac_config_3 dac_config_5 col_event_rst_top_right[23] dac_config_4
+ row_on_detect_top[17] dac_config_0 dac_config_1 row_off_detect_top[16] x2_net81
+ dac_config_2 vdda1 vssa1 vssc1 col_event_rst_top_right[22] x2_net82
+ row_on_detect_top[16] row_off_detect_top[17] openDVS_pixel2x2_top
x2_x277 dac_config_3 dac_config_5 col_event_rst_top_right[21] dac_config_4
+ row_on_detect_top[17] dac_config_0 dac_config_1 row_off_detect_top[16] x2_net85
+ dac_config_2 vdda1 vssa1 vssc1 col_event_rst_top_right[20] x2_net86
+ row_on_detect_top[16] row_off_detect_top[17] openDVS_pixel2x2_top
x2_x278 dac_config_3 dac_config_5 col_event_rst_top_right[19] dac_config_4
+ row_on_detect_top[17] dac_config_0 dac_config_1 row_off_detect_top[16] x2_net89
+ dac_config_2 vdda1 vssa1 vssc1 col_event_rst_top_right[18] x2_net90
+ row_on_detect_top[16] row_off_detect_top[17] openDVS_pixel2x2_top
x2_x279 dac_config_3 dac_config_5 col_event_rst_top_right[17] dac_config_4
+ row_on_detect_top[17] dac_config_0 dac_config_1 row_off_detect_top[16] x2_net93
+ dac_config_2 vdda1 vssa1 vssc1 col_event_rst_top_right[16] x2_net94
+ row_on_detect_top[16] row_off_detect_top[17] openDVS_pixel2x2_top
x2_x280 dac_config_3 dac_config_5 col_event_rst_top_right[15] dac_config_4
+ row_on_detect_top[17] dac_config_0 dac_config_1 row_off_detect_top[16] x2_net97
+ dac_config_2 vdda1 vssa1 vssc1 col_event_rst_top_right[14] x2_net98
+ row_on_detect_top[16] row_off_detect_top[17] openDVS_pixel2x2_top
x2_x281 dac_config_3 dac_config_5 col_event_rst_top_right[13] dac_config_4
+ row_on_detect_top[17] dac_config_0 dac_config_1 row_off_detect_top[16] x2_net101
+ dac_config_2 vdda1 vssa1 vssc1 col_event_rst_top_right[12] x2_net102
+ row_on_detect_top[16] row_off_detect_top[17] openDVS_pixel2x2_top
x2_x282 dac_config_3 dac_config_5 col_event_rst_top_right[11] dac_config_4
+ row_on_detect_top[17] dac_config_0 dac_config_1 row_off_detect_top[16] x2_net105
+ dac_config_2 vdda1 vssa1 vssc1 col_event_rst_top_right[10] x2_net106
+ row_on_detect_top[16] row_off_detect_top[17] openDVS_pixel2x2_top
x2_x283 dac_config_3 dac_config_5 col_event_rst_top_right[9] dac_config_4
+ row_on_detect_top[17] dac_config_0 dac_config_1 row_off_detect_top[16] x2_net109
+ dac_config_2 vdda1 vssa1 vssc1 col_event_rst_top_right[8] x2_net110
+ row_on_detect_top[16] row_off_detect_top[17] openDVS_pixel2x2_top
x2_x284 dac_config_3 dac_config_5 col_event_rst_top_right[7] dac_config_4
+ row_on_detect_top[17] dac_config_0 dac_config_1 row_off_detect_top[16] x2_net113
+ dac_config_2 vdda1 vssa1 vssc1 col_event_rst_top_right[6] x2_net114
+ row_on_detect_top[16] row_off_detect_top[17] openDVS_pixel2x2_top
x2_x285 dac_config_3 dac_config_5 col_event_rst_top_right[5] dac_config_4
+ row_on_detect_top[17] dac_config_0 dac_config_1 row_off_detect_top[16] x2_net117
+ dac_config_2 vdda1 vssa1 vssc1 col_event_rst_top_right[4] x2_net118
+ row_on_detect_top[16] row_off_detect_top[17] openDVS_pixel2x2_top
x2_x286 dac_config_3 dac_config_5 col_event_rst_top_right[3] dac_config_4
+ row_on_detect_top[17] dac_config_0 dac_config_1 row_off_detect_top[16] x2_net121
+ dac_config_2 vdda1 vssa1 vssc1 col_event_rst_top_right[2] x2_net122
+ row_on_detect_top[16] row_off_detect_top[17] openDVS_pixel2x2_top
x2_x287 dac_config_3 dac_config_5 col_event_rst_top_right[1] dac_config_4
+ row_on_detect_top[17] dac_config_0 dac_config_1 row_off_detect_top[16] x2_net125
+ dac_config_2 vdda1 vssa1 vssc1 col_event_rst_top_right[0] x2_net126
+ row_on_detect_top[16] row_off_detect_top[17] openDVS_pixel2x2_top
x2_x288 dac_config_3 dac_config_5 col_event_rst_top_right[63] dac_config_4
+ row_on_detect_top[19] dac_config_0 dac_config_1 row_off_detect_top[18] x2_net1
+ dac_config_2 vdda1 vssa1 vssc1 col_event_rst_top_right[62] x2_net2 row_on_detect_top[18]
+ row_off_detect_top[19] openDVS_pixel2x2_top
x2_x289 dac_config_3 dac_config_5 col_event_rst_top_right[61] dac_config_4
+ row_on_detect_top[19] dac_config_0 dac_config_1 row_off_detect_top[18] x2_net5
+ dac_config_2 vdda1 vssa1 vssc1 col_event_rst_top_right[60] x2_net6 row_on_detect_top[18]
+ row_off_detect_top[19] openDVS_pixel2x2_top
x2_x290 dac_config_3 dac_config_5 col_event_rst_top_right[59] dac_config_4
+ row_on_detect_top[19] dac_config_0 dac_config_1 row_off_detect_top[18] x2_net9
+ dac_config_2 vdda1 vssa1 vssc1 col_event_rst_top_right[58] x2_net10
+ row_on_detect_top[18] row_off_detect_top[19] openDVS_pixel2x2_top
x2_x291 dac_config_3 dac_config_5 col_event_rst_top_right[57] dac_config_4
+ row_on_detect_top[19] dac_config_0 dac_config_1 row_off_detect_top[18] x2_net13
+ dac_config_2 vdda1 vssa1 vssc1 col_event_rst_top_right[56] x2_net14
+ row_on_detect_top[18] row_off_detect_top[19] openDVS_pixel2x2_top
x2_x292 dac_config_3 dac_config_5 col_event_rst_top_right[55] dac_config_4
+ row_on_detect_top[19] dac_config_0 dac_config_1 row_off_detect_top[18] x2_net17
+ dac_config_2 vdda1 vssa1 vssc1 col_event_rst_top_right[54] x2_net18
+ row_on_detect_top[18] row_off_detect_top[19] openDVS_pixel2x2_top
x2_x293 dac_config_3 dac_config_5 col_event_rst_top_right[53] dac_config_4
+ row_on_detect_top[19] dac_config_0 dac_config_1 row_off_detect_top[18] x2_net21
+ dac_config_2 vdda1 vssa1 vssc1 col_event_rst_top_right[52] x2_net22
+ row_on_detect_top[18] row_off_detect_top[19] openDVS_pixel2x2_top
x2_x294 dac_config_3 dac_config_5 col_event_rst_top_right[51] dac_config_4
+ row_on_detect_top[19] dac_config_0 dac_config_1 row_off_detect_top[18] x2_net25
+ dac_config_2 vdda1 vssa1 vssc1 col_event_rst_top_right[50] x2_net26
+ row_on_detect_top[18] row_off_detect_top[19] openDVS_pixel2x2_top
x2_x295 dac_config_3 dac_config_5 col_event_rst_top_right[49] dac_config_4
+ row_on_detect_top[19] dac_config_0 dac_config_1 row_off_detect_top[18] x2_net29
+ dac_config_2 vdda1 vssa1 vssc1 col_event_rst_top_right[48] x2_net30
+ row_on_detect_top[18] row_off_detect_top[19] openDVS_pixel2x2_top
x2_x296 dac_config_3 dac_config_5 col_event_rst_top_right[47] dac_config_4
+ row_on_detect_top[19] dac_config_0 dac_config_1 row_off_detect_top[18] x2_net33
+ dac_config_2 vdda1 vssa1 vssc1 col_event_rst_top_right[46] x2_net34
+ row_on_detect_top[18] row_off_detect_top[19] openDVS_pixel2x2_top
x2_x297 dac_config_3 dac_config_5 col_event_rst_top_right[45] dac_config_4
+ row_on_detect_top[19] dac_config_0 dac_config_1 row_off_detect_top[18] x2_net37
+ dac_config_2 vdda1 vssa1 vssc1 col_event_rst_top_right[44] x2_net38
+ row_on_detect_top[18] row_off_detect_top[19] openDVS_pixel2x2_top
x2_x298 dac_config_3 dac_config_5 col_event_rst_top_right[43] dac_config_4
+ row_on_detect_top[19] dac_config_0 dac_config_1 row_off_detect_top[18] x2_net41
+ dac_config_2 vdda1 vssa1 vssc1 col_event_rst_top_right[42] x2_net42
+ row_on_detect_top[18] row_off_detect_top[19] openDVS_pixel2x2_top
x2_x299 dac_config_3 dac_config_5 col_event_rst_top_right[41] dac_config_4
+ row_on_detect_top[19] dac_config_0 dac_config_1 row_off_detect_top[18] x2_net45
+ dac_config_2 vdda1 vssa1 vssc1 col_event_rst_top_right[40] x2_net46
+ row_on_detect_top[18] row_off_detect_top[19] openDVS_pixel2x2_top
x2_x300 dac_config_3 dac_config_5 col_event_rst_top_right[39] dac_config_4
+ row_on_detect_top[19] dac_config_0 dac_config_1 row_off_detect_top[18] x2_net49
+ dac_config_2 vdda1 vssa1 vssc1 col_event_rst_top_right[38] x2_net50
+ row_on_detect_top[18] row_off_detect_top[19] openDVS_pixel2x2_top
x2_x301 dac_config_3 dac_config_5 col_event_rst_top_right[37] dac_config_4
+ row_on_detect_top[19] dac_config_0 dac_config_1 row_off_detect_top[18] x2_net53
+ dac_config_2 vdda1 vssa1 vssc1 col_event_rst_top_right[36] x2_net54
+ row_on_detect_top[18] row_off_detect_top[19] openDVS_pixel2x2_top
x2_x302 dac_config_3 dac_config_5 col_event_rst_top_right[35] dac_config_4
+ row_on_detect_top[19] dac_config_0 dac_config_1 row_off_detect_top[18] x2_net57
+ dac_config_2 vdda1 vssa1 vssc1 col_event_rst_top_right[34] x2_net58
+ row_on_detect_top[18] row_off_detect_top[19] openDVS_pixel2x2_top
x2_x303 dac_config_3 dac_config_5 col_event_rst_top_right[33] dac_config_4
+ row_on_detect_top[19] dac_config_0 dac_config_1 row_off_detect_top[18] x2_net61
+ dac_config_2 vdda1 vssa1 vssc1 col_event_rst_top_right[32] x2_net62
+ row_on_detect_top[18] row_off_detect_top[19] openDVS_pixel2x2_top
x2_x304 dac_config_3 dac_config_5 col_event_rst_top_right[31] dac_config_4
+ row_on_detect_top[19] dac_config_0 dac_config_1 row_off_detect_top[18] x2_net65
+ dac_config_2 vdda1 vssa1 vssc1 col_event_rst_top_right[30] x2_net66
+ row_on_detect_top[18] row_off_detect_top[19] openDVS_pixel2x2_top
x2_x305 dac_config_3 dac_config_5 col_event_rst_top_right[29] dac_config_4
+ row_on_detect_top[19] dac_config_0 dac_config_1 row_off_detect_top[18] x2_net69
+ dac_config_2 vdda1 vssa1 vssc1 col_event_rst_top_right[28] x2_net70
+ row_on_detect_top[18] row_off_detect_top[19] openDVS_pixel2x2_top
x2_x306 dac_config_3 dac_config_5 col_event_rst_top_right[27] dac_config_4
+ row_on_detect_top[19] dac_config_0 dac_config_1 row_off_detect_top[18] x2_net73
+ dac_config_2 vdda1 vssa1 vssc1 col_event_rst_top_right[26] x2_net74
+ row_on_detect_top[18] row_off_detect_top[19] openDVS_pixel2x2_top
x2_x307 dac_config_3 dac_config_5 col_event_rst_top_right[25] dac_config_4
+ row_on_detect_top[19] dac_config_0 dac_config_1 row_off_detect_top[18] x2_net77
+ dac_config_2 vdda1 vssa1 vssc1 col_event_rst_top_right[24] x2_net78
+ row_on_detect_top[18] row_off_detect_top[19] openDVS_pixel2x2_top
x2_x308 dac_config_3 dac_config_5 col_event_rst_top_right[23] dac_config_4
+ row_on_detect_top[19] dac_config_0 dac_config_1 row_off_detect_top[18] x2_net81
+ dac_config_2 vdda1 vssa1 vssc1 col_event_rst_top_right[22] x2_net82
+ row_on_detect_top[18] row_off_detect_top[19] openDVS_pixel2x2_top
x2_x309 dac_config_3 dac_config_5 col_event_rst_top_right[21] dac_config_4
+ row_on_detect_top[19] dac_config_0 dac_config_1 row_off_detect_top[18] x2_net85
+ dac_config_2 vdda1 vssa1 vssc1 col_event_rst_top_right[20] x2_net86
+ row_on_detect_top[18] row_off_detect_top[19] openDVS_pixel2x2_top
x2_x310 dac_config_3 dac_config_5 col_event_rst_top_right[19] dac_config_4
+ row_on_detect_top[19] dac_config_0 dac_config_1 row_off_detect_top[18] x2_net89
+ dac_config_2 vdda1 vssa1 vssc1 col_event_rst_top_right[18] x2_net90
+ row_on_detect_top[18] row_off_detect_top[19] openDVS_pixel2x2_top
x2_x311 dac_config_3 dac_config_5 col_event_rst_top_right[17] dac_config_4
+ row_on_detect_top[19] dac_config_0 dac_config_1 row_off_detect_top[18] x2_net93
+ dac_config_2 vdda1 vssa1 vssc1 col_event_rst_top_right[16] x2_net94
+ row_on_detect_top[18] row_off_detect_top[19] openDVS_pixel2x2_top
x2_x312 dac_config_3 dac_config_5 col_event_rst_top_right[15] dac_config_4
+ row_on_detect_top[19] dac_config_0 dac_config_1 row_off_detect_top[18] x2_net97
+ dac_config_2 vdda1 vssa1 vssc1 col_event_rst_top_right[14] x2_net98
+ row_on_detect_top[18] row_off_detect_top[19] openDVS_pixel2x2_top
x2_x313 dac_config_3 dac_config_5 col_event_rst_top_right[13] dac_config_4
+ row_on_detect_top[19] dac_config_0 dac_config_1 row_off_detect_top[18] x2_net101
+ dac_config_2 vdda1 vssa1 vssc1 col_event_rst_top_right[12] x2_net102
+ row_on_detect_top[18] row_off_detect_top[19] openDVS_pixel2x2_top
x2_x314 dac_config_3 dac_config_5 col_event_rst_top_right[11] dac_config_4
+ row_on_detect_top[19] dac_config_0 dac_config_1 row_off_detect_top[18] x2_net105
+ dac_config_2 vdda1 vssa1 vssc1 col_event_rst_top_right[10] x2_net106
+ row_on_detect_top[18] row_off_detect_top[19] openDVS_pixel2x2_top
x2_x315 dac_config_3 dac_config_5 col_event_rst_top_right[9] dac_config_4
+ row_on_detect_top[19] dac_config_0 dac_config_1 row_off_detect_top[18] x2_net109
+ dac_config_2 vdda1 vssa1 vssc1 col_event_rst_top_right[8] x2_net110
+ row_on_detect_top[18] row_off_detect_top[19] openDVS_pixel2x2_top
x2_x316 dac_config_3 dac_config_5 col_event_rst_top_right[7] dac_config_4
+ row_on_detect_top[19] dac_config_0 dac_config_1 row_off_detect_top[18] x2_net113
+ dac_config_2 vdda1 vssa1 vssc1 col_event_rst_top_right[6] x2_net114
+ row_on_detect_top[18] row_off_detect_top[19] openDVS_pixel2x2_top
x2_x317 dac_config_3 dac_config_5 col_event_rst_top_right[5] dac_config_4
+ row_on_detect_top[19] dac_config_0 dac_config_1 row_off_detect_top[18] x2_net117
+ dac_config_2 vdda1 vssa1 vssc1 col_event_rst_top_right[4] x2_net118
+ row_on_detect_top[18] row_off_detect_top[19] openDVS_pixel2x2_top
x2_x318 dac_config_3 dac_config_5 col_event_rst_top_right[3] dac_config_4
+ row_on_detect_top[19] dac_config_0 dac_config_1 row_off_detect_top[18] x2_net121
+ dac_config_2 vdda1 vssa1 vssc1 col_event_rst_top_right[2] x2_net122
+ row_on_detect_top[18] row_off_detect_top[19] openDVS_pixel2x2_top
x2_x319 dac_config_3 dac_config_5 col_event_rst_top_right[1] dac_config_4
+ row_on_detect_top[19] dac_config_0 dac_config_1 row_off_detect_top[18] x2_net125
+ dac_config_2 vdda1 vssa1 vssc1 col_event_rst_top_right[0] x2_net126
+ row_on_detect_top[18] row_off_detect_top[19] openDVS_pixel2x2_top
x2_x320 dac_config_3 dac_config_5 col_event_rst_top_right[63] dac_config_4
+ row_on_detect_top[21] dac_config_0 dac_config_1 row_off_detect_top[20] x2_net1
+ dac_config_2 vdda1 vssa1 vssc1 col_event_rst_top_right[62] x2_net2 row_on_detect_top[20]
+ row_off_detect_top[21] openDVS_pixel2x2_top
x2_x321 dac_config_3 dac_config_5 col_event_rst_top_right[61] dac_config_4
+ row_on_detect_top[21] dac_config_0 dac_config_1 row_off_detect_top[20] x2_net5
+ dac_config_2 vdda1 vssa1 vssc1 col_event_rst_top_right[60] x2_net6 row_on_detect_top[20]
+ row_off_detect_top[21] openDVS_pixel2x2_top
x2_x322 dac_config_3 dac_config_5 col_event_rst_top_right[59] dac_config_4
+ row_on_detect_top[21] dac_config_0 dac_config_1 row_off_detect_top[20] x2_net9
+ dac_config_2 vdda1 vssa1 vssc1 col_event_rst_top_right[58] x2_net10
+ row_on_detect_top[20] row_off_detect_top[21] openDVS_pixel2x2_top
x2_x323 dac_config_3 dac_config_5 col_event_rst_top_right[57] dac_config_4
+ row_on_detect_top[21] dac_config_0 dac_config_1 row_off_detect_top[20] x2_net13
+ dac_config_2 vdda1 vssa1 vssc1 col_event_rst_top_right[56] x2_net14
+ row_on_detect_top[20] row_off_detect_top[21] openDVS_pixel2x2_top
x2_x324 dac_config_3 dac_config_5 col_event_rst_top_right[55] dac_config_4
+ row_on_detect_top[21] dac_config_0 dac_config_1 row_off_detect_top[20] x2_net17
+ dac_config_2 vdda1 vssa1 vssc1 col_event_rst_top_right[54] x2_net18
+ row_on_detect_top[20] row_off_detect_top[21] openDVS_pixel2x2_top
x2_x325 dac_config_3 dac_config_5 col_event_rst_top_right[53] dac_config_4
+ row_on_detect_top[21] dac_config_0 dac_config_1 row_off_detect_top[20] x2_net21
+ dac_config_2 vdda1 vssa1 vssc1 col_event_rst_top_right[52] x2_net22
+ row_on_detect_top[20] row_off_detect_top[21] openDVS_pixel2x2_top
x2_x326 dac_config_3 dac_config_5 col_event_rst_top_right[51] dac_config_4
+ row_on_detect_top[21] dac_config_0 dac_config_1 row_off_detect_top[20] x2_net25
+ dac_config_2 vdda1 vssa1 vssc1 col_event_rst_top_right[50] x2_net26
+ row_on_detect_top[20] row_off_detect_top[21] openDVS_pixel2x2_top
x2_x327 dac_config_3 dac_config_5 col_event_rst_top_right[49] dac_config_4
+ row_on_detect_top[21] dac_config_0 dac_config_1 row_off_detect_top[20] x2_net29
+ dac_config_2 vdda1 vssa1 vssc1 col_event_rst_top_right[48] x2_net30
+ row_on_detect_top[20] row_off_detect_top[21] openDVS_pixel2x2_top
x2_x328 dac_config_3 dac_config_5 col_event_rst_top_right[47] dac_config_4
+ row_on_detect_top[21] dac_config_0 dac_config_1 row_off_detect_top[20] x2_net33
+ dac_config_2 vdda1 vssa1 vssc1 col_event_rst_top_right[46] x2_net34
+ row_on_detect_top[20] row_off_detect_top[21] openDVS_pixel2x2_top
x2_x329 dac_config_3 dac_config_5 col_event_rst_top_right[45] dac_config_4
+ row_on_detect_top[21] dac_config_0 dac_config_1 row_off_detect_top[20] x2_net37
+ dac_config_2 vdda1 vssa1 vssc1 col_event_rst_top_right[44] x2_net38
+ row_on_detect_top[20] row_off_detect_top[21] openDVS_pixel2x2_top
x2_x330 dac_config_3 dac_config_5 col_event_rst_top_right[43] dac_config_4
+ row_on_detect_top[21] dac_config_0 dac_config_1 row_off_detect_top[20] x2_net41
+ dac_config_2 vdda1 vssa1 vssc1 col_event_rst_top_right[42] x2_net42
+ row_on_detect_top[20] row_off_detect_top[21] openDVS_pixel2x2_top
x2_x331 dac_config_3 dac_config_5 col_event_rst_top_right[41] dac_config_4
+ row_on_detect_top[21] dac_config_0 dac_config_1 row_off_detect_top[20] x2_net45
+ dac_config_2 vdda1 vssa1 vssc1 col_event_rst_top_right[40] x2_net46
+ row_on_detect_top[20] row_off_detect_top[21] openDVS_pixel2x2_top
x2_x332 dac_config_3 dac_config_5 col_event_rst_top_right[39] dac_config_4
+ row_on_detect_top[21] dac_config_0 dac_config_1 row_off_detect_top[20] x2_net49
+ dac_config_2 vdda1 vssa1 vssc1 col_event_rst_top_right[38] x2_net50
+ row_on_detect_top[20] row_off_detect_top[21] openDVS_pixel2x2_top
x2_x333 dac_config_3 dac_config_5 col_event_rst_top_right[37] dac_config_4
+ row_on_detect_top[21] dac_config_0 dac_config_1 row_off_detect_top[20] x2_net53
+ dac_config_2 vdda1 vssa1 vssc1 col_event_rst_top_right[36] x2_net54
+ row_on_detect_top[20] row_off_detect_top[21] openDVS_pixel2x2_top
x2_x334 dac_config_3 dac_config_5 col_event_rst_top_right[35] dac_config_4
+ row_on_detect_top[21] dac_config_0 dac_config_1 row_off_detect_top[20] x2_net57
+ dac_config_2 vdda1 vssa1 vssc1 col_event_rst_top_right[34] x2_net58
+ row_on_detect_top[20] row_off_detect_top[21] openDVS_pixel2x2_top
x2_x335 dac_config_3 dac_config_5 col_event_rst_top_right[33] dac_config_4
+ row_on_detect_top[21] dac_config_0 dac_config_1 row_off_detect_top[20] x2_net61
+ dac_config_2 vdda1 vssa1 vssc1 col_event_rst_top_right[32] x2_net62
+ row_on_detect_top[20] row_off_detect_top[21] openDVS_pixel2x2_top
x2_x336 dac_config_3 dac_config_5 col_event_rst_top_right[31] dac_config_4
+ row_on_detect_top[21] dac_config_0 dac_config_1 row_off_detect_top[20] x2_net65
+ dac_config_2 vdda1 vssa1 vssc1 col_event_rst_top_right[30] x2_net66
+ row_on_detect_top[20] row_off_detect_top[21] openDVS_pixel2x2_top
x2_x337 dac_config_3 dac_config_5 col_event_rst_top_right[29] dac_config_4
+ row_on_detect_top[21] dac_config_0 dac_config_1 row_off_detect_top[20] x2_net69
+ dac_config_2 vdda1 vssa1 vssc1 col_event_rst_top_right[28] x2_net70
+ row_on_detect_top[20] row_off_detect_top[21] openDVS_pixel2x2_top
x2_x338 dac_config_3 dac_config_5 col_event_rst_top_right[27] dac_config_4
+ row_on_detect_top[21] dac_config_0 dac_config_1 row_off_detect_top[20] x2_net73
+ dac_config_2 vdda1 vssa1 vssc1 col_event_rst_top_right[26] x2_net74
+ row_on_detect_top[20] row_off_detect_top[21] openDVS_pixel2x2_top
x2_x339 dac_config_3 dac_config_5 col_event_rst_top_right[25] dac_config_4
+ row_on_detect_top[21] dac_config_0 dac_config_1 row_off_detect_top[20] x2_net77
+ dac_config_2 vdda1 vssa1 vssc1 col_event_rst_top_right[24] x2_net78
+ row_on_detect_top[20] row_off_detect_top[21] openDVS_pixel2x2_top
x2_x340 dac_config_3 dac_config_5 col_event_rst_top_right[23] dac_config_4
+ row_on_detect_top[21] dac_config_0 dac_config_1 row_off_detect_top[20] x2_net81
+ dac_config_2 vdda1 vssa1 vssc1 col_event_rst_top_right[22] x2_net82
+ row_on_detect_top[20] row_off_detect_top[21] openDVS_pixel2x2_top
x2_x341 dac_config_3 dac_config_5 col_event_rst_top_right[21] dac_config_4
+ row_on_detect_top[21] dac_config_0 dac_config_1 row_off_detect_top[20] x2_net85
+ dac_config_2 vdda1 vssa1 vssc1 col_event_rst_top_right[20] x2_net86
+ row_on_detect_top[20] row_off_detect_top[21] openDVS_pixel2x2_top
x2_x342 dac_config_3 dac_config_5 col_event_rst_top_right[19] dac_config_4
+ row_on_detect_top[21] dac_config_0 dac_config_1 row_off_detect_top[20] x2_net89
+ dac_config_2 vdda1 vssa1 vssc1 col_event_rst_top_right[18] x2_net90
+ row_on_detect_top[20] row_off_detect_top[21] openDVS_pixel2x2_top
x2_x343 dac_config_3 dac_config_5 col_event_rst_top_right[17] dac_config_4
+ row_on_detect_top[21] dac_config_0 dac_config_1 row_off_detect_top[20] x2_net93
+ dac_config_2 vdda1 vssa1 vssc1 col_event_rst_top_right[16] x2_net94
+ row_on_detect_top[20] row_off_detect_top[21] openDVS_pixel2x2_top
x2_x344 dac_config_3 dac_config_5 col_event_rst_top_right[15] dac_config_4
+ row_on_detect_top[21] dac_config_0 dac_config_1 row_off_detect_top[20] x2_net97
+ dac_config_2 vdda1 vssa1 vssc1 col_event_rst_top_right[14] x2_net98
+ row_on_detect_top[20] row_off_detect_top[21] openDVS_pixel2x2_top
x2_x345 dac_config_3 dac_config_5 col_event_rst_top_right[13] dac_config_4
+ row_on_detect_top[21] dac_config_0 dac_config_1 row_off_detect_top[20] x2_net101
+ dac_config_2 vdda1 vssa1 vssc1 col_event_rst_top_right[12] x2_net102
+ row_on_detect_top[20] row_off_detect_top[21] openDVS_pixel2x2_top
x2_x346 dac_config_3 dac_config_5 col_event_rst_top_right[11] dac_config_4
+ row_on_detect_top[21] dac_config_0 dac_config_1 row_off_detect_top[20] x2_net105
+ dac_config_2 vdda1 vssa1 vssc1 col_event_rst_top_right[10] x2_net106
+ row_on_detect_top[20] row_off_detect_top[21] openDVS_pixel2x2_top
x2_x347 dac_config_3 dac_config_5 col_event_rst_top_right[9] dac_config_4
+ row_on_detect_top[21] dac_config_0 dac_config_1 row_off_detect_top[20] x2_net109
+ dac_config_2 vdda1 vssa1 vssc1 col_event_rst_top_right[8] x2_net110
+ row_on_detect_top[20] row_off_detect_top[21] openDVS_pixel2x2_top
x2_x348 dac_config_3 dac_config_5 col_event_rst_top_right[7] dac_config_4
+ row_on_detect_top[21] dac_config_0 dac_config_1 row_off_detect_top[20] x2_net113
+ dac_config_2 vdda1 vssa1 vssc1 col_event_rst_top_right[6] x2_net114
+ row_on_detect_top[20] row_off_detect_top[21] openDVS_pixel2x2_top
x2_x349 dac_config_3 dac_config_5 col_event_rst_top_right[5] dac_config_4
+ row_on_detect_top[21] dac_config_0 dac_config_1 row_off_detect_top[20] x2_net117
+ dac_config_2 vdda1 vssa1 vssc1 col_event_rst_top_right[4] x2_net118
+ row_on_detect_top[20] row_off_detect_top[21] openDVS_pixel2x2_top
x2_x350 dac_config_3 dac_config_5 col_event_rst_top_right[3] dac_config_4
+ row_on_detect_top[21] dac_config_0 dac_config_1 row_off_detect_top[20] x2_net121
+ dac_config_2 vdda1 vssa1 vssc1 col_event_rst_top_right[2] x2_net122
+ row_on_detect_top[20] row_off_detect_top[21] openDVS_pixel2x2_top
x2_x351 dac_config_3 dac_config_5 col_event_rst_top_right[1] dac_config_4
+ row_on_detect_top[21] dac_config_0 dac_config_1 row_off_detect_top[20] x2_net125
+ dac_config_2 vdda1 vssa1 vssc1 col_event_rst_top_right[0] x2_net126
+ row_on_detect_top[20] row_off_detect_top[21] openDVS_pixel2x2_top
x2_x352 dac_config_3 dac_config_5 col_event_rst_top_right[63] dac_config_4
+ row_on_detect_top[23] dac_config_0 dac_config_1 row_off_detect_top[22] x2_net1
+ dac_config_2 vdda1 vssa1 vssc1 col_event_rst_top_right[62] x2_net2 row_on_detect_top[22]
+ row_off_detect_top[23] openDVS_pixel2x2_top
x2_x353 dac_config_3 dac_config_5 col_event_rst_top_right[61] dac_config_4
+ row_on_detect_top[23] dac_config_0 dac_config_1 row_off_detect_top[22] x2_net5
+ dac_config_2 vdda1 vssa1 vssc1 col_event_rst_top_right[60] x2_net6 row_on_detect_top[22]
+ row_off_detect_top[23] openDVS_pixel2x2_top
x2_x354 dac_config_3 dac_config_5 col_event_rst_top_right[59] dac_config_4
+ row_on_detect_top[23] dac_config_0 dac_config_1 row_off_detect_top[22] x2_net9
+ dac_config_2 vdda1 vssa1 vssc1 col_event_rst_top_right[58] x2_net10
+ row_on_detect_top[22] row_off_detect_top[23] openDVS_pixel2x2_top
x2_x355 dac_config_3 dac_config_5 col_event_rst_top_right[57] dac_config_4
+ row_on_detect_top[23] dac_config_0 dac_config_1 row_off_detect_top[22] x2_net13
+ dac_config_2 vdda1 vssa1 vssc1 col_event_rst_top_right[56] x2_net14
+ row_on_detect_top[22] row_off_detect_top[23] openDVS_pixel2x2_top
x2_x356 dac_config_3 dac_config_5 col_event_rst_top_right[55] dac_config_4
+ row_on_detect_top[23] dac_config_0 dac_config_1 row_off_detect_top[22] x2_net17
+ dac_config_2 vdda1 vssa1 vssc1 col_event_rst_top_right[54] x2_net18
+ row_on_detect_top[22] row_off_detect_top[23] openDVS_pixel2x2_top
x2_x357 dac_config_3 dac_config_5 col_event_rst_top_right[53] dac_config_4
+ row_on_detect_top[23] dac_config_0 dac_config_1 row_off_detect_top[22] x2_net21
+ dac_config_2 vdda1 vssa1 vssc1 col_event_rst_top_right[52] x2_net22
+ row_on_detect_top[22] row_off_detect_top[23] openDVS_pixel2x2_top
x2_x358 dac_config_3 dac_config_5 col_event_rst_top_right[51] dac_config_4
+ row_on_detect_top[23] dac_config_0 dac_config_1 row_off_detect_top[22] x2_net25
+ dac_config_2 vdda1 vssa1 vssc1 col_event_rst_top_right[50] x2_net26
+ row_on_detect_top[22] row_off_detect_top[23] openDVS_pixel2x2_top
x2_x359 dac_config_3 dac_config_5 col_event_rst_top_right[49] dac_config_4
+ row_on_detect_top[23] dac_config_0 dac_config_1 row_off_detect_top[22] x2_net29
+ dac_config_2 vdda1 vssa1 vssc1 col_event_rst_top_right[48] x2_net30
+ row_on_detect_top[22] row_off_detect_top[23] openDVS_pixel2x2_top
x2_x360 dac_config_3 dac_config_5 col_event_rst_top_right[47] dac_config_4
+ row_on_detect_top[23] dac_config_0 dac_config_1 row_off_detect_top[22] x2_net33
+ dac_config_2 vdda1 vssa1 vssc1 col_event_rst_top_right[46] x2_net34
+ row_on_detect_top[22] row_off_detect_top[23] openDVS_pixel2x2_top
x2_x361 dac_config_3 dac_config_5 col_event_rst_top_right[45] dac_config_4
+ row_on_detect_top[23] dac_config_0 dac_config_1 row_off_detect_top[22] x2_net37
+ dac_config_2 vdda1 vssa1 vssc1 col_event_rst_top_right[44] x2_net38
+ row_on_detect_top[22] row_off_detect_top[23] openDVS_pixel2x2_top
x2_x362 dac_config_3 dac_config_5 col_event_rst_top_right[43] dac_config_4
+ row_on_detect_top[23] dac_config_0 dac_config_1 row_off_detect_top[22] x2_net41
+ dac_config_2 vdda1 vssa1 vssc1 col_event_rst_top_right[42] x2_net42
+ row_on_detect_top[22] row_off_detect_top[23] openDVS_pixel2x2_top
x2_x363 dac_config_3 dac_config_5 col_event_rst_top_right[41] dac_config_4
+ row_on_detect_top[23] dac_config_0 dac_config_1 row_off_detect_top[22] x2_net45
+ dac_config_2 vdda1 vssa1 vssc1 col_event_rst_top_right[40] x2_net46
+ row_on_detect_top[22] row_off_detect_top[23] openDVS_pixel2x2_top
x2_x364 dac_config_3 dac_config_5 col_event_rst_top_right[39] dac_config_4
+ row_on_detect_top[23] dac_config_0 dac_config_1 row_off_detect_top[22] x2_net49
+ dac_config_2 vdda1 vssa1 vssc1 col_event_rst_top_right[38] x2_net50
+ row_on_detect_top[22] row_off_detect_top[23] openDVS_pixel2x2_top
x2_x365 dac_config_3 dac_config_5 col_event_rst_top_right[37] dac_config_4
+ row_on_detect_top[23] dac_config_0 dac_config_1 row_off_detect_top[22] x2_net53
+ dac_config_2 vdda1 vssa1 vssc1 col_event_rst_top_right[36] x2_net54
+ row_on_detect_top[22] row_off_detect_top[23] openDVS_pixel2x2_top
x2_x366 dac_config_3 dac_config_5 col_event_rst_top_right[35] dac_config_4
+ row_on_detect_top[23] dac_config_0 dac_config_1 row_off_detect_top[22] x2_net57
+ dac_config_2 vdda1 vssa1 vssc1 col_event_rst_top_right[34] x2_net58
+ row_on_detect_top[22] row_off_detect_top[23] openDVS_pixel2x2_top
x2_x367 dac_config_3 dac_config_5 col_event_rst_top_right[33] dac_config_4
+ row_on_detect_top[23] dac_config_0 dac_config_1 row_off_detect_top[22] x2_net61
+ dac_config_2 vdda1 vssa1 vssc1 col_event_rst_top_right[32] x2_net62
+ row_on_detect_top[22] row_off_detect_top[23] openDVS_pixel2x2_top
x2_x368 dac_config_3 dac_config_5 col_event_rst_top_right[31] dac_config_4
+ row_on_detect_top[23] dac_config_0 dac_config_1 row_off_detect_top[22] x2_net65
+ dac_config_2 vdda1 vssa1 vssc1 col_event_rst_top_right[30] x2_net66
+ row_on_detect_top[22] row_off_detect_top[23] openDVS_pixel2x2_top
x2_x369 dac_config_3 dac_config_5 col_event_rst_top_right[29] dac_config_4
+ row_on_detect_top[23] dac_config_0 dac_config_1 row_off_detect_top[22] x2_net69
+ dac_config_2 vdda1 vssa1 vssc1 col_event_rst_top_right[28] x2_net70
+ row_on_detect_top[22] row_off_detect_top[23] openDVS_pixel2x2_top
x2_x370 dac_config_3 dac_config_5 col_event_rst_top_right[27] dac_config_4
+ row_on_detect_top[23] dac_config_0 dac_config_1 row_off_detect_top[22] x2_net73
+ dac_config_2 vdda1 vssa1 vssc1 col_event_rst_top_right[26] x2_net74
+ row_on_detect_top[22] row_off_detect_top[23] openDVS_pixel2x2_top
x2_x371 dac_config_3 dac_config_5 col_event_rst_top_right[25] dac_config_4
+ row_on_detect_top[23] dac_config_0 dac_config_1 row_off_detect_top[22] x2_net77
+ dac_config_2 vdda1 vssa1 vssc1 col_event_rst_top_right[24] x2_net78
+ row_on_detect_top[22] row_off_detect_top[23] openDVS_pixel2x2_top
x2_x372 dac_config_3 dac_config_5 col_event_rst_top_right[23] dac_config_4
+ row_on_detect_top[23] dac_config_0 dac_config_1 row_off_detect_top[22] x2_net81
+ dac_config_2 vdda1 vssa1 vssc1 col_event_rst_top_right[22] x2_net82
+ row_on_detect_top[22] row_off_detect_top[23] openDVS_pixel2x2_top
x2_x373 dac_config_3 dac_config_5 col_event_rst_top_right[21] dac_config_4
+ row_on_detect_top[23] dac_config_0 dac_config_1 row_off_detect_top[22] x2_net85
+ dac_config_2 vdda1 vssa1 vssc1 col_event_rst_top_right[20] x2_net86
+ row_on_detect_top[22] row_off_detect_top[23] openDVS_pixel2x2_top
x2_x374 dac_config_3 dac_config_5 col_event_rst_top_right[19] dac_config_4
+ row_on_detect_top[23] dac_config_0 dac_config_1 row_off_detect_top[22] x2_net89
+ dac_config_2 vdda1 vssa1 vssc1 col_event_rst_top_right[18] x2_net90
+ row_on_detect_top[22] row_off_detect_top[23] openDVS_pixel2x2_top
x2_x375 dac_config_3 dac_config_5 col_event_rst_top_right[17] dac_config_4
+ row_on_detect_top[23] dac_config_0 dac_config_1 row_off_detect_top[22] x2_net93
+ dac_config_2 vdda1 vssa1 vssc1 col_event_rst_top_right[16] x2_net94
+ row_on_detect_top[22] row_off_detect_top[23] openDVS_pixel2x2_top
x2_x376 dac_config_3 dac_config_5 col_event_rst_top_right[15] dac_config_4
+ row_on_detect_top[23] dac_config_0 dac_config_1 row_off_detect_top[22] x2_net97
+ dac_config_2 vdda1 vssa1 vssc1 col_event_rst_top_right[14] x2_net98
+ row_on_detect_top[22] row_off_detect_top[23] openDVS_pixel2x2_top
x2_x377 dac_config_3 dac_config_5 col_event_rst_top_right[13] dac_config_4
+ row_on_detect_top[23] dac_config_0 dac_config_1 row_off_detect_top[22] x2_net101
+ dac_config_2 vdda1 vssa1 vssc1 col_event_rst_top_right[12] x2_net102
+ row_on_detect_top[22] row_off_detect_top[23] openDVS_pixel2x2_top
x2_x378 dac_config_3 dac_config_5 col_event_rst_top_right[11] dac_config_4
+ row_on_detect_top[23] dac_config_0 dac_config_1 row_off_detect_top[22] x2_net105
+ dac_config_2 vdda1 vssa1 vssc1 col_event_rst_top_right[10] x2_net106
+ row_on_detect_top[22] row_off_detect_top[23] openDVS_pixel2x2_top
x2_x379 dac_config_3 dac_config_5 col_event_rst_top_right[9] dac_config_4
+ row_on_detect_top[23] dac_config_0 dac_config_1 row_off_detect_top[22] x2_net109
+ dac_config_2 vdda1 vssa1 vssc1 col_event_rst_top_right[8] x2_net110
+ row_on_detect_top[22] row_off_detect_top[23] openDVS_pixel2x2_top
x2_x380 dac_config_3 dac_config_5 col_event_rst_top_right[7] dac_config_4
+ row_on_detect_top[23] dac_config_0 dac_config_1 row_off_detect_top[22] x2_net113
+ dac_config_2 vdda1 vssa1 vssc1 col_event_rst_top_right[6] x2_net114
+ row_on_detect_top[22] row_off_detect_top[23] openDVS_pixel2x2_top
x2_x381 dac_config_3 dac_config_5 col_event_rst_top_right[5] dac_config_4
+ row_on_detect_top[23] dac_config_0 dac_config_1 row_off_detect_top[22] x2_net117
+ dac_config_2 vdda1 vssa1 vssc1 col_event_rst_top_right[4] x2_net118
+ row_on_detect_top[22] row_off_detect_top[23] openDVS_pixel2x2_top
x2_x382 dac_config_3 dac_config_5 col_event_rst_top_right[3] dac_config_4
+ row_on_detect_top[23] dac_config_0 dac_config_1 row_off_detect_top[22] x2_net121
+ dac_config_2 vdda1 vssa1 vssc1 col_event_rst_top_right[2] x2_net122
+ row_on_detect_top[22] row_off_detect_top[23] openDVS_pixel2x2_top
x2_x383 dac_config_3 dac_config_5 col_event_rst_top_right[1] dac_config_4
+ row_on_detect_top[23] dac_config_0 dac_config_1 row_off_detect_top[22] x2_net125
+ dac_config_2 vdda1 vssa1 vssc1 col_event_rst_top_right[0] x2_net126
+ row_on_detect_top[22] row_off_detect_top[23] openDVS_pixel2x2_top
x2_x384 dac_config_3 dac_config_5 col_event_rst_top_right[63] dac_config_4
+ row_on_detect_top[25] dac_config_0 dac_config_1 row_off_detect_top[24] x2_net1
+ dac_config_2 vdda1 vssa1 vssc1 col_event_rst_top_right[62] x2_net2 row_on_detect_top[24]
+ row_off_detect_top[25] openDVS_pixel2x2_top
x2_x385 dac_config_3 dac_config_5 col_event_rst_top_right[61] dac_config_4
+ row_on_detect_top[25] dac_config_0 dac_config_1 row_off_detect_top[24] x2_net5
+ dac_config_2 vdda1 vssa1 vssc1 col_event_rst_top_right[60] x2_net6 row_on_detect_top[24]
+ row_off_detect_top[25] openDVS_pixel2x2_top
x2_x386 dac_config_3 dac_config_5 col_event_rst_top_right[59] dac_config_4
+ row_on_detect_top[25] dac_config_0 dac_config_1 row_off_detect_top[24] x2_net9
+ dac_config_2 vdda1 vssa1 vssc1 col_event_rst_top_right[58] x2_net10
+ row_on_detect_top[24] row_off_detect_top[25] openDVS_pixel2x2_top
x2_x387 dac_config_3 dac_config_5 col_event_rst_top_right[57] dac_config_4
+ row_on_detect_top[25] dac_config_0 dac_config_1 row_off_detect_top[24] x2_net13
+ dac_config_2 vdda1 vssa1 vssc1 col_event_rst_top_right[56] x2_net14
+ row_on_detect_top[24] row_off_detect_top[25] openDVS_pixel2x2_top
x2_x388 dac_config_3 dac_config_5 col_event_rst_top_right[55] dac_config_4
+ row_on_detect_top[25] dac_config_0 dac_config_1 row_off_detect_top[24] x2_net17
+ dac_config_2 vdda1 vssa1 vssc1 col_event_rst_top_right[54] x2_net18
+ row_on_detect_top[24] row_off_detect_top[25] openDVS_pixel2x2_top
x2_x389 dac_config_3 dac_config_5 col_event_rst_top_right[53] dac_config_4
+ row_on_detect_top[25] dac_config_0 dac_config_1 row_off_detect_top[24] x2_net21
+ dac_config_2 vdda1 vssa1 vssc1 col_event_rst_top_right[52] x2_net22
+ row_on_detect_top[24] row_off_detect_top[25] openDVS_pixel2x2_top
x2_x390 dac_config_3 dac_config_5 col_event_rst_top_right[51] dac_config_4
+ row_on_detect_top[25] dac_config_0 dac_config_1 row_off_detect_top[24] x2_net25
+ dac_config_2 vdda1 vssa1 vssc1 col_event_rst_top_right[50] x2_net26
+ row_on_detect_top[24] row_off_detect_top[25] openDVS_pixel2x2_top
x2_x391 dac_config_3 dac_config_5 col_event_rst_top_right[49] dac_config_4
+ row_on_detect_top[25] dac_config_0 dac_config_1 row_off_detect_top[24] x2_net29
+ dac_config_2 vdda1 vssa1 vssc1 col_event_rst_top_right[48] x2_net30
+ row_on_detect_top[24] row_off_detect_top[25] openDVS_pixel2x2_top
x2_x392 dac_config_3 dac_config_5 col_event_rst_top_right[47] dac_config_4
+ row_on_detect_top[25] dac_config_0 dac_config_1 row_off_detect_top[24] x2_net33
+ dac_config_2 vdda1 vssa1 vssc1 col_event_rst_top_right[46] x2_net34
+ row_on_detect_top[24] row_off_detect_top[25] openDVS_pixel2x2_top
x2_x393 dac_config_3 dac_config_5 col_event_rst_top_right[45] dac_config_4
+ row_on_detect_top[25] dac_config_0 dac_config_1 row_off_detect_top[24] x2_net37
+ dac_config_2 vdda1 vssa1 vssc1 col_event_rst_top_right[44] x2_net38
+ row_on_detect_top[24] row_off_detect_top[25] openDVS_pixel2x2_top
x2_x394 dac_config_3 dac_config_5 col_event_rst_top_right[43] dac_config_4
+ row_on_detect_top[25] dac_config_0 dac_config_1 row_off_detect_top[24] x2_net41
+ dac_config_2 vdda1 vssa1 vssc1 col_event_rst_top_right[42] x2_net42
+ row_on_detect_top[24] row_off_detect_top[25] openDVS_pixel2x2_top
x2_x395 dac_config_3 dac_config_5 col_event_rst_top_right[41] dac_config_4
+ row_on_detect_top[25] dac_config_0 dac_config_1 row_off_detect_top[24] x2_net45
+ dac_config_2 vdda1 vssa1 vssc1 col_event_rst_top_right[40] x2_net46
+ row_on_detect_top[24] row_off_detect_top[25] openDVS_pixel2x2_top
x2_x396 dac_config_3 dac_config_5 col_event_rst_top_right[39] dac_config_4
+ row_on_detect_top[25] dac_config_0 dac_config_1 row_off_detect_top[24] x2_net49
+ dac_config_2 vdda1 vssa1 vssc1 col_event_rst_top_right[38] x2_net50
+ row_on_detect_top[24] row_off_detect_top[25] openDVS_pixel2x2_top
x2_x397 dac_config_3 dac_config_5 col_event_rst_top_right[37] dac_config_4
+ row_on_detect_top[25] dac_config_0 dac_config_1 row_off_detect_top[24] x2_net53
+ dac_config_2 vdda1 vssa1 vssc1 col_event_rst_top_right[36] x2_net54
+ row_on_detect_top[24] row_off_detect_top[25] openDVS_pixel2x2_top
x2_x398 dac_config_3 dac_config_5 col_event_rst_top_right[35] dac_config_4
+ row_on_detect_top[25] dac_config_0 dac_config_1 row_off_detect_top[24] x2_net57
+ dac_config_2 vdda1 vssa1 vssc1 col_event_rst_top_right[34] x2_net58
+ row_on_detect_top[24] row_off_detect_top[25] openDVS_pixel2x2_top
x2_x399 dac_config_3 dac_config_5 col_event_rst_top_right[33] dac_config_4
+ row_on_detect_top[25] dac_config_0 dac_config_1 row_off_detect_top[24] x2_net61
+ dac_config_2 vdda1 vssa1 vssc1 col_event_rst_top_right[32] x2_net62
+ row_on_detect_top[24] row_off_detect_top[25] openDVS_pixel2x2_top
x2_x400 dac_config_3 dac_config_5 col_event_rst_top_right[31] dac_config_4
+ row_on_detect_top[25] dac_config_0 dac_config_1 row_off_detect_top[24] x2_net65
+ dac_config_2 vdda1 vssa1 vssc1 col_event_rst_top_right[30] x2_net66
+ row_on_detect_top[24] row_off_detect_top[25] openDVS_pixel2x2_top
x2_x401 dac_config_3 dac_config_5 col_event_rst_top_right[29] dac_config_4
+ row_on_detect_top[25] dac_config_0 dac_config_1 row_off_detect_top[24] x2_net69
+ dac_config_2 vdda1 vssa1 vssc1 col_event_rst_top_right[28] x2_net70
+ row_on_detect_top[24] row_off_detect_top[25] openDVS_pixel2x2_top
x2_x402 dac_config_3 dac_config_5 col_event_rst_top_right[27] dac_config_4
+ row_on_detect_top[25] dac_config_0 dac_config_1 row_off_detect_top[24] x2_net73
+ dac_config_2 vdda1 vssa1 vssc1 col_event_rst_top_right[26] x2_net74
+ row_on_detect_top[24] row_off_detect_top[25] openDVS_pixel2x2_top
x2_x403 dac_config_3 dac_config_5 col_event_rst_top_right[25] dac_config_4
+ row_on_detect_top[25] dac_config_0 dac_config_1 row_off_detect_top[24] x2_net77
+ dac_config_2 vdda1 vssa1 vssc1 col_event_rst_top_right[24] x2_net78
+ row_on_detect_top[24] row_off_detect_top[25] openDVS_pixel2x2_top
x2_x404 dac_config_3 dac_config_5 col_event_rst_top_right[23] dac_config_4
+ row_on_detect_top[25] dac_config_0 dac_config_1 row_off_detect_top[24] x2_net81
+ dac_config_2 vdda1 vssa1 vssc1 col_event_rst_top_right[22] x2_net82
+ row_on_detect_top[24] row_off_detect_top[25] openDVS_pixel2x2_top
x2_x405 dac_config_3 dac_config_5 col_event_rst_top_right[21] dac_config_4
+ row_on_detect_top[25] dac_config_0 dac_config_1 row_off_detect_top[24] x2_net85
+ dac_config_2 vdda1 vssa1 vssc1 col_event_rst_top_right[20] x2_net86
+ row_on_detect_top[24] row_off_detect_top[25] openDVS_pixel2x2_top
x2_x406 dac_config_3 dac_config_5 col_event_rst_top_right[19] dac_config_4
+ row_on_detect_top[25] dac_config_0 dac_config_1 row_off_detect_top[24] x2_net89
+ dac_config_2 vdda1 vssa1 vssc1 col_event_rst_top_right[18] x2_net90
+ row_on_detect_top[24] row_off_detect_top[25] openDVS_pixel2x2_top
x2_x407 dac_config_3 dac_config_5 col_event_rst_top_right[17] dac_config_4
+ row_on_detect_top[25] dac_config_0 dac_config_1 row_off_detect_top[24] x2_net93
+ dac_config_2 vdda1 vssa1 vssc1 col_event_rst_top_right[16] x2_net94
+ row_on_detect_top[24] row_off_detect_top[25] openDVS_pixel2x2_top
x2_x408 dac_config_3 dac_config_5 col_event_rst_top_right[15] dac_config_4
+ row_on_detect_top[25] dac_config_0 dac_config_1 row_off_detect_top[24] x2_net97
+ dac_config_2 vdda1 vssa1 vssc1 col_event_rst_top_right[14] x2_net98
+ row_on_detect_top[24] row_off_detect_top[25] openDVS_pixel2x2_top
x2_x409 dac_config_3 dac_config_5 col_event_rst_top_right[13] dac_config_4
+ row_on_detect_top[25] dac_config_0 dac_config_1 row_off_detect_top[24] x2_net101
+ dac_config_2 vdda1 vssa1 vssc1 col_event_rst_top_right[12] x2_net102
+ row_on_detect_top[24] row_off_detect_top[25] openDVS_pixel2x2_top
x2_x410 dac_config_3 dac_config_5 col_event_rst_top_right[11] dac_config_4
+ row_on_detect_top[25] dac_config_0 dac_config_1 row_off_detect_top[24] x2_net105
+ dac_config_2 vdda1 vssa1 vssc1 col_event_rst_top_right[10] x2_net106
+ row_on_detect_top[24] row_off_detect_top[25] openDVS_pixel2x2_top
x2_x411 dac_config_3 dac_config_5 col_event_rst_top_right[9] dac_config_4
+ row_on_detect_top[25] dac_config_0 dac_config_1 row_off_detect_top[24] x2_net109
+ dac_config_2 vdda1 vssa1 vssc1 col_event_rst_top_right[8] x2_net110
+ row_on_detect_top[24] row_off_detect_top[25] openDVS_pixel2x2_top
x2_x412 dac_config_3 dac_config_5 col_event_rst_top_right[7] dac_config_4
+ row_on_detect_top[25] dac_config_0 dac_config_1 row_off_detect_top[24] x2_net113
+ dac_config_2 vdda1 vssa1 vssc1 col_event_rst_top_right[6] x2_net114
+ row_on_detect_top[24] row_off_detect_top[25] openDVS_pixel2x2_top
x2_x413 dac_config_3 dac_config_5 col_event_rst_top_right[5] dac_config_4
+ row_on_detect_top[25] dac_config_0 dac_config_1 row_off_detect_top[24] x2_net117
+ dac_config_2 vdda1 vssa1 vssc1 col_event_rst_top_right[4] x2_net118
+ row_on_detect_top[24] row_off_detect_top[25] openDVS_pixel2x2_top
x2_x414 dac_config_3 dac_config_5 col_event_rst_top_right[3] dac_config_4
+ row_on_detect_top[25] dac_config_0 dac_config_1 row_off_detect_top[24] x2_net121
+ dac_config_2 vdda1 vssa1 vssc1 col_event_rst_top_right[2] x2_net122
+ row_on_detect_top[24] row_off_detect_top[25] openDVS_pixel2x2_top
x2_x415 dac_config_3 dac_config_5 col_event_rst_top_right[1] dac_config_4
+ row_on_detect_top[25] dac_config_0 dac_config_1 row_off_detect_top[24] x2_net125
+ dac_config_2 vdda1 vssa1 vssc1 col_event_rst_top_right[0] x2_net126
+ row_on_detect_top[24] row_off_detect_top[25] openDVS_pixel2x2_top
x2_x416 dac_config_3 dac_config_5 col_event_rst_top_right[63] dac_config_4
+ row_on_detect_top[27] dac_config_0 dac_config_1 row_off_detect_top[26] x2_net1
+ dac_config_2 vdda1 vssa1 vssc1 col_event_rst_top_right[62] x2_net2 row_on_detect_top[26]
+ row_off_detect_top[27] openDVS_pixel2x2_top
x2_x417 dac_config_3 dac_config_5 col_event_rst_top_right[61] dac_config_4
+ row_on_detect_top[27] dac_config_0 dac_config_1 row_off_detect_top[26] x2_net5
+ dac_config_2 vdda1 vssa1 vssc1 col_event_rst_top_right[60] x2_net6 row_on_detect_top[26]
+ row_off_detect_top[27] openDVS_pixel2x2_top
x2_x418 dac_config_3 dac_config_5 col_event_rst_top_right[59] dac_config_4
+ row_on_detect_top[27] dac_config_0 dac_config_1 row_off_detect_top[26] x2_net9
+ dac_config_2 vdda1 vssa1 vssc1 col_event_rst_top_right[58] x2_net10
+ row_on_detect_top[26] row_off_detect_top[27] openDVS_pixel2x2_top
x2_x419 dac_config_3 dac_config_5 col_event_rst_top_right[57] dac_config_4
+ row_on_detect_top[27] dac_config_0 dac_config_1 row_off_detect_top[26] x2_net13
+ dac_config_2 vdda1 vssa1 vssc1 col_event_rst_top_right[56] x2_net14
+ row_on_detect_top[26] row_off_detect_top[27] openDVS_pixel2x2_top
x2_x420 dac_config_3 dac_config_5 col_event_rst_top_right[55] dac_config_4
+ row_on_detect_top[27] dac_config_0 dac_config_1 row_off_detect_top[26] x2_net17
+ dac_config_2 vdda1 vssa1 vssc1 col_event_rst_top_right[54] x2_net18
+ row_on_detect_top[26] row_off_detect_top[27] openDVS_pixel2x2_top
x2_x421 dac_config_3 dac_config_5 col_event_rst_top_right[53] dac_config_4
+ row_on_detect_top[27] dac_config_0 dac_config_1 row_off_detect_top[26] x2_net21
+ dac_config_2 vdda1 vssa1 vssc1 col_event_rst_top_right[52] x2_net22
+ row_on_detect_top[26] row_off_detect_top[27] openDVS_pixel2x2_top
x2_x422 dac_config_3 dac_config_5 col_event_rst_top_right[51] dac_config_4
+ row_on_detect_top[27] dac_config_0 dac_config_1 row_off_detect_top[26] x2_net25
+ dac_config_2 vdda1 vssa1 vssc1 col_event_rst_top_right[50] x2_net26
+ row_on_detect_top[26] row_off_detect_top[27] openDVS_pixel2x2_top
x2_x423 dac_config_3 dac_config_5 col_event_rst_top_right[49] dac_config_4
+ row_on_detect_top[27] dac_config_0 dac_config_1 row_off_detect_top[26] x2_net29
+ dac_config_2 vdda1 vssa1 vssc1 col_event_rst_top_right[48] x2_net30
+ row_on_detect_top[26] row_off_detect_top[27] openDVS_pixel2x2_top
x2_x424 dac_config_3 dac_config_5 col_event_rst_top_right[47] dac_config_4
+ row_on_detect_top[27] dac_config_0 dac_config_1 row_off_detect_top[26] x2_net33
+ dac_config_2 vdda1 vssa1 vssc1 col_event_rst_top_right[46] x2_net34
+ row_on_detect_top[26] row_off_detect_top[27] openDVS_pixel2x2_top
x2_x425 dac_config_3 dac_config_5 col_event_rst_top_right[45] dac_config_4
+ row_on_detect_top[27] dac_config_0 dac_config_1 row_off_detect_top[26] x2_net37
+ dac_config_2 vdda1 vssa1 vssc1 col_event_rst_top_right[44] x2_net38
+ row_on_detect_top[26] row_off_detect_top[27] openDVS_pixel2x2_top
x2_x426 dac_config_3 dac_config_5 col_event_rst_top_right[43] dac_config_4
+ row_on_detect_top[27] dac_config_0 dac_config_1 row_off_detect_top[26] x2_net41
+ dac_config_2 vdda1 vssa1 vssc1 col_event_rst_top_right[42] x2_net42
+ row_on_detect_top[26] row_off_detect_top[27] openDVS_pixel2x2_top
x2_x427 dac_config_3 dac_config_5 col_event_rst_top_right[41] dac_config_4
+ row_on_detect_top[27] dac_config_0 dac_config_1 row_off_detect_top[26] x2_net45
+ dac_config_2 vdda1 vssa1 vssc1 col_event_rst_top_right[40] x2_net46
+ row_on_detect_top[26] row_off_detect_top[27] openDVS_pixel2x2_top
x2_x428 dac_config_3 dac_config_5 col_event_rst_top_right[39] dac_config_4
+ row_on_detect_top[27] dac_config_0 dac_config_1 row_off_detect_top[26] x2_net49
+ dac_config_2 vdda1 vssa1 vssc1 col_event_rst_top_right[38] x2_net50
+ row_on_detect_top[26] row_off_detect_top[27] openDVS_pixel2x2_top
x2_x429 dac_config_3 dac_config_5 col_event_rst_top_right[37] dac_config_4
+ row_on_detect_top[27] dac_config_0 dac_config_1 row_off_detect_top[26] x2_net53
+ dac_config_2 vdda1 vssa1 vssc1 col_event_rst_top_right[36] x2_net54
+ row_on_detect_top[26] row_off_detect_top[27] openDVS_pixel2x2_top
x2_x430 dac_config_3 dac_config_5 col_event_rst_top_right[35] dac_config_4
+ row_on_detect_top[27] dac_config_0 dac_config_1 row_off_detect_top[26] x2_net57
+ dac_config_2 vdda1 vssa1 vssc1 col_event_rst_top_right[34] x2_net58
+ row_on_detect_top[26] row_off_detect_top[27] openDVS_pixel2x2_top
x2_x431 dac_config_3 dac_config_5 col_event_rst_top_right[33] dac_config_4
+ row_on_detect_top[27] dac_config_0 dac_config_1 row_off_detect_top[26] x2_net61
+ dac_config_2 vdda1 vssa1 vssc1 col_event_rst_top_right[32] x2_net62
+ row_on_detect_top[26] row_off_detect_top[27] openDVS_pixel2x2_top
x2_x432 dac_config_3 dac_config_5 col_event_rst_top_right[31] dac_config_4
+ row_on_detect_top[27] dac_config_0 dac_config_1 row_off_detect_top[26] x2_net65
+ dac_config_2 vdda1 vssa1 vssc1 col_event_rst_top_right[30] x2_net66
+ row_on_detect_top[26] row_off_detect_top[27] openDVS_pixel2x2_top
x2_x433 dac_config_3 dac_config_5 col_event_rst_top_right[29] dac_config_4
+ row_on_detect_top[27] dac_config_0 dac_config_1 row_off_detect_top[26] x2_net69
+ dac_config_2 vdda1 vssa1 vssc1 col_event_rst_top_right[28] x2_net70
+ row_on_detect_top[26] row_off_detect_top[27] openDVS_pixel2x2_top
x2_x434 dac_config_3 dac_config_5 col_event_rst_top_right[27] dac_config_4
+ row_on_detect_top[27] dac_config_0 dac_config_1 row_off_detect_top[26] x2_net73
+ dac_config_2 vdda1 vssa1 vssc1 col_event_rst_top_right[26] x2_net74
+ row_on_detect_top[26] row_off_detect_top[27] openDVS_pixel2x2_top
x2_x435 dac_config_3 dac_config_5 col_event_rst_top_right[25] dac_config_4
+ row_on_detect_top[27] dac_config_0 dac_config_1 row_off_detect_top[26] x2_net77
+ dac_config_2 vdda1 vssa1 vssc1 col_event_rst_top_right[24] x2_net78
+ row_on_detect_top[26] row_off_detect_top[27] openDVS_pixel2x2_top
x2_x436 dac_config_3 dac_config_5 col_event_rst_top_right[23] dac_config_4
+ row_on_detect_top[27] dac_config_0 dac_config_1 row_off_detect_top[26] x2_net81
+ dac_config_2 vdda1 vssa1 vssc1 col_event_rst_top_right[22] x2_net82
+ row_on_detect_top[26] row_off_detect_top[27] openDVS_pixel2x2_top
x2_x437 dac_config_3 dac_config_5 col_event_rst_top_right[21] dac_config_4
+ row_on_detect_top[27] dac_config_0 dac_config_1 row_off_detect_top[26] x2_net85
+ dac_config_2 vdda1 vssa1 vssc1 col_event_rst_top_right[20] x2_net86
+ row_on_detect_top[26] row_off_detect_top[27] openDVS_pixel2x2_top
x2_x438 dac_config_3 dac_config_5 col_event_rst_top_right[19] dac_config_4
+ row_on_detect_top[27] dac_config_0 dac_config_1 row_off_detect_top[26] x2_net89
+ dac_config_2 vdda1 vssa1 vssc1 col_event_rst_top_right[18] x2_net90
+ row_on_detect_top[26] row_off_detect_top[27] openDVS_pixel2x2_top
x2_x439 dac_config_3 dac_config_5 col_event_rst_top_right[17] dac_config_4
+ row_on_detect_top[27] dac_config_0 dac_config_1 row_off_detect_top[26] x2_net93
+ dac_config_2 vdda1 vssa1 vssc1 col_event_rst_top_right[16] x2_net94
+ row_on_detect_top[26] row_off_detect_top[27] openDVS_pixel2x2_top
x2_x440 dac_config_3 dac_config_5 col_event_rst_top_right[15] dac_config_4
+ row_on_detect_top[27] dac_config_0 dac_config_1 row_off_detect_top[26] x2_net97
+ dac_config_2 vdda1 vssa1 vssc1 col_event_rst_top_right[14] x2_net98
+ row_on_detect_top[26] row_off_detect_top[27] openDVS_pixel2x2_top
x2_x441 dac_config_3 dac_config_5 col_event_rst_top_right[13] dac_config_4
+ row_on_detect_top[27] dac_config_0 dac_config_1 row_off_detect_top[26] x2_net101
+ dac_config_2 vdda1 vssa1 vssc1 col_event_rst_top_right[12] x2_net102
+ row_on_detect_top[26] row_off_detect_top[27] openDVS_pixel2x2_top
x2_x442 dac_config_3 dac_config_5 col_event_rst_top_right[11] dac_config_4
+ row_on_detect_top[27] dac_config_0 dac_config_1 row_off_detect_top[26] x2_net105
+ dac_config_2 vdda1 vssa1 vssc1 col_event_rst_top_right[10] x2_net106
+ row_on_detect_top[26] row_off_detect_top[27] openDVS_pixel2x2_top
x2_x443 dac_config_3 dac_config_5 col_event_rst_top_right[9] dac_config_4
+ row_on_detect_top[27] dac_config_0 dac_config_1 row_off_detect_top[26] x2_net109
+ dac_config_2 vdda1 vssa1 vssc1 col_event_rst_top_right[8] x2_net110
+ row_on_detect_top[26] row_off_detect_top[27] openDVS_pixel2x2_top
x2_x444 dac_config_3 dac_config_5 col_event_rst_top_right[7] dac_config_4
+ row_on_detect_top[27] dac_config_0 dac_config_1 row_off_detect_top[26] x2_net113
+ dac_config_2 vdda1 vssa1 vssc1 col_event_rst_top_right[6] x2_net114
+ row_on_detect_top[26] row_off_detect_top[27] openDVS_pixel2x2_top
x2_x445 dac_config_3 dac_config_5 col_event_rst_top_right[5] dac_config_4
+ row_on_detect_top[27] dac_config_0 dac_config_1 row_off_detect_top[26] x2_net117
+ dac_config_2 vdda1 vssa1 vssc1 col_event_rst_top_right[4] x2_net118
+ row_on_detect_top[26] row_off_detect_top[27] openDVS_pixel2x2_top
x2_x446 dac_config_3 dac_config_5 col_event_rst_top_right[3] dac_config_4
+ row_on_detect_top[27] dac_config_0 dac_config_1 row_off_detect_top[26] x2_net121
+ dac_config_2 vdda1 vssa1 vssc1 col_event_rst_top_right[2] x2_net122
+ row_on_detect_top[26] row_off_detect_top[27] openDVS_pixel2x2_top
x2_x447 dac_config_3 dac_config_5 col_event_rst_top_right[1] dac_config_4
+ row_on_detect_top[27] dac_config_0 dac_config_1 row_off_detect_top[26] x2_net125
+ dac_config_2 vdda1 vssa1 vssc1 col_event_rst_top_right[0] x2_net126
+ row_on_detect_top[26] row_off_detect_top[27] openDVS_pixel2x2_top
x2_x448 dac_config_3 dac_config_5 col_event_rst_top_right[63] dac_config_4
+ row_on_detect_top[29] dac_config_0 dac_config_1 row_off_detect_top[28] x2_net1
+ dac_config_2 vdda1 vssa1 vssc1 col_event_rst_top_right[62] x2_net2 row_on_detect_top[28]
+ row_off_detect_top[29] openDVS_pixel2x2_top
x2_x449 dac_config_3 dac_config_5 col_event_rst_top_right[61] dac_config_4
+ row_on_detect_top[29] dac_config_0 dac_config_1 row_off_detect_top[28] x2_net5
+ dac_config_2 vdda1 vssa1 vssc1 col_event_rst_top_right[60] x2_net6 row_on_detect_top[28]
+ row_off_detect_top[29] openDVS_pixel2x2_top
x2_x450 dac_config_3 dac_config_5 col_event_rst_top_right[59] dac_config_4
+ row_on_detect_top[29] dac_config_0 dac_config_1 row_off_detect_top[28] x2_net9
+ dac_config_2 vdda1 vssa1 vssc1 col_event_rst_top_right[58] x2_net10
+ row_on_detect_top[28] row_off_detect_top[29] openDVS_pixel2x2_top
x2_x451 dac_config_3 dac_config_5 col_event_rst_top_right[57] dac_config_4
+ row_on_detect_top[29] dac_config_0 dac_config_1 row_off_detect_top[28] x2_net13
+ dac_config_2 vdda1 vssa1 vssc1 col_event_rst_top_right[56] x2_net14
+ row_on_detect_top[28] row_off_detect_top[29] openDVS_pixel2x2_top
x2_x452 dac_config_3 dac_config_5 col_event_rst_top_right[55] dac_config_4
+ row_on_detect_top[29] dac_config_0 dac_config_1 row_off_detect_top[28] x2_net17
+ dac_config_2 vdda1 vssa1 vssc1 col_event_rst_top_right[54] x2_net18
+ row_on_detect_top[28] row_off_detect_top[29] openDVS_pixel2x2_top
x2_x453 dac_config_3 dac_config_5 col_event_rst_top_right[53] dac_config_4
+ row_on_detect_top[29] dac_config_0 dac_config_1 row_off_detect_top[28] x2_net21
+ dac_config_2 vdda1 vssa1 vssc1 col_event_rst_top_right[52] x2_net22
+ row_on_detect_top[28] row_off_detect_top[29] openDVS_pixel2x2_top
x2_x454 dac_config_3 dac_config_5 col_event_rst_top_right[51] dac_config_4
+ row_on_detect_top[29] dac_config_0 dac_config_1 row_off_detect_top[28] x2_net25
+ dac_config_2 vdda1 vssa1 vssc1 col_event_rst_top_right[50] x2_net26
+ row_on_detect_top[28] row_off_detect_top[29] openDVS_pixel2x2_top
x2_x455 dac_config_3 dac_config_5 col_event_rst_top_right[49] dac_config_4
+ row_on_detect_top[29] dac_config_0 dac_config_1 row_off_detect_top[28] x2_net29
+ dac_config_2 vdda1 vssa1 vssc1 col_event_rst_top_right[48] x2_net30
+ row_on_detect_top[28] row_off_detect_top[29] openDVS_pixel2x2_top
x2_x456 dac_config_3 dac_config_5 col_event_rst_top_right[47] dac_config_4
+ row_on_detect_top[29] dac_config_0 dac_config_1 row_off_detect_top[28] x2_net33
+ dac_config_2 vdda1 vssa1 vssc1 col_event_rst_top_right[46] x2_net34
+ row_on_detect_top[28] row_off_detect_top[29] openDVS_pixel2x2_top
x2_x457 dac_config_3 dac_config_5 col_event_rst_top_right[45] dac_config_4
+ row_on_detect_top[29] dac_config_0 dac_config_1 row_off_detect_top[28] x2_net37
+ dac_config_2 vdda1 vssa1 vssc1 col_event_rst_top_right[44] x2_net38
+ row_on_detect_top[28] row_off_detect_top[29] openDVS_pixel2x2_top
x2_x458 dac_config_3 dac_config_5 col_event_rst_top_right[43] dac_config_4
+ row_on_detect_top[29] dac_config_0 dac_config_1 row_off_detect_top[28] x2_net41
+ dac_config_2 vdda1 vssa1 vssc1 col_event_rst_top_right[42] x2_net42
+ row_on_detect_top[28] row_off_detect_top[29] openDVS_pixel2x2_top
x2_x459 dac_config_3 dac_config_5 col_event_rst_top_right[41] dac_config_4
+ row_on_detect_top[29] dac_config_0 dac_config_1 row_off_detect_top[28] x2_net45
+ dac_config_2 vdda1 vssa1 vssc1 col_event_rst_top_right[40] x2_net46
+ row_on_detect_top[28] row_off_detect_top[29] openDVS_pixel2x2_top
x2_x460 dac_config_3 dac_config_5 col_event_rst_top_right[39] dac_config_4
+ row_on_detect_top[29] dac_config_0 dac_config_1 row_off_detect_top[28] x2_net49
+ dac_config_2 vdda1 vssa1 vssc1 col_event_rst_top_right[38] x2_net50
+ row_on_detect_top[28] row_off_detect_top[29] openDVS_pixel2x2_top
x2_x461 dac_config_3 dac_config_5 col_event_rst_top_right[37] dac_config_4
+ row_on_detect_top[29] dac_config_0 dac_config_1 row_off_detect_top[28] x2_net53
+ dac_config_2 vdda1 vssa1 vssc1 col_event_rst_top_right[36] x2_net54
+ row_on_detect_top[28] row_off_detect_top[29] openDVS_pixel2x2_top
x2_x462 dac_config_3 dac_config_5 col_event_rst_top_right[35] dac_config_4
+ row_on_detect_top[29] dac_config_0 dac_config_1 row_off_detect_top[28] x2_net57
+ dac_config_2 vdda1 vssa1 vssc1 col_event_rst_top_right[34] x2_net58
+ row_on_detect_top[28] row_off_detect_top[29] openDVS_pixel2x2_top
x2_x463 dac_config_3 dac_config_5 col_event_rst_top_right[33] dac_config_4
+ row_on_detect_top[29] dac_config_0 dac_config_1 row_off_detect_top[28] x2_net61
+ dac_config_2 vdda1 vssa1 vssc1 col_event_rst_top_right[32] x2_net62
+ row_on_detect_top[28] row_off_detect_top[29] openDVS_pixel2x2_top
x2_x464 dac_config_3 dac_config_5 col_event_rst_top_right[31] dac_config_4
+ row_on_detect_top[29] dac_config_0 dac_config_1 row_off_detect_top[28] x2_net65
+ dac_config_2 vdda1 vssa1 vssc1 col_event_rst_top_right[30] x2_net66
+ row_on_detect_top[28] row_off_detect_top[29] openDVS_pixel2x2_top
x2_x465 dac_config_3 dac_config_5 col_event_rst_top_right[29] dac_config_4
+ row_on_detect_top[29] dac_config_0 dac_config_1 row_off_detect_top[28] x2_net69
+ dac_config_2 vdda1 vssa1 vssc1 col_event_rst_top_right[28] x2_net70
+ row_on_detect_top[28] row_off_detect_top[29] openDVS_pixel2x2_top
x2_x466 dac_config_3 dac_config_5 col_event_rst_top_right[27] dac_config_4
+ row_on_detect_top[29] dac_config_0 dac_config_1 row_off_detect_top[28] x2_net73
+ dac_config_2 vdda1 vssa1 vssc1 col_event_rst_top_right[26] x2_net74
+ row_on_detect_top[28] row_off_detect_top[29] openDVS_pixel2x2_top
x2_x467 dac_config_3 dac_config_5 col_event_rst_top_right[25] dac_config_4
+ row_on_detect_top[29] dac_config_0 dac_config_1 row_off_detect_top[28] x2_net77
+ dac_config_2 vdda1 vssa1 vssc1 col_event_rst_top_right[24] x2_net78
+ row_on_detect_top[28] row_off_detect_top[29] openDVS_pixel2x2_top
x2_x468 dac_config_3 dac_config_5 col_event_rst_top_right[23] dac_config_4
+ row_on_detect_top[29] dac_config_0 dac_config_1 row_off_detect_top[28] x2_net81
+ dac_config_2 vdda1 vssa1 vssc1 col_event_rst_top_right[22] x2_net82
+ row_on_detect_top[28] row_off_detect_top[29] openDVS_pixel2x2_top
x2_x469 dac_config_3 dac_config_5 col_event_rst_top_right[21] dac_config_4
+ row_on_detect_top[29] dac_config_0 dac_config_1 row_off_detect_top[28] x2_net85
+ dac_config_2 vdda1 vssa1 vssc1 col_event_rst_top_right[20] x2_net86
+ row_on_detect_top[28] row_off_detect_top[29] openDVS_pixel2x2_top
x2_x470 dac_config_3 dac_config_5 col_event_rst_top_right[19] dac_config_4
+ row_on_detect_top[29] dac_config_0 dac_config_1 row_off_detect_top[28] x2_net89
+ dac_config_2 vdda1 vssa1 vssc1 col_event_rst_top_right[18] x2_net90
+ row_on_detect_top[28] row_off_detect_top[29] openDVS_pixel2x2_top
x2_x471 dac_config_3 dac_config_5 col_event_rst_top_right[17] dac_config_4
+ row_on_detect_top[29] dac_config_0 dac_config_1 row_off_detect_top[28] x2_net93
+ dac_config_2 vdda1 vssa1 vssc1 col_event_rst_top_right[16] x2_net94
+ row_on_detect_top[28] row_off_detect_top[29] openDVS_pixel2x2_top
x2_x472 dac_config_3 dac_config_5 col_event_rst_top_right[15] dac_config_4
+ row_on_detect_top[29] dac_config_0 dac_config_1 row_off_detect_top[28] x2_net97
+ dac_config_2 vdda1 vssa1 vssc1 col_event_rst_top_right[14] x2_net98
+ row_on_detect_top[28] row_off_detect_top[29] openDVS_pixel2x2_top
x2_x473 dac_config_3 dac_config_5 col_event_rst_top_right[13] dac_config_4
+ row_on_detect_top[29] dac_config_0 dac_config_1 row_off_detect_top[28] x2_net101
+ dac_config_2 vdda1 vssa1 vssc1 col_event_rst_top_right[12] x2_net102
+ row_on_detect_top[28] row_off_detect_top[29] openDVS_pixel2x2_top
x2_x474 dac_config_3 dac_config_5 col_event_rst_top_right[11] dac_config_4
+ row_on_detect_top[29] dac_config_0 dac_config_1 row_off_detect_top[28] x2_net105
+ dac_config_2 vdda1 vssa1 vssc1 col_event_rst_top_right[10] x2_net106
+ row_on_detect_top[28] row_off_detect_top[29] openDVS_pixel2x2_top
x2_x475 dac_config_3 dac_config_5 col_event_rst_top_right[9] dac_config_4
+ row_on_detect_top[29] dac_config_0 dac_config_1 row_off_detect_top[28] x2_net109
+ dac_config_2 vdda1 vssa1 vssc1 col_event_rst_top_right[8] x2_net110
+ row_on_detect_top[28] row_off_detect_top[29] openDVS_pixel2x2_top
x2_x476 dac_config_3 dac_config_5 col_event_rst_top_right[7] dac_config_4
+ row_on_detect_top[29] dac_config_0 dac_config_1 row_off_detect_top[28] x2_net113
+ dac_config_2 vdda1 vssa1 vssc1 col_event_rst_top_right[6] x2_net114
+ row_on_detect_top[28] row_off_detect_top[29] openDVS_pixel2x2_top
x2_x477 dac_config_3 dac_config_5 col_event_rst_top_right[5] dac_config_4
+ row_on_detect_top[29] dac_config_0 dac_config_1 row_off_detect_top[28] x2_net117
+ dac_config_2 vdda1 vssa1 vssc1 col_event_rst_top_right[4] x2_net118
+ row_on_detect_top[28] row_off_detect_top[29] openDVS_pixel2x2_top
x2_x478 dac_config_3 dac_config_5 col_event_rst_top_right[3] dac_config_4
+ row_on_detect_top[29] dac_config_0 dac_config_1 row_off_detect_top[28] x2_net121
+ dac_config_2 vdda1 vssa1 vssc1 col_event_rst_top_right[2] x2_net122
+ row_on_detect_top[28] row_off_detect_top[29] openDVS_pixel2x2_top
x2_x479 dac_config_3 dac_config_5 col_event_rst_top_right[1] dac_config_4
+ row_on_detect_top[29] dac_config_0 dac_config_1 row_off_detect_top[28] x2_net125
+ dac_config_2 vdda1 vssa1 vssc1 col_event_rst_top_right[0] x2_net126
+ row_on_detect_top[28] row_off_detect_top[29] openDVS_pixel2x2_top
x2_x480 dac_config_3 dac_config_5 col_event_rst_top_right[63] dac_config_4
+ row_on_detect_top[31] dac_config_0 dac_config_1 row_off_detect_top[30] x2_net1
+ dac_config_2 vdda1 vssa1 vssc1 col_event_rst_top_right[62] x2_net2 row_on_detect_top[30]
+ row_off_detect_top[31] openDVS_pixel2x2_top
x2_x481 dac_config_3 dac_config_5 col_event_rst_top_right[61] dac_config_4
+ row_on_detect_top[31] dac_config_0 dac_config_1 row_off_detect_top[30] x2_net5
+ dac_config_2 vdda1 vssa1 vssc1 col_event_rst_top_right[60] x2_net6 row_on_detect_top[30]
+ row_off_detect_top[31] openDVS_pixel2x2_top
x2_x482 dac_config_3 dac_config_5 col_event_rst_top_right[59] dac_config_4
+ row_on_detect_top[31] dac_config_0 dac_config_1 row_off_detect_top[30] x2_net9
+ dac_config_2 vdda1 vssa1 vssc1 col_event_rst_top_right[58] x2_net10
+ row_on_detect_top[30] row_off_detect_top[31] openDVS_pixel2x2_top
x2_x483 dac_config_3 dac_config_5 col_event_rst_top_right[57] dac_config_4
+ row_on_detect_top[31] dac_config_0 dac_config_1 row_off_detect_top[30] x2_net13
+ dac_config_2 vdda1 vssa1 vssc1 col_event_rst_top_right[56] x2_net14
+ row_on_detect_top[30] row_off_detect_top[31] openDVS_pixel2x2_top
x2_x484 dac_config_3 dac_config_5 col_event_rst_top_right[55] dac_config_4
+ row_on_detect_top[31] dac_config_0 dac_config_1 row_off_detect_top[30] x2_net17
+ dac_config_2 vdda1 vssa1 vssc1 col_event_rst_top_right[54] x2_net18
+ row_on_detect_top[30] row_off_detect_top[31] openDVS_pixel2x2_top
x2_x485 dac_config_3 dac_config_5 col_event_rst_top_right[53] dac_config_4
+ row_on_detect_top[31] dac_config_0 dac_config_1 row_off_detect_top[30] x2_net21
+ dac_config_2 vdda1 vssa1 vssc1 col_event_rst_top_right[52] x2_net22
+ row_on_detect_top[30] row_off_detect_top[31] openDVS_pixel2x2_top
x2_x486 dac_config_3 dac_config_5 col_event_rst_top_right[51] dac_config_4
+ row_on_detect_top[31] dac_config_0 dac_config_1 row_off_detect_top[30] x2_net25
+ dac_config_2 vdda1 vssa1 vssc1 col_event_rst_top_right[50] x2_net26
+ row_on_detect_top[30] row_off_detect_top[31] openDVS_pixel2x2_top
x2_x487 dac_config_3 dac_config_5 col_event_rst_top_right[49] dac_config_4
+ row_on_detect_top[31] dac_config_0 dac_config_1 row_off_detect_top[30] x2_net29
+ dac_config_2 vdda1 vssa1 vssc1 col_event_rst_top_right[48] x2_net30
+ row_on_detect_top[30] row_off_detect_top[31] openDVS_pixel2x2_top
x2_x488 dac_config_3 dac_config_5 col_event_rst_top_right[47] dac_config_4
+ row_on_detect_top[31] dac_config_0 dac_config_1 row_off_detect_top[30] x2_net33
+ dac_config_2 vdda1 vssa1 vssc1 col_event_rst_top_right[46] x2_net34
+ row_on_detect_top[30] row_off_detect_top[31] openDVS_pixel2x2_top
x2_x489 dac_config_3 dac_config_5 col_event_rst_top_right[45] dac_config_4
+ row_on_detect_top[31] dac_config_0 dac_config_1 row_off_detect_top[30] x2_net37
+ dac_config_2 vdda1 vssa1 vssc1 col_event_rst_top_right[44] x2_net38
+ row_on_detect_top[30] row_off_detect_top[31] openDVS_pixel2x2_top
x2_x490 dac_config_3 dac_config_5 col_event_rst_top_right[43] dac_config_4
+ row_on_detect_top[31] dac_config_0 dac_config_1 row_off_detect_top[30] x2_net41
+ dac_config_2 vdda1 vssa1 vssc1 col_event_rst_top_right[42] x2_net42
+ row_on_detect_top[30] row_off_detect_top[31] openDVS_pixel2x2_top
x2_x491 dac_config_3 dac_config_5 col_event_rst_top_right[41] dac_config_4
+ row_on_detect_top[31] dac_config_0 dac_config_1 row_off_detect_top[30] x2_net45
+ dac_config_2 vdda1 vssa1 vssc1 col_event_rst_top_right[40] x2_net46
+ row_on_detect_top[30] row_off_detect_top[31] openDVS_pixel2x2_top
x2_x492 dac_config_3 dac_config_5 col_event_rst_top_right[39] dac_config_4
+ row_on_detect_top[31] dac_config_0 dac_config_1 row_off_detect_top[30] x2_net49
+ dac_config_2 vdda1 vssa1 vssc1 col_event_rst_top_right[38] x2_net50
+ row_on_detect_top[30] row_off_detect_top[31] openDVS_pixel2x2_top
x2_x493 dac_config_3 dac_config_5 col_event_rst_top_right[37] dac_config_4
+ row_on_detect_top[31] dac_config_0 dac_config_1 row_off_detect_top[30] x2_net53
+ dac_config_2 vdda1 vssa1 vssc1 col_event_rst_top_right[36] x2_net54
+ row_on_detect_top[30] row_off_detect_top[31] openDVS_pixel2x2_top
x2_x494 dac_config_3 dac_config_5 col_event_rst_top_right[35] dac_config_4
+ row_on_detect_top[31] dac_config_0 dac_config_1 row_off_detect_top[30] x2_net57
+ dac_config_2 vdda1 vssa1 vssc1 col_event_rst_top_right[34] x2_net58
+ row_on_detect_top[30] row_off_detect_top[31] openDVS_pixel2x2_top
x2_x495 dac_config_3 dac_config_5 col_event_rst_top_right[33] dac_config_4
+ row_on_detect_top[31] dac_config_0 dac_config_1 row_off_detect_top[30] x2_net61
+ dac_config_2 vdda1 vssa1 vssc1 col_event_rst_top_right[32] x2_net62
+ row_on_detect_top[30] row_off_detect_top[31] openDVS_pixel2x2_top
x2_x496 dac_config_3 dac_config_5 col_event_rst_top_right[31] dac_config_4
+ row_on_detect_top[31] dac_config_0 dac_config_1 row_off_detect_top[30] x2_net65
+ dac_config_2 vdda1 vssa1 vssc1 col_event_rst_top_right[30] x2_net66
+ row_on_detect_top[30] row_off_detect_top[31] openDVS_pixel2x2_top
x2_x497 dac_config_3 dac_config_5 col_event_rst_top_right[29] dac_config_4
+ row_on_detect_top[31] dac_config_0 dac_config_1 row_off_detect_top[30] x2_net69
+ dac_config_2 vdda1 vssa1 vssc1 col_event_rst_top_right[28] x2_net70
+ row_on_detect_top[30] row_off_detect_top[31] openDVS_pixel2x2_top
x2_x498 dac_config_3 dac_config_5 col_event_rst_top_right[27] dac_config_4
+ row_on_detect_top[31] dac_config_0 dac_config_1 row_off_detect_top[30] x2_net73
+ dac_config_2 vdda1 vssa1 vssc1 col_event_rst_top_right[26] x2_net74
+ row_on_detect_top[30] row_off_detect_top[31] openDVS_pixel2x2_top
x2_x499 dac_config_3 dac_config_5 col_event_rst_top_right[25] dac_config_4
+ row_on_detect_top[31] dac_config_0 dac_config_1 row_off_detect_top[30] x2_net77
+ dac_config_2 vdda1 vssa1 vssc1 col_event_rst_top_right[24] x2_net78
+ row_on_detect_top[30] row_off_detect_top[31] openDVS_pixel2x2_top
x2_x500 dac_config_3 dac_config_5 col_event_rst_top_right[23] dac_config_4
+ row_on_detect_top[31] dac_config_0 dac_config_1 row_off_detect_top[30] x2_net81
+ dac_config_2 vdda1 vssa1 vssc1 col_event_rst_top_right[22] x2_net82
+ row_on_detect_top[30] row_off_detect_top[31] openDVS_pixel2x2_top
x2_x501 dac_config_3 dac_config_5 col_event_rst_top_right[21] dac_config_4
+ row_on_detect_top[31] dac_config_0 dac_config_1 row_off_detect_top[30] x2_net85
+ dac_config_2 vdda1 vssa1 vssc1 col_event_rst_top_right[20] x2_net86
+ row_on_detect_top[30] row_off_detect_top[31] openDVS_pixel2x2_top
x2_x502 dac_config_3 dac_config_5 col_event_rst_top_right[19] dac_config_4
+ row_on_detect_top[31] dac_config_0 dac_config_1 row_off_detect_top[30] x2_net89
+ dac_config_2 vdda1 vssa1 vssc1 col_event_rst_top_right[18] x2_net90
+ row_on_detect_top[30] row_off_detect_top[31] openDVS_pixel2x2_top
x2_x503 dac_config_3 dac_config_5 col_event_rst_top_right[17] dac_config_4
+ row_on_detect_top[31] dac_config_0 dac_config_1 row_off_detect_top[30] x2_net93
+ dac_config_2 vdda1 vssa1 vssc1 col_event_rst_top_right[16] x2_net94
+ row_on_detect_top[30] row_off_detect_top[31] openDVS_pixel2x2_top
x2_x504 dac_config_3 dac_config_5 col_event_rst_top_right[15] dac_config_4
+ row_on_detect_top[31] dac_config_0 dac_config_1 row_off_detect_top[30] x2_net97
+ dac_config_2 vdda1 vssa1 vssc1 col_event_rst_top_right[14] x2_net98
+ row_on_detect_top[30] row_off_detect_top[31] openDVS_pixel2x2_top
x2_x505 dac_config_3 dac_config_5 col_event_rst_top_right[13] dac_config_4
+ row_on_detect_top[31] dac_config_0 dac_config_1 row_off_detect_top[30] x2_net101
+ dac_config_2 vdda1 vssa1 vssc1 col_event_rst_top_right[12] x2_net102
+ row_on_detect_top[30] row_off_detect_top[31] openDVS_pixel2x2_top
x2_x506 dac_config_3 dac_config_5 col_event_rst_top_right[11] dac_config_4
+ row_on_detect_top[31] dac_config_0 dac_config_1 row_off_detect_top[30] x2_net105
+ dac_config_2 vdda1 vssa1 vssc1 col_event_rst_top_right[10] x2_net106
+ row_on_detect_top[30] row_off_detect_top[31] openDVS_pixel2x2_top
x2_x507 dac_config_3 dac_config_5 col_event_rst_top_right[9] dac_config_4
+ row_on_detect_top[31] dac_config_0 dac_config_1 row_off_detect_top[30] x2_net109
+ dac_config_2 vdda1 vssa1 vssc1 col_event_rst_top_right[8] x2_net110
+ row_on_detect_top[30] row_off_detect_top[31] openDVS_pixel2x2_top
x2_x508 dac_config_3 dac_config_5 col_event_rst_top_right[7] dac_config_4
+ row_on_detect_top[31] dac_config_0 dac_config_1 row_off_detect_top[30] x2_net113
+ dac_config_2 vdda1 vssa1 vssc1 col_event_rst_top_right[6] x2_net114
+ row_on_detect_top[30] row_off_detect_top[31] openDVS_pixel2x2_top
x2_x509 dac_config_3 dac_config_5 col_event_rst_top_right[5] dac_config_4
+ row_on_detect_top[31] dac_config_0 dac_config_1 row_off_detect_top[30] x2_net117
+ dac_config_2 vdda1 vssa1 vssc1 col_event_rst_top_right[4] x2_net118
+ row_on_detect_top[30] row_off_detect_top[31] openDVS_pixel2x2_top
x2_x510 dac_config_3 dac_config_5 col_event_rst_top_right[3] dac_config_4
+ row_on_detect_top[31] dac_config_0 dac_config_1 row_off_detect_top[30] x2_net121
+ dac_config_2 vdda1 vssa1 vssc1 col_event_rst_top_right[2] x2_net122
+ row_on_detect_top[30] row_off_detect_top[31] openDVS_pixel2x2_top
x2_x511 dac_config_3 dac_config_5 col_event_rst_top_right[1] dac_config_4
+ row_on_detect_top[31] dac_config_0 dac_config_1 row_off_detect_top[30] x2_net125
+ dac_config_2 vdda1 vssa1 vssc1 col_event_rst_top_right[0] x2_net126
+ row_on_detect_top[30] row_off_detect_top[31] openDVS_pixel2x2_top
x2_x512 dac_config_3 dac_config_5 col_event_rst_top_right[63] dac_config_4
+ row_on_detect_top[33] dac_config_0 dac_config_1 row_off_detect_top[32] x2_net1
+ dac_config_2 vdda1 vssa1 vssc1 col_event_rst_top_right[62] x2_net2 row_on_detect_top[32]
+ row_off_detect_top[33] openDVS_pixel2x2_top
x2_x513 dac_config_3 dac_config_5 col_event_rst_top_right[61] dac_config_4
+ row_on_detect_top[33] dac_config_0 dac_config_1 row_off_detect_top[32] x2_net5
+ dac_config_2 vdda1 vssa1 vssc1 col_event_rst_top_right[60] x2_net6 row_on_detect_top[32]
+ row_off_detect_top[33] openDVS_pixel2x2_top
x2_x514 dac_config_3 dac_config_5 col_event_rst_top_right[59] dac_config_4
+ row_on_detect_top[33] dac_config_0 dac_config_1 row_off_detect_top[32] x2_net9
+ dac_config_2 vdda1 vssa1 vssc1 col_event_rst_top_right[58] x2_net10
+ row_on_detect_top[32] row_off_detect_top[33] openDVS_pixel2x2_top
x2_x515 dac_config_3 dac_config_5 col_event_rst_top_right[57] dac_config_4
+ row_on_detect_top[33] dac_config_0 dac_config_1 row_off_detect_top[32] x2_net13
+ dac_config_2 vdda1 vssa1 vssc1 col_event_rst_top_right[56] x2_net14
+ row_on_detect_top[32] row_off_detect_top[33] openDVS_pixel2x2_top
x2_x516 dac_config_3 dac_config_5 col_event_rst_top_right[55] dac_config_4
+ row_on_detect_top[33] dac_config_0 dac_config_1 row_off_detect_top[32] x2_net17
+ dac_config_2 vdda1 vssa1 vssc1 col_event_rst_top_right[54] x2_net18
+ row_on_detect_top[32] row_off_detect_top[33] openDVS_pixel2x2_top
x2_x517 dac_config_3 dac_config_5 col_event_rst_top_right[53] dac_config_4
+ row_on_detect_top[33] dac_config_0 dac_config_1 row_off_detect_top[32] x2_net21
+ dac_config_2 vdda1 vssa1 vssc1 col_event_rst_top_right[52] x2_net22
+ row_on_detect_top[32] row_off_detect_top[33] openDVS_pixel2x2_top
x2_x518 dac_config_3 dac_config_5 col_event_rst_top_right[51] dac_config_4
+ row_on_detect_top[33] dac_config_0 dac_config_1 row_off_detect_top[32] x2_net25
+ dac_config_2 vdda1 vssa1 vssc1 col_event_rst_top_right[50] x2_net26
+ row_on_detect_top[32] row_off_detect_top[33] openDVS_pixel2x2_top
x2_x519 dac_config_3 dac_config_5 col_event_rst_top_right[49] dac_config_4
+ row_on_detect_top[33] dac_config_0 dac_config_1 row_off_detect_top[32] x2_net29
+ dac_config_2 vdda1 vssa1 vssc1 col_event_rst_top_right[48] x2_net30
+ row_on_detect_top[32] row_off_detect_top[33] openDVS_pixel2x2_top
x2_x520 dac_config_3 dac_config_5 col_event_rst_top_right[47] dac_config_4
+ row_on_detect_top[33] dac_config_0 dac_config_1 row_off_detect_top[32] x2_net33
+ dac_config_2 vdda1 vssa1 vssc1 col_event_rst_top_right[46] x2_net34
+ row_on_detect_top[32] row_off_detect_top[33] openDVS_pixel2x2_top
x2_x521 dac_config_3 dac_config_5 col_event_rst_top_right[45] dac_config_4
+ row_on_detect_top[33] dac_config_0 dac_config_1 row_off_detect_top[32] x2_net37
+ dac_config_2 vdda1 vssa1 vssc1 col_event_rst_top_right[44] x2_net38
+ row_on_detect_top[32] row_off_detect_top[33] openDVS_pixel2x2_top
x2_x522 dac_config_3 dac_config_5 col_event_rst_top_right[43] dac_config_4
+ row_on_detect_top[33] dac_config_0 dac_config_1 row_off_detect_top[32] x2_net41
+ dac_config_2 vdda1 vssa1 vssc1 col_event_rst_top_right[42] x2_net42
+ row_on_detect_top[32] row_off_detect_top[33] openDVS_pixel2x2_top
x2_x523 dac_config_3 dac_config_5 col_event_rst_top_right[41] dac_config_4
+ row_on_detect_top[33] dac_config_0 dac_config_1 row_off_detect_top[32] x2_net45
+ dac_config_2 vdda1 vssa1 vssc1 col_event_rst_top_right[40] x2_net46
+ row_on_detect_top[32] row_off_detect_top[33] openDVS_pixel2x2_top
x2_x524 dac_config_3 dac_config_5 col_event_rst_top_right[39] dac_config_4
+ row_on_detect_top[33] dac_config_0 dac_config_1 row_off_detect_top[32] x2_net49
+ dac_config_2 vdda1 vssa1 vssc1 col_event_rst_top_right[38] x2_net50
+ row_on_detect_top[32] row_off_detect_top[33] openDVS_pixel2x2_top
x2_x525 dac_config_3 dac_config_5 col_event_rst_top_right[37] dac_config_4
+ row_on_detect_top[33] dac_config_0 dac_config_1 row_off_detect_top[32] x2_net53
+ dac_config_2 vdda1 vssa1 vssc1 col_event_rst_top_right[36] x2_net54
+ row_on_detect_top[32] row_off_detect_top[33] openDVS_pixel2x2_top
x2_x526 dac_config_3 dac_config_5 col_event_rst_top_right[35] dac_config_4
+ row_on_detect_top[33] dac_config_0 dac_config_1 row_off_detect_top[32] x2_net57
+ dac_config_2 vdda1 vssa1 vssc1 col_event_rst_top_right[34] x2_net58
+ row_on_detect_top[32] row_off_detect_top[33] openDVS_pixel2x2_top
x2_x527 dac_config_3 dac_config_5 col_event_rst_top_right[33] dac_config_4
+ row_on_detect_top[33] dac_config_0 dac_config_1 row_off_detect_top[32] x2_net61
+ dac_config_2 vdda1 vssa1 vssc1 col_event_rst_top_right[32] x2_net62
+ row_on_detect_top[32] row_off_detect_top[33] openDVS_pixel2x2_top
x2_x528 dac_config_3 dac_config_5 col_event_rst_top_right[31] dac_config_4
+ row_on_detect_top[33] dac_config_0 dac_config_1 row_off_detect_top[32] x2_net65
+ dac_config_2 vdda1 vssa1 vssc1 col_event_rst_top_right[30] x2_net66
+ row_on_detect_top[32] row_off_detect_top[33] openDVS_pixel2x2_top
x2_x529 dac_config_3 dac_config_5 col_event_rst_top_right[29] dac_config_4
+ row_on_detect_top[33] dac_config_0 dac_config_1 row_off_detect_top[32] x2_net69
+ dac_config_2 vdda1 vssa1 vssc1 col_event_rst_top_right[28] x2_net70
+ row_on_detect_top[32] row_off_detect_top[33] openDVS_pixel2x2_top
x2_x530 dac_config_3 dac_config_5 col_event_rst_top_right[27] dac_config_4
+ row_on_detect_top[33] dac_config_0 dac_config_1 row_off_detect_top[32] x2_net73
+ dac_config_2 vdda1 vssa1 vssc1 col_event_rst_top_right[26] x2_net74
+ row_on_detect_top[32] row_off_detect_top[33] openDVS_pixel2x2_top
x2_x531 dac_config_3 dac_config_5 col_event_rst_top_right[25] dac_config_4
+ row_on_detect_top[33] dac_config_0 dac_config_1 row_off_detect_top[32] x2_net77
+ dac_config_2 vdda1 vssa1 vssc1 col_event_rst_top_right[24] x2_net78
+ row_on_detect_top[32] row_off_detect_top[33] openDVS_pixel2x2_top
x2_x532 dac_config_3 dac_config_5 col_event_rst_top_right[23] dac_config_4
+ row_on_detect_top[33] dac_config_0 dac_config_1 row_off_detect_top[32] x2_net81
+ dac_config_2 vdda1 vssa1 vssc1 col_event_rst_top_right[22] x2_net82
+ row_on_detect_top[32] row_off_detect_top[33] openDVS_pixel2x2_top
x2_x533 dac_config_3 dac_config_5 col_event_rst_top_right[21] dac_config_4
+ row_on_detect_top[33] dac_config_0 dac_config_1 row_off_detect_top[32] x2_net85
+ dac_config_2 vdda1 vssa1 vssc1 col_event_rst_top_right[20] x2_net86
+ row_on_detect_top[32] row_off_detect_top[33] openDVS_pixel2x2_top
x2_x534 dac_config_3 dac_config_5 col_event_rst_top_right[19] dac_config_4
+ row_on_detect_top[33] dac_config_0 dac_config_1 row_off_detect_top[32] x2_net89
+ dac_config_2 vdda1 vssa1 vssc1 col_event_rst_top_right[18] x2_net90
+ row_on_detect_top[32] row_off_detect_top[33] openDVS_pixel2x2_top
x2_x535 dac_config_3 dac_config_5 col_event_rst_top_right[17] dac_config_4
+ row_on_detect_top[33] dac_config_0 dac_config_1 row_off_detect_top[32] x2_net93
+ dac_config_2 vdda1 vssa1 vssc1 col_event_rst_top_right[16] x2_net94
+ row_on_detect_top[32] row_off_detect_top[33] openDVS_pixel2x2_top
x2_x536 dac_config_3 dac_config_5 col_event_rst_top_right[15] dac_config_4
+ row_on_detect_top[33] dac_config_0 dac_config_1 row_off_detect_top[32] x2_net97
+ dac_config_2 vdda1 vssa1 vssc1 col_event_rst_top_right[14] x2_net98
+ row_on_detect_top[32] row_off_detect_top[33] openDVS_pixel2x2_top
x2_x537 dac_config_3 dac_config_5 col_event_rst_top_right[13] dac_config_4
+ row_on_detect_top[33] dac_config_0 dac_config_1 row_off_detect_top[32] x2_net101
+ dac_config_2 vdda1 vssa1 vssc1 col_event_rst_top_right[12] x2_net102
+ row_on_detect_top[32] row_off_detect_top[33] openDVS_pixel2x2_top
x2_x538 dac_config_3 dac_config_5 col_event_rst_top_right[11] dac_config_4
+ row_on_detect_top[33] dac_config_0 dac_config_1 row_off_detect_top[32] x2_net105
+ dac_config_2 vdda1 vssa1 vssc1 col_event_rst_top_right[10] x2_net106
+ row_on_detect_top[32] row_off_detect_top[33] openDVS_pixel2x2_top
x2_x539 dac_config_3 dac_config_5 col_event_rst_top_right[9] dac_config_4
+ row_on_detect_top[33] dac_config_0 dac_config_1 row_off_detect_top[32] x2_net109
+ dac_config_2 vdda1 vssa1 vssc1 col_event_rst_top_right[8] x2_net110
+ row_on_detect_top[32] row_off_detect_top[33] openDVS_pixel2x2_top
x2_x540 dac_config_3 dac_config_5 col_event_rst_top_right[7] dac_config_4
+ row_on_detect_top[33] dac_config_0 dac_config_1 row_off_detect_top[32] x2_net113
+ dac_config_2 vdda1 vssa1 vssc1 col_event_rst_top_right[6] x2_net114
+ row_on_detect_top[32] row_off_detect_top[33] openDVS_pixel2x2_top
x2_x541 dac_config_3 dac_config_5 col_event_rst_top_right[5] dac_config_4
+ row_on_detect_top[33] dac_config_0 dac_config_1 row_off_detect_top[32] x2_net117
+ dac_config_2 vdda1 vssa1 vssc1 col_event_rst_top_right[4] x2_net118
+ row_on_detect_top[32] row_off_detect_top[33] openDVS_pixel2x2_top
x2_x542 dac_config_3 dac_config_5 col_event_rst_top_right[3] dac_config_4
+ row_on_detect_top[33] dac_config_0 dac_config_1 row_off_detect_top[32] x2_net121
+ dac_config_2 vdda1 vssa1 vssc1 col_event_rst_top_right[2] x2_net122
+ row_on_detect_top[32] row_off_detect_top[33] openDVS_pixel2x2_top
x2_x543 dac_config_3 dac_config_5 col_event_rst_top_right[1] dac_config_4
+ row_on_detect_top[33] dac_config_0 dac_config_1 row_off_detect_top[32] x2_net125
+ dac_config_2 vdda1 vssa1 vssc1 col_event_rst_top_right[0] x2_net126
+ row_on_detect_top[32] row_off_detect_top[33] openDVS_pixel2x2_top
x2_x544 dac_config_3 dac_config_5 col_event_rst_top_right[63] dac_config_4
+ row_on_detect_top[35] dac_config_0 dac_config_1 row_off_detect_top[34] x2_net1
+ dac_config_2 vdda1 vssa1 vssc1 col_event_rst_top_right[62] x2_net2 row_on_detect_top[34]
+ row_off_detect_top[35] openDVS_pixel2x2_top
x2_x545 dac_config_3 dac_config_5 col_event_rst_top_right[61] dac_config_4
+ row_on_detect_top[35] dac_config_0 dac_config_1 row_off_detect_top[34] x2_net5
+ dac_config_2 vdda1 vssa1 vssc1 col_event_rst_top_right[60] x2_net6 row_on_detect_top[34]
+ row_off_detect_top[35] openDVS_pixel2x2_top
x2_x546 dac_config_3 dac_config_5 col_event_rst_top_right[59] dac_config_4
+ row_on_detect_top[35] dac_config_0 dac_config_1 row_off_detect_top[34] x2_net9
+ dac_config_2 vdda1 vssa1 vssc1 col_event_rst_top_right[58] x2_net10
+ row_on_detect_top[34] row_off_detect_top[35] openDVS_pixel2x2_top
x2_x547 dac_config_3 dac_config_5 col_event_rst_top_right[57] dac_config_4
+ row_on_detect_top[35] dac_config_0 dac_config_1 row_off_detect_top[34] x2_net13
+ dac_config_2 vdda1 vssa1 vssc1 col_event_rst_top_right[56] x2_net14
+ row_on_detect_top[34] row_off_detect_top[35] openDVS_pixel2x2_top
x2_x548 dac_config_3 dac_config_5 col_event_rst_top_right[55] dac_config_4
+ row_on_detect_top[35] dac_config_0 dac_config_1 row_off_detect_top[34] x2_net17
+ dac_config_2 vdda1 vssa1 vssc1 col_event_rst_top_right[54] x2_net18
+ row_on_detect_top[34] row_off_detect_top[35] openDVS_pixel2x2_top
x2_x549 dac_config_3 dac_config_5 col_event_rst_top_right[53] dac_config_4
+ row_on_detect_top[35] dac_config_0 dac_config_1 row_off_detect_top[34] x2_net21
+ dac_config_2 vdda1 vssa1 vssc1 col_event_rst_top_right[52] x2_net22
+ row_on_detect_top[34] row_off_detect_top[35] openDVS_pixel2x2_top
x2_x550 dac_config_3 dac_config_5 col_event_rst_top_right[51] dac_config_4
+ row_on_detect_top[35] dac_config_0 dac_config_1 row_off_detect_top[34] x2_net25
+ dac_config_2 vdda1 vssa1 vssc1 col_event_rst_top_right[50] x2_net26
+ row_on_detect_top[34] row_off_detect_top[35] openDVS_pixel2x2_top
x2_x551 dac_config_3 dac_config_5 col_event_rst_top_right[49] dac_config_4
+ row_on_detect_top[35] dac_config_0 dac_config_1 row_off_detect_top[34] x2_net29
+ dac_config_2 vdda1 vssa1 vssc1 col_event_rst_top_right[48] x2_net30
+ row_on_detect_top[34] row_off_detect_top[35] openDVS_pixel2x2_top
x2_x552 dac_config_3 dac_config_5 col_event_rst_top_right[47] dac_config_4
+ row_on_detect_top[35] dac_config_0 dac_config_1 row_off_detect_top[34] x2_net33
+ dac_config_2 vdda1 vssa1 vssc1 col_event_rst_top_right[46] x2_net34
+ row_on_detect_top[34] row_off_detect_top[35] openDVS_pixel2x2_top
x2_x553 dac_config_3 dac_config_5 col_event_rst_top_right[45] dac_config_4
+ row_on_detect_top[35] dac_config_0 dac_config_1 row_off_detect_top[34] x2_net37
+ dac_config_2 vdda1 vssa1 vssc1 col_event_rst_top_right[44] x2_net38
+ row_on_detect_top[34] row_off_detect_top[35] openDVS_pixel2x2_top
x2_x554 dac_config_3 dac_config_5 col_event_rst_top_right[43] dac_config_4
+ row_on_detect_top[35] dac_config_0 dac_config_1 row_off_detect_top[34] x2_net41
+ dac_config_2 vdda1 vssa1 vssc1 col_event_rst_top_right[42] x2_net42
+ row_on_detect_top[34] row_off_detect_top[35] openDVS_pixel2x2_top
x2_x555 dac_config_3 dac_config_5 col_event_rst_top_right[41] dac_config_4
+ row_on_detect_top[35] dac_config_0 dac_config_1 row_off_detect_top[34] x2_net45
+ dac_config_2 vdda1 vssa1 vssc1 col_event_rst_top_right[40] x2_net46
+ row_on_detect_top[34] row_off_detect_top[35] openDVS_pixel2x2_top
x2_x556 dac_config_3 dac_config_5 col_event_rst_top_right[39] dac_config_4
+ row_on_detect_top[35] dac_config_0 dac_config_1 row_off_detect_top[34] x2_net49
+ dac_config_2 vdda1 vssa1 vssc1 col_event_rst_top_right[38] x2_net50
+ row_on_detect_top[34] row_off_detect_top[35] openDVS_pixel2x2_top
x2_x557 dac_config_3 dac_config_5 col_event_rst_top_right[37] dac_config_4
+ row_on_detect_top[35] dac_config_0 dac_config_1 row_off_detect_top[34] x2_net53
+ dac_config_2 vdda1 vssa1 vssc1 col_event_rst_top_right[36] x2_net54
+ row_on_detect_top[34] row_off_detect_top[35] openDVS_pixel2x2_top
x2_x558 dac_config_3 dac_config_5 col_event_rst_top_right[35] dac_config_4
+ row_on_detect_top[35] dac_config_0 dac_config_1 row_off_detect_top[34] x2_net57
+ dac_config_2 vdda1 vssa1 vssc1 col_event_rst_top_right[34] x2_net58
+ row_on_detect_top[34] row_off_detect_top[35] openDVS_pixel2x2_top
x2_x559 dac_config_3 dac_config_5 col_event_rst_top_right[33] dac_config_4
+ row_on_detect_top[35] dac_config_0 dac_config_1 row_off_detect_top[34] x2_net61
+ dac_config_2 vdda1 vssa1 vssc1 col_event_rst_top_right[32] x2_net62
+ row_on_detect_top[34] row_off_detect_top[35] openDVS_pixel2x2_top
x2_x560 dac_config_3 dac_config_5 col_event_rst_top_right[31] dac_config_4
+ row_on_detect_top[35] dac_config_0 dac_config_1 row_off_detect_top[34] x2_net65
+ dac_config_2 vdda1 vssa1 vssc1 col_event_rst_top_right[30] x2_net66
+ row_on_detect_top[34] row_off_detect_top[35] openDVS_pixel2x2_top
x2_x561 dac_config_3 dac_config_5 col_event_rst_top_right[29] dac_config_4
+ row_on_detect_top[35] dac_config_0 dac_config_1 row_off_detect_top[34] x2_net69
+ dac_config_2 vdda1 vssa1 vssc1 col_event_rst_top_right[28] x2_net70
+ row_on_detect_top[34] row_off_detect_top[35] openDVS_pixel2x2_top
x2_x562 dac_config_3 dac_config_5 col_event_rst_top_right[27] dac_config_4
+ row_on_detect_top[35] dac_config_0 dac_config_1 row_off_detect_top[34] x2_net73
+ dac_config_2 vdda1 vssa1 vssc1 col_event_rst_top_right[26] x2_net74
+ row_on_detect_top[34] row_off_detect_top[35] openDVS_pixel2x2_top
x2_x563 dac_config_3 dac_config_5 col_event_rst_top_right[25] dac_config_4
+ row_on_detect_top[35] dac_config_0 dac_config_1 row_off_detect_top[34] x2_net77
+ dac_config_2 vdda1 vssa1 vssc1 col_event_rst_top_right[24] x2_net78
+ row_on_detect_top[34] row_off_detect_top[35] openDVS_pixel2x2_top
x2_x564 dac_config_3 dac_config_5 col_event_rst_top_right[23] dac_config_4
+ row_on_detect_top[35] dac_config_0 dac_config_1 row_off_detect_top[34] x2_net81
+ dac_config_2 vdda1 vssa1 vssc1 col_event_rst_top_right[22] x2_net82
+ row_on_detect_top[34] row_off_detect_top[35] openDVS_pixel2x2_top
x2_x565 dac_config_3 dac_config_5 col_event_rst_top_right[21] dac_config_4
+ row_on_detect_top[35] dac_config_0 dac_config_1 row_off_detect_top[34] x2_net85
+ dac_config_2 vdda1 vssa1 vssc1 col_event_rst_top_right[20] x2_net86
+ row_on_detect_top[34] row_off_detect_top[35] openDVS_pixel2x2_top
x2_x566 dac_config_3 dac_config_5 col_event_rst_top_right[19] dac_config_4
+ row_on_detect_top[35] dac_config_0 dac_config_1 row_off_detect_top[34] x2_net89
+ dac_config_2 vdda1 vssa1 vssc1 col_event_rst_top_right[18] x2_net90
+ row_on_detect_top[34] row_off_detect_top[35] openDVS_pixel2x2_top
x2_x567 dac_config_3 dac_config_5 col_event_rst_top_right[17] dac_config_4
+ row_on_detect_top[35] dac_config_0 dac_config_1 row_off_detect_top[34] x2_net93
+ dac_config_2 vdda1 vssa1 vssc1 col_event_rst_top_right[16] x2_net94
+ row_on_detect_top[34] row_off_detect_top[35] openDVS_pixel2x2_top
x2_x568 dac_config_3 dac_config_5 col_event_rst_top_right[15] dac_config_4
+ row_on_detect_top[35] dac_config_0 dac_config_1 row_off_detect_top[34] x2_net97
+ dac_config_2 vdda1 vssa1 vssc1 col_event_rst_top_right[14] x2_net98
+ row_on_detect_top[34] row_off_detect_top[35] openDVS_pixel2x2_top
x2_x569 dac_config_3 dac_config_5 col_event_rst_top_right[13] dac_config_4
+ row_on_detect_top[35] dac_config_0 dac_config_1 row_off_detect_top[34] x2_net101
+ dac_config_2 vdda1 vssa1 vssc1 col_event_rst_top_right[12] x2_net102
+ row_on_detect_top[34] row_off_detect_top[35] openDVS_pixel2x2_top
x2_x570 dac_config_3 dac_config_5 col_event_rst_top_right[11] dac_config_4
+ row_on_detect_top[35] dac_config_0 dac_config_1 row_off_detect_top[34] x2_net105
+ dac_config_2 vdda1 vssa1 vssc1 col_event_rst_top_right[10] x2_net106
+ row_on_detect_top[34] row_off_detect_top[35] openDVS_pixel2x2_top
x2_x571 dac_config_3 dac_config_5 col_event_rst_top_right[9] dac_config_4
+ row_on_detect_top[35] dac_config_0 dac_config_1 row_off_detect_top[34] x2_net109
+ dac_config_2 vdda1 vssa1 vssc1 col_event_rst_top_right[8] x2_net110
+ row_on_detect_top[34] row_off_detect_top[35] openDVS_pixel2x2_top
x2_x572 dac_config_3 dac_config_5 col_event_rst_top_right[7] dac_config_4
+ row_on_detect_top[35] dac_config_0 dac_config_1 row_off_detect_top[34] x2_net113
+ dac_config_2 vdda1 vssa1 vssc1 col_event_rst_top_right[6] x2_net114
+ row_on_detect_top[34] row_off_detect_top[35] openDVS_pixel2x2_top
x2_x573 dac_config_3 dac_config_5 col_event_rst_top_right[5] dac_config_4
+ row_on_detect_top[35] dac_config_0 dac_config_1 row_off_detect_top[34] x2_net117
+ dac_config_2 vdda1 vssa1 vssc1 col_event_rst_top_right[4] x2_net118
+ row_on_detect_top[34] row_off_detect_top[35] openDVS_pixel2x2_top
x2_x574 dac_config_3 dac_config_5 col_event_rst_top_right[3] dac_config_4
+ row_on_detect_top[35] dac_config_0 dac_config_1 row_off_detect_top[34] x2_net121
+ dac_config_2 vdda1 vssa1 vssc1 col_event_rst_top_right[2] x2_net122
+ row_on_detect_top[34] row_off_detect_top[35] openDVS_pixel2x2_top
x2_x575 dac_config_3 dac_config_5 col_event_rst_top_right[1] dac_config_4
+ row_on_detect_top[35] dac_config_0 dac_config_1 row_off_detect_top[34] x2_net125
+ dac_config_2 vdda1 vssa1 vssc1 col_event_rst_top_right[0] x2_net126
+ row_on_detect_top[34] row_off_detect_top[35] openDVS_pixel2x2_top
x2_x576 dac_config_3 dac_config_5 col_event_rst_top_right[63] dac_config_4
+ row_on_detect_top[37] dac_config_0 dac_config_1 row_off_detect_top[36] x2_net1
+ dac_config_2 vdda1 vssa1 vssc1 col_event_rst_top_right[62] x2_net2 row_on_detect_top[36]
+ row_off_detect_top[37] openDVS_pixel2x2_top
x2_x577 dac_config_3 dac_config_5 col_event_rst_top_right[61] dac_config_4
+ row_on_detect_top[37] dac_config_0 dac_config_1 row_off_detect_top[36] x2_net5
+ dac_config_2 vdda1 vssa1 vssc1 col_event_rst_top_right[60] x2_net6 row_on_detect_top[36]
+ row_off_detect_top[37] openDVS_pixel2x2_top
x2_x578 dac_config_3 dac_config_5 col_event_rst_top_right[59] dac_config_4
+ row_on_detect_top[37] dac_config_0 dac_config_1 row_off_detect_top[36] x2_net9
+ dac_config_2 vdda1 vssa1 vssc1 col_event_rst_top_right[58] x2_net10
+ row_on_detect_top[36] row_off_detect_top[37] openDVS_pixel2x2_top
x2_x579 dac_config_3 dac_config_5 col_event_rst_top_right[57] dac_config_4
+ row_on_detect_top[37] dac_config_0 dac_config_1 row_off_detect_top[36] x2_net13
+ dac_config_2 vdda1 vssa1 vssc1 col_event_rst_top_right[56] x2_net14
+ row_on_detect_top[36] row_off_detect_top[37] openDVS_pixel2x2_top
x2_x580 dac_config_3 dac_config_5 col_event_rst_top_right[55] dac_config_4
+ row_on_detect_top[37] dac_config_0 dac_config_1 row_off_detect_top[36] x2_net17
+ dac_config_2 vdda1 vssa1 vssc1 col_event_rst_top_right[54] x2_net18
+ row_on_detect_top[36] row_off_detect_top[37] openDVS_pixel2x2_top
x2_x581 dac_config_3 dac_config_5 col_event_rst_top_right[53] dac_config_4
+ row_on_detect_top[37] dac_config_0 dac_config_1 row_off_detect_top[36] x2_net21
+ dac_config_2 vdda1 vssa1 vssc1 col_event_rst_top_right[52] x2_net22
+ row_on_detect_top[36] row_off_detect_top[37] openDVS_pixel2x2_top
x2_x582 dac_config_3 dac_config_5 col_event_rst_top_right[51] dac_config_4
+ row_on_detect_top[37] dac_config_0 dac_config_1 row_off_detect_top[36] x2_net25
+ dac_config_2 vdda1 vssa1 vssc1 col_event_rst_top_right[50] x2_net26
+ row_on_detect_top[36] row_off_detect_top[37] openDVS_pixel2x2_top
x2_x583 dac_config_3 dac_config_5 col_event_rst_top_right[49] dac_config_4
+ row_on_detect_top[37] dac_config_0 dac_config_1 row_off_detect_top[36] x2_net29
+ dac_config_2 vdda1 vssa1 vssc1 col_event_rst_top_right[48] x2_net30
+ row_on_detect_top[36] row_off_detect_top[37] openDVS_pixel2x2_top
x2_x584 dac_config_3 dac_config_5 col_event_rst_top_right[47] dac_config_4
+ row_on_detect_top[37] dac_config_0 dac_config_1 row_off_detect_top[36] x2_net33
+ dac_config_2 vdda1 vssa1 vssc1 col_event_rst_top_right[46] x2_net34
+ row_on_detect_top[36] row_off_detect_top[37] openDVS_pixel2x2_top
x2_x585 dac_config_3 dac_config_5 col_event_rst_top_right[45] dac_config_4
+ row_on_detect_top[37] dac_config_0 dac_config_1 row_off_detect_top[36] x2_net37
+ dac_config_2 vdda1 vssa1 vssc1 col_event_rst_top_right[44] x2_net38
+ row_on_detect_top[36] row_off_detect_top[37] openDVS_pixel2x2_top
x2_x586 dac_config_3 dac_config_5 col_event_rst_top_right[43] dac_config_4
+ row_on_detect_top[37] dac_config_0 dac_config_1 row_off_detect_top[36] x2_net41
+ dac_config_2 vdda1 vssa1 vssc1 col_event_rst_top_right[42] x2_net42
+ row_on_detect_top[36] row_off_detect_top[37] openDVS_pixel2x2_top
x2_x587 dac_config_3 dac_config_5 col_event_rst_top_right[41] dac_config_4
+ row_on_detect_top[37] dac_config_0 dac_config_1 row_off_detect_top[36] x2_net45
+ dac_config_2 vdda1 vssa1 vssc1 col_event_rst_top_right[40] x2_net46
+ row_on_detect_top[36] row_off_detect_top[37] openDVS_pixel2x2_top
x2_x588 dac_config_3 dac_config_5 col_event_rst_top_right[39] dac_config_4
+ row_on_detect_top[37] dac_config_0 dac_config_1 row_off_detect_top[36] x2_net49
+ dac_config_2 vdda1 vssa1 vssc1 col_event_rst_top_right[38] x2_net50
+ row_on_detect_top[36] row_off_detect_top[37] openDVS_pixel2x2_top
x2_x589 dac_config_3 dac_config_5 col_event_rst_top_right[37] dac_config_4
+ row_on_detect_top[37] dac_config_0 dac_config_1 row_off_detect_top[36] x2_net53
+ dac_config_2 vdda1 vssa1 vssc1 col_event_rst_top_right[36] x2_net54
+ row_on_detect_top[36] row_off_detect_top[37] openDVS_pixel2x2_top
x2_x590 dac_config_3 dac_config_5 col_event_rst_top_right[35] dac_config_4
+ row_on_detect_top[37] dac_config_0 dac_config_1 row_off_detect_top[36] x2_net57
+ dac_config_2 vdda1 vssa1 vssc1 col_event_rst_top_right[34] x2_net58
+ row_on_detect_top[36] row_off_detect_top[37] openDVS_pixel2x2_top
x2_x591 dac_config_3 dac_config_5 col_event_rst_top_right[33] dac_config_4
+ row_on_detect_top[37] dac_config_0 dac_config_1 row_off_detect_top[36] x2_net61
+ dac_config_2 vdda1 vssa1 vssc1 col_event_rst_top_right[32] x2_net62
+ row_on_detect_top[36] row_off_detect_top[37] openDVS_pixel2x2_top
x2_x592 dac_config_3 dac_config_5 col_event_rst_top_right[31] dac_config_4
+ row_on_detect_top[37] dac_config_0 dac_config_1 row_off_detect_top[36] x2_net65
+ dac_config_2 vdda1 vssa1 vssc1 col_event_rst_top_right[30] x2_net66
+ row_on_detect_top[36] row_off_detect_top[37] openDVS_pixel2x2_top
x2_x593 dac_config_3 dac_config_5 col_event_rst_top_right[29] dac_config_4
+ row_on_detect_top[37] dac_config_0 dac_config_1 row_off_detect_top[36] x2_net69
+ dac_config_2 vdda1 vssa1 vssc1 col_event_rst_top_right[28] x2_net70
+ row_on_detect_top[36] row_off_detect_top[37] openDVS_pixel2x2_top
x2_x594 dac_config_3 dac_config_5 col_event_rst_top_right[27] dac_config_4
+ row_on_detect_top[37] dac_config_0 dac_config_1 row_off_detect_top[36] x2_net73
+ dac_config_2 vdda1 vssa1 vssc1 col_event_rst_top_right[26] x2_net74
+ row_on_detect_top[36] row_off_detect_top[37] openDVS_pixel2x2_top
x2_x595 dac_config_3 dac_config_5 col_event_rst_top_right[25] dac_config_4
+ row_on_detect_top[37] dac_config_0 dac_config_1 row_off_detect_top[36] x2_net77
+ dac_config_2 vdda1 vssa1 vssc1 col_event_rst_top_right[24] x2_net78
+ row_on_detect_top[36] row_off_detect_top[37] openDVS_pixel2x2_top
x2_x596 dac_config_3 dac_config_5 col_event_rst_top_right[23] dac_config_4
+ row_on_detect_top[37] dac_config_0 dac_config_1 row_off_detect_top[36] x2_net81
+ dac_config_2 vdda1 vssa1 vssc1 col_event_rst_top_right[22] x2_net82
+ row_on_detect_top[36] row_off_detect_top[37] openDVS_pixel2x2_top
x2_x597 dac_config_3 dac_config_5 col_event_rst_top_right[21] dac_config_4
+ row_on_detect_top[37] dac_config_0 dac_config_1 row_off_detect_top[36] x2_net85
+ dac_config_2 vdda1 vssa1 vssc1 col_event_rst_top_right[20] x2_net86
+ row_on_detect_top[36] row_off_detect_top[37] openDVS_pixel2x2_top
x2_x598 dac_config_3 dac_config_5 col_event_rst_top_right[19] dac_config_4
+ row_on_detect_top[37] dac_config_0 dac_config_1 row_off_detect_top[36] x2_net89
+ dac_config_2 vdda1 vssa1 vssc1 col_event_rst_top_right[18] x2_net90
+ row_on_detect_top[36] row_off_detect_top[37] openDVS_pixel2x2_top
x2_x599 dac_config_3 dac_config_5 col_event_rst_top_right[17] dac_config_4
+ row_on_detect_top[37] dac_config_0 dac_config_1 row_off_detect_top[36] x2_net93
+ dac_config_2 vdda1 vssa1 vssc1 col_event_rst_top_right[16] x2_net94
+ row_on_detect_top[36] row_off_detect_top[37] openDVS_pixel2x2_top
x2_x600 dac_config_3 dac_config_5 col_event_rst_top_right[15] dac_config_4
+ row_on_detect_top[37] dac_config_0 dac_config_1 row_off_detect_top[36] x2_net97
+ dac_config_2 vdda1 vssa1 vssc1 col_event_rst_top_right[14] x2_net98
+ row_on_detect_top[36] row_off_detect_top[37] openDVS_pixel2x2_top
x2_x601 dac_config_3 dac_config_5 col_event_rst_top_right[13] dac_config_4
+ row_on_detect_top[37] dac_config_0 dac_config_1 row_off_detect_top[36] x2_net101
+ dac_config_2 vdda1 vssa1 vssc1 col_event_rst_top_right[12] x2_net102
+ row_on_detect_top[36] row_off_detect_top[37] openDVS_pixel2x2_top
x2_x602 dac_config_3 dac_config_5 col_event_rst_top_right[11] dac_config_4
+ row_on_detect_top[37] dac_config_0 dac_config_1 row_off_detect_top[36] x2_net105
+ dac_config_2 vdda1 vssa1 vssc1 col_event_rst_top_right[10] x2_net106
+ row_on_detect_top[36] row_off_detect_top[37] openDVS_pixel2x2_top
x2_x603 dac_config_3 dac_config_5 col_event_rst_top_right[9] dac_config_4
+ row_on_detect_top[37] dac_config_0 dac_config_1 row_off_detect_top[36] x2_net109
+ dac_config_2 vdda1 vssa1 vssc1 col_event_rst_top_right[8] x2_net110
+ row_on_detect_top[36] row_off_detect_top[37] openDVS_pixel2x2_top
x2_x604 dac_config_3 dac_config_5 col_event_rst_top_right[7] dac_config_4
+ row_on_detect_top[37] dac_config_0 dac_config_1 row_off_detect_top[36] x2_net113
+ dac_config_2 vdda1 vssa1 vssc1 col_event_rst_top_right[6] x2_net114
+ row_on_detect_top[36] row_off_detect_top[37] openDVS_pixel2x2_top
x2_x605 dac_config_3 dac_config_5 col_event_rst_top_right[5] dac_config_4
+ row_on_detect_top[37] dac_config_0 dac_config_1 row_off_detect_top[36] x2_net117
+ dac_config_2 vdda1 vssa1 vssc1 col_event_rst_top_right[4] x2_net118
+ row_on_detect_top[36] row_off_detect_top[37] openDVS_pixel2x2_top
x2_x606 dac_config_3 dac_config_5 col_event_rst_top_right[3] dac_config_4
+ row_on_detect_top[37] dac_config_0 dac_config_1 row_off_detect_top[36] x2_net121
+ dac_config_2 vdda1 vssa1 vssc1 col_event_rst_top_right[2] x2_net122
+ row_on_detect_top[36] row_off_detect_top[37] openDVS_pixel2x2_top
x2_x607 dac_config_3 dac_config_5 col_event_rst_top_right[1] dac_config_4
+ row_on_detect_top[37] dac_config_0 dac_config_1 row_off_detect_top[36] x2_net125
+ dac_config_2 vdda1 vssa1 vssc1 col_event_rst_top_right[0] x2_net126
+ row_on_detect_top[36] row_off_detect_top[37] openDVS_pixel2x2_top
x2_x608 dac_config_3 dac_config_5 col_event_rst_top_right[63] dac_config_4
+ row_on_detect_top[39] dac_config_0 dac_config_1 row_off_detect_top[38] x2_net1
+ dac_config_2 vdda1 vssa1 vssc1 col_event_rst_top_right[62] x2_net2 row_on_detect_top[38]
+ row_off_detect_top[39] openDVS_pixel2x2_top
x2_x609 dac_config_3 dac_config_5 col_event_rst_top_right[61] dac_config_4
+ row_on_detect_top[39] dac_config_0 dac_config_1 row_off_detect_top[38] x2_net5
+ dac_config_2 vdda1 vssa1 vssc1 col_event_rst_top_right[60] x2_net6 row_on_detect_top[38]
+ row_off_detect_top[39] openDVS_pixel2x2_top
x2_x610 dac_config_3 dac_config_5 col_event_rst_top_right[59] dac_config_4
+ row_on_detect_top[39] dac_config_0 dac_config_1 row_off_detect_top[38] x2_net9
+ dac_config_2 vdda1 vssa1 vssc1 col_event_rst_top_right[58] x2_net10
+ row_on_detect_top[38] row_off_detect_top[39] openDVS_pixel2x2_top
x2_x611 dac_config_3 dac_config_5 col_event_rst_top_right[57] dac_config_4
+ row_on_detect_top[39] dac_config_0 dac_config_1 row_off_detect_top[38] x2_net13
+ dac_config_2 vdda1 vssa1 vssc1 col_event_rst_top_right[56] x2_net14
+ row_on_detect_top[38] row_off_detect_top[39] openDVS_pixel2x2_top
x2_x612 dac_config_3 dac_config_5 col_event_rst_top_right[55] dac_config_4
+ row_on_detect_top[39] dac_config_0 dac_config_1 row_off_detect_top[38] x2_net17
+ dac_config_2 vdda1 vssa1 vssc1 col_event_rst_top_right[54] x2_net18
+ row_on_detect_top[38] row_off_detect_top[39] openDVS_pixel2x2_top
x2_x613 dac_config_3 dac_config_5 col_event_rst_top_right[53] dac_config_4
+ row_on_detect_top[39] dac_config_0 dac_config_1 row_off_detect_top[38] x2_net21
+ dac_config_2 vdda1 vssa1 vssc1 col_event_rst_top_right[52] x2_net22
+ row_on_detect_top[38] row_off_detect_top[39] openDVS_pixel2x2_top
x2_x614 dac_config_3 dac_config_5 col_event_rst_top_right[51] dac_config_4
+ row_on_detect_top[39] dac_config_0 dac_config_1 row_off_detect_top[38] x2_net25
+ dac_config_2 vdda1 vssa1 vssc1 col_event_rst_top_right[50] x2_net26
+ row_on_detect_top[38] row_off_detect_top[39] openDVS_pixel2x2_top
x2_x615 dac_config_3 dac_config_5 col_event_rst_top_right[49] dac_config_4
+ row_on_detect_top[39] dac_config_0 dac_config_1 row_off_detect_top[38] x2_net29
+ dac_config_2 vdda1 vssa1 vssc1 col_event_rst_top_right[48] x2_net30
+ row_on_detect_top[38] row_off_detect_top[39] openDVS_pixel2x2_top
x2_x616 dac_config_3 dac_config_5 col_event_rst_top_right[47] dac_config_4
+ row_on_detect_top[39] dac_config_0 dac_config_1 row_off_detect_top[38] x2_net33
+ dac_config_2 vdda1 vssa1 vssc1 col_event_rst_top_right[46] x2_net34
+ row_on_detect_top[38] row_off_detect_top[39] openDVS_pixel2x2_top
x2_x617 dac_config_3 dac_config_5 col_event_rst_top_right[45] dac_config_4
+ row_on_detect_top[39] dac_config_0 dac_config_1 row_off_detect_top[38] x2_net37
+ dac_config_2 vdda1 vssa1 vssc1 col_event_rst_top_right[44] x2_net38
+ row_on_detect_top[38] row_off_detect_top[39] openDVS_pixel2x2_top
x2_x618 dac_config_3 dac_config_5 col_event_rst_top_right[43] dac_config_4
+ row_on_detect_top[39] dac_config_0 dac_config_1 row_off_detect_top[38] x2_net41
+ dac_config_2 vdda1 vssa1 vssc1 col_event_rst_top_right[42] x2_net42
+ row_on_detect_top[38] row_off_detect_top[39] openDVS_pixel2x2_top
x2_x619 dac_config_3 dac_config_5 col_event_rst_top_right[41] dac_config_4
+ row_on_detect_top[39] dac_config_0 dac_config_1 row_off_detect_top[38] x2_net45
+ dac_config_2 vdda1 vssa1 vssc1 col_event_rst_top_right[40] x2_net46
+ row_on_detect_top[38] row_off_detect_top[39] openDVS_pixel2x2_top
x2_x620 dac_config_3 dac_config_5 col_event_rst_top_right[39] dac_config_4
+ row_on_detect_top[39] dac_config_0 dac_config_1 row_off_detect_top[38] x2_net49
+ dac_config_2 vdda1 vssa1 vssc1 col_event_rst_top_right[38] x2_net50
+ row_on_detect_top[38] row_off_detect_top[39] openDVS_pixel2x2_top
x2_x621 dac_config_3 dac_config_5 col_event_rst_top_right[37] dac_config_4
+ row_on_detect_top[39] dac_config_0 dac_config_1 row_off_detect_top[38] x2_net53
+ dac_config_2 vdda1 vssa1 vssc1 col_event_rst_top_right[36] x2_net54
+ row_on_detect_top[38] row_off_detect_top[39] openDVS_pixel2x2_top
x2_x622 dac_config_3 dac_config_5 col_event_rst_top_right[35] dac_config_4
+ row_on_detect_top[39] dac_config_0 dac_config_1 row_off_detect_top[38] x2_net57
+ dac_config_2 vdda1 vssa1 vssc1 col_event_rst_top_right[34] x2_net58
+ row_on_detect_top[38] row_off_detect_top[39] openDVS_pixel2x2_top
x2_x623 dac_config_3 dac_config_5 col_event_rst_top_right[33] dac_config_4
+ row_on_detect_top[39] dac_config_0 dac_config_1 row_off_detect_top[38] x2_net61
+ dac_config_2 vdda1 vssa1 vssc1 col_event_rst_top_right[32] x2_net62
+ row_on_detect_top[38] row_off_detect_top[39] openDVS_pixel2x2_top
x2_x624 dac_config_3 dac_config_5 col_event_rst_top_right[31] dac_config_4
+ row_on_detect_top[39] dac_config_0 dac_config_1 row_off_detect_top[38] x2_net65
+ dac_config_2 vdda1 vssa1 vssc1 col_event_rst_top_right[30] x2_net66
+ row_on_detect_top[38] row_off_detect_top[39] openDVS_pixel2x2_top
x2_x625 dac_config_3 dac_config_5 col_event_rst_top_right[29] dac_config_4
+ row_on_detect_top[39] dac_config_0 dac_config_1 row_off_detect_top[38] x2_net69
+ dac_config_2 vdda1 vssa1 vssc1 col_event_rst_top_right[28] x2_net70
+ row_on_detect_top[38] row_off_detect_top[39] openDVS_pixel2x2_top
x2_x626 dac_config_3 dac_config_5 col_event_rst_top_right[27] dac_config_4
+ row_on_detect_top[39] dac_config_0 dac_config_1 row_off_detect_top[38] x2_net73
+ dac_config_2 vdda1 vssa1 vssc1 col_event_rst_top_right[26] x2_net74
+ row_on_detect_top[38] row_off_detect_top[39] openDVS_pixel2x2_top
x2_x627 dac_config_3 dac_config_5 col_event_rst_top_right[25] dac_config_4
+ row_on_detect_top[39] dac_config_0 dac_config_1 row_off_detect_top[38] x2_net77
+ dac_config_2 vdda1 vssa1 vssc1 col_event_rst_top_right[24] x2_net78
+ row_on_detect_top[38] row_off_detect_top[39] openDVS_pixel2x2_top
x2_x628 dac_config_3 dac_config_5 col_event_rst_top_right[23] dac_config_4
+ row_on_detect_top[39] dac_config_0 dac_config_1 row_off_detect_top[38] x2_net81
+ dac_config_2 vdda1 vssa1 vssc1 col_event_rst_top_right[22] x2_net82
+ row_on_detect_top[38] row_off_detect_top[39] openDVS_pixel2x2_top
x2_x629 dac_config_3 dac_config_5 col_event_rst_top_right[21] dac_config_4
+ row_on_detect_top[39] dac_config_0 dac_config_1 row_off_detect_top[38] x2_net85
+ dac_config_2 vdda1 vssa1 vssc1 col_event_rst_top_right[20] x2_net86
+ row_on_detect_top[38] row_off_detect_top[39] openDVS_pixel2x2_top
x2_x630 dac_config_3 dac_config_5 col_event_rst_top_right[19] dac_config_4
+ row_on_detect_top[39] dac_config_0 dac_config_1 row_off_detect_top[38] x2_net89
+ dac_config_2 vdda1 vssa1 vssc1 col_event_rst_top_right[18] x2_net90
+ row_on_detect_top[38] row_off_detect_top[39] openDVS_pixel2x2_top
x2_x631 dac_config_3 dac_config_5 col_event_rst_top_right[17] dac_config_4
+ row_on_detect_top[39] dac_config_0 dac_config_1 row_off_detect_top[38] x2_net93
+ dac_config_2 vdda1 vssa1 vssc1 col_event_rst_top_right[16] x2_net94
+ row_on_detect_top[38] row_off_detect_top[39] openDVS_pixel2x2_top
x2_x632 dac_config_3 dac_config_5 col_event_rst_top_right[15] dac_config_4
+ row_on_detect_top[39] dac_config_0 dac_config_1 row_off_detect_top[38] x2_net97
+ dac_config_2 vdda1 vssa1 vssc1 col_event_rst_top_right[14] x2_net98
+ row_on_detect_top[38] row_off_detect_top[39] openDVS_pixel2x2_top
x2_x633 dac_config_3 dac_config_5 col_event_rst_top_right[13] dac_config_4
+ row_on_detect_top[39] dac_config_0 dac_config_1 row_off_detect_top[38] x2_net101
+ dac_config_2 vdda1 vssa1 vssc1 col_event_rst_top_right[12] x2_net102
+ row_on_detect_top[38] row_off_detect_top[39] openDVS_pixel2x2_top
x2_x634 dac_config_3 dac_config_5 col_event_rst_top_right[11] dac_config_4
+ row_on_detect_top[39] dac_config_0 dac_config_1 row_off_detect_top[38] x2_net105
+ dac_config_2 vdda1 vssa1 vssc1 col_event_rst_top_right[10] x2_net106
+ row_on_detect_top[38] row_off_detect_top[39] openDVS_pixel2x2_top
x2_x635 dac_config_3 dac_config_5 col_event_rst_top_right[9] dac_config_4
+ row_on_detect_top[39] dac_config_0 dac_config_1 row_off_detect_top[38] x2_net109
+ dac_config_2 vdda1 vssa1 vssc1 col_event_rst_top_right[8] x2_net110
+ row_on_detect_top[38] row_off_detect_top[39] openDVS_pixel2x2_top
x2_x636 dac_config_3 dac_config_5 col_event_rst_top_right[7] dac_config_4
+ row_on_detect_top[39] dac_config_0 dac_config_1 row_off_detect_top[38] x2_net113
+ dac_config_2 vdda1 vssa1 vssc1 col_event_rst_top_right[6] x2_net114
+ row_on_detect_top[38] row_off_detect_top[39] openDVS_pixel2x2_top
x2_x637 dac_config_3 dac_config_5 col_event_rst_top_right[5] dac_config_4
+ row_on_detect_top[39] dac_config_0 dac_config_1 row_off_detect_top[38] x2_net117
+ dac_config_2 vdda1 vssa1 vssc1 col_event_rst_top_right[4] x2_net118
+ row_on_detect_top[38] row_off_detect_top[39] openDVS_pixel2x2_top
x2_x638 dac_config_3 dac_config_5 col_event_rst_top_right[3] dac_config_4
+ row_on_detect_top[39] dac_config_0 dac_config_1 row_off_detect_top[38] x2_net121
+ dac_config_2 vdda1 vssa1 vssc1 col_event_rst_top_right[2] x2_net122
+ row_on_detect_top[38] row_off_detect_top[39] openDVS_pixel2x2_top
x2_x639 dac_config_3 dac_config_5 col_event_rst_top_right[1] dac_config_4
+ row_on_detect_top[39] dac_config_0 dac_config_1 row_off_detect_top[38] x2_net125
+ dac_config_2 vdda1 vssa1 vssc1 col_event_rst_top_right[0] x2_net126
+ row_on_detect_top[38] row_off_detect_top[39] openDVS_pixel2x2_top
x2_x640 dac_config_3 dac_config_5 col_event_rst_top_right[63] dac_config_4
+ row_on_detect_top[41] dac_config_0 dac_config_1 row_off_detect_top[40] x2_net1
+ dac_config_2 vdda1 vssa1 vssc1 col_event_rst_top_right[62] x2_net2 row_on_detect_top[40]
+ row_off_detect_top[41] openDVS_pixel2x2_top
x2_x641 dac_config_3 dac_config_5 col_event_rst_top_right[61] dac_config_4
+ row_on_detect_top[41] dac_config_0 dac_config_1 row_off_detect_top[40] x2_net5
+ dac_config_2 vdda1 vssa1 vssc1 col_event_rst_top_right[60] x2_net6 row_on_detect_top[40]
+ row_off_detect_top[41] openDVS_pixel2x2_top
x2_x642 dac_config_3 dac_config_5 col_event_rst_top_right[59] dac_config_4
+ row_on_detect_top[41] dac_config_0 dac_config_1 row_off_detect_top[40] x2_net9
+ dac_config_2 vdda1 vssa1 vssc1 col_event_rst_top_right[58] x2_net10
+ row_on_detect_top[40] row_off_detect_top[41] openDVS_pixel2x2_top
x2_x643 dac_config_3 dac_config_5 col_event_rst_top_right[57] dac_config_4
+ row_on_detect_top[41] dac_config_0 dac_config_1 row_off_detect_top[40] x2_net13
+ dac_config_2 vdda1 vssa1 vssc1 col_event_rst_top_right[56] x2_net14
+ row_on_detect_top[40] row_off_detect_top[41] openDVS_pixel2x2_top
x2_x644 dac_config_3 dac_config_5 col_event_rst_top_right[55] dac_config_4
+ row_on_detect_top[41] dac_config_0 dac_config_1 row_off_detect_top[40] x2_net17
+ dac_config_2 vdda1 vssa1 vssc1 col_event_rst_top_right[54] x2_net18
+ row_on_detect_top[40] row_off_detect_top[41] openDVS_pixel2x2_top
x2_x645 dac_config_3 dac_config_5 col_event_rst_top_right[53] dac_config_4
+ row_on_detect_top[41] dac_config_0 dac_config_1 row_off_detect_top[40] x2_net21
+ dac_config_2 vdda1 vssa1 vssc1 col_event_rst_top_right[52] x2_net22
+ row_on_detect_top[40] row_off_detect_top[41] openDVS_pixel2x2_top
x2_x646 dac_config_3 dac_config_5 col_event_rst_top_right[51] dac_config_4
+ row_on_detect_top[41] dac_config_0 dac_config_1 row_off_detect_top[40] x2_net25
+ dac_config_2 vdda1 vssa1 vssc1 col_event_rst_top_right[50] x2_net26
+ row_on_detect_top[40] row_off_detect_top[41] openDVS_pixel2x2_top
x2_x647 dac_config_3 dac_config_5 col_event_rst_top_right[49] dac_config_4
+ row_on_detect_top[41] dac_config_0 dac_config_1 row_off_detect_top[40] x2_net29
+ dac_config_2 vdda1 vssa1 vssc1 col_event_rst_top_right[48] x2_net30
+ row_on_detect_top[40] row_off_detect_top[41] openDVS_pixel2x2_top
x2_x648 dac_config_3 dac_config_5 col_event_rst_top_right[47] dac_config_4
+ row_on_detect_top[41] dac_config_0 dac_config_1 row_off_detect_top[40] x2_net33
+ dac_config_2 vdda1 vssa1 vssc1 col_event_rst_top_right[46] x2_net34
+ row_on_detect_top[40] row_off_detect_top[41] openDVS_pixel2x2_top
x2_x649 dac_config_3 dac_config_5 col_event_rst_top_right[45] dac_config_4
+ row_on_detect_top[41] dac_config_0 dac_config_1 row_off_detect_top[40] x2_net37
+ dac_config_2 vdda1 vssa1 vssc1 col_event_rst_top_right[44] x2_net38
+ row_on_detect_top[40] row_off_detect_top[41] openDVS_pixel2x2_top
x2_x650 dac_config_3 dac_config_5 col_event_rst_top_right[43] dac_config_4
+ row_on_detect_top[41] dac_config_0 dac_config_1 row_off_detect_top[40] x2_net41
+ dac_config_2 vdda1 vssa1 vssc1 col_event_rst_top_right[42] x2_net42
+ row_on_detect_top[40] row_off_detect_top[41] openDVS_pixel2x2_top
x2_x651 dac_config_3 dac_config_5 col_event_rst_top_right[41] dac_config_4
+ row_on_detect_top[41] dac_config_0 dac_config_1 row_off_detect_top[40] x2_net45
+ dac_config_2 vdda1 vssa1 vssc1 col_event_rst_top_right[40] x2_net46
+ row_on_detect_top[40] row_off_detect_top[41] openDVS_pixel2x2_top
x2_x652 dac_config_3 dac_config_5 col_event_rst_top_right[39] dac_config_4
+ row_on_detect_top[41] dac_config_0 dac_config_1 row_off_detect_top[40] x2_net49
+ dac_config_2 vdda1 vssa1 vssc1 col_event_rst_top_right[38] x2_net50
+ row_on_detect_top[40] row_off_detect_top[41] openDVS_pixel2x2_top
x2_x653 dac_config_3 dac_config_5 col_event_rst_top_right[37] dac_config_4
+ row_on_detect_top[41] dac_config_0 dac_config_1 row_off_detect_top[40] x2_net53
+ dac_config_2 vdda1 vssa1 vssc1 col_event_rst_top_right[36] x2_net54
+ row_on_detect_top[40] row_off_detect_top[41] openDVS_pixel2x2_top
x2_x654 dac_config_3 dac_config_5 col_event_rst_top_right[35] dac_config_4
+ row_on_detect_top[41] dac_config_0 dac_config_1 row_off_detect_top[40] x2_net57
+ dac_config_2 vdda1 vssa1 vssc1 col_event_rst_top_right[34] x2_net58
+ row_on_detect_top[40] row_off_detect_top[41] openDVS_pixel2x2_top
x2_x655 dac_config_3 dac_config_5 col_event_rst_top_right[33] dac_config_4
+ row_on_detect_top[41] dac_config_0 dac_config_1 row_off_detect_top[40] x2_net61
+ dac_config_2 vdda1 vssa1 vssc1 col_event_rst_top_right[32] x2_net62
+ row_on_detect_top[40] row_off_detect_top[41] openDVS_pixel2x2_top
x2_x656 dac_config_3 dac_config_5 col_event_rst_top_right[31] dac_config_4
+ row_on_detect_top[41] dac_config_0 dac_config_1 row_off_detect_top[40] x2_net65
+ dac_config_2 vdda1 vssa1 vssc1 col_event_rst_top_right[30] x2_net66
+ row_on_detect_top[40] row_off_detect_top[41] openDVS_pixel2x2_top
x2_x657 dac_config_3 dac_config_5 col_event_rst_top_right[29] dac_config_4
+ row_on_detect_top[41] dac_config_0 dac_config_1 row_off_detect_top[40] x2_net69
+ dac_config_2 vdda1 vssa1 vssc1 col_event_rst_top_right[28] x2_net70
+ row_on_detect_top[40] row_off_detect_top[41] openDVS_pixel2x2_top
x2_x658 dac_config_3 dac_config_5 col_event_rst_top_right[27] dac_config_4
+ row_on_detect_top[41] dac_config_0 dac_config_1 row_off_detect_top[40] x2_net73
+ dac_config_2 vdda1 vssa1 vssc1 col_event_rst_top_right[26] x2_net74
+ row_on_detect_top[40] row_off_detect_top[41] openDVS_pixel2x2_top
x2_x659 dac_config_3 dac_config_5 col_event_rst_top_right[25] dac_config_4
+ row_on_detect_top[41] dac_config_0 dac_config_1 row_off_detect_top[40] x2_net77
+ dac_config_2 vdda1 vssa1 vssc1 col_event_rst_top_right[24] x2_net78
+ row_on_detect_top[40] row_off_detect_top[41] openDVS_pixel2x2_top
x2_x660 dac_config_3 dac_config_5 col_event_rst_top_right[23] dac_config_4
+ row_on_detect_top[41] dac_config_0 dac_config_1 row_off_detect_top[40] x2_net81
+ dac_config_2 vdda1 vssa1 vssc1 col_event_rst_top_right[22] x2_net82
+ row_on_detect_top[40] row_off_detect_top[41] openDVS_pixel2x2_top
x2_x661 dac_config_3 dac_config_5 col_event_rst_top_right[21] dac_config_4
+ row_on_detect_top[41] dac_config_0 dac_config_1 row_off_detect_top[40] x2_net85
+ dac_config_2 vdda1 vssa1 vssc1 col_event_rst_top_right[20] x2_net86
+ row_on_detect_top[40] row_off_detect_top[41] openDVS_pixel2x2_top
x2_x662 dac_config_3 dac_config_5 col_event_rst_top_right[19] dac_config_4
+ row_on_detect_top[41] dac_config_0 dac_config_1 row_off_detect_top[40] x2_net89
+ dac_config_2 vdda1 vssa1 vssc1 col_event_rst_top_right[18] x2_net90
+ row_on_detect_top[40] row_off_detect_top[41] openDVS_pixel2x2_top
x2_x663 dac_config_3 dac_config_5 col_event_rst_top_right[17] dac_config_4
+ row_on_detect_top[41] dac_config_0 dac_config_1 row_off_detect_top[40] x2_net93
+ dac_config_2 vdda1 vssa1 vssc1 col_event_rst_top_right[16] x2_net94
+ row_on_detect_top[40] row_off_detect_top[41] openDVS_pixel2x2_top
x2_x664 dac_config_3 dac_config_5 col_event_rst_top_right[15] dac_config_4
+ row_on_detect_top[41] dac_config_0 dac_config_1 row_off_detect_top[40] x2_net97
+ dac_config_2 vdda1 vssa1 vssc1 col_event_rst_top_right[14] x2_net98
+ row_on_detect_top[40] row_off_detect_top[41] openDVS_pixel2x2_top
x2_x665 dac_config_3 dac_config_5 col_event_rst_top_right[13] dac_config_4
+ row_on_detect_top[41] dac_config_0 dac_config_1 row_off_detect_top[40] x2_net101
+ dac_config_2 vdda1 vssa1 vssc1 col_event_rst_top_right[12] x2_net102
+ row_on_detect_top[40] row_off_detect_top[41] openDVS_pixel2x2_top
x2_x666 dac_config_3 dac_config_5 col_event_rst_top_right[11] dac_config_4
+ row_on_detect_top[41] dac_config_0 dac_config_1 row_off_detect_top[40] x2_net105
+ dac_config_2 vdda1 vssa1 vssc1 col_event_rst_top_right[10] x2_net106
+ row_on_detect_top[40] row_off_detect_top[41] openDVS_pixel2x2_top
x2_x667 dac_config_3 dac_config_5 col_event_rst_top_right[9] dac_config_4
+ row_on_detect_top[41] dac_config_0 dac_config_1 row_off_detect_top[40] x2_net109
+ dac_config_2 vdda1 vssa1 vssc1 col_event_rst_top_right[8] x2_net110
+ row_on_detect_top[40] row_off_detect_top[41] openDVS_pixel2x2_top
x2_x668 dac_config_3 dac_config_5 col_event_rst_top_right[7] dac_config_4
+ row_on_detect_top[41] dac_config_0 dac_config_1 row_off_detect_top[40] x2_net113
+ dac_config_2 vdda1 vssa1 vssc1 col_event_rst_top_right[6] x2_net114
+ row_on_detect_top[40] row_off_detect_top[41] openDVS_pixel2x2_top
x2_x669 dac_config_3 dac_config_5 col_event_rst_top_right[5] dac_config_4
+ row_on_detect_top[41] dac_config_0 dac_config_1 row_off_detect_top[40] x2_net117
+ dac_config_2 vdda1 vssa1 vssc1 col_event_rst_top_right[4] x2_net118
+ row_on_detect_top[40] row_off_detect_top[41] openDVS_pixel2x2_top
x2_x670 dac_config_3 dac_config_5 col_event_rst_top_right[3] dac_config_4
+ row_on_detect_top[41] dac_config_0 dac_config_1 row_off_detect_top[40] x2_net121
+ dac_config_2 vdda1 vssa1 vssc1 col_event_rst_top_right[2] x2_net122
+ row_on_detect_top[40] row_off_detect_top[41] openDVS_pixel2x2_top
x2_x671 dac_config_3 dac_config_5 col_event_rst_top_right[1] dac_config_4
+ row_on_detect_top[41] dac_config_0 dac_config_1 row_off_detect_top[40] x2_net125
+ dac_config_2 vdda1 vssa1 vssc1 col_event_rst_top_right[0] x2_net126
+ row_on_detect_top[40] row_off_detect_top[41] openDVS_pixel2x2_top
x2_x672 dac_config_3 dac_config_5 col_event_rst_top_right[63] dac_config_4
+ row_on_detect_top[43] dac_config_0 dac_config_1 row_off_detect_top[42] x2_net1
+ dac_config_2 vdda1 vssa1 vssc1 col_event_rst_top_right[62] x2_net2 row_on_detect_top[42]
+ row_off_detect_top[43] openDVS_pixel2x2_top
x2_x673 dac_config_3 dac_config_5 col_event_rst_top_right[61] dac_config_4
+ row_on_detect_top[43] dac_config_0 dac_config_1 row_off_detect_top[42] x2_net5
+ dac_config_2 vdda1 vssa1 vssc1 col_event_rst_top_right[60] x2_net6 row_on_detect_top[42]
+ row_off_detect_top[43] openDVS_pixel2x2_top
x2_x674 dac_config_3 dac_config_5 col_event_rst_top_right[59] dac_config_4
+ row_on_detect_top[43] dac_config_0 dac_config_1 row_off_detect_top[42] x2_net9
+ dac_config_2 vdda1 vssa1 vssc1 col_event_rst_top_right[58] x2_net10
+ row_on_detect_top[42] row_off_detect_top[43] openDVS_pixel2x2_top
x2_x675 dac_config_3 dac_config_5 col_event_rst_top_right[57] dac_config_4
+ row_on_detect_top[43] dac_config_0 dac_config_1 row_off_detect_top[42] x2_net13
+ dac_config_2 vdda1 vssa1 vssc1 col_event_rst_top_right[56] x2_net14
+ row_on_detect_top[42] row_off_detect_top[43] openDVS_pixel2x2_top
x2_x676 dac_config_3 dac_config_5 col_event_rst_top_right[55] dac_config_4
+ row_on_detect_top[43] dac_config_0 dac_config_1 row_off_detect_top[42] x2_net17
+ dac_config_2 vdda1 vssa1 vssc1 col_event_rst_top_right[54] x2_net18
+ row_on_detect_top[42] row_off_detect_top[43] openDVS_pixel2x2_top
x2_x677 dac_config_3 dac_config_5 col_event_rst_top_right[53] dac_config_4
+ row_on_detect_top[43] dac_config_0 dac_config_1 row_off_detect_top[42] x2_net21
+ dac_config_2 vdda1 vssa1 vssc1 col_event_rst_top_right[52] x2_net22
+ row_on_detect_top[42] row_off_detect_top[43] openDVS_pixel2x2_top
x2_x678 dac_config_3 dac_config_5 col_event_rst_top_right[51] dac_config_4
+ row_on_detect_top[43] dac_config_0 dac_config_1 row_off_detect_top[42] x2_net25
+ dac_config_2 vdda1 vssa1 vssc1 col_event_rst_top_right[50] x2_net26
+ row_on_detect_top[42] row_off_detect_top[43] openDVS_pixel2x2_top
x2_x679 dac_config_3 dac_config_5 col_event_rst_top_right[49] dac_config_4
+ row_on_detect_top[43] dac_config_0 dac_config_1 row_off_detect_top[42] x2_net29
+ dac_config_2 vdda1 vssa1 vssc1 col_event_rst_top_right[48] x2_net30
+ row_on_detect_top[42] row_off_detect_top[43] openDVS_pixel2x2_top
x2_x680 dac_config_3 dac_config_5 col_event_rst_top_right[47] dac_config_4
+ row_on_detect_top[43] dac_config_0 dac_config_1 row_off_detect_top[42] x2_net33
+ dac_config_2 vdda1 vssa1 vssc1 col_event_rst_top_right[46] x2_net34
+ row_on_detect_top[42] row_off_detect_top[43] openDVS_pixel2x2_top
x2_x681 dac_config_3 dac_config_5 col_event_rst_top_right[45] dac_config_4
+ row_on_detect_top[43] dac_config_0 dac_config_1 row_off_detect_top[42] x2_net37
+ dac_config_2 vdda1 vssa1 vssc1 col_event_rst_top_right[44] x2_net38
+ row_on_detect_top[42] row_off_detect_top[43] openDVS_pixel2x2_top
x2_x682 dac_config_3 dac_config_5 col_event_rst_top_right[43] dac_config_4
+ row_on_detect_top[43] dac_config_0 dac_config_1 row_off_detect_top[42] x2_net41
+ dac_config_2 vdda1 vssa1 vssc1 col_event_rst_top_right[42] x2_net42
+ row_on_detect_top[42] row_off_detect_top[43] openDVS_pixel2x2_top
x2_x683 dac_config_3 dac_config_5 col_event_rst_top_right[41] dac_config_4
+ row_on_detect_top[43] dac_config_0 dac_config_1 row_off_detect_top[42] x2_net45
+ dac_config_2 vdda1 vssa1 vssc1 col_event_rst_top_right[40] x2_net46
+ row_on_detect_top[42] row_off_detect_top[43] openDVS_pixel2x2_top
x2_x684 dac_config_3 dac_config_5 col_event_rst_top_right[39] dac_config_4
+ row_on_detect_top[43] dac_config_0 dac_config_1 row_off_detect_top[42] x2_net49
+ dac_config_2 vdda1 vssa1 vssc1 col_event_rst_top_right[38] x2_net50
+ row_on_detect_top[42] row_off_detect_top[43] openDVS_pixel2x2_top
x2_x685 dac_config_3 dac_config_5 col_event_rst_top_right[37] dac_config_4
+ row_on_detect_top[43] dac_config_0 dac_config_1 row_off_detect_top[42] x2_net53
+ dac_config_2 vdda1 vssa1 vssc1 col_event_rst_top_right[36] x2_net54
+ row_on_detect_top[42] row_off_detect_top[43] openDVS_pixel2x2_top
x2_x686 dac_config_3 dac_config_5 col_event_rst_top_right[35] dac_config_4
+ row_on_detect_top[43] dac_config_0 dac_config_1 row_off_detect_top[42] x2_net57
+ dac_config_2 vdda1 vssa1 vssc1 col_event_rst_top_right[34] x2_net58
+ row_on_detect_top[42] row_off_detect_top[43] openDVS_pixel2x2_top
x2_x687 dac_config_3 dac_config_5 col_event_rst_top_right[33] dac_config_4
+ row_on_detect_top[43] dac_config_0 dac_config_1 row_off_detect_top[42] x2_net61
+ dac_config_2 vdda1 vssa1 vssc1 col_event_rst_top_right[32] x2_net62
+ row_on_detect_top[42] row_off_detect_top[43] openDVS_pixel2x2_top
x2_x688 dac_config_3 dac_config_5 col_event_rst_top_right[31] dac_config_4
+ row_on_detect_top[43] dac_config_0 dac_config_1 row_off_detect_top[42] x2_net65
+ dac_config_2 vdda1 vssa1 vssc1 col_event_rst_top_right[30] x2_net66
+ row_on_detect_top[42] row_off_detect_top[43] openDVS_pixel2x2_top
x2_x689 dac_config_3 dac_config_5 col_event_rst_top_right[29] dac_config_4
+ row_on_detect_top[43] dac_config_0 dac_config_1 row_off_detect_top[42] x2_net69
+ dac_config_2 vdda1 vssa1 vssc1 col_event_rst_top_right[28] x2_net70
+ row_on_detect_top[42] row_off_detect_top[43] openDVS_pixel2x2_top
x2_x690 dac_config_3 dac_config_5 col_event_rst_top_right[27] dac_config_4
+ row_on_detect_top[43] dac_config_0 dac_config_1 row_off_detect_top[42] x2_net73
+ dac_config_2 vdda1 vssa1 vssc1 col_event_rst_top_right[26] x2_net74
+ row_on_detect_top[42] row_off_detect_top[43] openDVS_pixel2x2_top
x2_x691 dac_config_3 dac_config_5 col_event_rst_top_right[25] dac_config_4
+ row_on_detect_top[43] dac_config_0 dac_config_1 row_off_detect_top[42] x2_net77
+ dac_config_2 vdda1 vssa1 vssc1 col_event_rst_top_right[24] x2_net78
+ row_on_detect_top[42] row_off_detect_top[43] openDVS_pixel2x2_top
x2_x692 dac_config_3 dac_config_5 col_event_rst_top_right[23] dac_config_4
+ row_on_detect_top[43] dac_config_0 dac_config_1 row_off_detect_top[42] x2_net81
+ dac_config_2 vdda1 vssa1 vssc1 col_event_rst_top_right[22] x2_net82
+ row_on_detect_top[42] row_off_detect_top[43] openDVS_pixel2x2_top
x2_x693 dac_config_3 dac_config_5 col_event_rst_top_right[21] dac_config_4
+ row_on_detect_top[43] dac_config_0 dac_config_1 row_off_detect_top[42] x2_net85
+ dac_config_2 vdda1 vssa1 vssc1 col_event_rst_top_right[20] x2_net86
+ row_on_detect_top[42] row_off_detect_top[43] openDVS_pixel2x2_top
x2_x694 dac_config_3 dac_config_5 col_event_rst_top_right[19] dac_config_4
+ row_on_detect_top[43] dac_config_0 dac_config_1 row_off_detect_top[42] x2_net89
+ dac_config_2 vdda1 vssa1 vssc1 col_event_rst_top_right[18] x2_net90
+ row_on_detect_top[42] row_off_detect_top[43] openDVS_pixel2x2_top
x2_x695 dac_config_3 dac_config_5 col_event_rst_top_right[17] dac_config_4
+ row_on_detect_top[43] dac_config_0 dac_config_1 row_off_detect_top[42] x2_net93
+ dac_config_2 vdda1 vssa1 vssc1 col_event_rst_top_right[16] x2_net94
+ row_on_detect_top[42] row_off_detect_top[43] openDVS_pixel2x2_top
x2_x696 dac_config_3 dac_config_5 col_event_rst_top_right[15] dac_config_4
+ row_on_detect_top[43] dac_config_0 dac_config_1 row_off_detect_top[42] x2_net97
+ dac_config_2 vdda1 vssa1 vssc1 col_event_rst_top_right[14] x2_net98
+ row_on_detect_top[42] row_off_detect_top[43] openDVS_pixel2x2_top
x2_x697 dac_config_3 dac_config_5 col_event_rst_top_right[13] dac_config_4
+ row_on_detect_top[43] dac_config_0 dac_config_1 row_off_detect_top[42] x2_net101
+ dac_config_2 vdda1 vssa1 vssc1 col_event_rst_top_right[12] x2_net102
+ row_on_detect_top[42] row_off_detect_top[43] openDVS_pixel2x2_top
x2_x698 dac_config_3 dac_config_5 col_event_rst_top_right[11] dac_config_4
+ row_on_detect_top[43] dac_config_0 dac_config_1 row_off_detect_top[42] x2_net105
+ dac_config_2 vdda1 vssa1 vssc1 col_event_rst_top_right[10] x2_net106
+ row_on_detect_top[42] row_off_detect_top[43] openDVS_pixel2x2_top
x2_x699 dac_config_3 dac_config_5 col_event_rst_top_right[9] dac_config_4
+ row_on_detect_top[43] dac_config_0 dac_config_1 row_off_detect_top[42] x2_net109
+ dac_config_2 vdda1 vssa1 vssc1 col_event_rst_top_right[8] x2_net110
+ row_on_detect_top[42] row_off_detect_top[43] openDVS_pixel2x2_top
x2_x700 dac_config_3 dac_config_5 col_event_rst_top_right[7] dac_config_4
+ row_on_detect_top[43] dac_config_0 dac_config_1 row_off_detect_top[42] x2_net113
+ dac_config_2 vdda1 vssa1 vssc1 col_event_rst_top_right[6] x2_net114
+ row_on_detect_top[42] row_off_detect_top[43] openDVS_pixel2x2_top
x2_x701 dac_config_3 dac_config_5 col_event_rst_top_right[5] dac_config_4
+ row_on_detect_top[43] dac_config_0 dac_config_1 row_off_detect_top[42] x2_net117
+ dac_config_2 vdda1 vssa1 vssc1 col_event_rst_top_right[4] x2_net118
+ row_on_detect_top[42] row_off_detect_top[43] openDVS_pixel2x2_top
x2_x702 dac_config_3 dac_config_5 col_event_rst_top_right[3] dac_config_4
+ row_on_detect_top[43] dac_config_0 dac_config_1 row_off_detect_top[42] x2_net121
+ dac_config_2 vdda1 vssa1 vssc1 col_event_rst_top_right[2] x2_net122
+ row_on_detect_top[42] row_off_detect_top[43] openDVS_pixel2x2_top
x2_x703 dac_config_3 dac_config_5 col_event_rst_top_right[1] dac_config_4
+ row_on_detect_top[43] dac_config_0 dac_config_1 row_off_detect_top[42] x2_net125
+ dac_config_2 vdda1 vssa1 vssc1 col_event_rst_top_right[0] x2_net126
+ row_on_detect_top[42] row_off_detect_top[43] openDVS_pixel2x2_top
x2_x704 dac_config_3 dac_config_5 col_event_rst_top_right[63] dac_config_4
+ row_on_detect_top[45] dac_config_0 dac_config_1 row_off_detect_top[44] x2_net1
+ dac_config_2 vdda1 vssa1 vssc1 col_event_rst_top_right[62] x2_net2 row_on_detect_top[44]
+ row_off_detect_top[45] openDVS_pixel2x2_top
x2_x705 dac_config_3 dac_config_5 col_event_rst_top_right[61] dac_config_4
+ row_on_detect_top[45] dac_config_0 dac_config_1 row_off_detect_top[44] x2_net5
+ dac_config_2 vdda1 vssa1 vssc1 col_event_rst_top_right[60] x2_net6 row_on_detect_top[44]
+ row_off_detect_top[45] openDVS_pixel2x2_top
x2_x706 dac_config_3 dac_config_5 col_event_rst_top_right[59] dac_config_4
+ row_on_detect_top[45] dac_config_0 dac_config_1 row_off_detect_top[44] x2_net9
+ dac_config_2 vdda1 vssa1 vssc1 col_event_rst_top_right[58] x2_net10
+ row_on_detect_top[44] row_off_detect_top[45] openDVS_pixel2x2_top
x2_x707 dac_config_3 dac_config_5 col_event_rst_top_right[57] dac_config_4
+ row_on_detect_top[45] dac_config_0 dac_config_1 row_off_detect_top[44] x2_net13
+ dac_config_2 vdda1 vssa1 vssc1 col_event_rst_top_right[56] x2_net14
+ row_on_detect_top[44] row_off_detect_top[45] openDVS_pixel2x2_top
x2_x708 dac_config_3 dac_config_5 col_event_rst_top_right[55] dac_config_4
+ row_on_detect_top[45] dac_config_0 dac_config_1 row_off_detect_top[44] x2_net17
+ dac_config_2 vdda1 vssa1 vssc1 col_event_rst_top_right[54] x2_net18
+ row_on_detect_top[44] row_off_detect_top[45] openDVS_pixel2x2_top
x2_x709 dac_config_3 dac_config_5 col_event_rst_top_right[53] dac_config_4
+ row_on_detect_top[45] dac_config_0 dac_config_1 row_off_detect_top[44] x2_net21
+ dac_config_2 vdda1 vssa1 vssc1 col_event_rst_top_right[52] x2_net22
+ row_on_detect_top[44] row_off_detect_top[45] openDVS_pixel2x2_top
x2_x710 dac_config_3 dac_config_5 col_event_rst_top_right[51] dac_config_4
+ row_on_detect_top[45] dac_config_0 dac_config_1 row_off_detect_top[44] x2_net25
+ dac_config_2 vdda1 vssa1 vssc1 col_event_rst_top_right[50] x2_net26
+ row_on_detect_top[44] row_off_detect_top[45] openDVS_pixel2x2_top
x2_x711 dac_config_3 dac_config_5 col_event_rst_top_right[49] dac_config_4
+ row_on_detect_top[45] dac_config_0 dac_config_1 row_off_detect_top[44] x2_net29
+ dac_config_2 vdda1 vssa1 vssc1 col_event_rst_top_right[48] x2_net30
+ row_on_detect_top[44] row_off_detect_top[45] openDVS_pixel2x2_top
x2_x712 dac_config_3 dac_config_5 col_event_rst_top_right[47] dac_config_4
+ row_on_detect_top[45] dac_config_0 dac_config_1 row_off_detect_top[44] x2_net33
+ dac_config_2 vdda1 vssa1 vssc1 col_event_rst_top_right[46] x2_net34
+ row_on_detect_top[44] row_off_detect_top[45] openDVS_pixel2x2_top
x2_x713 dac_config_3 dac_config_5 col_event_rst_top_right[45] dac_config_4
+ row_on_detect_top[45] dac_config_0 dac_config_1 row_off_detect_top[44] x2_net37
+ dac_config_2 vdda1 vssa1 vssc1 col_event_rst_top_right[44] x2_net38
+ row_on_detect_top[44] row_off_detect_top[45] openDVS_pixel2x2_top
x2_x714 dac_config_3 dac_config_5 col_event_rst_top_right[43] dac_config_4
+ row_on_detect_top[45] dac_config_0 dac_config_1 row_off_detect_top[44] x2_net41
+ dac_config_2 vdda1 vssa1 vssc1 col_event_rst_top_right[42] x2_net42
+ row_on_detect_top[44] row_off_detect_top[45] openDVS_pixel2x2_top
x2_x715 dac_config_3 dac_config_5 col_event_rst_top_right[41] dac_config_4
+ row_on_detect_top[45] dac_config_0 dac_config_1 row_off_detect_top[44] x2_net45
+ dac_config_2 vdda1 vssa1 vssc1 col_event_rst_top_right[40] x2_net46
+ row_on_detect_top[44] row_off_detect_top[45] openDVS_pixel2x2_top
x2_x716 dac_config_3 dac_config_5 col_event_rst_top_right[39] dac_config_4
+ row_on_detect_top[45] dac_config_0 dac_config_1 row_off_detect_top[44] x2_net49
+ dac_config_2 vdda1 vssa1 vssc1 col_event_rst_top_right[38] x2_net50
+ row_on_detect_top[44] row_off_detect_top[45] openDVS_pixel2x2_top
x2_x717 dac_config_3 dac_config_5 col_event_rst_top_right[37] dac_config_4
+ row_on_detect_top[45] dac_config_0 dac_config_1 row_off_detect_top[44] x2_net53
+ dac_config_2 vdda1 vssa1 vssc1 col_event_rst_top_right[36] x2_net54
+ row_on_detect_top[44] row_off_detect_top[45] openDVS_pixel2x2_top
x2_x718 dac_config_3 dac_config_5 col_event_rst_top_right[35] dac_config_4
+ row_on_detect_top[45] dac_config_0 dac_config_1 row_off_detect_top[44] x2_net57
+ dac_config_2 vdda1 vssa1 vssc1 col_event_rst_top_right[34] x2_net58
+ row_on_detect_top[44] row_off_detect_top[45] openDVS_pixel2x2_top
x2_x719 dac_config_3 dac_config_5 col_event_rst_top_right[33] dac_config_4
+ row_on_detect_top[45] dac_config_0 dac_config_1 row_off_detect_top[44] x2_net61
+ dac_config_2 vdda1 vssa1 vssc1 col_event_rst_top_right[32] x2_net62
+ row_on_detect_top[44] row_off_detect_top[45] openDVS_pixel2x2_top
x2_x720 dac_config_3 dac_config_5 col_event_rst_top_right[31] dac_config_4
+ row_on_detect_top[45] dac_config_0 dac_config_1 row_off_detect_top[44] x2_net65
+ dac_config_2 vdda1 vssa1 vssc1 col_event_rst_top_right[30] x2_net66
+ row_on_detect_top[44] row_off_detect_top[45] openDVS_pixel2x2_top
x2_x721 dac_config_3 dac_config_5 col_event_rst_top_right[29] dac_config_4
+ row_on_detect_top[45] dac_config_0 dac_config_1 row_off_detect_top[44] x2_net69
+ dac_config_2 vdda1 vssa1 vssc1 col_event_rst_top_right[28] x2_net70
+ row_on_detect_top[44] row_off_detect_top[45] openDVS_pixel2x2_top
x2_x722 dac_config_3 dac_config_5 col_event_rst_top_right[27] dac_config_4
+ row_on_detect_top[45] dac_config_0 dac_config_1 row_off_detect_top[44] x2_net73
+ dac_config_2 vdda1 vssa1 vssc1 col_event_rst_top_right[26] x2_net74
+ row_on_detect_top[44] row_off_detect_top[45] openDVS_pixel2x2_top
x2_x723 dac_config_3 dac_config_5 col_event_rst_top_right[25] dac_config_4
+ row_on_detect_top[45] dac_config_0 dac_config_1 row_off_detect_top[44] x2_net77
+ dac_config_2 vdda1 vssa1 vssc1 col_event_rst_top_right[24] x2_net78
+ row_on_detect_top[44] row_off_detect_top[45] openDVS_pixel2x2_top
x2_x724 dac_config_3 dac_config_5 col_event_rst_top_right[23] dac_config_4
+ row_on_detect_top[45] dac_config_0 dac_config_1 row_off_detect_top[44] x2_net81
+ dac_config_2 vdda1 vssa1 vssc1 col_event_rst_top_right[22] x2_net82
+ row_on_detect_top[44] row_off_detect_top[45] openDVS_pixel2x2_top
x2_x725 dac_config_3 dac_config_5 col_event_rst_top_right[21] dac_config_4
+ row_on_detect_top[45] dac_config_0 dac_config_1 row_off_detect_top[44] x2_net85
+ dac_config_2 vdda1 vssa1 vssc1 col_event_rst_top_right[20] x2_net86
+ row_on_detect_top[44] row_off_detect_top[45] openDVS_pixel2x2_top
x2_x726 dac_config_3 dac_config_5 col_event_rst_top_right[19] dac_config_4
+ row_on_detect_top[45] dac_config_0 dac_config_1 row_off_detect_top[44] x2_net89
+ dac_config_2 vdda1 vssa1 vssc1 col_event_rst_top_right[18] x2_net90
+ row_on_detect_top[44] row_off_detect_top[45] openDVS_pixel2x2_top
x2_x727 dac_config_3 dac_config_5 col_event_rst_top_right[17] dac_config_4
+ row_on_detect_top[45] dac_config_0 dac_config_1 row_off_detect_top[44] x2_net93
+ dac_config_2 vdda1 vssa1 vssc1 col_event_rst_top_right[16] x2_net94
+ row_on_detect_top[44] row_off_detect_top[45] openDVS_pixel2x2_top
x2_x728 dac_config_3 dac_config_5 col_event_rst_top_right[15] dac_config_4
+ row_on_detect_top[45] dac_config_0 dac_config_1 row_off_detect_top[44] x2_net97
+ dac_config_2 vdda1 vssa1 vssc1 col_event_rst_top_right[14] x2_net98
+ row_on_detect_top[44] row_off_detect_top[45] openDVS_pixel2x2_top
x2_x729 dac_config_3 dac_config_5 col_event_rst_top_right[13] dac_config_4
+ row_on_detect_top[45] dac_config_0 dac_config_1 row_off_detect_top[44] x2_net101
+ dac_config_2 vdda1 vssa1 vssc1 col_event_rst_top_right[12] x2_net102
+ row_on_detect_top[44] row_off_detect_top[45] openDVS_pixel2x2_top
x2_x730 dac_config_3 dac_config_5 col_event_rst_top_right[11] dac_config_4
+ row_on_detect_top[45] dac_config_0 dac_config_1 row_off_detect_top[44] x2_net105
+ dac_config_2 vdda1 vssa1 vssc1 col_event_rst_top_right[10] x2_net106
+ row_on_detect_top[44] row_off_detect_top[45] openDVS_pixel2x2_top
x2_x731 dac_config_3 dac_config_5 col_event_rst_top_right[9] dac_config_4
+ row_on_detect_top[45] dac_config_0 dac_config_1 row_off_detect_top[44] x2_net109
+ dac_config_2 vdda1 vssa1 vssc1 col_event_rst_top_right[8] x2_net110
+ row_on_detect_top[44] row_off_detect_top[45] openDVS_pixel2x2_top
x2_x732 dac_config_3 dac_config_5 col_event_rst_top_right[7] dac_config_4
+ row_on_detect_top[45] dac_config_0 dac_config_1 row_off_detect_top[44] x2_net113
+ dac_config_2 vdda1 vssa1 vssc1 col_event_rst_top_right[6] x2_net114
+ row_on_detect_top[44] row_off_detect_top[45] openDVS_pixel2x2_top
x2_x733 dac_config_3 dac_config_5 col_event_rst_top_right[5] dac_config_4
+ row_on_detect_top[45] dac_config_0 dac_config_1 row_off_detect_top[44] x2_net117
+ dac_config_2 vdda1 vssa1 vssc1 col_event_rst_top_right[4] x2_net118
+ row_on_detect_top[44] row_off_detect_top[45] openDVS_pixel2x2_top
x2_x734 dac_config_3 dac_config_5 col_event_rst_top_right[3] dac_config_4
+ row_on_detect_top[45] dac_config_0 dac_config_1 row_off_detect_top[44] x2_net121
+ dac_config_2 vdda1 vssa1 vssc1 col_event_rst_top_right[2] x2_net122
+ row_on_detect_top[44] row_off_detect_top[45] openDVS_pixel2x2_top
x2_x735 dac_config_3 dac_config_5 col_event_rst_top_right[1] dac_config_4
+ row_on_detect_top[45] dac_config_0 dac_config_1 row_off_detect_top[44] x2_net125
+ dac_config_2 vdda1 vssa1 vssc1 col_event_rst_top_right[0] x2_net126
+ row_on_detect_top[44] row_off_detect_top[45] openDVS_pixel2x2_top
x2_x736 dac_config_3 dac_config_5 col_event_rst_top_right[63] dac_config_4
+ row_on_detect_top[47] dac_config_0 dac_config_1 row_off_detect_top[46] x2_net1
+ dac_config_2 vdda1 vssa1 vssc1 col_event_rst_top_right[62] x2_net2 row_on_detect_top[46]
+ row_off_detect_top[47] openDVS_pixel2x2_top
x2_x737 dac_config_3 dac_config_5 col_event_rst_top_right[61] dac_config_4
+ row_on_detect_top[47] dac_config_0 dac_config_1 row_off_detect_top[46] x2_net5
+ dac_config_2 vdda1 vssa1 vssc1 col_event_rst_top_right[60] x2_net6 row_on_detect_top[46]
+ row_off_detect_top[47] openDVS_pixel2x2_top
x2_x738 dac_config_3 dac_config_5 col_event_rst_top_right[59] dac_config_4
+ row_on_detect_top[47] dac_config_0 dac_config_1 row_off_detect_top[46] x2_net9
+ dac_config_2 vdda1 vssa1 vssc1 col_event_rst_top_right[58] x2_net10
+ row_on_detect_top[46] row_off_detect_top[47] openDVS_pixel2x2_top
x2_x739 dac_config_3 dac_config_5 col_event_rst_top_right[57] dac_config_4
+ row_on_detect_top[47] dac_config_0 dac_config_1 row_off_detect_top[46] x2_net13
+ dac_config_2 vdda1 vssa1 vssc1 col_event_rst_top_right[56] x2_net14
+ row_on_detect_top[46] row_off_detect_top[47] openDVS_pixel2x2_top
x2_x740 dac_config_3 dac_config_5 col_event_rst_top_right[55] dac_config_4
+ row_on_detect_top[47] dac_config_0 dac_config_1 row_off_detect_top[46] x2_net17
+ dac_config_2 vdda1 vssa1 vssc1 col_event_rst_top_right[54] x2_net18
+ row_on_detect_top[46] row_off_detect_top[47] openDVS_pixel2x2_top
x2_x741 dac_config_3 dac_config_5 col_event_rst_top_right[53] dac_config_4
+ row_on_detect_top[47] dac_config_0 dac_config_1 row_off_detect_top[46] x2_net21
+ dac_config_2 vdda1 vssa1 vssc1 col_event_rst_top_right[52] x2_net22
+ row_on_detect_top[46] row_off_detect_top[47] openDVS_pixel2x2_top
x2_x742 dac_config_3 dac_config_5 col_event_rst_top_right[51] dac_config_4
+ row_on_detect_top[47] dac_config_0 dac_config_1 row_off_detect_top[46] x2_net25
+ dac_config_2 vdda1 vssa1 vssc1 col_event_rst_top_right[50] x2_net26
+ row_on_detect_top[46] row_off_detect_top[47] openDVS_pixel2x2_top
x2_x743 dac_config_3 dac_config_5 col_event_rst_top_right[49] dac_config_4
+ row_on_detect_top[47] dac_config_0 dac_config_1 row_off_detect_top[46] x2_net29
+ dac_config_2 vdda1 vssa1 vssc1 col_event_rst_top_right[48] x2_net30
+ row_on_detect_top[46] row_off_detect_top[47] openDVS_pixel2x2_top
x2_x744 dac_config_3 dac_config_5 col_event_rst_top_right[47] dac_config_4
+ row_on_detect_top[47] dac_config_0 dac_config_1 row_off_detect_top[46] x2_net33
+ dac_config_2 vdda1 vssa1 vssc1 col_event_rst_top_right[46] x2_net34
+ row_on_detect_top[46] row_off_detect_top[47] openDVS_pixel2x2_top
x2_x745 dac_config_3 dac_config_5 col_event_rst_top_right[45] dac_config_4
+ row_on_detect_top[47] dac_config_0 dac_config_1 row_off_detect_top[46] x2_net37
+ dac_config_2 vdda1 vssa1 vssc1 col_event_rst_top_right[44] x2_net38
+ row_on_detect_top[46] row_off_detect_top[47] openDVS_pixel2x2_top
x2_x746 dac_config_3 dac_config_5 col_event_rst_top_right[43] dac_config_4
+ row_on_detect_top[47] dac_config_0 dac_config_1 row_off_detect_top[46] x2_net41
+ dac_config_2 vdda1 vssa1 vssc1 col_event_rst_top_right[42] x2_net42
+ row_on_detect_top[46] row_off_detect_top[47] openDVS_pixel2x2_top
x2_x747 dac_config_3 dac_config_5 col_event_rst_top_right[41] dac_config_4
+ row_on_detect_top[47] dac_config_0 dac_config_1 row_off_detect_top[46] x2_net45
+ dac_config_2 vdda1 vssa1 vssc1 col_event_rst_top_right[40] x2_net46
+ row_on_detect_top[46] row_off_detect_top[47] openDVS_pixel2x2_top
x2_x748 dac_config_3 dac_config_5 col_event_rst_top_right[39] dac_config_4
+ row_on_detect_top[47] dac_config_0 dac_config_1 row_off_detect_top[46] x2_net49
+ dac_config_2 vdda1 vssa1 vssc1 col_event_rst_top_right[38] x2_net50
+ row_on_detect_top[46] row_off_detect_top[47] openDVS_pixel2x2_top
x2_x749 dac_config_3 dac_config_5 col_event_rst_top_right[37] dac_config_4
+ row_on_detect_top[47] dac_config_0 dac_config_1 row_off_detect_top[46] x2_net53
+ dac_config_2 vdda1 vssa1 vssc1 col_event_rst_top_right[36] x2_net54
+ row_on_detect_top[46] row_off_detect_top[47] openDVS_pixel2x2_top
x2_x750 dac_config_3 dac_config_5 col_event_rst_top_right[35] dac_config_4
+ row_on_detect_top[47] dac_config_0 dac_config_1 row_off_detect_top[46] x2_net57
+ dac_config_2 vdda1 vssa1 vssc1 col_event_rst_top_right[34] x2_net58
+ row_on_detect_top[46] row_off_detect_top[47] openDVS_pixel2x2_top
x2_x751 dac_config_3 dac_config_5 col_event_rst_top_right[33] dac_config_4
+ row_on_detect_top[47] dac_config_0 dac_config_1 row_off_detect_top[46] x2_net61
+ dac_config_2 vdda1 vssa1 vssc1 col_event_rst_top_right[32] x2_net62
+ row_on_detect_top[46] row_off_detect_top[47] openDVS_pixel2x2_top
x2_x752 dac_config_3 dac_config_5 col_event_rst_top_right[31] dac_config_4
+ row_on_detect_top[47] dac_config_0 dac_config_1 row_off_detect_top[46] x2_net65
+ dac_config_2 vdda1 vssa1 vssc1 col_event_rst_top_right[30] x2_net66
+ row_on_detect_top[46] row_off_detect_top[47] openDVS_pixel2x2_top
x2_x753 dac_config_3 dac_config_5 col_event_rst_top_right[29] dac_config_4
+ row_on_detect_top[47] dac_config_0 dac_config_1 row_off_detect_top[46] x2_net69
+ dac_config_2 vdda1 vssa1 vssc1 col_event_rst_top_right[28] x2_net70
+ row_on_detect_top[46] row_off_detect_top[47] openDVS_pixel2x2_top
x2_x754 dac_config_3 dac_config_5 col_event_rst_top_right[27] dac_config_4
+ row_on_detect_top[47] dac_config_0 dac_config_1 row_off_detect_top[46] x2_net73
+ dac_config_2 vdda1 vssa1 vssc1 col_event_rst_top_right[26] x2_net74
+ row_on_detect_top[46] row_off_detect_top[47] openDVS_pixel2x2_top
x2_x755 dac_config_3 dac_config_5 col_event_rst_top_right[25] dac_config_4
+ row_on_detect_top[47] dac_config_0 dac_config_1 row_off_detect_top[46] x2_net77
+ dac_config_2 vdda1 vssa1 vssc1 col_event_rst_top_right[24] x2_net78
+ row_on_detect_top[46] row_off_detect_top[47] openDVS_pixel2x2_top
x2_x756 dac_config_3 dac_config_5 col_event_rst_top_right[23] dac_config_4
+ row_on_detect_top[47] dac_config_0 dac_config_1 row_off_detect_top[46] x2_net81
+ dac_config_2 vdda1 vssa1 vssc1 col_event_rst_top_right[22] x2_net82
+ row_on_detect_top[46] row_off_detect_top[47] openDVS_pixel2x2_top
x2_x757 dac_config_3 dac_config_5 col_event_rst_top_right[21] dac_config_4
+ row_on_detect_top[47] dac_config_0 dac_config_1 row_off_detect_top[46] x2_net85
+ dac_config_2 vdda1 vssa1 vssc1 col_event_rst_top_right[20] x2_net86
+ row_on_detect_top[46] row_off_detect_top[47] openDVS_pixel2x2_top
x2_x758 dac_config_3 dac_config_5 col_event_rst_top_right[19] dac_config_4
+ row_on_detect_top[47] dac_config_0 dac_config_1 row_off_detect_top[46] x2_net89
+ dac_config_2 vdda1 vssa1 vssc1 col_event_rst_top_right[18] x2_net90
+ row_on_detect_top[46] row_off_detect_top[47] openDVS_pixel2x2_top
x2_x759 dac_config_3 dac_config_5 col_event_rst_top_right[17] dac_config_4
+ row_on_detect_top[47] dac_config_0 dac_config_1 row_off_detect_top[46] x2_net93
+ dac_config_2 vdda1 vssa1 vssc1 col_event_rst_top_right[16] x2_net94
+ row_on_detect_top[46] row_off_detect_top[47] openDVS_pixel2x2_top
x2_x760 dac_config_3 dac_config_5 col_event_rst_top_right[15] dac_config_4
+ row_on_detect_top[47] dac_config_0 dac_config_1 row_off_detect_top[46] x2_net97
+ dac_config_2 vdda1 vssa1 vssc1 col_event_rst_top_right[14] x2_net98
+ row_on_detect_top[46] row_off_detect_top[47] openDVS_pixel2x2_top
x2_x761 dac_config_3 dac_config_5 col_event_rst_top_right[13] dac_config_4
+ row_on_detect_top[47] dac_config_0 dac_config_1 row_off_detect_top[46] x2_net101
+ dac_config_2 vdda1 vssa1 vssc1 col_event_rst_top_right[12] x2_net102
+ row_on_detect_top[46] row_off_detect_top[47] openDVS_pixel2x2_top
x2_x762 dac_config_3 dac_config_5 col_event_rst_top_right[11] dac_config_4
+ row_on_detect_top[47] dac_config_0 dac_config_1 row_off_detect_top[46] x2_net105
+ dac_config_2 vdda1 vssa1 vssc1 col_event_rst_top_right[10] x2_net106
+ row_on_detect_top[46] row_off_detect_top[47] openDVS_pixel2x2_top
x2_x763 dac_config_3 dac_config_5 col_event_rst_top_right[9] dac_config_4
+ row_on_detect_top[47] dac_config_0 dac_config_1 row_off_detect_top[46] x2_net109
+ dac_config_2 vdda1 vssa1 vssc1 col_event_rst_top_right[8] x2_net110
+ row_on_detect_top[46] row_off_detect_top[47] openDVS_pixel2x2_top
x2_x764 dac_config_3 dac_config_5 col_event_rst_top_right[7] dac_config_4
+ row_on_detect_top[47] dac_config_0 dac_config_1 row_off_detect_top[46] x2_net113
+ dac_config_2 vdda1 vssa1 vssc1 col_event_rst_top_right[6] x2_net114
+ row_on_detect_top[46] row_off_detect_top[47] openDVS_pixel2x2_top
x2_x765 dac_config_3 dac_config_5 col_event_rst_top_right[5] dac_config_4
+ row_on_detect_top[47] dac_config_0 dac_config_1 row_off_detect_top[46] x2_net117
+ dac_config_2 vdda1 vssa1 vssc1 col_event_rst_top_right[4] x2_net118
+ row_on_detect_top[46] row_off_detect_top[47] openDVS_pixel2x2_top
x2_x766 dac_config_3 dac_config_5 col_event_rst_top_right[3] dac_config_4
+ row_on_detect_top[47] dac_config_0 dac_config_1 row_off_detect_top[46] x2_net121
+ dac_config_2 vdda1 vssa1 vssc1 col_event_rst_top_right[2] x2_net122
+ row_on_detect_top[46] row_off_detect_top[47] openDVS_pixel2x2_top
x2_x767 dac_config_3 dac_config_5 col_event_rst_top_right[1] dac_config_4
+ row_on_detect_top[47] dac_config_0 dac_config_1 row_off_detect_top[46] x2_net125
+ dac_config_2 vdda1 vssa1 vssc1 col_event_rst_top_right[0] x2_net126
+ row_on_detect_top[46] row_off_detect_top[47] openDVS_pixel2x2_top
x2_x768 dac_config_3 dac_config_5 col_event_rst_top_right[63] dac_config_4
+ row_on_detect_top[49] dac_config_0 dac_config_1 row_off_detect_top[48] x2_net1
+ dac_config_2 vdda1 vssa1 vssc1 col_event_rst_top_right[62] x2_net2 row_on_detect_top[48]
+ row_off_detect_top[49] openDVS_pixel2x2_top
x2_x769 dac_config_3 dac_config_5 col_event_rst_top_right[61] dac_config_4
+ row_on_detect_top[49] dac_config_0 dac_config_1 row_off_detect_top[48] x2_net5
+ dac_config_2 vdda1 vssa1 vssc1 col_event_rst_top_right[60] x2_net6 row_on_detect_top[48]
+ row_off_detect_top[49] openDVS_pixel2x2_top
x2_x770 dac_config_3 dac_config_5 col_event_rst_top_right[59] dac_config_4
+ row_on_detect_top[49] dac_config_0 dac_config_1 row_off_detect_top[48] x2_net9
+ dac_config_2 vdda1 vssa1 vssc1 col_event_rst_top_right[58] x2_net10
+ row_on_detect_top[48] row_off_detect_top[49] openDVS_pixel2x2_top
x2_x771 dac_config_3 dac_config_5 col_event_rst_top_right[57] dac_config_4
+ row_on_detect_top[49] dac_config_0 dac_config_1 row_off_detect_top[48] x2_net13
+ dac_config_2 vdda1 vssa1 vssc1 col_event_rst_top_right[56] x2_net14
+ row_on_detect_top[48] row_off_detect_top[49] openDVS_pixel2x2_top
x2_x772 dac_config_3 dac_config_5 col_event_rst_top_right[55] dac_config_4
+ row_on_detect_top[49] dac_config_0 dac_config_1 row_off_detect_top[48] x2_net17
+ dac_config_2 vdda1 vssa1 vssc1 col_event_rst_top_right[54] x2_net18
+ row_on_detect_top[48] row_off_detect_top[49] openDVS_pixel2x2_top
x2_x773 dac_config_3 dac_config_5 col_event_rst_top_right[53] dac_config_4
+ row_on_detect_top[49] dac_config_0 dac_config_1 row_off_detect_top[48] x2_net21
+ dac_config_2 vdda1 vssa1 vssc1 col_event_rst_top_right[52] x2_net22
+ row_on_detect_top[48] row_off_detect_top[49] openDVS_pixel2x2_top
x2_x774 dac_config_3 dac_config_5 col_event_rst_top_right[51] dac_config_4
+ row_on_detect_top[49] dac_config_0 dac_config_1 row_off_detect_top[48] x2_net25
+ dac_config_2 vdda1 vssa1 vssc1 col_event_rst_top_right[50] x2_net26
+ row_on_detect_top[48] row_off_detect_top[49] openDVS_pixel2x2_top
x2_x775 dac_config_3 dac_config_5 col_event_rst_top_right[49] dac_config_4
+ row_on_detect_top[49] dac_config_0 dac_config_1 row_off_detect_top[48] x2_net29
+ dac_config_2 vdda1 vssa1 vssc1 col_event_rst_top_right[48] x2_net30
+ row_on_detect_top[48] row_off_detect_top[49] openDVS_pixel2x2_top
x2_x776 dac_config_3 dac_config_5 col_event_rst_top_right[47] dac_config_4
+ row_on_detect_top[49] dac_config_0 dac_config_1 row_off_detect_top[48] x2_net33
+ dac_config_2 vdda1 vssa1 vssc1 col_event_rst_top_right[46] x2_net34
+ row_on_detect_top[48] row_off_detect_top[49] openDVS_pixel2x2_top
x2_x777 dac_config_3 dac_config_5 col_event_rst_top_right[45] dac_config_4
+ row_on_detect_top[49] dac_config_0 dac_config_1 row_off_detect_top[48] x2_net37
+ dac_config_2 vdda1 vssa1 vssc1 col_event_rst_top_right[44] x2_net38
+ row_on_detect_top[48] row_off_detect_top[49] openDVS_pixel2x2_top
x2_x778 dac_config_3 dac_config_5 col_event_rst_top_right[43] dac_config_4
+ row_on_detect_top[49] dac_config_0 dac_config_1 row_off_detect_top[48] x2_net41
+ dac_config_2 vdda1 vssa1 vssc1 col_event_rst_top_right[42] x2_net42
+ row_on_detect_top[48] row_off_detect_top[49] openDVS_pixel2x2_top
x2_x779 dac_config_3 dac_config_5 col_event_rst_top_right[41] dac_config_4
+ row_on_detect_top[49] dac_config_0 dac_config_1 row_off_detect_top[48] x2_net45
+ dac_config_2 vdda1 vssa1 vssc1 col_event_rst_top_right[40] x2_net46
+ row_on_detect_top[48] row_off_detect_top[49] openDVS_pixel2x2_top
x2_x780 dac_config_3 dac_config_5 col_event_rst_top_right[39] dac_config_4
+ row_on_detect_top[49] dac_config_0 dac_config_1 row_off_detect_top[48] x2_net49
+ dac_config_2 vdda1 vssa1 vssc1 col_event_rst_top_right[38] x2_net50
+ row_on_detect_top[48] row_off_detect_top[49] openDVS_pixel2x2_top
x2_x781 dac_config_3 dac_config_5 col_event_rst_top_right[37] dac_config_4
+ row_on_detect_top[49] dac_config_0 dac_config_1 row_off_detect_top[48] x2_net53
+ dac_config_2 vdda1 vssa1 vssc1 col_event_rst_top_right[36] x2_net54
+ row_on_detect_top[48] row_off_detect_top[49] openDVS_pixel2x2_top
x2_x782 dac_config_3 dac_config_5 col_event_rst_top_right[35] dac_config_4
+ row_on_detect_top[49] dac_config_0 dac_config_1 row_off_detect_top[48] x2_net57
+ dac_config_2 vdda1 vssa1 vssc1 col_event_rst_top_right[34] x2_net58
+ row_on_detect_top[48] row_off_detect_top[49] openDVS_pixel2x2_top
x2_x783 dac_config_3 dac_config_5 col_event_rst_top_right[33] dac_config_4
+ row_on_detect_top[49] dac_config_0 dac_config_1 row_off_detect_top[48] x2_net61
+ dac_config_2 vdda1 vssa1 vssc1 col_event_rst_top_right[32] x2_net62
+ row_on_detect_top[48] row_off_detect_top[49] openDVS_pixel2x2_top
x2_x784 dac_config_3 dac_config_5 col_event_rst_top_right[31] dac_config_4
+ row_on_detect_top[49] dac_config_0 dac_config_1 row_off_detect_top[48] x2_net65
+ dac_config_2 vdda1 vssa1 vssc1 col_event_rst_top_right[30] x2_net66
+ row_on_detect_top[48] row_off_detect_top[49] openDVS_pixel2x2_top
x2_x785 dac_config_3 dac_config_5 col_event_rst_top_right[29] dac_config_4
+ row_on_detect_top[49] dac_config_0 dac_config_1 row_off_detect_top[48] x2_net69
+ dac_config_2 vdda1 vssa1 vssc1 col_event_rst_top_right[28] x2_net70
+ row_on_detect_top[48] row_off_detect_top[49] openDVS_pixel2x2_top
x2_x786 dac_config_3 dac_config_5 col_event_rst_top_right[27] dac_config_4
+ row_on_detect_top[49] dac_config_0 dac_config_1 row_off_detect_top[48] x2_net73
+ dac_config_2 vdda1 vssa1 vssc1 col_event_rst_top_right[26] x2_net74
+ row_on_detect_top[48] row_off_detect_top[49] openDVS_pixel2x2_top
x2_x787 dac_config_3 dac_config_5 col_event_rst_top_right[25] dac_config_4
+ row_on_detect_top[49] dac_config_0 dac_config_1 row_off_detect_top[48] x2_net77
+ dac_config_2 vdda1 vssa1 vssc1 col_event_rst_top_right[24] x2_net78
+ row_on_detect_top[48] row_off_detect_top[49] openDVS_pixel2x2_top
x2_x788 dac_config_3 dac_config_5 col_event_rst_top_right[23] dac_config_4
+ row_on_detect_top[49] dac_config_0 dac_config_1 row_off_detect_top[48] x2_net81
+ dac_config_2 vdda1 vssa1 vssc1 col_event_rst_top_right[22] x2_net82
+ row_on_detect_top[48] row_off_detect_top[49] openDVS_pixel2x2_top
x2_x789 dac_config_3 dac_config_5 col_event_rst_top_right[21] dac_config_4
+ row_on_detect_top[49] dac_config_0 dac_config_1 row_off_detect_top[48] x2_net85
+ dac_config_2 vdda1 vssa1 vssc1 col_event_rst_top_right[20] x2_net86
+ row_on_detect_top[48] row_off_detect_top[49] openDVS_pixel2x2_top
x2_x790 dac_config_3 dac_config_5 col_event_rst_top_right[19] dac_config_4
+ row_on_detect_top[49] dac_config_0 dac_config_1 row_off_detect_top[48] x2_net89
+ dac_config_2 vdda1 vssa1 vssc1 col_event_rst_top_right[18] x2_net90
+ row_on_detect_top[48] row_off_detect_top[49] openDVS_pixel2x2_top
x2_x791 dac_config_3 dac_config_5 col_event_rst_top_right[17] dac_config_4
+ row_on_detect_top[49] dac_config_0 dac_config_1 row_off_detect_top[48] x2_net93
+ dac_config_2 vdda1 vssa1 vssc1 col_event_rst_top_right[16] x2_net94
+ row_on_detect_top[48] row_off_detect_top[49] openDVS_pixel2x2_top
x2_x792 dac_config_3 dac_config_5 col_event_rst_top_right[15] dac_config_4
+ row_on_detect_top[49] dac_config_0 dac_config_1 row_off_detect_top[48] x2_net97
+ dac_config_2 vdda1 vssa1 vssc1 col_event_rst_top_right[14] x2_net98
+ row_on_detect_top[48] row_off_detect_top[49] openDVS_pixel2x2_top
x2_x793 dac_config_3 dac_config_5 col_event_rst_top_right[13] dac_config_4
+ row_on_detect_top[49] dac_config_0 dac_config_1 row_off_detect_top[48] x2_net101
+ dac_config_2 vdda1 vssa1 vssc1 col_event_rst_top_right[12] x2_net102
+ row_on_detect_top[48] row_off_detect_top[49] openDVS_pixel2x2_top
x2_x794 dac_config_3 dac_config_5 col_event_rst_top_right[11] dac_config_4
+ row_on_detect_top[49] dac_config_0 dac_config_1 row_off_detect_top[48] x2_net105
+ dac_config_2 vdda1 vssa1 vssc1 col_event_rst_top_right[10] x2_net106
+ row_on_detect_top[48] row_off_detect_top[49] openDVS_pixel2x2_top
x2_x795 dac_config_3 dac_config_5 col_event_rst_top_right[9] dac_config_4
+ row_on_detect_top[49] dac_config_0 dac_config_1 row_off_detect_top[48] x2_net109
+ dac_config_2 vdda1 vssa1 vssc1 col_event_rst_top_right[8] x2_net110
+ row_on_detect_top[48] row_off_detect_top[49] openDVS_pixel2x2_top
x2_x796 dac_config_3 dac_config_5 col_event_rst_top_right[7] dac_config_4
+ row_on_detect_top[49] dac_config_0 dac_config_1 row_off_detect_top[48] x2_net113
+ dac_config_2 vdda1 vssa1 vssc1 col_event_rst_top_right[6] x2_net114
+ row_on_detect_top[48] row_off_detect_top[49] openDVS_pixel2x2_top
x2_x797 dac_config_3 dac_config_5 col_event_rst_top_right[5] dac_config_4
+ row_on_detect_top[49] dac_config_0 dac_config_1 row_off_detect_top[48] x2_net117
+ dac_config_2 vdda1 vssa1 vssc1 col_event_rst_top_right[4] x2_net118
+ row_on_detect_top[48] row_off_detect_top[49] openDVS_pixel2x2_top
x2_x798 dac_config_3 dac_config_5 col_event_rst_top_right[3] dac_config_4
+ row_on_detect_top[49] dac_config_0 dac_config_1 row_off_detect_top[48] x2_net121
+ dac_config_2 vdda1 vssa1 vssc1 col_event_rst_top_right[2] x2_net122
+ row_on_detect_top[48] row_off_detect_top[49] openDVS_pixel2x2_top
x2_x799 dac_config_3 dac_config_5 col_event_rst_top_right[1] dac_config_4
+ row_on_detect_top[49] dac_config_0 dac_config_1 row_off_detect_top[48] x2_net125
+ dac_config_2 vdda1 vssa1 vssc1 col_event_rst_top_right[0] x2_net126
+ row_on_detect_top[48] row_off_detect_top[49] openDVS_pixel2x2_top
x2_x800 dac_config_3 dac_config_5 col_event_rst_top_right[63] dac_config_4
+ row_on_detect_top[51] dac_config_0 dac_config_1 row_off_detect_top[50] x2_net1
+ dac_config_2 vdda1 vssa1 vssc1 col_event_rst_top_right[62] x2_net2 row_on_detect_top[50]
+ row_off_detect_top[51] openDVS_pixel2x2_top
x2_x801 dac_config_3 dac_config_5 col_event_rst_top_right[61] dac_config_4
+ row_on_detect_top[51] dac_config_0 dac_config_1 row_off_detect_top[50] x2_net5
+ dac_config_2 vdda1 vssa1 vssc1 col_event_rst_top_right[60] x2_net6 row_on_detect_top[50]
+ row_off_detect_top[51] openDVS_pixel2x2_top
x2_x802 dac_config_3 dac_config_5 col_event_rst_top_right[59] dac_config_4
+ row_on_detect_top[51] dac_config_0 dac_config_1 row_off_detect_top[50] x2_net9
+ dac_config_2 vdda1 vssa1 vssc1 col_event_rst_top_right[58] x2_net10
+ row_on_detect_top[50] row_off_detect_top[51] openDVS_pixel2x2_top
x2_x803 dac_config_3 dac_config_5 col_event_rst_top_right[57] dac_config_4
+ row_on_detect_top[51] dac_config_0 dac_config_1 row_off_detect_top[50] x2_net13
+ dac_config_2 vdda1 vssa1 vssc1 col_event_rst_top_right[56] x2_net14
+ row_on_detect_top[50] row_off_detect_top[51] openDVS_pixel2x2_top
x2_x804 dac_config_3 dac_config_5 col_event_rst_top_right[55] dac_config_4
+ row_on_detect_top[51] dac_config_0 dac_config_1 row_off_detect_top[50] x2_net17
+ dac_config_2 vdda1 vssa1 vssc1 col_event_rst_top_right[54] x2_net18
+ row_on_detect_top[50] row_off_detect_top[51] openDVS_pixel2x2_top
x2_x805 dac_config_3 dac_config_5 col_event_rst_top_right[53] dac_config_4
+ row_on_detect_top[51] dac_config_0 dac_config_1 row_off_detect_top[50] x2_net21
+ dac_config_2 vdda1 vssa1 vssc1 col_event_rst_top_right[52] x2_net22
+ row_on_detect_top[50] row_off_detect_top[51] openDVS_pixel2x2_top
x2_x806 dac_config_3 dac_config_5 col_event_rst_top_right[51] dac_config_4
+ row_on_detect_top[51] dac_config_0 dac_config_1 row_off_detect_top[50] x2_net25
+ dac_config_2 vdda1 vssa1 vssc1 col_event_rst_top_right[50] x2_net26
+ row_on_detect_top[50] row_off_detect_top[51] openDVS_pixel2x2_top
x2_x807 dac_config_3 dac_config_5 col_event_rst_top_right[49] dac_config_4
+ row_on_detect_top[51] dac_config_0 dac_config_1 row_off_detect_top[50] x2_net29
+ dac_config_2 vdda1 vssa1 vssc1 col_event_rst_top_right[48] x2_net30
+ row_on_detect_top[50] row_off_detect_top[51] openDVS_pixel2x2_top
x2_x808 dac_config_3 dac_config_5 col_event_rst_top_right[47] dac_config_4
+ row_on_detect_top[51] dac_config_0 dac_config_1 row_off_detect_top[50] x2_net33
+ dac_config_2 vdda1 vssa1 vssc1 col_event_rst_top_right[46] x2_net34
+ row_on_detect_top[50] row_off_detect_top[51] openDVS_pixel2x2_top
x2_x809 dac_config_3 dac_config_5 col_event_rst_top_right[45] dac_config_4
+ row_on_detect_top[51] dac_config_0 dac_config_1 row_off_detect_top[50] x2_net37
+ dac_config_2 vdda1 vssa1 vssc1 col_event_rst_top_right[44] x2_net38
+ row_on_detect_top[50] row_off_detect_top[51] openDVS_pixel2x2_top
x2_x810 dac_config_3 dac_config_5 col_event_rst_top_right[43] dac_config_4
+ row_on_detect_top[51] dac_config_0 dac_config_1 row_off_detect_top[50] x2_net41
+ dac_config_2 vdda1 vssa1 vssc1 col_event_rst_top_right[42] x2_net42
+ row_on_detect_top[50] row_off_detect_top[51] openDVS_pixel2x2_top
x2_x811 dac_config_3 dac_config_5 col_event_rst_top_right[41] dac_config_4
+ row_on_detect_top[51] dac_config_0 dac_config_1 row_off_detect_top[50] x2_net45
+ dac_config_2 vdda1 vssa1 vssc1 col_event_rst_top_right[40] x2_net46
+ row_on_detect_top[50] row_off_detect_top[51] openDVS_pixel2x2_top
x2_x812 dac_config_3 dac_config_5 col_event_rst_top_right[39] dac_config_4
+ row_on_detect_top[51] dac_config_0 dac_config_1 row_off_detect_top[50] x2_net49
+ dac_config_2 vdda1 vssa1 vssc1 col_event_rst_top_right[38] x2_net50
+ row_on_detect_top[50] row_off_detect_top[51] openDVS_pixel2x2_top
x2_x813 dac_config_3 dac_config_5 col_event_rst_top_right[37] dac_config_4
+ row_on_detect_top[51] dac_config_0 dac_config_1 row_off_detect_top[50] x2_net53
+ dac_config_2 vdda1 vssa1 vssc1 col_event_rst_top_right[36] x2_net54
+ row_on_detect_top[50] row_off_detect_top[51] openDVS_pixel2x2_top
x2_x814 dac_config_3 dac_config_5 col_event_rst_top_right[35] dac_config_4
+ row_on_detect_top[51] dac_config_0 dac_config_1 row_off_detect_top[50] x2_net57
+ dac_config_2 vdda1 vssa1 vssc1 col_event_rst_top_right[34] x2_net58
+ row_on_detect_top[50] row_off_detect_top[51] openDVS_pixel2x2_top
x2_x815 dac_config_3 dac_config_5 col_event_rst_top_right[33] dac_config_4
+ row_on_detect_top[51] dac_config_0 dac_config_1 row_off_detect_top[50] x2_net61
+ dac_config_2 vdda1 vssa1 vssc1 col_event_rst_top_right[32] x2_net62
+ row_on_detect_top[50] row_off_detect_top[51] openDVS_pixel2x2_top
x2_x816 dac_config_3 dac_config_5 col_event_rst_top_right[31] dac_config_4
+ row_on_detect_top[51] dac_config_0 dac_config_1 row_off_detect_top[50] x2_net65
+ dac_config_2 vdda1 vssa1 vssc1 col_event_rst_top_right[30] x2_net66
+ row_on_detect_top[50] row_off_detect_top[51] openDVS_pixel2x2_top
x2_x817 dac_config_3 dac_config_5 col_event_rst_top_right[29] dac_config_4
+ row_on_detect_top[51] dac_config_0 dac_config_1 row_off_detect_top[50] x2_net69
+ dac_config_2 vdda1 vssa1 vssc1 col_event_rst_top_right[28] x2_net70
+ row_on_detect_top[50] row_off_detect_top[51] openDVS_pixel2x2_top
x2_x818 dac_config_3 dac_config_5 col_event_rst_top_right[27] dac_config_4
+ row_on_detect_top[51] dac_config_0 dac_config_1 row_off_detect_top[50] x2_net73
+ dac_config_2 vdda1 vssa1 vssc1 col_event_rst_top_right[26] x2_net74
+ row_on_detect_top[50] row_off_detect_top[51] openDVS_pixel2x2_top
x2_x819 dac_config_3 dac_config_5 col_event_rst_top_right[25] dac_config_4
+ row_on_detect_top[51] dac_config_0 dac_config_1 row_off_detect_top[50] x2_net77
+ dac_config_2 vdda1 vssa1 vssc1 col_event_rst_top_right[24] x2_net78
+ row_on_detect_top[50] row_off_detect_top[51] openDVS_pixel2x2_top
x2_x820 dac_config_3 dac_config_5 col_event_rst_top_right[23] dac_config_4
+ row_on_detect_top[51] dac_config_0 dac_config_1 row_off_detect_top[50] x2_net81
+ dac_config_2 vdda1 vssa1 vssc1 col_event_rst_top_right[22] x2_net82
+ row_on_detect_top[50] row_off_detect_top[51] openDVS_pixel2x2_top
x2_x821 dac_config_3 dac_config_5 col_event_rst_top_right[21] dac_config_4
+ row_on_detect_top[51] dac_config_0 dac_config_1 row_off_detect_top[50] x2_net85
+ dac_config_2 vdda1 vssa1 vssc1 col_event_rst_top_right[20] x2_net86
+ row_on_detect_top[50] row_off_detect_top[51] openDVS_pixel2x2_top
x2_x822 dac_config_3 dac_config_5 col_event_rst_top_right[19] dac_config_4
+ row_on_detect_top[51] dac_config_0 dac_config_1 row_off_detect_top[50] x2_net89
+ dac_config_2 vdda1 vssa1 vssc1 col_event_rst_top_right[18] x2_net90
+ row_on_detect_top[50] row_off_detect_top[51] openDVS_pixel2x2_top
x2_x823 dac_config_3 dac_config_5 col_event_rst_top_right[17] dac_config_4
+ row_on_detect_top[51] dac_config_0 dac_config_1 row_off_detect_top[50] x2_net93
+ dac_config_2 vdda1 vssa1 vssc1 col_event_rst_top_right[16] x2_net94
+ row_on_detect_top[50] row_off_detect_top[51] openDVS_pixel2x2_top
x2_x824 dac_config_3 dac_config_5 col_event_rst_top_right[15] dac_config_4
+ row_on_detect_top[51] dac_config_0 dac_config_1 row_off_detect_top[50] x2_net97
+ dac_config_2 vdda1 vssa1 vssc1 col_event_rst_top_right[14] x2_net98
+ row_on_detect_top[50] row_off_detect_top[51] openDVS_pixel2x2_top
x2_x825 dac_config_3 dac_config_5 col_event_rst_top_right[13] dac_config_4
+ row_on_detect_top[51] dac_config_0 dac_config_1 row_off_detect_top[50] x2_net101
+ dac_config_2 vdda1 vssa1 vssc1 col_event_rst_top_right[12] x2_net102
+ row_on_detect_top[50] row_off_detect_top[51] openDVS_pixel2x2_top
x2_x826 dac_config_3 dac_config_5 col_event_rst_top_right[11] dac_config_4
+ row_on_detect_top[51] dac_config_0 dac_config_1 row_off_detect_top[50] x2_net105
+ dac_config_2 vdda1 vssa1 vssc1 col_event_rst_top_right[10] x2_net106
+ row_on_detect_top[50] row_off_detect_top[51] openDVS_pixel2x2_top
x2_x827 dac_config_3 dac_config_5 col_event_rst_top_right[9] dac_config_4
+ row_on_detect_top[51] dac_config_0 dac_config_1 row_off_detect_top[50] x2_net109
+ dac_config_2 vdda1 vssa1 vssc1 col_event_rst_top_right[8] x2_net110
+ row_on_detect_top[50] row_off_detect_top[51] openDVS_pixel2x2_top
x2_x828 dac_config_3 dac_config_5 col_event_rst_top_right[7] dac_config_4
+ row_on_detect_top[51] dac_config_0 dac_config_1 row_off_detect_top[50] x2_net113
+ dac_config_2 vdda1 vssa1 vssc1 col_event_rst_top_right[6] x2_net114
+ row_on_detect_top[50] row_off_detect_top[51] openDVS_pixel2x2_top
x2_x829 dac_config_3 dac_config_5 col_event_rst_top_right[5] dac_config_4
+ row_on_detect_top[51] dac_config_0 dac_config_1 row_off_detect_top[50] x2_net117
+ dac_config_2 vdda1 vssa1 vssc1 col_event_rst_top_right[4] x2_net118
+ row_on_detect_top[50] row_off_detect_top[51] openDVS_pixel2x2_top
x2_x830 dac_config_3 dac_config_5 col_event_rst_top_right[3] dac_config_4
+ row_on_detect_top[51] dac_config_0 dac_config_1 row_off_detect_top[50] x2_net121
+ dac_config_2 vdda1 vssa1 vssc1 col_event_rst_top_right[2] x2_net122
+ row_on_detect_top[50] row_off_detect_top[51] openDVS_pixel2x2_top
x2_x831 dac_config_3 dac_config_5 col_event_rst_top_right[1] dac_config_4
+ row_on_detect_top[51] dac_config_0 dac_config_1 row_off_detect_top[50] x2_net125
+ dac_config_2 vdda1 vssa1 vssc1 col_event_rst_top_right[0] x2_net126
+ row_on_detect_top[50] row_off_detect_top[51] openDVS_pixel2x2_top
x2_x832 dac_config_3 dac_config_5 col_event_rst_top_right[63] dac_config_4
+ row_on_detect_top[53] dac_config_0 dac_config_1 row_off_detect_top[52] x2_net1
+ dac_config_2 vdda1 vssa1 vssc1 col_event_rst_top_right[62] x2_net2 row_on_detect_top[52]
+ row_off_detect_top[53] openDVS_pixel2x2_top
x2_x833 dac_config_3 dac_config_5 col_event_rst_top_right[61] dac_config_4
+ row_on_detect_top[53] dac_config_0 dac_config_1 row_off_detect_top[52] x2_net5
+ dac_config_2 vdda1 vssa1 vssc1 col_event_rst_top_right[60] x2_net6 row_on_detect_top[52]
+ row_off_detect_top[53] openDVS_pixel2x2_top
x2_x834 dac_config_3 dac_config_5 col_event_rst_top_right[59] dac_config_4
+ row_on_detect_top[53] dac_config_0 dac_config_1 row_off_detect_top[52] x2_net9
+ dac_config_2 vdda1 vssa1 vssc1 col_event_rst_top_right[58] x2_net10
+ row_on_detect_top[52] row_off_detect_top[53] openDVS_pixel2x2_top
x2_x835 dac_config_3 dac_config_5 col_event_rst_top_right[57] dac_config_4
+ row_on_detect_top[53] dac_config_0 dac_config_1 row_off_detect_top[52] x2_net13
+ dac_config_2 vdda1 vssa1 vssc1 col_event_rst_top_right[56] x2_net14
+ row_on_detect_top[52] row_off_detect_top[53] openDVS_pixel2x2_top
x2_x836 dac_config_3 dac_config_5 col_event_rst_top_right[55] dac_config_4
+ row_on_detect_top[53] dac_config_0 dac_config_1 row_off_detect_top[52] x2_net17
+ dac_config_2 vdda1 vssa1 vssc1 col_event_rst_top_right[54] x2_net18
+ row_on_detect_top[52] row_off_detect_top[53] openDVS_pixel2x2_top
x2_x837 dac_config_3 dac_config_5 col_event_rst_top_right[53] dac_config_4
+ row_on_detect_top[53] dac_config_0 dac_config_1 row_off_detect_top[52] x2_net21
+ dac_config_2 vdda1 vssa1 vssc1 col_event_rst_top_right[52] x2_net22
+ row_on_detect_top[52] row_off_detect_top[53] openDVS_pixel2x2_top
x2_x838 dac_config_3 dac_config_5 col_event_rst_top_right[51] dac_config_4
+ row_on_detect_top[53] dac_config_0 dac_config_1 row_off_detect_top[52] x2_net25
+ dac_config_2 vdda1 vssa1 vssc1 col_event_rst_top_right[50] x2_net26
+ row_on_detect_top[52] row_off_detect_top[53] openDVS_pixel2x2_top
x2_x839 dac_config_3 dac_config_5 col_event_rst_top_right[49] dac_config_4
+ row_on_detect_top[53] dac_config_0 dac_config_1 row_off_detect_top[52] x2_net29
+ dac_config_2 vdda1 vssa1 vssc1 col_event_rst_top_right[48] x2_net30
+ row_on_detect_top[52] row_off_detect_top[53] openDVS_pixel2x2_top
x2_x840 dac_config_3 dac_config_5 col_event_rst_top_right[47] dac_config_4
+ row_on_detect_top[53] dac_config_0 dac_config_1 row_off_detect_top[52] x2_net33
+ dac_config_2 vdda1 vssa1 vssc1 col_event_rst_top_right[46] x2_net34
+ row_on_detect_top[52] row_off_detect_top[53] openDVS_pixel2x2_top
x2_x841 dac_config_3 dac_config_5 col_event_rst_top_right[45] dac_config_4
+ row_on_detect_top[53] dac_config_0 dac_config_1 row_off_detect_top[52] x2_net37
+ dac_config_2 vdda1 vssa1 vssc1 col_event_rst_top_right[44] x2_net38
+ row_on_detect_top[52] row_off_detect_top[53] openDVS_pixel2x2_top
x2_x842 dac_config_3 dac_config_5 col_event_rst_top_right[43] dac_config_4
+ row_on_detect_top[53] dac_config_0 dac_config_1 row_off_detect_top[52] x2_net41
+ dac_config_2 vdda1 vssa1 vssc1 col_event_rst_top_right[42] x2_net42
+ row_on_detect_top[52] row_off_detect_top[53] openDVS_pixel2x2_top
x2_x843 dac_config_3 dac_config_5 col_event_rst_top_right[41] dac_config_4
+ row_on_detect_top[53] dac_config_0 dac_config_1 row_off_detect_top[52] x2_net45
+ dac_config_2 vdda1 vssa1 vssc1 col_event_rst_top_right[40] x2_net46
+ row_on_detect_top[52] row_off_detect_top[53] openDVS_pixel2x2_top
x2_x844 dac_config_3 dac_config_5 col_event_rst_top_right[39] dac_config_4
+ row_on_detect_top[53] dac_config_0 dac_config_1 row_off_detect_top[52] x2_net49
+ dac_config_2 vdda1 vssa1 vssc1 col_event_rst_top_right[38] x2_net50
+ row_on_detect_top[52] row_off_detect_top[53] openDVS_pixel2x2_top
x2_x845 dac_config_3 dac_config_5 col_event_rst_top_right[37] dac_config_4
+ row_on_detect_top[53] dac_config_0 dac_config_1 row_off_detect_top[52] x2_net53
+ dac_config_2 vdda1 vssa1 vssc1 col_event_rst_top_right[36] x2_net54
+ row_on_detect_top[52] row_off_detect_top[53] openDVS_pixel2x2_top
x2_x846 dac_config_3 dac_config_5 col_event_rst_top_right[35] dac_config_4
+ row_on_detect_top[53] dac_config_0 dac_config_1 row_off_detect_top[52] x2_net57
+ dac_config_2 vdda1 vssa1 vssc1 col_event_rst_top_right[34] x2_net58
+ row_on_detect_top[52] row_off_detect_top[53] openDVS_pixel2x2_top
x2_x847 dac_config_3 dac_config_5 col_event_rst_top_right[33] dac_config_4
+ row_on_detect_top[53] dac_config_0 dac_config_1 row_off_detect_top[52] x2_net61
+ dac_config_2 vdda1 vssa1 vssc1 col_event_rst_top_right[32] x2_net62
+ row_on_detect_top[52] row_off_detect_top[53] openDVS_pixel2x2_top
x2_x848 dac_config_3 dac_config_5 col_event_rst_top_right[31] dac_config_4
+ row_on_detect_top[53] dac_config_0 dac_config_1 row_off_detect_top[52] x2_net65
+ dac_config_2 vdda1 vssa1 vssc1 col_event_rst_top_right[30] x2_net66
+ row_on_detect_top[52] row_off_detect_top[53] openDVS_pixel2x2_top
x2_x849 dac_config_3 dac_config_5 col_event_rst_top_right[29] dac_config_4
+ row_on_detect_top[53] dac_config_0 dac_config_1 row_off_detect_top[52] x2_net69
+ dac_config_2 vdda1 vssa1 vssc1 col_event_rst_top_right[28] x2_net70
+ row_on_detect_top[52] row_off_detect_top[53] openDVS_pixel2x2_top
x2_x850 dac_config_3 dac_config_5 col_event_rst_top_right[27] dac_config_4
+ row_on_detect_top[53] dac_config_0 dac_config_1 row_off_detect_top[52] x2_net73
+ dac_config_2 vdda1 vssa1 vssc1 col_event_rst_top_right[26] x2_net74
+ row_on_detect_top[52] row_off_detect_top[53] openDVS_pixel2x2_top
x2_x851 dac_config_3 dac_config_5 col_event_rst_top_right[25] dac_config_4
+ row_on_detect_top[53] dac_config_0 dac_config_1 row_off_detect_top[52] x2_net77
+ dac_config_2 vdda1 vssa1 vssc1 col_event_rst_top_right[24] x2_net78
+ row_on_detect_top[52] row_off_detect_top[53] openDVS_pixel2x2_top
x2_x852 dac_config_3 dac_config_5 col_event_rst_top_right[23] dac_config_4
+ row_on_detect_top[53] dac_config_0 dac_config_1 row_off_detect_top[52] x2_net81
+ dac_config_2 vdda1 vssa1 vssc1 col_event_rst_top_right[22] x2_net82
+ row_on_detect_top[52] row_off_detect_top[53] openDVS_pixel2x2_top
x2_x853 dac_config_3 dac_config_5 col_event_rst_top_right[21] dac_config_4
+ row_on_detect_top[53] dac_config_0 dac_config_1 row_off_detect_top[52] x2_net85
+ dac_config_2 vdda1 vssa1 vssc1 col_event_rst_top_right[20] x2_net86
+ row_on_detect_top[52] row_off_detect_top[53] openDVS_pixel2x2_top
x2_x854 dac_config_3 dac_config_5 col_event_rst_top_right[19] dac_config_4
+ row_on_detect_top[53] dac_config_0 dac_config_1 row_off_detect_top[52] x2_net89
+ dac_config_2 vdda1 vssa1 vssc1 col_event_rst_top_right[18] x2_net90
+ row_on_detect_top[52] row_off_detect_top[53] openDVS_pixel2x2_top
x2_x855 dac_config_3 dac_config_5 col_event_rst_top_right[17] dac_config_4
+ row_on_detect_top[53] dac_config_0 dac_config_1 row_off_detect_top[52] x2_net93
+ dac_config_2 vdda1 vssa1 vssc1 col_event_rst_top_right[16] x2_net94
+ row_on_detect_top[52] row_off_detect_top[53] openDVS_pixel2x2_top
x2_x856 dac_config_3 dac_config_5 col_event_rst_top_right[15] dac_config_4
+ row_on_detect_top[53] dac_config_0 dac_config_1 row_off_detect_top[52] x2_net97
+ dac_config_2 vdda1 vssa1 vssc1 col_event_rst_top_right[14] x2_net98
+ row_on_detect_top[52] row_off_detect_top[53] openDVS_pixel2x2_top
x2_x857 dac_config_3 dac_config_5 col_event_rst_top_right[13] dac_config_4
+ row_on_detect_top[53] dac_config_0 dac_config_1 row_off_detect_top[52] x2_net101
+ dac_config_2 vdda1 vssa1 vssc1 col_event_rst_top_right[12] x2_net102
+ row_on_detect_top[52] row_off_detect_top[53] openDVS_pixel2x2_top
x2_x858 dac_config_3 dac_config_5 col_event_rst_top_right[11] dac_config_4
+ row_on_detect_top[53] dac_config_0 dac_config_1 row_off_detect_top[52] x2_net105
+ dac_config_2 vdda1 vssa1 vssc1 col_event_rst_top_right[10] x2_net106
+ row_on_detect_top[52] row_off_detect_top[53] openDVS_pixel2x2_top
x2_x859 dac_config_3 dac_config_5 col_event_rst_top_right[9] dac_config_4
+ row_on_detect_top[53] dac_config_0 dac_config_1 row_off_detect_top[52] x2_net109
+ dac_config_2 vdda1 vssa1 vssc1 col_event_rst_top_right[8] x2_net110
+ row_on_detect_top[52] row_off_detect_top[53] openDVS_pixel2x2_top
x2_x860 dac_config_3 dac_config_5 col_event_rst_top_right[7] dac_config_4
+ row_on_detect_top[53] dac_config_0 dac_config_1 row_off_detect_top[52] x2_net113
+ dac_config_2 vdda1 vssa1 vssc1 col_event_rst_top_right[6] x2_net114
+ row_on_detect_top[52] row_off_detect_top[53] openDVS_pixel2x2_top
x2_x861 dac_config_3 dac_config_5 col_event_rst_top_right[5] dac_config_4
+ row_on_detect_top[53] dac_config_0 dac_config_1 row_off_detect_top[52] x2_net117
+ dac_config_2 vdda1 vssa1 vssc1 col_event_rst_top_right[4] x2_net118
+ row_on_detect_top[52] row_off_detect_top[53] openDVS_pixel2x2_top
x2_x862 dac_config_3 dac_config_5 col_event_rst_top_right[3] dac_config_4
+ row_on_detect_top[53] dac_config_0 dac_config_1 row_off_detect_top[52] x2_net121
+ dac_config_2 vdda1 vssa1 vssc1 col_event_rst_top_right[2] x2_net122
+ row_on_detect_top[52] row_off_detect_top[53] openDVS_pixel2x2_top
x2_x863 dac_config_3 dac_config_5 col_event_rst_top_right[1] dac_config_4
+ row_on_detect_top[53] dac_config_0 dac_config_1 row_off_detect_top[52] x2_net125
+ dac_config_2 vdda1 vssa1 vssc1 col_event_rst_top_right[0] x2_net126
+ row_on_detect_top[52] row_off_detect_top[53] openDVS_pixel2x2_top
x2_x864 dac_config_3 dac_config_5 col_event_rst_top_right[63] dac_config_4
+ row_on_detect_top[55] dac_config_0 dac_config_1 row_off_detect_top[54] x2_net1
+ dac_config_2 vdda1 vssa1 vssc1 col_event_rst_top_right[62] x2_net2 row_on_detect_top[54]
+ row_off_detect_top[55] openDVS_pixel2x2_top
x2_x865 dac_config_3 dac_config_5 col_event_rst_top_right[61] dac_config_4
+ row_on_detect_top[55] dac_config_0 dac_config_1 row_off_detect_top[54] x2_net5
+ dac_config_2 vdda1 vssa1 vssc1 col_event_rst_top_right[60] x2_net6 row_on_detect_top[54]
+ row_off_detect_top[55] openDVS_pixel2x2_top
x2_x866 dac_config_3 dac_config_5 col_event_rst_top_right[59] dac_config_4
+ row_on_detect_top[55] dac_config_0 dac_config_1 row_off_detect_top[54] x2_net9
+ dac_config_2 vdda1 vssa1 vssc1 col_event_rst_top_right[58] x2_net10
+ row_on_detect_top[54] row_off_detect_top[55] openDVS_pixel2x2_top
x2_x867 dac_config_3 dac_config_5 col_event_rst_top_right[57] dac_config_4
+ row_on_detect_top[55] dac_config_0 dac_config_1 row_off_detect_top[54] x2_net13
+ dac_config_2 vdda1 vssa1 vssc1 col_event_rst_top_right[56] x2_net14
+ row_on_detect_top[54] row_off_detect_top[55] openDVS_pixel2x2_top
x2_x868 dac_config_3 dac_config_5 col_event_rst_top_right[55] dac_config_4
+ row_on_detect_top[55] dac_config_0 dac_config_1 row_off_detect_top[54] x2_net17
+ dac_config_2 vdda1 vssa1 vssc1 col_event_rst_top_right[54] x2_net18
+ row_on_detect_top[54] row_off_detect_top[55] openDVS_pixel2x2_top
x2_x869 dac_config_3 dac_config_5 col_event_rst_top_right[53] dac_config_4
+ row_on_detect_top[55] dac_config_0 dac_config_1 row_off_detect_top[54] x2_net21
+ dac_config_2 vdda1 vssa1 vssc1 col_event_rst_top_right[52] x2_net22
+ row_on_detect_top[54] row_off_detect_top[55] openDVS_pixel2x2_top
x2_x870 dac_config_3 dac_config_5 col_event_rst_top_right[51] dac_config_4
+ row_on_detect_top[55] dac_config_0 dac_config_1 row_off_detect_top[54] x2_net25
+ dac_config_2 vdda1 vssa1 vssc1 col_event_rst_top_right[50] x2_net26
+ row_on_detect_top[54] row_off_detect_top[55] openDVS_pixel2x2_top
x2_x871 dac_config_3 dac_config_5 col_event_rst_top_right[49] dac_config_4
+ row_on_detect_top[55] dac_config_0 dac_config_1 row_off_detect_top[54] x2_net29
+ dac_config_2 vdda1 vssa1 vssc1 col_event_rst_top_right[48] x2_net30
+ row_on_detect_top[54] row_off_detect_top[55] openDVS_pixel2x2_top
x2_x872 dac_config_3 dac_config_5 col_event_rst_top_right[47] dac_config_4
+ row_on_detect_top[55] dac_config_0 dac_config_1 row_off_detect_top[54] x2_net33
+ dac_config_2 vdda1 vssa1 vssc1 col_event_rst_top_right[46] x2_net34
+ row_on_detect_top[54] row_off_detect_top[55] openDVS_pixel2x2_top
x2_x873 dac_config_3 dac_config_5 col_event_rst_top_right[45] dac_config_4
+ row_on_detect_top[55] dac_config_0 dac_config_1 row_off_detect_top[54] x2_net37
+ dac_config_2 vdda1 vssa1 vssc1 col_event_rst_top_right[44] x2_net38
+ row_on_detect_top[54] row_off_detect_top[55] openDVS_pixel2x2_top
x2_x874 dac_config_3 dac_config_5 col_event_rst_top_right[43] dac_config_4
+ row_on_detect_top[55] dac_config_0 dac_config_1 row_off_detect_top[54] x2_net41
+ dac_config_2 vdda1 vssa1 vssc1 col_event_rst_top_right[42] x2_net42
+ row_on_detect_top[54] row_off_detect_top[55] openDVS_pixel2x2_top
x2_x875 dac_config_3 dac_config_5 col_event_rst_top_right[41] dac_config_4
+ row_on_detect_top[55] dac_config_0 dac_config_1 row_off_detect_top[54] x2_net45
+ dac_config_2 vdda1 vssa1 vssc1 col_event_rst_top_right[40] x2_net46
+ row_on_detect_top[54] row_off_detect_top[55] openDVS_pixel2x2_top
x2_x876 dac_config_3 dac_config_5 col_event_rst_top_right[39] dac_config_4
+ row_on_detect_top[55] dac_config_0 dac_config_1 row_off_detect_top[54] x2_net49
+ dac_config_2 vdda1 vssa1 vssc1 col_event_rst_top_right[38] x2_net50
+ row_on_detect_top[54] row_off_detect_top[55] openDVS_pixel2x2_top
x2_x877 dac_config_3 dac_config_5 col_event_rst_top_right[37] dac_config_4
+ row_on_detect_top[55] dac_config_0 dac_config_1 row_off_detect_top[54] x2_net53
+ dac_config_2 vdda1 vssa1 vssc1 col_event_rst_top_right[36] x2_net54
+ row_on_detect_top[54] row_off_detect_top[55] openDVS_pixel2x2_top
x2_x878 dac_config_3 dac_config_5 col_event_rst_top_right[35] dac_config_4
+ row_on_detect_top[55] dac_config_0 dac_config_1 row_off_detect_top[54] x2_net57
+ dac_config_2 vdda1 vssa1 vssc1 col_event_rst_top_right[34] x2_net58
+ row_on_detect_top[54] row_off_detect_top[55] openDVS_pixel2x2_top
x2_x879 dac_config_3 dac_config_5 col_event_rst_top_right[33] dac_config_4
+ row_on_detect_top[55] dac_config_0 dac_config_1 row_off_detect_top[54] x2_net61
+ dac_config_2 vdda1 vssa1 vssc1 col_event_rst_top_right[32] x2_net62
+ row_on_detect_top[54] row_off_detect_top[55] openDVS_pixel2x2_top
x2_x880 dac_config_3 dac_config_5 col_event_rst_top_right[31] dac_config_4
+ row_on_detect_top[55] dac_config_0 dac_config_1 row_off_detect_top[54] x2_net65
+ dac_config_2 vdda1 vssa1 vssc1 col_event_rst_top_right[30] x2_net66
+ row_on_detect_top[54] row_off_detect_top[55] openDVS_pixel2x2_top
x2_x881 dac_config_3 dac_config_5 col_event_rst_top_right[29] dac_config_4
+ row_on_detect_top[55] dac_config_0 dac_config_1 row_off_detect_top[54] x2_net69
+ dac_config_2 vdda1 vssa1 vssc1 col_event_rst_top_right[28] x2_net70
+ row_on_detect_top[54] row_off_detect_top[55] openDVS_pixel2x2_top
x2_x882 dac_config_3 dac_config_5 col_event_rst_top_right[27] dac_config_4
+ row_on_detect_top[55] dac_config_0 dac_config_1 row_off_detect_top[54] x2_net73
+ dac_config_2 vdda1 vssa1 vssc1 col_event_rst_top_right[26] x2_net74
+ row_on_detect_top[54] row_off_detect_top[55] openDVS_pixel2x2_top
x2_x883 dac_config_3 dac_config_5 col_event_rst_top_right[25] dac_config_4
+ row_on_detect_top[55] dac_config_0 dac_config_1 row_off_detect_top[54] x2_net77
+ dac_config_2 vdda1 vssa1 vssc1 col_event_rst_top_right[24] x2_net78
+ row_on_detect_top[54] row_off_detect_top[55] openDVS_pixel2x2_top
x2_x884 dac_config_3 dac_config_5 col_event_rst_top_right[23] dac_config_4
+ row_on_detect_top[55] dac_config_0 dac_config_1 row_off_detect_top[54] x2_net81
+ dac_config_2 vdda1 vssa1 vssc1 col_event_rst_top_right[22] x2_net82
+ row_on_detect_top[54] row_off_detect_top[55] openDVS_pixel2x2_top
x2_x885 dac_config_3 dac_config_5 col_event_rst_top_right[21] dac_config_4
+ row_on_detect_top[55] dac_config_0 dac_config_1 row_off_detect_top[54] x2_net85
+ dac_config_2 vdda1 vssa1 vssc1 col_event_rst_top_right[20] x2_net86
+ row_on_detect_top[54] row_off_detect_top[55] openDVS_pixel2x2_top
x2_x886 dac_config_3 dac_config_5 col_event_rst_top_right[19] dac_config_4
+ row_on_detect_top[55] dac_config_0 dac_config_1 row_off_detect_top[54] x2_net89
+ dac_config_2 vdda1 vssa1 vssc1 col_event_rst_top_right[18] x2_net90
+ row_on_detect_top[54] row_off_detect_top[55] openDVS_pixel2x2_top
x2_x887 dac_config_3 dac_config_5 col_event_rst_top_right[17] dac_config_4
+ row_on_detect_top[55] dac_config_0 dac_config_1 row_off_detect_top[54] x2_net93
+ dac_config_2 vdda1 vssa1 vssc1 col_event_rst_top_right[16] x2_net94
+ row_on_detect_top[54] row_off_detect_top[55] openDVS_pixel2x2_top
x2_x888 dac_config_3 dac_config_5 col_event_rst_top_right[15] dac_config_4
+ row_on_detect_top[55] dac_config_0 dac_config_1 row_off_detect_top[54] x2_net97
+ dac_config_2 vdda1 vssa1 vssc1 col_event_rst_top_right[14] x2_net98
+ row_on_detect_top[54] row_off_detect_top[55] openDVS_pixel2x2_top
x2_x889 dac_config_3 dac_config_5 col_event_rst_top_right[13] dac_config_4
+ row_on_detect_top[55] dac_config_0 dac_config_1 row_off_detect_top[54] x2_net101
+ dac_config_2 vdda1 vssa1 vssc1 col_event_rst_top_right[12] x2_net102
+ row_on_detect_top[54] row_off_detect_top[55] openDVS_pixel2x2_top
x2_x890 dac_config_3 dac_config_5 col_event_rst_top_right[11] dac_config_4
+ row_on_detect_top[55] dac_config_0 dac_config_1 row_off_detect_top[54] x2_net105
+ dac_config_2 vdda1 vssa1 vssc1 col_event_rst_top_right[10] x2_net106
+ row_on_detect_top[54] row_off_detect_top[55] openDVS_pixel2x2_top
x2_x891 dac_config_3 dac_config_5 col_event_rst_top_right[9] dac_config_4
+ row_on_detect_top[55] dac_config_0 dac_config_1 row_off_detect_top[54] x2_net109
+ dac_config_2 vdda1 vssa1 vssc1 col_event_rst_top_right[8] x2_net110
+ row_on_detect_top[54] row_off_detect_top[55] openDVS_pixel2x2_top
x2_x892 dac_config_3 dac_config_5 col_event_rst_top_right[7] dac_config_4
+ row_on_detect_top[55] dac_config_0 dac_config_1 row_off_detect_top[54] x2_net113
+ dac_config_2 vdda1 vssa1 vssc1 col_event_rst_top_right[6] x2_net114
+ row_on_detect_top[54] row_off_detect_top[55] openDVS_pixel2x2_top
x2_x893 dac_config_3 dac_config_5 col_event_rst_top_right[5] dac_config_4
+ row_on_detect_top[55] dac_config_0 dac_config_1 row_off_detect_top[54] x2_net117
+ dac_config_2 vdda1 vssa1 vssc1 col_event_rst_top_right[4] x2_net118
+ row_on_detect_top[54] row_off_detect_top[55] openDVS_pixel2x2_top
x2_x894 dac_config_3 dac_config_5 col_event_rst_top_right[3] dac_config_4
+ row_on_detect_top[55] dac_config_0 dac_config_1 row_off_detect_top[54] x2_net121
+ dac_config_2 vdda1 vssa1 vssc1 col_event_rst_top_right[2] x2_net122
+ row_on_detect_top[54] row_off_detect_top[55] openDVS_pixel2x2_top
x2_x895 dac_config_3 dac_config_5 col_event_rst_top_right[1] dac_config_4
+ row_on_detect_top[55] dac_config_0 dac_config_1 row_off_detect_top[54] x2_net125
+ dac_config_2 vdda1 vssa1 vssc1 col_event_rst_top_right[0] x2_net126
+ row_on_detect_top[54] row_off_detect_top[55] openDVS_pixel2x2_top
x2_x896 dac_config_3 dac_config_5 col_event_rst_top_right[63] dac_config_4
+ row_on_detect_top[57] dac_config_0 dac_config_1 row_off_detect_top[56] x2_net1
+ dac_config_2 vdda1 vssa1 vssc1 col_event_rst_top_right[62] x2_net2 row_on_detect_top[56]
+ row_off_detect_top[57] openDVS_pixel2x2_top
x2_x897 dac_config_3 dac_config_5 col_event_rst_top_right[61] dac_config_4
+ row_on_detect_top[57] dac_config_0 dac_config_1 row_off_detect_top[56] x2_net5
+ dac_config_2 vdda1 vssa1 vssc1 col_event_rst_top_right[60] x2_net6 row_on_detect_top[56]
+ row_off_detect_top[57] openDVS_pixel2x2_top
x2_x898 dac_config_3 dac_config_5 col_event_rst_top_right[59] dac_config_4
+ row_on_detect_top[57] dac_config_0 dac_config_1 row_off_detect_top[56] x2_net9
+ dac_config_2 vdda1 vssa1 vssc1 col_event_rst_top_right[58] x2_net10
+ row_on_detect_top[56] row_off_detect_top[57] openDVS_pixel2x2_top
x2_x899 dac_config_3 dac_config_5 col_event_rst_top_right[57] dac_config_4
+ row_on_detect_top[57] dac_config_0 dac_config_1 row_off_detect_top[56] x2_net13
+ dac_config_2 vdda1 vssa1 vssc1 col_event_rst_top_right[56] x2_net14
+ row_on_detect_top[56] row_off_detect_top[57] openDVS_pixel2x2_top
x2_x900 dac_config_3 dac_config_5 col_event_rst_top_right[55] dac_config_4
+ row_on_detect_top[57] dac_config_0 dac_config_1 row_off_detect_top[56] x2_net17
+ dac_config_2 vdda1 vssa1 vssc1 col_event_rst_top_right[54] x2_net18
+ row_on_detect_top[56] row_off_detect_top[57] openDVS_pixel2x2_top
x2_x901 dac_config_3 dac_config_5 col_event_rst_top_right[53] dac_config_4
+ row_on_detect_top[57] dac_config_0 dac_config_1 row_off_detect_top[56] x2_net21
+ dac_config_2 vdda1 vssa1 vssc1 col_event_rst_top_right[52] x2_net22
+ row_on_detect_top[56] row_off_detect_top[57] openDVS_pixel2x2_top
x2_x902 dac_config_3 dac_config_5 col_event_rst_top_right[51] dac_config_4
+ row_on_detect_top[57] dac_config_0 dac_config_1 row_off_detect_top[56] x2_net25
+ dac_config_2 vdda1 vssa1 vssc1 col_event_rst_top_right[50] x2_net26
+ row_on_detect_top[56] row_off_detect_top[57] openDVS_pixel2x2_top
x2_x903 dac_config_3 dac_config_5 col_event_rst_top_right[49] dac_config_4
+ row_on_detect_top[57] dac_config_0 dac_config_1 row_off_detect_top[56] x2_net29
+ dac_config_2 vdda1 vssa1 vssc1 col_event_rst_top_right[48] x2_net30
+ row_on_detect_top[56] row_off_detect_top[57] openDVS_pixel2x2_top
x2_x904 dac_config_3 dac_config_5 col_event_rst_top_right[47] dac_config_4
+ row_on_detect_top[57] dac_config_0 dac_config_1 row_off_detect_top[56] x2_net33
+ dac_config_2 vdda1 vssa1 vssc1 col_event_rst_top_right[46] x2_net34
+ row_on_detect_top[56] row_off_detect_top[57] openDVS_pixel2x2_top
x2_x905 dac_config_3 dac_config_5 col_event_rst_top_right[45] dac_config_4
+ row_on_detect_top[57] dac_config_0 dac_config_1 row_off_detect_top[56] x2_net37
+ dac_config_2 vdda1 vssa1 vssc1 col_event_rst_top_right[44] x2_net38
+ row_on_detect_top[56] row_off_detect_top[57] openDVS_pixel2x2_top
x2_x906 dac_config_3 dac_config_5 col_event_rst_top_right[43] dac_config_4
+ row_on_detect_top[57] dac_config_0 dac_config_1 row_off_detect_top[56] x2_net41
+ dac_config_2 vdda1 vssa1 vssc1 col_event_rst_top_right[42] x2_net42
+ row_on_detect_top[56] row_off_detect_top[57] openDVS_pixel2x2_top
x2_x907 dac_config_3 dac_config_5 col_event_rst_top_right[41] dac_config_4
+ row_on_detect_top[57] dac_config_0 dac_config_1 row_off_detect_top[56] x2_net45
+ dac_config_2 vdda1 vssa1 vssc1 col_event_rst_top_right[40] x2_net46
+ row_on_detect_top[56] row_off_detect_top[57] openDVS_pixel2x2_top
x2_x908 dac_config_3 dac_config_5 col_event_rst_top_right[39] dac_config_4
+ row_on_detect_top[57] dac_config_0 dac_config_1 row_off_detect_top[56] x2_net49
+ dac_config_2 vdda1 vssa1 vssc1 col_event_rst_top_right[38] x2_net50
+ row_on_detect_top[56] row_off_detect_top[57] openDVS_pixel2x2_top
x2_x909 dac_config_3 dac_config_5 col_event_rst_top_right[37] dac_config_4
+ row_on_detect_top[57] dac_config_0 dac_config_1 row_off_detect_top[56] x2_net53
+ dac_config_2 vdda1 vssa1 vssc1 col_event_rst_top_right[36] x2_net54
+ row_on_detect_top[56] row_off_detect_top[57] openDVS_pixel2x2_top
x2_x910 dac_config_3 dac_config_5 col_event_rst_top_right[35] dac_config_4
+ row_on_detect_top[57] dac_config_0 dac_config_1 row_off_detect_top[56] x2_net57
+ dac_config_2 vdda1 vssa1 vssc1 col_event_rst_top_right[34] x2_net58
+ row_on_detect_top[56] row_off_detect_top[57] openDVS_pixel2x2_top
x2_x911 dac_config_3 dac_config_5 col_event_rst_top_right[33] dac_config_4
+ row_on_detect_top[57] dac_config_0 dac_config_1 row_off_detect_top[56] x2_net61
+ dac_config_2 vdda1 vssa1 vssc1 col_event_rst_top_right[32] x2_net62
+ row_on_detect_top[56] row_off_detect_top[57] openDVS_pixel2x2_top
x2_x912 dac_config_3 dac_config_5 col_event_rst_top_right[31] dac_config_4
+ row_on_detect_top[57] dac_config_0 dac_config_1 row_off_detect_top[56] x2_net65
+ dac_config_2 vdda1 vssa1 vssc1 col_event_rst_top_right[30] x2_net66
+ row_on_detect_top[56] row_off_detect_top[57] openDVS_pixel2x2_top
x2_x913 dac_config_3 dac_config_5 col_event_rst_top_right[29] dac_config_4
+ row_on_detect_top[57] dac_config_0 dac_config_1 row_off_detect_top[56] x2_net69
+ dac_config_2 vdda1 vssa1 vssc1 col_event_rst_top_right[28] x2_net70
+ row_on_detect_top[56] row_off_detect_top[57] openDVS_pixel2x2_top
x2_x914 dac_config_3 dac_config_5 col_event_rst_top_right[27] dac_config_4
+ row_on_detect_top[57] dac_config_0 dac_config_1 row_off_detect_top[56] x2_net73
+ dac_config_2 vdda1 vssa1 vssc1 col_event_rst_top_right[26] x2_net74
+ row_on_detect_top[56] row_off_detect_top[57] openDVS_pixel2x2_top
x2_x915 dac_config_3 dac_config_5 col_event_rst_top_right[25] dac_config_4
+ row_on_detect_top[57] dac_config_0 dac_config_1 row_off_detect_top[56] x2_net77
+ dac_config_2 vdda1 vssa1 vssc1 col_event_rst_top_right[24] x2_net78
+ row_on_detect_top[56] row_off_detect_top[57] openDVS_pixel2x2_top
x2_x916 dac_config_3 dac_config_5 col_event_rst_top_right[23] dac_config_4
+ row_on_detect_top[57] dac_config_0 dac_config_1 row_off_detect_top[56] x2_net81
+ dac_config_2 vdda1 vssa1 vssc1 col_event_rst_top_right[22] x2_net82
+ row_on_detect_top[56] row_off_detect_top[57] openDVS_pixel2x2_top
x2_x917 dac_config_3 dac_config_5 col_event_rst_top_right[21] dac_config_4
+ row_on_detect_top[57] dac_config_0 dac_config_1 row_off_detect_top[56] x2_net85
+ dac_config_2 vdda1 vssa1 vssc1 col_event_rst_top_right[20] x2_net86
+ row_on_detect_top[56] row_off_detect_top[57] openDVS_pixel2x2_top
x2_x918 dac_config_3 dac_config_5 col_event_rst_top_right[19] dac_config_4
+ row_on_detect_top[57] dac_config_0 dac_config_1 row_off_detect_top[56] x2_net89
+ dac_config_2 vdda1 vssa1 vssc1 col_event_rst_top_right[18] x2_net90
+ row_on_detect_top[56] row_off_detect_top[57] openDVS_pixel2x2_top
x2_x919 dac_config_3 dac_config_5 col_event_rst_top_right[17] dac_config_4
+ row_on_detect_top[57] dac_config_0 dac_config_1 row_off_detect_top[56] x2_net93
+ dac_config_2 vdda1 vssa1 vssc1 col_event_rst_top_right[16] x2_net94
+ row_on_detect_top[56] row_off_detect_top[57] openDVS_pixel2x2_top
x2_x920 dac_config_3 dac_config_5 col_event_rst_top_right[15] dac_config_4
+ row_on_detect_top[57] dac_config_0 dac_config_1 row_off_detect_top[56] x2_net97
+ dac_config_2 vdda1 vssa1 vssc1 col_event_rst_top_right[14] x2_net98
+ row_on_detect_top[56] row_off_detect_top[57] openDVS_pixel2x2_top
x2_x921 dac_config_3 dac_config_5 col_event_rst_top_right[13] dac_config_4
+ row_on_detect_top[57] dac_config_0 dac_config_1 row_off_detect_top[56] x2_net101
+ dac_config_2 vdda1 vssa1 vssc1 col_event_rst_top_right[12] x2_net102
+ row_on_detect_top[56] row_off_detect_top[57] openDVS_pixel2x2_top
x2_x922 dac_config_3 dac_config_5 col_event_rst_top_right[11] dac_config_4
+ row_on_detect_top[57] dac_config_0 dac_config_1 row_off_detect_top[56] x2_net105
+ dac_config_2 vdda1 vssa1 vssc1 col_event_rst_top_right[10] x2_net106
+ row_on_detect_top[56] row_off_detect_top[57] openDVS_pixel2x2_top
x2_x923 dac_config_3 dac_config_5 col_event_rst_top_right[9] dac_config_4
+ row_on_detect_top[57] dac_config_0 dac_config_1 row_off_detect_top[56] x2_net109
+ dac_config_2 vdda1 vssa1 vssc1 col_event_rst_top_right[8] x2_net110
+ row_on_detect_top[56] row_off_detect_top[57] openDVS_pixel2x2_top
x2_x924 dac_config_3 dac_config_5 col_event_rst_top_right[7] dac_config_4
+ row_on_detect_top[57] dac_config_0 dac_config_1 row_off_detect_top[56] x2_net113
+ dac_config_2 vdda1 vssa1 vssc1 col_event_rst_top_right[6] x2_net114
+ row_on_detect_top[56] row_off_detect_top[57] openDVS_pixel2x2_top
x2_x925 dac_config_3 dac_config_5 col_event_rst_top_right[5] dac_config_4
+ row_on_detect_top[57] dac_config_0 dac_config_1 row_off_detect_top[56] x2_net117
+ dac_config_2 vdda1 vssa1 vssc1 col_event_rst_top_right[4] x2_net118
+ row_on_detect_top[56] row_off_detect_top[57] openDVS_pixel2x2_top
x2_x926 dac_config_3 dac_config_5 col_event_rst_top_right[3] dac_config_4
+ row_on_detect_top[57] dac_config_0 dac_config_1 row_off_detect_top[56] x2_net121
+ dac_config_2 vdda1 vssa1 vssc1 col_event_rst_top_right[2] x2_net122
+ row_on_detect_top[56] row_off_detect_top[57] openDVS_pixel2x2_top
x2_x927 dac_config_3 dac_config_5 col_event_rst_top_right[1] dac_config_4
+ row_on_detect_top[57] dac_config_0 dac_config_1 row_off_detect_top[56] x2_net125
+ dac_config_2 vdda1 vssa1 vssc1 col_event_rst_top_right[0] x2_net126
+ row_on_detect_top[56] row_off_detect_top[57] openDVS_pixel2x2_top
x2_x928 dac_config_3 dac_config_5 col_event_rst_top_right[63] dac_config_4
+ row_on_detect_top[59] dac_config_0 dac_config_1 row_off_detect_top[58] x2_net1
+ dac_config_2 vdda1 vssa1 vssc1 col_event_rst_top_right[62] x2_net2 row_on_detect_top[58]
+ row_off_detect_top[59] openDVS_pixel2x2_top
x2_x929 dac_config_3 dac_config_5 col_event_rst_top_right[61] dac_config_4
+ row_on_detect_top[59] dac_config_0 dac_config_1 row_off_detect_top[58] x2_net5
+ dac_config_2 vdda1 vssa1 vssc1 col_event_rst_top_right[60] x2_net6 row_on_detect_top[58]
+ row_off_detect_top[59] openDVS_pixel2x2_top
x2_x930 dac_config_3 dac_config_5 col_event_rst_top_right[59] dac_config_4
+ row_on_detect_top[59] dac_config_0 dac_config_1 row_off_detect_top[58] x2_net9
+ dac_config_2 vdda1 vssa1 vssc1 col_event_rst_top_right[58] x2_net10
+ row_on_detect_top[58] row_off_detect_top[59] openDVS_pixel2x2_top
x2_x931 dac_config_3 dac_config_5 col_event_rst_top_right[57] dac_config_4
+ row_on_detect_top[59] dac_config_0 dac_config_1 row_off_detect_top[58] x2_net13
+ dac_config_2 vdda1 vssa1 vssc1 col_event_rst_top_right[56] x2_net14
+ row_on_detect_top[58] row_off_detect_top[59] openDVS_pixel2x2_top
x2_x932 dac_config_3 dac_config_5 col_event_rst_top_right[55] dac_config_4
+ row_on_detect_top[59] dac_config_0 dac_config_1 row_off_detect_top[58] x2_net17
+ dac_config_2 vdda1 vssa1 vssc1 col_event_rst_top_right[54] x2_net18
+ row_on_detect_top[58] row_off_detect_top[59] openDVS_pixel2x2_top
x2_x933 dac_config_3 dac_config_5 col_event_rst_top_right[53] dac_config_4
+ row_on_detect_top[59] dac_config_0 dac_config_1 row_off_detect_top[58] x2_net21
+ dac_config_2 vdda1 vssa1 vssc1 col_event_rst_top_right[52] x2_net22
+ row_on_detect_top[58] row_off_detect_top[59] openDVS_pixel2x2_top
x2_x934 dac_config_3 dac_config_5 col_event_rst_top_right[51] dac_config_4
+ row_on_detect_top[59] dac_config_0 dac_config_1 row_off_detect_top[58] x2_net25
+ dac_config_2 vdda1 vssa1 vssc1 col_event_rst_top_right[50] x2_net26
+ row_on_detect_top[58] row_off_detect_top[59] openDVS_pixel2x2_top
x2_x935 dac_config_3 dac_config_5 col_event_rst_top_right[49] dac_config_4
+ row_on_detect_top[59] dac_config_0 dac_config_1 row_off_detect_top[58] x2_net29
+ dac_config_2 vdda1 vssa1 vssc1 col_event_rst_top_right[48] x2_net30
+ row_on_detect_top[58] row_off_detect_top[59] openDVS_pixel2x2_top
x2_x936 dac_config_3 dac_config_5 col_event_rst_top_right[47] dac_config_4
+ row_on_detect_top[59] dac_config_0 dac_config_1 row_off_detect_top[58] x2_net33
+ dac_config_2 vdda1 vssa1 vssc1 col_event_rst_top_right[46] x2_net34
+ row_on_detect_top[58] row_off_detect_top[59] openDVS_pixel2x2_top
x2_x937 dac_config_3 dac_config_5 col_event_rst_top_right[45] dac_config_4
+ row_on_detect_top[59] dac_config_0 dac_config_1 row_off_detect_top[58] x2_net37
+ dac_config_2 vdda1 vssa1 vssc1 col_event_rst_top_right[44] x2_net38
+ row_on_detect_top[58] row_off_detect_top[59] openDVS_pixel2x2_top
x2_x938 dac_config_3 dac_config_5 col_event_rst_top_right[43] dac_config_4
+ row_on_detect_top[59] dac_config_0 dac_config_1 row_off_detect_top[58] x2_net41
+ dac_config_2 vdda1 vssa1 vssc1 col_event_rst_top_right[42] x2_net42
+ row_on_detect_top[58] row_off_detect_top[59] openDVS_pixel2x2_top
x2_x939 dac_config_3 dac_config_5 col_event_rst_top_right[41] dac_config_4
+ row_on_detect_top[59] dac_config_0 dac_config_1 row_off_detect_top[58] x2_net45
+ dac_config_2 vdda1 vssa1 vssc1 col_event_rst_top_right[40] x2_net46
+ row_on_detect_top[58] row_off_detect_top[59] openDVS_pixel2x2_top
x2_x940 dac_config_3 dac_config_5 col_event_rst_top_right[39] dac_config_4
+ row_on_detect_top[59] dac_config_0 dac_config_1 row_off_detect_top[58] x2_net49
+ dac_config_2 vdda1 vssa1 vssc1 col_event_rst_top_right[38] x2_net50
+ row_on_detect_top[58] row_off_detect_top[59] openDVS_pixel2x2_top
x2_x941 dac_config_3 dac_config_5 col_event_rst_top_right[37] dac_config_4
+ row_on_detect_top[59] dac_config_0 dac_config_1 row_off_detect_top[58] x2_net53
+ dac_config_2 vdda1 vssa1 vssc1 col_event_rst_top_right[36] x2_net54
+ row_on_detect_top[58] row_off_detect_top[59] openDVS_pixel2x2_top
x2_x942 dac_config_3 dac_config_5 col_event_rst_top_right[35] dac_config_4
+ row_on_detect_top[59] dac_config_0 dac_config_1 row_off_detect_top[58] x2_net57
+ dac_config_2 vdda1 vssa1 vssc1 col_event_rst_top_right[34] x2_net58
+ row_on_detect_top[58] row_off_detect_top[59] openDVS_pixel2x2_top
x2_x943 dac_config_3 dac_config_5 col_event_rst_top_right[33] dac_config_4
+ row_on_detect_top[59] dac_config_0 dac_config_1 row_off_detect_top[58] x2_net61
+ dac_config_2 vdda1 vssa1 vssc1 col_event_rst_top_right[32] x2_net62
+ row_on_detect_top[58] row_off_detect_top[59] openDVS_pixel2x2_top
x2_x944 dac_config_3 dac_config_5 col_event_rst_top_right[31] dac_config_4
+ row_on_detect_top[59] dac_config_0 dac_config_1 row_off_detect_top[58] x2_net65
+ dac_config_2 vdda1 vssa1 vssc1 col_event_rst_top_right[30] x2_net66
+ row_on_detect_top[58] row_off_detect_top[59] openDVS_pixel2x2_top
x2_x945 dac_config_3 dac_config_5 col_event_rst_top_right[29] dac_config_4
+ row_on_detect_top[59] dac_config_0 dac_config_1 row_off_detect_top[58] x2_net69
+ dac_config_2 vdda1 vssa1 vssc1 col_event_rst_top_right[28] x2_net70
+ row_on_detect_top[58] row_off_detect_top[59] openDVS_pixel2x2_top
x2_x946 dac_config_3 dac_config_5 col_event_rst_top_right[27] dac_config_4
+ row_on_detect_top[59] dac_config_0 dac_config_1 row_off_detect_top[58] x2_net73
+ dac_config_2 vdda1 vssa1 vssc1 col_event_rst_top_right[26] x2_net74
+ row_on_detect_top[58] row_off_detect_top[59] openDVS_pixel2x2_top
x2_x947 dac_config_3 dac_config_5 col_event_rst_top_right[25] dac_config_4
+ row_on_detect_top[59] dac_config_0 dac_config_1 row_off_detect_top[58] x2_net77
+ dac_config_2 vdda1 vssa1 vssc1 col_event_rst_top_right[24] x2_net78
+ row_on_detect_top[58] row_off_detect_top[59] openDVS_pixel2x2_top
x2_x948 dac_config_3 dac_config_5 col_event_rst_top_right[23] dac_config_4
+ row_on_detect_top[59] dac_config_0 dac_config_1 row_off_detect_top[58] x2_net81
+ dac_config_2 vdda1 vssa1 vssc1 col_event_rst_top_right[22] x2_net82
+ row_on_detect_top[58] row_off_detect_top[59] openDVS_pixel2x2_top
x2_x949 dac_config_3 dac_config_5 col_event_rst_top_right[21] dac_config_4
+ row_on_detect_top[59] dac_config_0 dac_config_1 row_off_detect_top[58] x2_net85
+ dac_config_2 vdda1 vssa1 vssc1 col_event_rst_top_right[20] x2_net86
+ row_on_detect_top[58] row_off_detect_top[59] openDVS_pixel2x2_top
x2_x950 dac_config_3 dac_config_5 col_event_rst_top_right[19] dac_config_4
+ row_on_detect_top[59] dac_config_0 dac_config_1 row_off_detect_top[58] x2_net89
+ dac_config_2 vdda1 vssa1 vssc1 col_event_rst_top_right[18] x2_net90
+ row_on_detect_top[58] row_off_detect_top[59] openDVS_pixel2x2_top
x2_x951 dac_config_3 dac_config_5 col_event_rst_top_right[17] dac_config_4
+ row_on_detect_top[59] dac_config_0 dac_config_1 row_off_detect_top[58] x2_net93
+ dac_config_2 vdda1 vssa1 vssc1 col_event_rst_top_right[16] x2_net94
+ row_on_detect_top[58] row_off_detect_top[59] openDVS_pixel2x2_top
x2_x952 dac_config_3 dac_config_5 col_event_rst_top_right[15] dac_config_4
+ row_on_detect_top[59] dac_config_0 dac_config_1 row_off_detect_top[58] x2_net97
+ dac_config_2 vdda1 vssa1 vssc1 col_event_rst_top_right[14] x2_net98
+ row_on_detect_top[58] row_off_detect_top[59] openDVS_pixel2x2_top
x2_x953 dac_config_3 dac_config_5 col_event_rst_top_right[13] dac_config_4
+ row_on_detect_top[59] dac_config_0 dac_config_1 row_off_detect_top[58] x2_net101
+ dac_config_2 vdda1 vssa1 vssc1 col_event_rst_top_right[12] x2_net102
+ row_on_detect_top[58] row_off_detect_top[59] openDVS_pixel2x2_top
x2_x954 dac_config_3 dac_config_5 col_event_rst_top_right[11] dac_config_4
+ row_on_detect_top[59] dac_config_0 dac_config_1 row_off_detect_top[58] x2_net105
+ dac_config_2 vdda1 vssa1 vssc1 col_event_rst_top_right[10] x2_net106
+ row_on_detect_top[58] row_off_detect_top[59] openDVS_pixel2x2_top
x2_x955 dac_config_3 dac_config_5 col_event_rst_top_right[9] dac_config_4
+ row_on_detect_top[59] dac_config_0 dac_config_1 row_off_detect_top[58] x2_net109
+ dac_config_2 vdda1 vssa1 vssc1 col_event_rst_top_right[8] x2_net110
+ row_on_detect_top[58] row_off_detect_top[59] openDVS_pixel2x2_top
x2_x956 dac_config_3 dac_config_5 col_event_rst_top_right[7] dac_config_4
+ row_on_detect_top[59] dac_config_0 dac_config_1 row_off_detect_top[58] x2_net113
+ dac_config_2 vdda1 vssa1 vssc1 col_event_rst_top_right[6] x2_net114
+ row_on_detect_top[58] row_off_detect_top[59] openDVS_pixel2x2_top
x2_x957 dac_config_3 dac_config_5 col_event_rst_top_right[5] dac_config_4
+ row_on_detect_top[59] dac_config_0 dac_config_1 row_off_detect_top[58] x2_net117
+ dac_config_2 vdda1 vssa1 vssc1 col_event_rst_top_right[4] x2_net118
+ row_on_detect_top[58] row_off_detect_top[59] openDVS_pixel2x2_top
x2_x958 dac_config_3 dac_config_5 col_event_rst_top_right[3] dac_config_4
+ row_on_detect_top[59] dac_config_0 dac_config_1 row_off_detect_top[58] x2_net121
+ dac_config_2 vdda1 vssa1 vssc1 col_event_rst_top_right[2] x2_net122
+ row_on_detect_top[58] row_off_detect_top[59] openDVS_pixel2x2_top
x2_x959 dac_config_3 dac_config_5 col_event_rst_top_right[1] dac_config_4
+ row_on_detect_top[59] dac_config_0 dac_config_1 row_off_detect_top[58] x2_net125
+ dac_config_2 vdda1 vssa1 vssc1 col_event_rst_top_right[0] x2_net126
+ row_on_detect_top[58] row_off_detect_top[59] openDVS_pixel2x2_top
x2_x960 dac_config_3 dac_config_5 col_event_rst_top_right[63] dac_config_4
+ row_on_detect_top[61] dac_config_0 dac_config_1 row_off_detect_top[60] x2_net1
+ dac_config_2 vdda1 vssa1 vssc1 col_event_rst_top_right[62] x2_net2 row_on_detect_top[60]
+ row_off_detect_top[61] openDVS_pixel2x2_top
x2_x961 dac_config_3 dac_config_5 col_event_rst_top_right[61] dac_config_4
+ row_on_detect_top[61] dac_config_0 dac_config_1 row_off_detect_top[60] x2_net5
+ dac_config_2 vdda1 vssa1 vssc1 col_event_rst_top_right[60] x2_net6 row_on_detect_top[60]
+ row_off_detect_top[61] openDVS_pixel2x2_top
x2_x962 dac_config_3 dac_config_5 col_event_rst_top_right[59] dac_config_4
+ row_on_detect_top[61] dac_config_0 dac_config_1 row_off_detect_top[60] x2_net9
+ dac_config_2 vdda1 vssa1 vssc1 col_event_rst_top_right[58] x2_net10
+ row_on_detect_top[60] row_off_detect_top[61] openDVS_pixel2x2_top
x2_x963 dac_config_3 dac_config_5 col_event_rst_top_right[57] dac_config_4
+ row_on_detect_top[61] dac_config_0 dac_config_1 row_off_detect_top[60] x2_net13
+ dac_config_2 vdda1 vssa1 vssc1 col_event_rst_top_right[56] x2_net14
+ row_on_detect_top[60] row_off_detect_top[61] openDVS_pixel2x2_top
x2_x964 dac_config_3 dac_config_5 col_event_rst_top_right[55] dac_config_4
+ row_on_detect_top[61] dac_config_0 dac_config_1 row_off_detect_top[60] x2_net17
+ dac_config_2 vdda1 vssa1 vssc1 col_event_rst_top_right[54] x2_net18
+ row_on_detect_top[60] row_off_detect_top[61] openDVS_pixel2x2_top
x2_x965 dac_config_3 dac_config_5 col_event_rst_top_right[53] dac_config_4
+ row_on_detect_top[61] dac_config_0 dac_config_1 row_off_detect_top[60] x2_net21
+ dac_config_2 vdda1 vssa1 vssc1 col_event_rst_top_right[52] x2_net22
+ row_on_detect_top[60] row_off_detect_top[61] openDVS_pixel2x2_top
x2_x966 dac_config_3 dac_config_5 col_event_rst_top_right[51] dac_config_4
+ row_on_detect_top[61] dac_config_0 dac_config_1 row_off_detect_top[60] x2_net25
+ dac_config_2 vdda1 vssa1 vssc1 col_event_rst_top_right[50] x2_net26
+ row_on_detect_top[60] row_off_detect_top[61] openDVS_pixel2x2_top
x2_x967 dac_config_3 dac_config_5 col_event_rst_top_right[49] dac_config_4
+ row_on_detect_top[61] dac_config_0 dac_config_1 row_off_detect_top[60] x2_net29
+ dac_config_2 vdda1 vssa1 vssc1 col_event_rst_top_right[48] x2_net30
+ row_on_detect_top[60] row_off_detect_top[61] openDVS_pixel2x2_top
x2_x968 dac_config_3 dac_config_5 col_event_rst_top_right[47] dac_config_4
+ row_on_detect_top[61] dac_config_0 dac_config_1 row_off_detect_top[60] x2_net33
+ dac_config_2 vdda1 vssa1 vssc1 col_event_rst_top_right[46] x2_net34
+ row_on_detect_top[60] row_off_detect_top[61] openDVS_pixel2x2_top
x2_x969 dac_config_3 dac_config_5 col_event_rst_top_right[45] dac_config_4
+ row_on_detect_top[61] dac_config_0 dac_config_1 row_off_detect_top[60] x2_net37
+ dac_config_2 vdda1 vssa1 vssc1 col_event_rst_top_right[44] x2_net38
+ row_on_detect_top[60] row_off_detect_top[61] openDVS_pixel2x2_top
x2_x970 dac_config_3 dac_config_5 col_event_rst_top_right[43] dac_config_4
+ row_on_detect_top[61] dac_config_0 dac_config_1 row_off_detect_top[60] x2_net41
+ dac_config_2 vdda1 vssa1 vssc1 col_event_rst_top_right[42] x2_net42
+ row_on_detect_top[60] row_off_detect_top[61] openDVS_pixel2x2_top
x2_x971 dac_config_3 dac_config_5 col_event_rst_top_right[41] dac_config_4
+ row_on_detect_top[61] dac_config_0 dac_config_1 row_off_detect_top[60] x2_net45
+ dac_config_2 vdda1 vssa1 vssc1 col_event_rst_top_right[40] x2_net46
+ row_on_detect_top[60] row_off_detect_top[61] openDVS_pixel2x2_top
x2_x972 dac_config_3 dac_config_5 col_event_rst_top_right[39] dac_config_4
+ row_on_detect_top[61] dac_config_0 dac_config_1 row_off_detect_top[60] x2_net49
+ dac_config_2 vdda1 vssa1 vssc1 col_event_rst_top_right[38] x2_net50
+ row_on_detect_top[60] row_off_detect_top[61] openDVS_pixel2x2_top
x2_x973 dac_config_3 dac_config_5 col_event_rst_top_right[37] dac_config_4
+ row_on_detect_top[61] dac_config_0 dac_config_1 row_off_detect_top[60] x2_net53
+ dac_config_2 vdda1 vssa1 vssc1 col_event_rst_top_right[36] x2_net54
+ row_on_detect_top[60] row_off_detect_top[61] openDVS_pixel2x2_top
x2_x974 dac_config_3 dac_config_5 col_event_rst_top_right[35] dac_config_4
+ row_on_detect_top[61] dac_config_0 dac_config_1 row_off_detect_top[60] x2_net57
+ dac_config_2 vdda1 vssa1 vssc1 col_event_rst_top_right[34] x2_net58
+ row_on_detect_top[60] row_off_detect_top[61] openDVS_pixel2x2_top
x2_x975 dac_config_3 dac_config_5 col_event_rst_top_right[33] dac_config_4
+ row_on_detect_top[61] dac_config_0 dac_config_1 row_off_detect_top[60] x2_net61
+ dac_config_2 vdda1 vssa1 vssc1 col_event_rst_top_right[32] x2_net62
+ row_on_detect_top[60] row_off_detect_top[61] openDVS_pixel2x2_top
x2_x976 dac_config_3 dac_config_5 col_event_rst_top_right[31] dac_config_4
+ row_on_detect_top[61] dac_config_0 dac_config_1 row_off_detect_top[60] x2_net65
+ dac_config_2 vdda1 vssa1 vssc1 col_event_rst_top_right[30] x2_net66
+ row_on_detect_top[60] row_off_detect_top[61] openDVS_pixel2x2_top
x2_x977 dac_config_3 dac_config_5 col_event_rst_top_right[29] dac_config_4
+ row_on_detect_top[61] dac_config_0 dac_config_1 row_off_detect_top[60] x2_net69
+ dac_config_2 vdda1 vssa1 vssc1 col_event_rst_top_right[28] x2_net70
+ row_on_detect_top[60] row_off_detect_top[61] openDVS_pixel2x2_top
x2_x978 dac_config_3 dac_config_5 col_event_rst_top_right[27] dac_config_4
+ row_on_detect_top[61] dac_config_0 dac_config_1 row_off_detect_top[60] x2_net73
+ dac_config_2 vdda1 vssa1 vssc1 col_event_rst_top_right[26] x2_net74
+ row_on_detect_top[60] row_off_detect_top[61] openDVS_pixel2x2_top
x2_x979 dac_config_3 dac_config_5 col_event_rst_top_right[25] dac_config_4
+ row_on_detect_top[61] dac_config_0 dac_config_1 row_off_detect_top[60] x2_net77
+ dac_config_2 vdda1 vssa1 vssc1 col_event_rst_top_right[24] x2_net78
+ row_on_detect_top[60] row_off_detect_top[61] openDVS_pixel2x2_top
x2_x980 dac_config_3 dac_config_5 col_event_rst_top_right[23] dac_config_4
+ row_on_detect_top[61] dac_config_0 dac_config_1 row_off_detect_top[60] x2_net81
+ dac_config_2 vdda1 vssa1 vssc1 col_event_rst_top_right[22] x2_net82
+ row_on_detect_top[60] row_off_detect_top[61] openDVS_pixel2x2_top
x2_x981 dac_config_3 dac_config_5 col_event_rst_top_right[21] dac_config_4
+ row_on_detect_top[61] dac_config_0 dac_config_1 row_off_detect_top[60] x2_net85
+ dac_config_2 vdda1 vssa1 vssc1 col_event_rst_top_right[20] x2_net86
+ row_on_detect_top[60] row_off_detect_top[61] openDVS_pixel2x2_top
x2_x982 dac_config_3 dac_config_5 col_event_rst_top_right[19] dac_config_4
+ row_on_detect_top[61] dac_config_0 dac_config_1 row_off_detect_top[60] x2_net89
+ dac_config_2 vdda1 vssa1 vssc1 col_event_rst_top_right[18] x2_net90
+ row_on_detect_top[60] row_off_detect_top[61] openDVS_pixel2x2_top
x2_x983 dac_config_3 dac_config_5 col_event_rst_top_right[17] dac_config_4
+ row_on_detect_top[61] dac_config_0 dac_config_1 row_off_detect_top[60] x2_net93
+ dac_config_2 vdda1 vssa1 vssc1 col_event_rst_top_right[16] x2_net94
+ row_on_detect_top[60] row_off_detect_top[61] openDVS_pixel2x2_top
x2_x984 dac_config_3 dac_config_5 col_event_rst_top_right[15] dac_config_4
+ row_on_detect_top[61] dac_config_0 dac_config_1 row_off_detect_top[60] x2_net97
+ dac_config_2 vdda1 vssa1 vssc1 col_event_rst_top_right[14] x2_net98
+ row_on_detect_top[60] row_off_detect_top[61] openDVS_pixel2x2_top
x2_x985 dac_config_3 dac_config_5 col_event_rst_top_right[13] dac_config_4
+ row_on_detect_top[61] dac_config_0 dac_config_1 row_off_detect_top[60] x2_net101
+ dac_config_2 vdda1 vssa1 vssc1 col_event_rst_top_right[12] x2_net102
+ row_on_detect_top[60] row_off_detect_top[61] openDVS_pixel2x2_top
x2_x986 dac_config_3 dac_config_5 col_event_rst_top_right[11] dac_config_4
+ row_on_detect_top[61] dac_config_0 dac_config_1 row_off_detect_top[60] x2_net105
+ dac_config_2 vdda1 vssa1 vssc1 col_event_rst_top_right[10] x2_net106
+ row_on_detect_top[60] row_off_detect_top[61] openDVS_pixel2x2_top
x2_x987 dac_config_3 dac_config_5 col_event_rst_top_right[9] dac_config_4
+ row_on_detect_top[61] dac_config_0 dac_config_1 row_off_detect_top[60] x2_net109
+ dac_config_2 vdda1 vssa1 vssc1 col_event_rst_top_right[8] x2_net110
+ row_on_detect_top[60] row_off_detect_top[61] openDVS_pixel2x2_top
x2_x988 dac_config_3 dac_config_5 col_event_rst_top_right[7] dac_config_4
+ row_on_detect_top[61] dac_config_0 dac_config_1 row_off_detect_top[60] x2_net113
+ dac_config_2 vdda1 vssa1 vssc1 col_event_rst_top_right[6] x2_net114
+ row_on_detect_top[60] row_off_detect_top[61] openDVS_pixel2x2_top
x2_x989 dac_config_3 dac_config_5 col_event_rst_top_right[5] dac_config_4
+ row_on_detect_top[61] dac_config_0 dac_config_1 row_off_detect_top[60] x2_net117
+ dac_config_2 vdda1 vssa1 vssc1 col_event_rst_top_right[4] x2_net118
+ row_on_detect_top[60] row_off_detect_top[61] openDVS_pixel2x2_top
x2_x990 dac_config_3 dac_config_5 col_event_rst_top_right[3] dac_config_4
+ row_on_detect_top[61] dac_config_0 dac_config_1 row_off_detect_top[60] x2_net121
+ dac_config_2 vdda1 vssa1 vssc1 col_event_rst_top_right[2] x2_net122
+ row_on_detect_top[60] row_off_detect_top[61] openDVS_pixel2x2_top
x2_x991 dac_config_3 dac_config_5 col_event_rst_top_right[1] dac_config_4
+ row_on_detect_top[61] dac_config_0 dac_config_1 row_off_detect_top[60] x2_net125
+ dac_config_2 vdda1 vssa1 vssc1 col_event_rst_top_right[0] x2_net126
+ row_on_detect_top[60] row_off_detect_top[61] openDVS_pixel2x2_top
x2_x992 dac_config_3 dac_config_5 col_event_rst_top_right[63] dac_config_4
+ row_on_detect_top[63] dac_config_0 dac_config_1 row_off_detect_top[62] x2_net1
+ dac_config_2 vdda1 vssa1 vssc1 col_event_rst_top_right[62] x2_net2 row_on_detect_top[62]
+ row_off_detect_top[63] openDVS_pixel2x2_top
x2_x993 dac_config_3 dac_config_5 col_event_rst_top_right[61] dac_config_4
+ row_on_detect_top[63] dac_config_0 dac_config_1 row_off_detect_top[62] x2_net5
+ dac_config_2 vdda1 vssa1 vssc1 col_event_rst_top_right[60] x2_net6 row_on_detect_top[62]
+ row_off_detect_top[63] openDVS_pixel2x2_top
x2_x994 dac_config_3 dac_config_5 col_event_rst_top_right[59] dac_config_4
+ row_on_detect_top[63] dac_config_0 dac_config_1 row_off_detect_top[62] x2_net9
+ dac_config_2 vdda1 vssa1 vssc1 col_event_rst_top_right[58] x2_net10
+ row_on_detect_top[62] row_off_detect_top[63] openDVS_pixel2x2_top
x2_x995 dac_config_3 dac_config_5 col_event_rst_top_right[57] dac_config_4
+ row_on_detect_top[63] dac_config_0 dac_config_1 row_off_detect_top[62] x2_net13
+ dac_config_2 vdda1 vssa1 vssc1 col_event_rst_top_right[56] x2_net14
+ row_on_detect_top[62] row_off_detect_top[63] openDVS_pixel2x2_top
x2_x996 dac_config_3 dac_config_5 col_event_rst_top_right[55] dac_config_4
+ row_on_detect_top[63] dac_config_0 dac_config_1 row_off_detect_top[62] x2_net17
+ dac_config_2 vdda1 vssa1 vssc1 col_event_rst_top_right[54] x2_net18
+ row_on_detect_top[62] row_off_detect_top[63] openDVS_pixel2x2_top
x2_x997 dac_config_3 dac_config_5 col_event_rst_top_right[53] dac_config_4
+ row_on_detect_top[63] dac_config_0 dac_config_1 row_off_detect_top[62] x2_net21
+ dac_config_2 vdda1 vssa1 vssc1 col_event_rst_top_right[52] x2_net22
+ row_on_detect_top[62] row_off_detect_top[63] openDVS_pixel2x2_top
x2_x998 dac_config_3 dac_config_5 col_event_rst_top_right[51] dac_config_4
+ row_on_detect_top[63] dac_config_0 dac_config_1 row_off_detect_top[62] x2_net25
+ dac_config_2 vdda1 vssa1 vssc1 col_event_rst_top_right[50] x2_net26
+ row_on_detect_top[62] row_off_detect_top[63] openDVS_pixel2x2_top
x2_x999 dac_config_3 dac_config_5 col_event_rst_top_right[49] dac_config_4
+ row_on_detect_top[63] dac_config_0 dac_config_1 row_off_detect_top[62] x2_net29
+ dac_config_2 vdda1 vssa1 vssc1 col_event_rst_top_right[48] x2_net30
+ row_on_detect_top[62] row_off_detect_top[63] openDVS_pixel2x2_top
x2_x1000 dac_config_3 dac_config_5 col_event_rst_top_right[47] dac_config_4
+ row_on_detect_top[63] dac_config_0 dac_config_1 row_off_detect_top[62] x2_net33
+ dac_config_2 vdda1 vssa1 vssc1 col_event_rst_top_right[46] x2_net34
+ row_on_detect_top[62] row_off_detect_top[63] openDVS_pixel2x2_top
x2_x1001 dac_config_3 dac_config_5 col_event_rst_top_right[45] dac_config_4
+ row_on_detect_top[63] dac_config_0 dac_config_1 row_off_detect_top[62] x2_net37
+ dac_config_2 vdda1 vssa1 vssc1 col_event_rst_top_right[44] x2_net38
+ row_on_detect_top[62] row_off_detect_top[63] openDVS_pixel2x2_top
x2_x1002 dac_config_3 dac_config_5 col_event_rst_top_right[43] dac_config_4
+ row_on_detect_top[63] dac_config_0 dac_config_1 row_off_detect_top[62] x2_net41
+ dac_config_2 vdda1 vssa1 vssc1 col_event_rst_top_right[42] x2_net42
+ row_on_detect_top[62] row_off_detect_top[63] openDVS_pixel2x2_top
x2_x1003 dac_config_3 dac_config_5 col_event_rst_top_right[41] dac_config_4
+ row_on_detect_top[63] dac_config_0 dac_config_1 row_off_detect_top[62] x2_net45
+ dac_config_2 vdda1 vssa1 vssc1 col_event_rst_top_right[40] x2_net46
+ row_on_detect_top[62] row_off_detect_top[63] openDVS_pixel2x2_top
x2_x1004 dac_config_3 dac_config_5 col_event_rst_top_right[39] dac_config_4
+ row_on_detect_top[63] dac_config_0 dac_config_1 row_off_detect_top[62] x2_net49
+ dac_config_2 vdda1 vssa1 vssc1 col_event_rst_top_right[38] x2_net50
+ row_on_detect_top[62] row_off_detect_top[63] openDVS_pixel2x2_top
x2_x1005 dac_config_3 dac_config_5 col_event_rst_top_right[37] dac_config_4
+ row_on_detect_top[63] dac_config_0 dac_config_1 row_off_detect_top[62] x2_net53
+ dac_config_2 vdda1 vssa1 vssc1 col_event_rst_top_right[36] x2_net54
+ row_on_detect_top[62] row_off_detect_top[63] openDVS_pixel2x2_top
x2_x1006 dac_config_3 dac_config_5 col_event_rst_top_right[35] dac_config_4
+ row_on_detect_top[63] dac_config_0 dac_config_1 row_off_detect_top[62] x2_net57
+ dac_config_2 vdda1 vssa1 vssc1 col_event_rst_top_right[34] x2_net58
+ row_on_detect_top[62] row_off_detect_top[63] openDVS_pixel2x2_top
x2_x1007 dac_config_3 dac_config_5 col_event_rst_top_right[33] dac_config_4
+ row_on_detect_top[63] dac_config_0 dac_config_1 row_off_detect_top[62] x2_net61
+ dac_config_2 vdda1 vssa1 vssc1 col_event_rst_top_right[32] x2_net62
+ row_on_detect_top[62] row_off_detect_top[63] openDVS_pixel2x2_top
x2_x1008 dac_config_3 dac_config_5 col_event_rst_top_right[31] dac_config_4
+ row_on_detect_top[63] dac_config_0 dac_config_1 row_off_detect_top[62] x2_net65
+ dac_config_2 vdda1 vssa1 vssc1 col_event_rst_top_right[30] x2_net66
+ row_on_detect_top[62] row_off_detect_top[63] openDVS_pixel2x2_top
x2_x1009 dac_config_3 dac_config_5 col_event_rst_top_right[29] dac_config_4
+ row_on_detect_top[63] dac_config_0 dac_config_1 row_off_detect_top[62] x2_net69
+ dac_config_2 vdda1 vssa1 vssc1 col_event_rst_top_right[28] x2_net70
+ row_on_detect_top[62] row_off_detect_top[63] openDVS_pixel2x2_top
x2_x1010 dac_config_3 dac_config_5 col_event_rst_top_right[27] dac_config_4
+ row_on_detect_top[63] dac_config_0 dac_config_1 row_off_detect_top[62] x2_net73
+ dac_config_2 vdda1 vssa1 vssc1 col_event_rst_top_right[26] x2_net74
+ row_on_detect_top[62] row_off_detect_top[63] openDVS_pixel2x2_top
x2_x1011 dac_config_3 dac_config_5 col_event_rst_top_right[25] dac_config_4
+ row_on_detect_top[63] dac_config_0 dac_config_1 row_off_detect_top[62] x2_net77
+ dac_config_2 vdda1 vssa1 vssc1 col_event_rst_top_right[24] x2_net78
+ row_on_detect_top[62] row_off_detect_top[63] openDVS_pixel2x2_top
x2_x1012 dac_config_3 dac_config_5 col_event_rst_top_right[23] dac_config_4
+ row_on_detect_top[63] dac_config_0 dac_config_1 row_off_detect_top[62] x2_net81
+ dac_config_2 vdda1 vssa1 vssc1 col_event_rst_top_right[22] x2_net82
+ row_on_detect_top[62] row_off_detect_top[63] openDVS_pixel2x2_top
x2_x1013 dac_config_3 dac_config_5 col_event_rst_top_right[21] dac_config_4
+ row_on_detect_top[63] dac_config_0 dac_config_1 row_off_detect_top[62] x2_net85
+ dac_config_2 vdda1 vssa1 vssc1 col_event_rst_top_right[20] x2_net86
+ row_on_detect_top[62] row_off_detect_top[63] openDVS_pixel2x2_top
x2_x1014 dac_config_3 dac_config_5 col_event_rst_top_right[19] dac_config_4
+ row_on_detect_top[63] dac_config_0 dac_config_1 row_off_detect_top[62] x2_net89
+ dac_config_2 vdda1 vssa1 vssc1 col_event_rst_top_right[18] x2_net90
+ row_on_detect_top[62] row_off_detect_top[63] openDVS_pixel2x2_top
x2_x1015 dac_config_3 dac_config_5 col_event_rst_top_right[17] dac_config_4
+ row_on_detect_top[63] dac_config_0 dac_config_1 row_off_detect_top[62] x2_net93
+ dac_config_2 vdda1 vssa1 vssc1 col_event_rst_top_right[16] x2_net94
+ row_on_detect_top[62] row_off_detect_top[63] openDVS_pixel2x2_top
x2_x1016 dac_config_3 dac_config_5 col_event_rst_top_right[15] dac_config_4
+ row_on_detect_top[63] dac_config_0 dac_config_1 row_off_detect_top[62] x2_net97
+ dac_config_2 vdda1 vssa1 vssc1 col_event_rst_top_right[14] x2_net98
+ row_on_detect_top[62] row_off_detect_top[63] openDVS_pixel2x2_top
x2_x1017 dac_config_3 dac_config_5 col_event_rst_top_right[13] dac_config_4
+ row_on_detect_top[63] dac_config_0 dac_config_1 row_off_detect_top[62] x2_net101
+ dac_config_2 vdda1 vssa1 vssc1 col_event_rst_top_right[12] x2_net102
+ row_on_detect_top[62] row_off_detect_top[63] openDVS_pixel2x2_top
x2_x1018 dac_config_3 dac_config_5 col_event_rst_top_right[11] dac_config_4
+ row_on_detect_top[63] dac_config_0 dac_config_1 row_off_detect_top[62] x2_net105
+ dac_config_2 vdda1 vssa1 vssc1 col_event_rst_top_right[10] x2_net106
+ row_on_detect_top[62] row_off_detect_top[63] openDVS_pixel2x2_top
x2_x1019 dac_config_3 dac_config_5 col_event_rst_top_right[9] dac_config_4
+ row_on_detect_top[63] dac_config_0 dac_config_1 row_off_detect_top[62] x2_net109
+ dac_config_2 vdda1 vssa1 vssc1 col_event_rst_top_right[8] x2_net110
+ row_on_detect_top[62] row_off_detect_top[63] openDVS_pixel2x2_top
x2_x1020 dac_config_3 dac_config_5 col_event_rst_top_right[7] dac_config_4
+ row_on_detect_top[63] dac_config_0 dac_config_1 row_off_detect_top[62] x2_net113
+ dac_config_2 vdda1 vssa1 vssc1 col_event_rst_top_right[6] x2_net114
+ row_on_detect_top[62] row_off_detect_top[63] openDVS_pixel2x2_top
x2_x1021 dac_config_3 dac_config_5 col_event_rst_top_right[5] dac_config_4
+ row_on_detect_top[63] dac_config_0 dac_config_1 row_off_detect_top[62] x2_net117
+ dac_config_2 vdda1 vssa1 vssc1 col_event_rst_top_right[4] x2_net118
+ row_on_detect_top[62] row_off_detect_top[63] openDVS_pixel2x2_top
x2_x1022 dac_config_3 dac_config_5 col_event_rst_top_right[3] dac_config_4
+ row_on_detect_top[63] dac_config_0 dac_config_1 row_off_detect_top[62] x2_net121
+ dac_config_2 vdda1 vssa1 vssc1 col_event_rst_top_right[2] x2_net122
+ row_on_detect_top[62] row_off_detect_top[63] openDVS_pixel2x2_top
x2_x1023 dac_config_3 dac_config_5 col_event_rst_top_right[1] dac_config_4
+ row_on_detect_top[63] dac_config_0 dac_config_1 row_off_detect_top[62] x2_net125
+ dac_config_2 vdda1 vssa1 vssc1 col_event_rst_top_right[0] x2_net126
+ row_on_detect_top[62] row_off_detect_top[63] openDVS_pixel2x2_top
x2_x1088 detect_pulse_global_top_left ndetect_pulse_global_top_left dac_config_6
+ pre_charge_global_top_left vdda1 vssa1 x2_net1 x2_net2 array_col_top_right[63]
+ array_col_top_right[62] col_event_rst_top_right[62] col_event_rst_top_right[63]
+ col_amp_2x1
x2_x1089 detect_pulse_global_top_left ndetect_pulse_global_top_left dac_config_6
+ pre_charge_global_top_left vdda1 vssa1 x2_net5 x2_net6 array_col_top_right[61]
+ array_col_top_right[60] col_event_rst_top_right[60] col_event_rst_top_right[61]
+ col_amp_2x1
x2_x1090 detect_pulse_global_top_left ndetect_pulse_global_top_left dac_config_6
+ pre_charge_global_top_left vdda1 vssa1 x2_net9 x2_net10 array_col_top_right[59]
+ array_col_top_right[58] col_event_rst_top_right[58] col_event_rst_top_right[59]
+ col_amp_2x1
x2_x1091 detect_pulse_global_top_left ndetect_pulse_global_top_left dac_config_6
+ pre_charge_global_top_left vdda1 vssa1 x2_net13 x2_net14 array_col_top_right[57]
+ array_col_top_right[56] col_event_rst_top_right[56] col_event_rst_top_right[57]
+ col_amp_2x1
x2_x1092 detect_pulse_global_top_left ndetect_pulse_global_top_left dac_config_6
+ pre_charge_global_top_left vdda1 vssa1 x2_net17 x2_net18 array_col_top_right[55]
+ array_col_top_right[54] col_event_rst_top_right[54] col_event_rst_top_right[55]
+ col_amp_2x1
x2_x1093 detect_pulse_global_top_left ndetect_pulse_global_top_left dac_config_6
+ pre_charge_global_top_left vdda1 vssa1 x2_net21 x2_net22 array_col_top_right[53]
+ array_col_top_right[52] col_event_rst_top_right[52] col_event_rst_top_right[53]
+ col_amp_2x1
x2_x1094 detect_pulse_global_top_left ndetect_pulse_global_top_left dac_config_6
+ pre_charge_global_top_left vdda1 vssa1 x2_net25 x2_net26 array_col_top_right[51]
+ array_col_top_right[50] col_event_rst_top_right[50] col_event_rst_top_right[51]
+ col_amp_2x1
x2_x1095 detect_pulse_global_top_left ndetect_pulse_global_top_left dac_config_6
+ pre_charge_global_top_left vdda1 vssa1 x2_net29 x2_net30 array_col_top_right[49]
+ array_col_top_right[48] col_event_rst_top_right[48] col_event_rst_top_right[49]
+ col_amp_2x1
x2_x1096 detect_pulse_global_top_left ndetect_pulse_global_top_left dac_config_6
+ pre_charge_global_top_left vdda1 vssa1 x2_net33 x2_net34 array_col_top_right[47]
+ array_col_top_right[46] col_event_rst_top_right[46] col_event_rst_top_right[47]
+ col_amp_2x1
x2_x1097 detect_pulse_global_top_left ndetect_pulse_global_top_left dac_config_6
+ pre_charge_global_top_left vdda1 vssa1 x2_net37 x2_net38 array_col_top_right[45]
+ array_col_top_right[44] col_event_rst_top_right[44] col_event_rst_top_right[45]
+ col_amp_2x1
x2_x1098 detect_pulse_global_top_left ndetect_pulse_global_top_left dac_config_6
+ pre_charge_global_top_left vdda1 vssa1 x2_net41 x2_net42 array_col_top_right[43]
+ array_col_top_right[42] col_event_rst_top_right[42] col_event_rst_top_right[43]
+ col_amp_2x1
x2_x1099 detect_pulse_global_top_left ndetect_pulse_global_top_left dac_config_6
+ pre_charge_global_top_left vdda1 vssa1 x2_net45 x2_net46 array_col_top_right[41]
+ array_col_top_right[40] col_event_rst_top_right[40] col_event_rst_top_right[41]
+ col_amp_2x1
x2_x1100 detect_pulse_global_top_left ndetect_pulse_global_top_left dac_config_6
+ pre_charge_global_top_left vdda1 vssa1 x2_net49 x2_net50 array_col_top_right[39]
+ array_col_top_right[38] col_event_rst_top_right[38] col_event_rst_top_right[39]
+ col_amp_2x1
x2_x1101 detect_pulse_global_top_left ndetect_pulse_global_top_left dac_config_6
+ pre_charge_global_top_left vdda1 vssa1 x2_net53 x2_net54 array_col_top_right[37]
+ array_col_top_right[36] col_event_rst_top_right[36] col_event_rst_top_right[37]
+ col_amp_2x1
x2_x1102 detect_pulse_global_top_left ndetect_pulse_global_top_left dac_config_6
+ pre_charge_global_top_left vdda1 vssa1 x2_net57 x2_net58 array_col_top_right[35]
+ array_col_top_right[34] col_event_rst_top_right[34] col_event_rst_top_right[35]
+ col_amp_2x1
x2_x1103 detect_pulse_global_top_left ndetect_pulse_global_top_left dac_config_6
+ pre_charge_global_top_left vdda1 vssa1 x2_net61 x2_net62 array_col_top_right[33]
+ array_col_top_right[32] col_event_rst_top_right[32] col_event_rst_top_right[33]
+ col_amp_2x1
x2_x1104 detect_pulse_global_top_left ndetect_pulse_global_top_left dac_config_6
+ pre_charge_global_top_left vdda1 vssa1 x2_net65 x2_net66 array_col_top_right[31]
+ array_col_top_right[30] col_event_rst_top_right[30] col_event_rst_top_right[31]
+ col_amp_2x1
x2_x1105 detect_pulse_global_top_left ndetect_pulse_global_top_left dac_config_6
+ pre_charge_global_top_left vdda1 vssa1 x2_net69 x2_net70 array_col_top_right[29]
+ array_col_top_right[28] col_event_rst_top_right[28] col_event_rst_top_right[29]
+ col_amp_2x1
x2_x1106 detect_pulse_global_top_left ndetect_pulse_global_top_left dac_config_6
+ pre_charge_global_top_left vdda1 vssa1 x2_net73 x2_net74 array_col_top_right[27]
+ array_col_top_right[26] col_event_rst_top_right[26] col_event_rst_top_right[27]
+ col_amp_2x1
x2_x1107 detect_pulse_global_top_left ndetect_pulse_global_top_left dac_config_6
+ pre_charge_global_top_left vdda1 vssa1 x2_net77 x2_net78 array_col_top_right[25]
+ array_col_top_right[24] col_event_rst_top_right[24] col_event_rst_top_right[25]
+ col_amp_2x1
x2_x1108 detect_pulse_global_top_left ndetect_pulse_global_top_left dac_config_6
+ pre_charge_global_top_left vdda1 vssa1 x2_net81 x2_net82 array_col_top_right[23]
+ array_col_top_right[22] col_event_rst_top_right[22] col_event_rst_top_right[23]
+ col_amp_2x1
x2_x1109 detect_pulse_global_top_left ndetect_pulse_global_top_left dac_config_6
+ pre_charge_global_top_left vdda1 vssa1 x2_net85 x2_net86 array_col_top_right[21]
+ array_col_top_right[20] col_event_rst_top_right[20] col_event_rst_top_right[21]
+ col_amp_2x1
x2_x1110 detect_pulse_global_top_left ndetect_pulse_global_top_left dac_config_6
+ pre_charge_global_top_left vdda1 vssa1 x2_net89 x2_net90 array_col_top_right[19]
+ array_col_top_right[18] col_event_rst_top_right[18] col_event_rst_top_right[19]
+ col_amp_2x1
x2_x1111 detect_pulse_global_top_left ndetect_pulse_global_top_left dac_config_6
+ pre_charge_global_top_left vdda1 vssa1 x2_net93 x2_net94 array_col_top_right[17]
+ array_col_top_right[16] col_event_rst_top_right[16] col_event_rst_top_right[17]
+ col_amp_2x1
x2_x1112 detect_pulse_global_top_left ndetect_pulse_global_top_left dac_config_6
+ pre_charge_global_top_left vdda1 vssa1 x2_net97 x2_net98 array_col_top_right[15]
+ array_col_top_right[14] col_event_rst_top_right[14] col_event_rst_top_right[15]
+ col_amp_2x1
x2_x1113 detect_pulse_global_top_left ndetect_pulse_global_top_left dac_config_6
+ pre_charge_global_top_left vdda1 vssa1 x2_net101 x2_net102 array_col_top_right[13]
+ array_col_top_right[12] col_event_rst_top_right[12] col_event_rst_top_right[13]
+ col_amp_2x1
x2_x1114 detect_pulse_global_top_left ndetect_pulse_global_top_left dac_config_6
+ pre_charge_global_top_left vdda1 vssa1 x2_net105 x2_net106 array_col_top_right[11]
+ array_col_top_right[10] col_event_rst_top_right[10] col_event_rst_top_right[11]
+ col_amp_2x1
x2_x1115 detect_pulse_global_top_left ndetect_pulse_global_top_left dac_config_6
+ pre_charge_global_top_left vdda1 vssa1 x2_net109 x2_net110 array_col_top_right[9]
+ array_col_top_right[8] col_event_rst_top_right[8] col_event_rst_top_right[9] col_amp_2x1
x2_x1116 detect_pulse_global_top_left ndetect_pulse_global_top_left dac_config_6
+ pre_charge_global_top_left vdda1 vssa1 x2_net113 x2_net114 array_col_top_right[7]
+ array_col_top_right[6] col_event_rst_top_right[6] col_event_rst_top_right[7] col_amp_2x1
x2_x1117 detect_pulse_global_top_left ndetect_pulse_global_top_left dac_config_6
+ pre_charge_global_top_left vdda1 vssa1 x2_net117 x2_net118 array_col_top_right[5]
+ array_col_top_right[4] col_event_rst_top_right[4] col_event_rst_top_right[5] col_amp_2x1
x2_x1118 detect_pulse_global_top_left ndetect_pulse_global_top_left dac_config_6
+ pre_charge_global_top_left vdda1 vssa1 x2_net121 x2_net122 array_col_top_right[3]
+ array_col_top_right[2] col_event_rst_top_right[2] col_event_rst_top_right[3] col_amp_2x1
x2_x1119 detect_pulse_global_top_left ndetect_pulse_global_top_left dac_config_6
+ pre_charge_global_top_left vdda1 vssa1 x2_net125 x2_net126 array_col_top_right[1]
+ array_col_top_right[0] col_event_rst_top_right[0] col_event_rst_top_right[1] col_amp_2x1
x3_x1024 detect_pulse_global_bot_left ndetect_pulse_global_bot_left dac_config_6
+ pre_charge_global_bot_left vdda1 vssa1 x3_net1 x3_net2 array_col_bot_left[63]
+ array_col_bot_left[62] col_event_rst_bot_left[62] col_event_rst_bot_left[63] col_amp_2x1
x3_x1025 detect_pulse_global_bot_left ndetect_pulse_global_bot_left dac_config_6
+ pre_charge_global_bot_left vdda1 vssa1 x3_net3 x3_net4 array_col_bot_left[61]
+ array_col_bot_left[60] col_event_rst_bot_left[60] col_event_rst_bot_left[61] col_amp_2x1
x3_x1026 detect_pulse_global_bot_left ndetect_pulse_global_bot_left dac_config_6
+ pre_charge_global_bot_left vdda1 vssa1 x3_net5 x3_net6 array_col_bot_left[59]
+ array_col_bot_left[58] col_event_rst_bot_left[58] col_event_rst_bot_left[59] col_amp_2x1
x3_x1027 detect_pulse_global_bot_left ndetect_pulse_global_bot_left dac_config_6
+ pre_charge_global_bot_left vdda1 vssa1 x3_net7 x3_net8 array_col_bot_left[57]
+ array_col_bot_left[56] col_event_rst_bot_left[56] col_event_rst_bot_left[57] col_amp_2x1
x3_x1028 detect_pulse_global_bot_left ndetect_pulse_global_bot_left dac_config_6
+ pre_charge_global_bot_left vdda1 vssa1 x3_net9 x3_net10 array_col_bot_left[55]
+ array_col_bot_left[54] col_event_rst_bot_left[54] col_event_rst_bot_left[55] col_amp_2x1
x3_x1029 detect_pulse_global_bot_left ndetect_pulse_global_bot_left dac_config_6
+ pre_charge_global_bot_left vdda1 vssa1 x3_net11 x3_net12 array_col_bot_left[53]
+ array_col_bot_left[52] col_event_rst_bot_left[52] col_event_rst_bot_left[53] col_amp_2x1
x3_x1030 detect_pulse_global_bot_left ndetect_pulse_global_bot_left dac_config_6
+ pre_charge_global_bot_left vdda1 vssa1 x3_net13 x3_net14 array_col_bot_left[51]
+ array_col_bot_left[50] col_event_rst_bot_left[50] col_event_rst_bot_left[51] col_amp_2x1
x3_x1031 detect_pulse_global_bot_left ndetect_pulse_global_bot_left dac_config_6
+ pre_charge_global_bot_left vdda1 vssa1 x3_net15 x3_net16 array_col_bot_left[49]
+ array_col_bot_left[48] col_event_rst_bot_left[48] col_event_rst_bot_left[49] col_amp_2x1
x3_x1032 detect_pulse_global_bot_left ndetect_pulse_global_bot_left dac_config_6
+ pre_charge_global_bot_left vdda1 vssa1 x3_net17 x3_net18 array_col_bot_left[47]
+ array_col_bot_left[46] col_event_rst_bot_left[46] col_event_rst_bot_left[47] col_amp_2x1
x3_x1033 detect_pulse_global_bot_left ndetect_pulse_global_bot_left dac_config_6
+ pre_charge_global_bot_left vdda1 vssa1 x3_net19 x3_net20 array_col_bot_left[45]
+ array_col_bot_left[44] col_event_rst_bot_left[44] col_event_rst_bot_left[45] col_amp_2x1
x3_x1034 detect_pulse_global_bot_left ndetect_pulse_global_bot_left dac_config_6
+ pre_charge_global_bot_left vdda1 vssa1 x3_net21 x3_net22 array_col_bot_left[43]
+ array_col_bot_left[42] col_event_rst_bot_left[42] col_event_rst_bot_left[43] col_amp_2x1
x3_x1035 detect_pulse_global_bot_left ndetect_pulse_global_bot_left dac_config_6
+ pre_charge_global_bot_left vdda1 vssa1 x3_net23 x3_net24 array_col_bot_left[41]
+ array_col_bot_left[40] col_event_rst_bot_left[40] col_event_rst_bot_left[41] col_amp_2x1
x3_x1036 detect_pulse_global_bot_left ndetect_pulse_global_bot_left dac_config_6
+ pre_charge_global_bot_left vdda1 vssa1 x3_net25 x3_net26 array_col_bot_left[39]
+ array_col_bot_left[38] col_event_rst_bot_left[38] col_event_rst_bot_left[39] col_amp_2x1
x3_x1037 detect_pulse_global_bot_left ndetect_pulse_global_bot_left dac_config_6
+ pre_charge_global_bot_left vdda1 vssa1 x3_net27 x3_net28 array_col_bot_left[37]
+ array_col_bot_left[36] col_event_rst_bot_left[36] col_event_rst_bot_left[37] col_amp_2x1
x3_x1038 detect_pulse_global_bot_left ndetect_pulse_global_bot_left dac_config_6
+ pre_charge_global_bot_left vdda1 vssa1 x3_net29 x3_net30 array_col_bot_left[35]
+ array_col_bot_left[34] col_event_rst_bot_left[34] col_event_rst_bot_left[35] col_amp_2x1
x3_x1039 detect_pulse_global_bot_left ndetect_pulse_global_bot_left dac_config_6
+ pre_charge_global_bot_left vdda1 vssa1 x3_net31 x3_net32 array_col_bot_left[33]
+ array_col_bot_left[32] col_event_rst_bot_left[32] col_event_rst_bot_left[33] col_amp_2x1
x3_x1040 detect_pulse_global_bot_left ndetect_pulse_global_bot_left dac_config_6
+ pre_charge_global_bot_left vdda1 vssa1 x3_net33 x3_net34 array_col_bot_left[31]
+ array_col_bot_left[30] col_event_rst_bot_left[30] col_event_rst_bot_left[31] col_amp_2x1
x3_x1041 detect_pulse_global_bot_left ndetect_pulse_global_bot_left dac_config_6
+ pre_charge_global_bot_left vdda1 vssa1 x3_net35 x3_net36 array_col_bot_left[29]
+ array_col_bot_left[28] col_event_rst_bot_left[28] col_event_rst_bot_left[29] col_amp_2x1
x3_x1042 detect_pulse_global_bot_left ndetect_pulse_global_bot_left dac_config_6
+ pre_charge_global_bot_left vdda1 vssa1 x3_net37 x3_net38 array_col_bot_left[27]
+ array_col_bot_left[26] col_event_rst_bot_left[26] col_event_rst_bot_left[27] col_amp_2x1
x3_x1043 detect_pulse_global_bot_left ndetect_pulse_global_bot_left dac_config_6
+ pre_charge_global_bot_left vdda1 vssa1 x3_net39 x3_net40 array_col_bot_left[25]
+ array_col_bot_left[24] col_event_rst_bot_left[24] col_event_rst_bot_left[25] col_amp_2x1
x3_x1044 detect_pulse_global_bot_left ndetect_pulse_global_bot_left dac_config_6
+ pre_charge_global_bot_left vdda1 vssa1 x3_net41 x3_net42 array_col_bot_left[23]
+ array_col_bot_left[22] col_event_rst_bot_left[22] col_event_rst_bot_left[23] col_amp_2x1
x3_x1045 detect_pulse_global_bot_left ndetect_pulse_global_bot_left dac_config_6
+ pre_charge_global_bot_left vdda1 vssa1 x3_net43 x3_net44 array_col_bot_left[21]
+ array_col_bot_left[20] col_event_rst_bot_left[20] col_event_rst_bot_left[21] col_amp_2x1
x3_x1046 detect_pulse_global_bot_left ndetect_pulse_global_bot_left dac_config_6
+ pre_charge_global_bot_left vdda1 vssa1 x3_net45 x3_net46 array_col_bot_left[19]
+ array_col_bot_left[18] col_event_rst_bot_left[18] col_event_rst_bot_left[19] col_amp_2x1
x3_x1047 detect_pulse_global_bot_left ndetect_pulse_global_bot_left dac_config_6
+ pre_charge_global_bot_left vdda1 vssa1 x3_net47 x3_net48 array_col_bot_left[17]
+ array_col_bot_left[16] col_event_rst_bot_left[16] col_event_rst_bot_left[17] col_amp_2x1
x3_x1048 detect_pulse_global_bot_left ndetect_pulse_global_bot_left dac_config_6
+ pre_charge_global_bot_left vdda1 vssa1 x3_net49 x3_net50 array_col_bot_left[15]
+ array_col_bot_left[14] col_event_rst_bot_left[14] col_event_rst_bot_left[15] col_amp_2x1
x3_x1049 detect_pulse_global_bot_left ndetect_pulse_global_bot_left dac_config_6
+ pre_charge_global_bot_left vdda1 vssa1 x3_net51 x3_net52 array_col_bot_left[13]
+ array_col_bot_left[12] col_event_rst_bot_left[12] col_event_rst_bot_left[13] col_amp_2x1
x3_x1050 detect_pulse_global_bot_left ndetect_pulse_global_bot_left dac_config_6
+ pre_charge_global_bot_left vdda1 vssa1 x3_net53 x3_net54 array_col_bot_left[11]
+ array_col_bot_left[10] col_event_rst_bot_left[10] col_event_rst_bot_left[11] col_amp_2x1
x3_x1051 detect_pulse_global_bot_left ndetect_pulse_global_bot_left dac_config_6
+ pre_charge_global_bot_left vdda1 vssa1 x3_net55 x3_net56 array_col_bot_left[9]
+ array_col_bot_left[8] col_event_rst_bot_left[8] col_event_rst_bot_left[9] col_amp_2x1
x3_x1052 detect_pulse_global_bot_left ndetect_pulse_global_bot_left dac_config_6
+ pre_charge_global_bot_left vdda1 vssa1 x3_net57 x3_net58 array_col_bot_left[7]
+ array_col_bot_left[6] col_event_rst_bot_left[6] col_event_rst_bot_left[7] col_amp_2x1
x3_x1053 detect_pulse_global_bot_left ndetect_pulse_global_bot_left dac_config_6
+ pre_charge_global_bot_left vdda1 vssa1 x3_net59 x3_net60 array_col_bot_left[5]
+ array_col_bot_left[4] col_event_rst_bot_left[4] col_event_rst_bot_left[5] col_amp_2x1
x3_x1054 detect_pulse_global_bot_left ndetect_pulse_global_bot_left dac_config_6
+ pre_charge_global_bot_left vdda1 vssa1 x3_net61 x3_net62 array_col_bot_left[3]
+ array_col_bot_left[2] col_event_rst_bot_left[2] col_event_rst_bot_left[3] col_amp_2x1
x3_x1055 detect_pulse_global_bot_left ndetect_pulse_global_bot_left dac_config_6
+ pre_charge_global_bot_left vdda1 vssa1 x3_net63 x3_net64 array_col_bot_left[1]
+ array_col_bot_left[0] col_event_rst_bot_left[0] col_event_rst_bot_left[1] col_amp_2x1
x3_x1 dac_config_3 dac_config_5 col_event_rst_bot_left[63] dac_config_4
+ row_on_detect_bot[0] dac_config_0 dac_config_1 row_off_detect_bot[1] x3_net1
+ dac_config_2 vdda1 vssa1 vssc1 col_event_rst_bot_left[62] x3_net2 row_on_detect_bot[1]
+ row_off_detect_bot[0] openDVS_pixel2x2_bot
x3_x2 dac_config_3 dac_config_5 col_event_rst_bot_left[61] dac_config_4
+ row_on_detect_bot[0] dac_config_0 dac_config_1 row_off_detect_bot[1] x3_net3
+ dac_config_2 vdda1 vssa1 vssc1 col_event_rst_bot_left[60] x3_net4 row_on_detect_bot[1]
+ row_off_detect_bot[0] openDVS_pixel2x2_bot
x3_x3 dac_config_3 dac_config_5 col_event_rst_bot_left[59] dac_config_4
+ row_on_detect_bot[0] dac_config_0 dac_config_1 row_off_detect_bot[1] x3_net5
+ dac_config_2 vdda1 vssa1 vssc1 col_event_rst_bot_left[58] x3_net6 row_on_detect_bot[1]
+ row_off_detect_bot[0] openDVS_pixel2x2_bot
x3_x4 dac_config_3 dac_config_5 col_event_rst_bot_left[57] dac_config_4
+ row_on_detect_bot[0] dac_config_0 dac_config_1 row_off_detect_bot[1] x3_net7
+ dac_config_2 vdda1 vssa1 vssc1 col_event_rst_bot_left[56] x3_net8 row_on_detect_bot[1]
+ row_off_detect_bot[0] openDVS_pixel2x2_bot
x3_x5 dac_config_3 dac_config_5 col_event_rst_bot_left[55] dac_config_4
+ row_on_detect_bot[0] dac_config_0 dac_config_1 row_off_detect_bot[1] x3_net9
+ dac_config_2 vdda1 vssa1 vssc1 col_event_rst_bot_left[54] x3_net10 row_on_detect_bot[1]
+ row_off_detect_bot[0] openDVS_pixel2x2_bot
x3_x6 dac_config_3 dac_config_5 col_event_rst_bot_left[53] dac_config_4
+ row_on_detect_bot[0] dac_config_0 dac_config_1 row_off_detect_bot[1] x3_net11
+ dac_config_2 vdda1 vssa1 vssc1 col_event_rst_bot_left[52] x3_net12 row_on_detect_bot[1]
+ row_off_detect_bot[0] openDVS_pixel2x2_bot
x3_x7 dac_config_3 dac_config_5 col_event_rst_bot_left[51] dac_config_4
+ row_on_detect_bot[0] dac_config_0 dac_config_1 row_off_detect_bot[1] x3_net13
+ dac_config_2 vdda1 vssa1 vssc1 col_event_rst_bot_left[50] x3_net14 row_on_detect_bot[1]
+ row_off_detect_bot[0] openDVS_pixel2x2_bot
x3_x8 dac_config_3 dac_config_5 col_event_rst_bot_left[49] dac_config_4
+ row_on_detect_bot[0] dac_config_0 dac_config_1 row_off_detect_bot[1] x3_net15
+ dac_config_2 vdda1 vssa1 vssc1 col_event_rst_bot_left[48] x3_net16 row_on_detect_bot[1]
+ row_off_detect_bot[0] openDVS_pixel2x2_bot
x3_x9 dac_config_3 dac_config_5 col_event_rst_bot_left[47] dac_config_4
+ row_on_detect_bot[0] dac_config_0 dac_config_1 row_off_detect_bot[1] x3_net17
+ dac_config_2 vdda1 vssa1 vssc1 col_event_rst_bot_left[46] x3_net18 row_on_detect_bot[1]
+ row_off_detect_bot[0] openDVS_pixel2x2_bot
x3_x10 dac_config_3 dac_config_5 col_event_rst_bot_left[45] dac_config_4
+ row_on_detect_bot[0] dac_config_0 dac_config_1 row_off_detect_bot[1] x3_net19
+ dac_config_2 vdda1 vssa1 vssc1 col_event_rst_bot_left[44] x3_net20 row_on_detect_bot[1]
+ row_off_detect_bot[0] openDVS_pixel2x2_bot
x3_x11 dac_config_3 dac_config_5 col_event_rst_bot_left[43] dac_config_4
+ row_on_detect_bot[0] dac_config_0 dac_config_1 row_off_detect_bot[1] x3_net21
+ dac_config_2 vdda1 vssa1 vssc1 col_event_rst_bot_left[42] x3_net22 row_on_detect_bot[1]
+ row_off_detect_bot[0] openDVS_pixel2x2_bot
x3_x12 dac_config_3 dac_config_5 col_event_rst_bot_left[41] dac_config_4
+ row_on_detect_bot[0] dac_config_0 dac_config_1 row_off_detect_bot[1] x3_net23
+ dac_config_2 vdda1 vssa1 vssc1 col_event_rst_bot_left[40] x3_net24 row_on_detect_bot[1]
+ row_off_detect_bot[0] openDVS_pixel2x2_bot
x3_x13 dac_config_3 dac_config_5 col_event_rst_bot_left[39] dac_config_4
+ row_on_detect_bot[0] dac_config_0 dac_config_1 row_off_detect_bot[1] x3_net25
+ dac_config_2 vdda1 vssa1 vssc1 col_event_rst_bot_left[38] x3_net26 row_on_detect_bot[1]
+ row_off_detect_bot[0] openDVS_pixel2x2_bot
x3_x14 dac_config_3 dac_config_5 col_event_rst_bot_left[37] dac_config_4
+ row_on_detect_bot[0] dac_config_0 dac_config_1 row_off_detect_bot[1] x3_net27
+ dac_config_2 vdda1 vssa1 vssc1 col_event_rst_bot_left[36] x3_net28 row_on_detect_bot[1]
+ row_off_detect_bot[0] openDVS_pixel2x2_bot
x3_x15 dac_config_3 dac_config_5 col_event_rst_bot_left[35] dac_config_4
+ row_on_detect_bot[0] dac_config_0 dac_config_1 row_off_detect_bot[1] x3_net29
+ dac_config_2 vdda1 vssa1 vssc1 col_event_rst_bot_left[34] x3_net30 row_on_detect_bot[1]
+ row_off_detect_bot[0] openDVS_pixel2x2_bot
x3_x16 dac_config_3 dac_config_5 col_event_rst_bot_left[33] dac_config_4
+ row_on_detect_bot[0] dac_config_0 dac_config_1 row_off_detect_bot[1] x3_net31
+ dac_config_2 vdda1 vssa1 vssc1 col_event_rst_bot_left[32] x3_net32 row_on_detect_bot[1]
+ row_off_detect_bot[0] openDVS_pixel2x2_bot
x3_x17 dac_config_3 dac_config_5 col_event_rst_bot_left[31] dac_config_4
+ row_on_detect_bot[0] dac_config_0 dac_config_1 row_off_detect_bot[1] x3_net33
+ dac_config_2 vdda1 vssa1 vssc1 col_event_rst_bot_left[30] x3_net34 row_on_detect_bot[1]
+ row_off_detect_bot[0] openDVS_pixel2x2_bot
x3_x18 dac_config_3 dac_config_5 col_event_rst_bot_left[29] dac_config_4
+ row_on_detect_bot[0] dac_config_0 dac_config_1 row_off_detect_bot[1] x3_net35
+ dac_config_2 vdda1 vssa1 vssc1 col_event_rst_bot_left[28] x3_net36 row_on_detect_bot[1]
+ row_off_detect_bot[0] openDVS_pixel2x2_bot
x3_x19 dac_config_3 dac_config_5 col_event_rst_bot_left[27] dac_config_4
+ row_on_detect_bot[0] dac_config_0 dac_config_1 row_off_detect_bot[1] x3_net37
+ dac_config_2 vdda1 vssa1 vssc1 col_event_rst_bot_left[26] x3_net38 row_on_detect_bot[1]
+ row_off_detect_bot[0] openDVS_pixel2x2_bot
x3_x20 dac_config_3 dac_config_5 col_event_rst_bot_left[25] dac_config_4
+ row_on_detect_bot[0] dac_config_0 dac_config_1 row_off_detect_bot[1] x3_net39
+ dac_config_2 vdda1 vssa1 vssc1 col_event_rst_bot_left[24] x3_net40 row_on_detect_bot[1]
+ row_off_detect_bot[0] openDVS_pixel2x2_bot
x3_x21 dac_config_3 dac_config_5 col_event_rst_bot_left[23] dac_config_4
+ row_on_detect_bot[0] dac_config_0 dac_config_1 row_off_detect_bot[1] x3_net41
+ dac_config_2 vdda1 vssa1 vssc1 col_event_rst_bot_left[22] x3_net42 row_on_detect_bot[1]
+ row_off_detect_bot[0] openDVS_pixel2x2_bot
x3_x22 dac_config_3 dac_config_5 col_event_rst_bot_left[21] dac_config_4
+ row_on_detect_bot[0] dac_config_0 dac_config_1 row_off_detect_bot[1] x3_net43
+ dac_config_2 vdda1 vssa1 vssc1 col_event_rst_bot_left[20] x3_net44 row_on_detect_bot[1]
+ row_off_detect_bot[0] openDVS_pixel2x2_bot
x3_x23 dac_config_3 dac_config_5 col_event_rst_bot_left[19] dac_config_4
+ row_on_detect_bot[0] dac_config_0 dac_config_1 row_off_detect_bot[1] x3_net45
+ dac_config_2 vdda1 vssa1 vssc1 col_event_rst_bot_left[18] x3_net46 row_on_detect_bot[1]
+ row_off_detect_bot[0] openDVS_pixel2x2_bot
x3_x24 dac_config_3 dac_config_5 col_event_rst_bot_left[17] dac_config_4
+ row_on_detect_bot[0] dac_config_0 dac_config_1 row_off_detect_bot[1] x3_net47
+ dac_config_2 vdda1 vssa1 vssc1 col_event_rst_bot_left[16] x3_net48 row_on_detect_bot[1]
+ row_off_detect_bot[0] openDVS_pixel2x2_bot
x3_x25 dac_config_3 dac_config_5 col_event_rst_bot_left[15] dac_config_4
+ row_on_detect_bot[0] dac_config_0 dac_config_1 row_off_detect_bot[1] x3_net49
+ dac_config_2 vdda1 vssa1 vssc1 col_event_rst_bot_left[14] x3_net50 row_on_detect_bot[1]
+ row_off_detect_bot[0] openDVS_pixel2x2_bot
x3_x26 dac_config_3 dac_config_5 col_event_rst_bot_left[13] dac_config_4
+ row_on_detect_bot[0] dac_config_0 dac_config_1 row_off_detect_bot[1] x3_net51
+ dac_config_2 vdda1 vssa1 vssc1 col_event_rst_bot_left[12] x3_net52 row_on_detect_bot[1]
+ row_off_detect_bot[0] openDVS_pixel2x2_bot
x3_x27 dac_config_3 dac_config_5 col_event_rst_bot_left[11] dac_config_4
+ row_on_detect_bot[0] dac_config_0 dac_config_1 row_off_detect_bot[1] x3_net53
+ dac_config_2 vdda1 vssa1 vssc1 col_event_rst_bot_left[10] x3_net54 row_on_detect_bot[1]
+ row_off_detect_bot[0] openDVS_pixel2x2_bot
x3_x28 dac_config_3 dac_config_5 col_event_rst_bot_left[9] dac_config_4
+ row_on_detect_bot[0] dac_config_0 dac_config_1 row_off_detect_bot[1] x3_net55
+ dac_config_2 vdda1 vssa1 vssc1 col_event_rst_bot_left[8] x3_net56 row_on_detect_bot[1]
+ row_off_detect_bot[0] openDVS_pixel2x2_bot
x3_x29 dac_config_3 dac_config_5 col_event_rst_bot_left[7] dac_config_4
+ row_on_detect_bot[0] dac_config_0 dac_config_1 row_off_detect_bot[1] x3_net57
+ dac_config_2 vdda1 vssa1 vssc1 col_event_rst_bot_left[6] x3_net58 row_on_detect_bot[1]
+ row_off_detect_bot[0] openDVS_pixel2x2_bot
x3_x30 dac_config_3 dac_config_5 col_event_rst_bot_left[5] dac_config_4
+ row_on_detect_bot[0] dac_config_0 dac_config_1 row_off_detect_bot[1] x3_net59
+ dac_config_2 vdda1 vssa1 vssc1 col_event_rst_bot_left[4] x3_net60 row_on_detect_bot[1]
+ row_off_detect_bot[0] openDVS_pixel2x2_bot
x3_x31 dac_config_3 dac_config_5 col_event_rst_bot_left[3] dac_config_4
+ row_on_detect_bot[0] dac_config_0 dac_config_1 row_off_detect_bot[1] x3_net61
+ dac_config_2 vdda1 vssa1 vssc1 col_event_rst_bot_left[2] x3_net62 row_on_detect_bot[1]
+ row_off_detect_bot[0] openDVS_pixel2x2_bot
x3_x32 dac_config_3 dac_config_5 col_event_rst_bot_left[1] dac_config_4
+ row_on_detect_bot[0] dac_config_0 dac_config_1 row_off_detect_bot[1] x3_net63
+ dac_config_2 vdda1 vssa1 vssc1 col_event_rst_bot_left[0] x3_net64 row_on_detect_bot[1]
+ row_off_detect_bot[0] openDVS_pixel2x2_bot
x3_x1056 dac_config_3 dac_config_5 col_event_rst_bot_left[63] dac_config_4
+ row_on_detect_bot[2] dac_config_0 dac_config_1 row_off_detect_bot[3] x3_net1
+ dac_config_2 vdda1 vssa1 vssc1 col_event_rst_bot_left[62] x3_net2 row_on_detect_bot[3]
+ row_off_detect_bot[2] openDVS_pixel2x2_bot
x3_x1057 dac_config_3 dac_config_5 col_event_rst_bot_left[61] dac_config_4
+ row_on_detect_bot[2] dac_config_0 dac_config_1 row_off_detect_bot[3] x3_net3
+ dac_config_2 vdda1 vssa1 vssc1 col_event_rst_bot_left[60] x3_net4 row_on_detect_bot[3]
+ row_off_detect_bot[2] openDVS_pixel2x2_bot
x3_x1058 dac_config_3 dac_config_5 col_event_rst_bot_left[59] dac_config_4
+ row_on_detect_bot[2] dac_config_0 dac_config_1 row_off_detect_bot[3] x3_net5
+ dac_config_2 vdda1 vssa1 vssc1 col_event_rst_bot_left[58] x3_net6 row_on_detect_bot[3]
+ row_off_detect_bot[2] openDVS_pixel2x2_bot
x3_x1059 dac_config_3 dac_config_5 col_event_rst_bot_left[57] dac_config_4
+ row_on_detect_bot[2] dac_config_0 dac_config_1 row_off_detect_bot[3] x3_net7
+ dac_config_2 vdda1 vssa1 vssc1 col_event_rst_bot_left[56] x3_net8 row_on_detect_bot[3]
+ row_off_detect_bot[2] openDVS_pixel2x2_bot
x3_x1060 dac_config_3 dac_config_5 col_event_rst_bot_left[55] dac_config_4
+ row_on_detect_bot[2] dac_config_0 dac_config_1 row_off_detect_bot[3] x3_net9
+ dac_config_2 vdda1 vssa1 vssc1 col_event_rst_bot_left[54] x3_net10 row_on_detect_bot[3]
+ row_off_detect_bot[2] openDVS_pixel2x2_bot
x3_x1061 dac_config_3 dac_config_5 col_event_rst_bot_left[53] dac_config_4
+ row_on_detect_bot[2] dac_config_0 dac_config_1 row_off_detect_bot[3] x3_net11
+ dac_config_2 vdda1 vssa1 vssc1 col_event_rst_bot_left[52] x3_net12 row_on_detect_bot[3]
+ row_off_detect_bot[2] openDVS_pixel2x2_bot
x3_x1062 dac_config_3 dac_config_5 col_event_rst_bot_left[51] dac_config_4
+ row_on_detect_bot[2] dac_config_0 dac_config_1 row_off_detect_bot[3] x3_net13
+ dac_config_2 vdda1 vssa1 vssc1 col_event_rst_bot_left[50] x3_net14 row_on_detect_bot[3]
+ row_off_detect_bot[2] openDVS_pixel2x2_bot
x3_x1063 dac_config_3 dac_config_5 col_event_rst_bot_left[49] dac_config_4
+ row_on_detect_bot[2] dac_config_0 dac_config_1 row_off_detect_bot[3] x3_net15
+ dac_config_2 vdda1 vssa1 vssc1 col_event_rst_bot_left[48] x3_net16 row_on_detect_bot[3]
+ row_off_detect_bot[2] openDVS_pixel2x2_bot
x3_x1064 dac_config_3 dac_config_5 col_event_rst_bot_left[47] dac_config_4
+ row_on_detect_bot[2] dac_config_0 dac_config_1 row_off_detect_bot[3] x3_net17
+ dac_config_2 vdda1 vssa1 vssc1 col_event_rst_bot_left[46] x3_net18 row_on_detect_bot[3]
+ row_off_detect_bot[2] openDVS_pixel2x2_bot
x3_x1065 dac_config_3 dac_config_5 col_event_rst_bot_left[45] dac_config_4
+ row_on_detect_bot[2] dac_config_0 dac_config_1 row_off_detect_bot[3] x3_net19
+ dac_config_2 vdda1 vssa1 vssc1 col_event_rst_bot_left[44] x3_net20 row_on_detect_bot[3]
+ row_off_detect_bot[2] openDVS_pixel2x2_bot
x3_x1066 dac_config_3 dac_config_5 col_event_rst_bot_left[43] dac_config_4
+ row_on_detect_bot[2] dac_config_0 dac_config_1 row_off_detect_bot[3] x3_net21
+ dac_config_2 vdda1 vssa1 vssc1 col_event_rst_bot_left[42] x3_net22 row_on_detect_bot[3]
+ row_off_detect_bot[2] openDVS_pixel2x2_bot
x3_x1067 dac_config_3 dac_config_5 col_event_rst_bot_left[41] dac_config_4
+ row_on_detect_bot[2] dac_config_0 dac_config_1 row_off_detect_bot[3] x3_net23
+ dac_config_2 vdda1 vssa1 vssc1 col_event_rst_bot_left[40] x3_net24 row_on_detect_bot[3]
+ row_off_detect_bot[2] openDVS_pixel2x2_bot
x3_x1068 dac_config_3 dac_config_5 col_event_rst_bot_left[39] dac_config_4
+ row_on_detect_bot[2] dac_config_0 dac_config_1 row_off_detect_bot[3] x3_net25
+ dac_config_2 vdda1 vssa1 vssc1 col_event_rst_bot_left[38] x3_net26 row_on_detect_bot[3]
+ row_off_detect_bot[2] openDVS_pixel2x2_bot
x3_x1069 dac_config_3 dac_config_5 col_event_rst_bot_left[37] dac_config_4
+ row_on_detect_bot[2] dac_config_0 dac_config_1 row_off_detect_bot[3] x3_net27
+ dac_config_2 vdda1 vssa1 vssc1 col_event_rst_bot_left[36] x3_net28 row_on_detect_bot[3]
+ row_off_detect_bot[2] openDVS_pixel2x2_bot
x3_x1070 dac_config_3 dac_config_5 col_event_rst_bot_left[35] dac_config_4
+ row_on_detect_bot[2] dac_config_0 dac_config_1 row_off_detect_bot[3] x3_net29
+ dac_config_2 vdda1 vssa1 vssc1 col_event_rst_bot_left[34] x3_net30 row_on_detect_bot[3]
+ row_off_detect_bot[2] openDVS_pixel2x2_bot
x3_x1071 dac_config_3 dac_config_5 col_event_rst_bot_left[33] dac_config_4
+ row_on_detect_bot[2] dac_config_0 dac_config_1 row_off_detect_bot[3] x3_net31
+ dac_config_2 vdda1 vssa1 vssc1 col_event_rst_bot_left[32] x3_net32 row_on_detect_bot[3]
+ row_off_detect_bot[2] openDVS_pixel2x2_bot
x3_x1072 dac_config_3 dac_config_5 col_event_rst_bot_left[31] dac_config_4
+ row_on_detect_bot[2] dac_config_0 dac_config_1 row_off_detect_bot[3] x3_net33
+ dac_config_2 vdda1 vssa1 vssc1 col_event_rst_bot_left[30] x3_net34 row_on_detect_bot[3]
+ row_off_detect_bot[2] openDVS_pixel2x2_bot
x3_x1073 dac_config_3 dac_config_5 col_event_rst_bot_left[29] dac_config_4
+ row_on_detect_bot[2] dac_config_0 dac_config_1 row_off_detect_bot[3] x3_net35
+ dac_config_2 vdda1 vssa1 vssc1 col_event_rst_bot_left[28] x3_net36 row_on_detect_bot[3]
+ row_off_detect_bot[2] openDVS_pixel2x2_bot
x3_x1074 dac_config_3 dac_config_5 col_event_rst_bot_left[27] dac_config_4
+ row_on_detect_bot[2] dac_config_0 dac_config_1 row_off_detect_bot[3] x3_net37
+ dac_config_2 vdda1 vssa1 vssc1 col_event_rst_bot_left[26] x3_net38 row_on_detect_bot[3]
+ row_off_detect_bot[2] openDVS_pixel2x2_bot
x3_x1075 dac_config_3 dac_config_5 col_event_rst_bot_left[25] dac_config_4
+ row_on_detect_bot[2] dac_config_0 dac_config_1 row_off_detect_bot[3] x3_net39
+ dac_config_2 vdda1 vssa1 vssc1 col_event_rst_bot_left[24] x3_net40 row_on_detect_bot[3]
+ row_off_detect_bot[2] openDVS_pixel2x2_bot
x3_x1076 dac_config_3 dac_config_5 col_event_rst_bot_left[23] dac_config_4
+ row_on_detect_bot[2] dac_config_0 dac_config_1 row_off_detect_bot[3] x3_net41
+ dac_config_2 vdda1 vssa1 vssc1 col_event_rst_bot_left[22] x3_net42 row_on_detect_bot[3]
+ row_off_detect_bot[2] openDVS_pixel2x2_bot
x3_x1077 dac_config_3 dac_config_5 col_event_rst_bot_left[21] dac_config_4
+ row_on_detect_bot[2] dac_config_0 dac_config_1 row_off_detect_bot[3] x3_net43
+ dac_config_2 vdda1 vssa1 vssc1 col_event_rst_bot_left[20] x3_net44 row_on_detect_bot[3]
+ row_off_detect_bot[2] openDVS_pixel2x2_bot
x3_x1078 dac_config_3 dac_config_5 col_event_rst_bot_left[19] dac_config_4
+ row_on_detect_bot[2] dac_config_0 dac_config_1 row_off_detect_bot[3] x3_net45
+ dac_config_2 vdda1 vssa1 vssc1 col_event_rst_bot_left[18] x3_net46 row_on_detect_bot[3]
+ row_off_detect_bot[2] openDVS_pixel2x2_bot
x3_x1079 dac_config_3 dac_config_5 col_event_rst_bot_left[17] dac_config_4
+ row_on_detect_bot[2] dac_config_0 dac_config_1 row_off_detect_bot[3] x3_net47
+ dac_config_2 vdda1 vssa1 vssc1 col_event_rst_bot_left[16] x3_net48 row_on_detect_bot[3]
+ row_off_detect_bot[2] openDVS_pixel2x2_bot
x3_x1080 dac_config_3 dac_config_5 col_event_rst_bot_left[15] dac_config_4
+ row_on_detect_bot[2] dac_config_0 dac_config_1 row_off_detect_bot[3] x3_net49
+ dac_config_2 vdda1 vssa1 vssc1 col_event_rst_bot_left[14] x3_net50 row_on_detect_bot[3]
+ row_off_detect_bot[2] openDVS_pixel2x2_bot
x3_x1081 dac_config_3 dac_config_5 col_event_rst_bot_left[13] dac_config_4
+ row_on_detect_bot[2] dac_config_0 dac_config_1 row_off_detect_bot[3] x3_net51
+ dac_config_2 vdda1 vssa1 vssc1 col_event_rst_bot_left[12] x3_net52 row_on_detect_bot[3]
+ row_off_detect_bot[2] openDVS_pixel2x2_bot
x3_x1082 dac_config_3 dac_config_5 col_event_rst_bot_left[11] dac_config_4
+ row_on_detect_bot[2] dac_config_0 dac_config_1 row_off_detect_bot[3] x3_net53
+ dac_config_2 vdda1 vssa1 vssc1 col_event_rst_bot_left[10] x3_net54 row_on_detect_bot[3]
+ row_off_detect_bot[2] openDVS_pixel2x2_bot
x3_x1083 dac_config_3 dac_config_5 col_event_rst_bot_left[9] dac_config_4
+ row_on_detect_bot[2] dac_config_0 dac_config_1 row_off_detect_bot[3] x3_net55
+ dac_config_2 vdda1 vssa1 vssc1 col_event_rst_bot_left[8] x3_net56 row_on_detect_bot[3]
+ row_off_detect_bot[2] openDVS_pixel2x2_bot
x3_x1084 dac_config_3 dac_config_5 col_event_rst_bot_left[7] dac_config_4
+ row_on_detect_bot[2] dac_config_0 dac_config_1 row_off_detect_bot[3] x3_net57
+ dac_config_2 vdda1 vssa1 vssc1 col_event_rst_bot_left[6] x3_net58 row_on_detect_bot[3]
+ row_off_detect_bot[2] openDVS_pixel2x2_bot
x3_x1085 dac_config_3 dac_config_5 col_event_rst_bot_left[5] dac_config_4
+ row_on_detect_bot[2] dac_config_0 dac_config_1 row_off_detect_bot[3] x3_net59
+ dac_config_2 vdda1 vssa1 vssc1 col_event_rst_bot_left[4] x3_net60 row_on_detect_bot[3]
+ row_off_detect_bot[2] openDVS_pixel2x2_bot
x3_x1086 dac_config_3 dac_config_5 col_event_rst_bot_left[3] dac_config_4
+ row_on_detect_bot[2] dac_config_0 dac_config_1 row_off_detect_bot[3] x3_net61
+ dac_config_2 vdda1 vssa1 vssc1 col_event_rst_bot_left[2] x3_net62 row_on_detect_bot[3]
+ row_off_detect_bot[2] openDVS_pixel2x2_bot
x3_x1087 dac_config_3 dac_config_5 col_event_rst_bot_left[1] dac_config_4
+ row_on_detect_bot[2] dac_config_0 dac_config_1 row_off_detect_bot[3] x3_net63
+ dac_config_2 vdda1 vssa1 vssc1 col_event_rst_bot_left[0] x3_net64 row_on_detect_bot[3]
+ row_off_detect_bot[2] openDVS_pixel2x2_bot
x3_x1120 dac_config_3 dac_config_5 col_event_rst_bot_left[63] dac_config_4
+ row_on_detect_bot[4] dac_config_0 dac_config_1 row_off_detect_bot[5] x3_net1
+ dac_config_2 vdda1 vssa1 vssc1 col_event_rst_bot_left[62] x3_net2 row_on_detect_bot[5]
+ row_off_detect_bot[4] openDVS_pixel2x2_bot
x3_x1121 dac_config_3 dac_config_5 col_event_rst_bot_left[61] dac_config_4
+ row_on_detect_bot[4] dac_config_0 dac_config_1 row_off_detect_bot[5] x3_net3
+ dac_config_2 vdda1 vssa1 vssc1 col_event_rst_bot_left[60] x3_net4 row_on_detect_bot[5]
+ row_off_detect_bot[4] openDVS_pixel2x2_bot
x3_x1122 dac_config_3 dac_config_5 col_event_rst_bot_left[59] dac_config_4
+ row_on_detect_bot[4] dac_config_0 dac_config_1 row_off_detect_bot[5] x3_net5
+ dac_config_2 vdda1 vssa1 vssc1 col_event_rst_bot_left[58] x3_net6 row_on_detect_bot[5]
+ row_off_detect_bot[4] openDVS_pixel2x2_bot
x3_x1123 dac_config_3 dac_config_5 col_event_rst_bot_left[57] dac_config_4
+ row_on_detect_bot[4] dac_config_0 dac_config_1 row_off_detect_bot[5] x3_net7
+ dac_config_2 vdda1 vssa1 vssc1 col_event_rst_bot_left[56] x3_net8 row_on_detect_bot[5]
+ row_off_detect_bot[4] openDVS_pixel2x2_bot
x3_x1124 dac_config_3 dac_config_5 col_event_rst_bot_left[55] dac_config_4
+ row_on_detect_bot[4] dac_config_0 dac_config_1 row_off_detect_bot[5] x3_net9
+ dac_config_2 vdda1 vssa1 vssc1 col_event_rst_bot_left[54] x3_net10 row_on_detect_bot[5]
+ row_off_detect_bot[4] openDVS_pixel2x2_bot
x3_x1125 dac_config_3 dac_config_5 col_event_rst_bot_left[53] dac_config_4
+ row_on_detect_bot[4] dac_config_0 dac_config_1 row_off_detect_bot[5] x3_net11
+ dac_config_2 vdda1 vssa1 vssc1 col_event_rst_bot_left[52] x3_net12 row_on_detect_bot[5]
+ row_off_detect_bot[4] openDVS_pixel2x2_bot
x3_x1126 dac_config_3 dac_config_5 col_event_rst_bot_left[51] dac_config_4
+ row_on_detect_bot[4] dac_config_0 dac_config_1 row_off_detect_bot[5] x3_net13
+ dac_config_2 vdda1 vssa1 vssc1 col_event_rst_bot_left[50] x3_net14 row_on_detect_bot[5]
+ row_off_detect_bot[4] openDVS_pixel2x2_bot
x3_x1127 dac_config_3 dac_config_5 col_event_rst_bot_left[49] dac_config_4
+ row_on_detect_bot[4] dac_config_0 dac_config_1 row_off_detect_bot[5] x3_net15
+ dac_config_2 vdda1 vssa1 vssc1 col_event_rst_bot_left[48] x3_net16 row_on_detect_bot[5]
+ row_off_detect_bot[4] openDVS_pixel2x2_bot
x3_x1128 dac_config_3 dac_config_5 col_event_rst_bot_left[47] dac_config_4
+ row_on_detect_bot[4] dac_config_0 dac_config_1 row_off_detect_bot[5] x3_net17
+ dac_config_2 vdda1 vssa1 vssc1 col_event_rst_bot_left[46] x3_net18 row_on_detect_bot[5]
+ row_off_detect_bot[4] openDVS_pixel2x2_bot
x3_x1129 dac_config_3 dac_config_5 col_event_rst_bot_left[45] dac_config_4
+ row_on_detect_bot[4] dac_config_0 dac_config_1 row_off_detect_bot[5] x3_net19
+ dac_config_2 vdda1 vssa1 vssc1 col_event_rst_bot_left[44] x3_net20 row_on_detect_bot[5]
+ row_off_detect_bot[4] openDVS_pixel2x2_bot
x3_x1130 dac_config_3 dac_config_5 col_event_rst_bot_left[43] dac_config_4
+ row_on_detect_bot[4] dac_config_0 dac_config_1 row_off_detect_bot[5] x3_net21
+ dac_config_2 vdda1 vssa1 vssc1 col_event_rst_bot_left[42] x3_net22 row_on_detect_bot[5]
+ row_off_detect_bot[4] openDVS_pixel2x2_bot
x3_x1131 dac_config_3 dac_config_5 col_event_rst_bot_left[41] dac_config_4
+ row_on_detect_bot[4] dac_config_0 dac_config_1 row_off_detect_bot[5] x3_net23
+ dac_config_2 vdda1 vssa1 vssc1 col_event_rst_bot_left[40] x3_net24 row_on_detect_bot[5]
+ row_off_detect_bot[4] openDVS_pixel2x2_bot
x3_x1132 dac_config_3 dac_config_5 col_event_rst_bot_left[39] dac_config_4
+ row_on_detect_bot[4] dac_config_0 dac_config_1 row_off_detect_bot[5] x3_net25
+ dac_config_2 vdda1 vssa1 vssc1 col_event_rst_bot_left[38] x3_net26 row_on_detect_bot[5]
+ row_off_detect_bot[4] openDVS_pixel2x2_bot
x3_x1133 dac_config_3 dac_config_5 col_event_rst_bot_left[37] dac_config_4
+ row_on_detect_bot[4] dac_config_0 dac_config_1 row_off_detect_bot[5] x3_net27
+ dac_config_2 vdda1 vssa1 vssc1 col_event_rst_bot_left[36] x3_net28 row_on_detect_bot[5]
+ row_off_detect_bot[4] openDVS_pixel2x2_bot
x3_x1134 dac_config_3 dac_config_5 col_event_rst_bot_left[35] dac_config_4
+ row_on_detect_bot[4] dac_config_0 dac_config_1 row_off_detect_bot[5] x3_net29
+ dac_config_2 vdda1 vssa1 vssc1 col_event_rst_bot_left[34] x3_net30 row_on_detect_bot[5]
+ row_off_detect_bot[4] openDVS_pixel2x2_bot
x3_x1135 dac_config_3 dac_config_5 col_event_rst_bot_left[33] dac_config_4
+ row_on_detect_bot[4] dac_config_0 dac_config_1 row_off_detect_bot[5] x3_net31
+ dac_config_2 vdda1 vssa1 vssc1 col_event_rst_bot_left[32] x3_net32 row_on_detect_bot[5]
+ row_off_detect_bot[4] openDVS_pixel2x2_bot
x3_x1136 dac_config_3 dac_config_5 col_event_rst_bot_left[31] dac_config_4
+ row_on_detect_bot[4] dac_config_0 dac_config_1 row_off_detect_bot[5] x3_net33
+ dac_config_2 vdda1 vssa1 vssc1 col_event_rst_bot_left[30] x3_net34 row_on_detect_bot[5]
+ row_off_detect_bot[4] openDVS_pixel2x2_bot
x3_x1137 dac_config_3 dac_config_5 col_event_rst_bot_left[29] dac_config_4
+ row_on_detect_bot[4] dac_config_0 dac_config_1 row_off_detect_bot[5] x3_net35
+ dac_config_2 vdda1 vssa1 vssc1 col_event_rst_bot_left[28] x3_net36 row_on_detect_bot[5]
+ row_off_detect_bot[4] openDVS_pixel2x2_bot
x3_x1138 dac_config_3 dac_config_5 col_event_rst_bot_left[27] dac_config_4
+ row_on_detect_bot[4] dac_config_0 dac_config_1 row_off_detect_bot[5] x3_net37
+ dac_config_2 vdda1 vssa1 vssc1 col_event_rst_bot_left[26] x3_net38 row_on_detect_bot[5]
+ row_off_detect_bot[4] openDVS_pixel2x2_bot
x3_x1139 dac_config_3 dac_config_5 col_event_rst_bot_left[25] dac_config_4
+ row_on_detect_bot[4] dac_config_0 dac_config_1 row_off_detect_bot[5] x3_net39
+ dac_config_2 vdda1 vssa1 vssc1 col_event_rst_bot_left[24] x3_net40 row_on_detect_bot[5]
+ row_off_detect_bot[4] openDVS_pixel2x2_bot
x3_x1140 dac_config_3 dac_config_5 col_event_rst_bot_left[23] dac_config_4
+ row_on_detect_bot[4] dac_config_0 dac_config_1 row_off_detect_bot[5] x3_net41
+ dac_config_2 vdda1 vssa1 vssc1 col_event_rst_bot_left[22] x3_net42 row_on_detect_bot[5]
+ row_off_detect_bot[4] openDVS_pixel2x2_bot
x3_x1141 dac_config_3 dac_config_5 col_event_rst_bot_left[21] dac_config_4
+ row_on_detect_bot[4] dac_config_0 dac_config_1 row_off_detect_bot[5] x3_net43
+ dac_config_2 vdda1 vssa1 vssc1 col_event_rst_bot_left[20] x3_net44 row_on_detect_bot[5]
+ row_off_detect_bot[4] openDVS_pixel2x2_bot
x3_x1142 dac_config_3 dac_config_5 col_event_rst_bot_left[19] dac_config_4
+ row_on_detect_bot[4] dac_config_0 dac_config_1 row_off_detect_bot[5] x3_net45
+ dac_config_2 vdda1 vssa1 vssc1 col_event_rst_bot_left[18] x3_net46 row_on_detect_bot[5]
+ row_off_detect_bot[4] openDVS_pixel2x2_bot
x3_x1143 dac_config_3 dac_config_5 col_event_rst_bot_left[17] dac_config_4
+ row_on_detect_bot[4] dac_config_0 dac_config_1 row_off_detect_bot[5] x3_net47
+ dac_config_2 vdda1 vssa1 vssc1 col_event_rst_bot_left[16] x3_net48 row_on_detect_bot[5]
+ row_off_detect_bot[4] openDVS_pixel2x2_bot
x3_x1144 dac_config_3 dac_config_5 col_event_rst_bot_left[15] dac_config_4
+ row_on_detect_bot[4] dac_config_0 dac_config_1 row_off_detect_bot[5] x3_net49
+ dac_config_2 vdda1 vssa1 vssc1 col_event_rst_bot_left[14] x3_net50 row_on_detect_bot[5]
+ row_off_detect_bot[4] openDVS_pixel2x2_bot
x3_x1145 dac_config_3 dac_config_5 col_event_rst_bot_left[13] dac_config_4
+ row_on_detect_bot[4] dac_config_0 dac_config_1 row_off_detect_bot[5] x3_net51
+ dac_config_2 vdda1 vssa1 vssc1 col_event_rst_bot_left[12] x3_net52 row_on_detect_bot[5]
+ row_off_detect_bot[4] openDVS_pixel2x2_bot
x3_x1146 dac_config_3 dac_config_5 col_event_rst_bot_left[11] dac_config_4
+ row_on_detect_bot[4] dac_config_0 dac_config_1 row_off_detect_bot[5] x3_net53
+ dac_config_2 vdda1 vssa1 vssc1 col_event_rst_bot_left[10] x3_net54 row_on_detect_bot[5]
+ row_off_detect_bot[4] openDVS_pixel2x2_bot
x3_x1147 dac_config_3 dac_config_5 col_event_rst_bot_left[9] dac_config_4
+ row_on_detect_bot[4] dac_config_0 dac_config_1 row_off_detect_bot[5] x3_net55
+ dac_config_2 vdda1 vssa1 vssc1 col_event_rst_bot_left[8] x3_net56 row_on_detect_bot[5]
+ row_off_detect_bot[4] openDVS_pixel2x2_bot
x3_x1148 dac_config_3 dac_config_5 col_event_rst_bot_left[7] dac_config_4
+ row_on_detect_bot[4] dac_config_0 dac_config_1 row_off_detect_bot[5] x3_net57
+ dac_config_2 vdda1 vssa1 vssc1 col_event_rst_bot_left[6] x3_net58 row_on_detect_bot[5]
+ row_off_detect_bot[4] openDVS_pixel2x2_bot
x3_x1149 dac_config_3 dac_config_5 col_event_rst_bot_left[5] dac_config_4
+ row_on_detect_bot[4] dac_config_0 dac_config_1 row_off_detect_bot[5] x3_net59
+ dac_config_2 vdda1 vssa1 vssc1 col_event_rst_bot_left[4] x3_net60 row_on_detect_bot[5]
+ row_off_detect_bot[4] openDVS_pixel2x2_bot
x3_x1150 dac_config_3 dac_config_5 col_event_rst_bot_left[3] dac_config_4
+ row_on_detect_bot[4] dac_config_0 dac_config_1 row_off_detect_bot[5] x3_net61
+ dac_config_2 vdda1 vssa1 vssc1 col_event_rst_bot_left[2] x3_net62 row_on_detect_bot[5]
+ row_off_detect_bot[4] openDVS_pixel2x2_bot
x3_x1151 dac_config_3 dac_config_5 col_event_rst_bot_left[1] dac_config_4
+ row_on_detect_bot[4] dac_config_0 dac_config_1 row_off_detect_bot[5] x3_net63
+ dac_config_2 vdda1 vssa1 vssc1 col_event_rst_bot_left[0] x3_net64 row_on_detect_bot[5]
+ row_off_detect_bot[4] openDVS_pixel2x2_bot
x3_x1152 dac_config_3 dac_config_5 col_event_rst_bot_left[63] dac_config_4
+ row_on_detect_bot[6] dac_config_0 dac_config_1 row_off_detect_bot[7] x3_net1
+ dac_config_2 vdda1 vssa1 vssc1 col_event_rst_bot_left[62] x3_net2 row_on_detect_bot[7]
+ row_off_detect_bot[6] openDVS_pixel2x2_bot
x3_x1153 dac_config_3 dac_config_5 col_event_rst_bot_left[61] dac_config_4
+ row_on_detect_bot[6] dac_config_0 dac_config_1 row_off_detect_bot[7] x3_net3
+ dac_config_2 vdda1 vssa1 vssc1 col_event_rst_bot_left[60] x3_net4 row_on_detect_bot[7]
+ row_off_detect_bot[6] openDVS_pixel2x2_bot
x3_x1154 dac_config_3 dac_config_5 col_event_rst_bot_left[59] dac_config_4
+ row_on_detect_bot[6] dac_config_0 dac_config_1 row_off_detect_bot[7] x3_net5
+ dac_config_2 vdda1 vssa1 vssc1 col_event_rst_bot_left[58] x3_net6 row_on_detect_bot[7]
+ row_off_detect_bot[6] openDVS_pixel2x2_bot
x3_x1155 dac_config_3 dac_config_5 col_event_rst_bot_left[57] dac_config_4
+ row_on_detect_bot[6] dac_config_0 dac_config_1 row_off_detect_bot[7] x3_net7
+ dac_config_2 vdda1 vssa1 vssc1 col_event_rst_bot_left[56] x3_net8 row_on_detect_bot[7]
+ row_off_detect_bot[6] openDVS_pixel2x2_bot
x3_x1156 dac_config_3 dac_config_5 col_event_rst_bot_left[55] dac_config_4
+ row_on_detect_bot[6] dac_config_0 dac_config_1 row_off_detect_bot[7] x3_net9
+ dac_config_2 vdda1 vssa1 vssc1 col_event_rst_bot_left[54] x3_net10 row_on_detect_bot[7]
+ row_off_detect_bot[6] openDVS_pixel2x2_bot
x3_x1157 dac_config_3 dac_config_5 col_event_rst_bot_left[53] dac_config_4
+ row_on_detect_bot[6] dac_config_0 dac_config_1 row_off_detect_bot[7] x3_net11
+ dac_config_2 vdda1 vssa1 vssc1 col_event_rst_bot_left[52] x3_net12 row_on_detect_bot[7]
+ row_off_detect_bot[6] openDVS_pixel2x2_bot
x3_x1158 dac_config_3 dac_config_5 col_event_rst_bot_left[51] dac_config_4
+ row_on_detect_bot[6] dac_config_0 dac_config_1 row_off_detect_bot[7] x3_net13
+ dac_config_2 vdda1 vssa1 vssc1 col_event_rst_bot_left[50] x3_net14 row_on_detect_bot[7]
+ row_off_detect_bot[6] openDVS_pixel2x2_bot
x3_x1159 dac_config_3 dac_config_5 col_event_rst_bot_left[49] dac_config_4
+ row_on_detect_bot[6] dac_config_0 dac_config_1 row_off_detect_bot[7] x3_net15
+ dac_config_2 vdda1 vssa1 vssc1 col_event_rst_bot_left[48] x3_net16 row_on_detect_bot[7]
+ row_off_detect_bot[6] openDVS_pixel2x2_bot
x3_x1160 dac_config_3 dac_config_5 col_event_rst_bot_left[47] dac_config_4
+ row_on_detect_bot[6] dac_config_0 dac_config_1 row_off_detect_bot[7] x3_net17
+ dac_config_2 vdda1 vssa1 vssc1 col_event_rst_bot_left[46] x3_net18 row_on_detect_bot[7]
+ row_off_detect_bot[6] openDVS_pixel2x2_bot
x3_x1161 dac_config_3 dac_config_5 col_event_rst_bot_left[45] dac_config_4
+ row_on_detect_bot[6] dac_config_0 dac_config_1 row_off_detect_bot[7] x3_net19
+ dac_config_2 vdda1 vssa1 vssc1 col_event_rst_bot_left[44] x3_net20 row_on_detect_bot[7]
+ row_off_detect_bot[6] openDVS_pixel2x2_bot
x3_x1162 dac_config_3 dac_config_5 col_event_rst_bot_left[43] dac_config_4
+ row_on_detect_bot[6] dac_config_0 dac_config_1 row_off_detect_bot[7] x3_net21
+ dac_config_2 vdda1 vssa1 vssc1 col_event_rst_bot_left[42] x3_net22 row_on_detect_bot[7]
+ row_off_detect_bot[6] openDVS_pixel2x2_bot
x3_x1163 dac_config_3 dac_config_5 col_event_rst_bot_left[41] dac_config_4
+ row_on_detect_bot[6] dac_config_0 dac_config_1 row_off_detect_bot[7] x3_net23
+ dac_config_2 vdda1 vssa1 vssc1 col_event_rst_bot_left[40] x3_net24 row_on_detect_bot[7]
+ row_off_detect_bot[6] openDVS_pixel2x2_bot
x3_x1164 dac_config_3 dac_config_5 col_event_rst_bot_left[39] dac_config_4
+ row_on_detect_bot[6] dac_config_0 dac_config_1 row_off_detect_bot[7] x3_net25
+ dac_config_2 vdda1 vssa1 vssc1 col_event_rst_bot_left[38] x3_net26 row_on_detect_bot[7]
+ row_off_detect_bot[6] openDVS_pixel2x2_bot
x3_x1165 dac_config_3 dac_config_5 col_event_rst_bot_left[37] dac_config_4
+ row_on_detect_bot[6] dac_config_0 dac_config_1 row_off_detect_bot[7] x3_net27
+ dac_config_2 vdda1 vssa1 vssc1 col_event_rst_bot_left[36] x3_net28 row_on_detect_bot[7]
+ row_off_detect_bot[6] openDVS_pixel2x2_bot
x3_x1166 dac_config_3 dac_config_5 col_event_rst_bot_left[35] dac_config_4
+ row_on_detect_bot[6] dac_config_0 dac_config_1 row_off_detect_bot[7] x3_net29
+ dac_config_2 vdda1 vssa1 vssc1 col_event_rst_bot_left[34] x3_net30 row_on_detect_bot[7]
+ row_off_detect_bot[6] openDVS_pixel2x2_bot
x3_x1167 dac_config_3 dac_config_5 col_event_rst_bot_left[33] dac_config_4
+ row_on_detect_bot[6] dac_config_0 dac_config_1 row_off_detect_bot[7] x3_net31
+ dac_config_2 vdda1 vssa1 vssc1 col_event_rst_bot_left[32] x3_net32 row_on_detect_bot[7]
+ row_off_detect_bot[6] openDVS_pixel2x2_bot
x3_x1168 dac_config_3 dac_config_5 col_event_rst_bot_left[31] dac_config_4
+ row_on_detect_bot[6] dac_config_0 dac_config_1 row_off_detect_bot[7] x3_net33
+ dac_config_2 vdda1 vssa1 vssc1 col_event_rst_bot_left[30] x3_net34 row_on_detect_bot[7]
+ row_off_detect_bot[6] openDVS_pixel2x2_bot
x3_x1169 dac_config_3 dac_config_5 col_event_rst_bot_left[29] dac_config_4
+ row_on_detect_bot[6] dac_config_0 dac_config_1 row_off_detect_bot[7] x3_net35
+ dac_config_2 vdda1 vssa1 vssc1 col_event_rst_bot_left[28] x3_net36 row_on_detect_bot[7]
+ row_off_detect_bot[6] openDVS_pixel2x2_bot
x3_x1170 dac_config_3 dac_config_5 col_event_rst_bot_left[27] dac_config_4
+ row_on_detect_bot[6] dac_config_0 dac_config_1 row_off_detect_bot[7] x3_net37
+ dac_config_2 vdda1 vssa1 vssc1 col_event_rst_bot_left[26] x3_net38 row_on_detect_bot[7]
+ row_off_detect_bot[6] openDVS_pixel2x2_bot
x3_x1171 dac_config_3 dac_config_5 col_event_rst_bot_left[25] dac_config_4
+ row_on_detect_bot[6] dac_config_0 dac_config_1 row_off_detect_bot[7] x3_net39
+ dac_config_2 vdda1 vssa1 vssc1 col_event_rst_bot_left[24] x3_net40 row_on_detect_bot[7]
+ row_off_detect_bot[6] openDVS_pixel2x2_bot
x3_x1172 dac_config_3 dac_config_5 col_event_rst_bot_left[23] dac_config_4
+ row_on_detect_bot[6] dac_config_0 dac_config_1 row_off_detect_bot[7] x3_net41
+ dac_config_2 vdda1 vssa1 vssc1 col_event_rst_bot_left[22] x3_net42 row_on_detect_bot[7]
+ row_off_detect_bot[6] openDVS_pixel2x2_bot
x3_x1173 dac_config_3 dac_config_5 col_event_rst_bot_left[21] dac_config_4
+ row_on_detect_bot[6] dac_config_0 dac_config_1 row_off_detect_bot[7] x3_net43
+ dac_config_2 vdda1 vssa1 vssc1 col_event_rst_bot_left[20] x3_net44 row_on_detect_bot[7]
+ row_off_detect_bot[6] openDVS_pixel2x2_bot
x3_x1174 dac_config_3 dac_config_5 col_event_rst_bot_left[19] dac_config_4
+ row_on_detect_bot[6] dac_config_0 dac_config_1 row_off_detect_bot[7] x3_net45
+ dac_config_2 vdda1 vssa1 vssc1 col_event_rst_bot_left[18] x3_net46 row_on_detect_bot[7]
+ row_off_detect_bot[6] openDVS_pixel2x2_bot
x3_x1175 dac_config_3 dac_config_5 col_event_rst_bot_left[17] dac_config_4
+ row_on_detect_bot[6] dac_config_0 dac_config_1 row_off_detect_bot[7] x3_net47
+ dac_config_2 vdda1 vssa1 vssc1 col_event_rst_bot_left[16] x3_net48 row_on_detect_bot[7]
+ row_off_detect_bot[6] openDVS_pixel2x2_bot
x3_x1176 dac_config_3 dac_config_5 col_event_rst_bot_left[15] dac_config_4
+ row_on_detect_bot[6] dac_config_0 dac_config_1 row_off_detect_bot[7] x3_net49
+ dac_config_2 vdda1 vssa1 vssc1 col_event_rst_bot_left[14] x3_net50 row_on_detect_bot[7]
+ row_off_detect_bot[6] openDVS_pixel2x2_bot
x3_x1177 dac_config_3 dac_config_5 col_event_rst_bot_left[13] dac_config_4
+ row_on_detect_bot[6] dac_config_0 dac_config_1 row_off_detect_bot[7] x3_net51
+ dac_config_2 vdda1 vssa1 vssc1 col_event_rst_bot_left[12] x3_net52 row_on_detect_bot[7]
+ row_off_detect_bot[6] openDVS_pixel2x2_bot
x3_x1178 dac_config_3 dac_config_5 col_event_rst_bot_left[11] dac_config_4
+ row_on_detect_bot[6] dac_config_0 dac_config_1 row_off_detect_bot[7] x3_net53
+ dac_config_2 vdda1 vssa1 vssc1 col_event_rst_bot_left[10] x3_net54 row_on_detect_bot[7]
+ row_off_detect_bot[6] openDVS_pixel2x2_bot
x3_x1179 dac_config_3 dac_config_5 col_event_rst_bot_left[9] dac_config_4
+ row_on_detect_bot[6] dac_config_0 dac_config_1 row_off_detect_bot[7] x3_net55
+ dac_config_2 vdda1 vssa1 vssc1 col_event_rst_bot_left[8] x3_net56 row_on_detect_bot[7]
+ row_off_detect_bot[6] openDVS_pixel2x2_bot
x3_x1180 dac_config_3 dac_config_5 col_event_rst_bot_left[7] dac_config_4
+ row_on_detect_bot[6] dac_config_0 dac_config_1 row_off_detect_bot[7] x3_net57
+ dac_config_2 vdda1 vssa1 vssc1 col_event_rst_bot_left[6] x3_net58 row_on_detect_bot[7]
+ row_off_detect_bot[6] openDVS_pixel2x2_bot
x3_x1181 dac_config_3 dac_config_5 col_event_rst_bot_left[5] dac_config_4
+ row_on_detect_bot[6] dac_config_0 dac_config_1 row_off_detect_bot[7] x3_net59
+ dac_config_2 vdda1 vssa1 vssc1 col_event_rst_bot_left[4] x3_net60 row_on_detect_bot[7]
+ row_off_detect_bot[6] openDVS_pixel2x2_bot
x3_x1182 dac_config_3 dac_config_5 col_event_rst_bot_left[3] dac_config_4
+ row_on_detect_bot[6] dac_config_0 dac_config_1 row_off_detect_bot[7] x3_net61
+ dac_config_2 vdda1 vssa1 vssc1 col_event_rst_bot_left[2] x3_net62 row_on_detect_bot[7]
+ row_off_detect_bot[6] openDVS_pixel2x2_bot
x3_x1183 dac_config_3 dac_config_5 col_event_rst_bot_left[1] dac_config_4
+ row_on_detect_bot[6] dac_config_0 dac_config_1 row_off_detect_bot[7] x3_net63
+ dac_config_2 vdda1 vssa1 vssc1 col_event_rst_bot_left[0] x3_net64 row_on_detect_bot[7]
+ row_off_detect_bot[6] openDVS_pixel2x2_bot
x3_x1184 dac_config_3 dac_config_5 col_event_rst_bot_left[63] dac_config_4
+ row_on_detect_bot[8] dac_config_0 dac_config_1 row_off_detect_bot[9] x3_net1
+ dac_config_2 vdda1 vssa1 vssc1 col_event_rst_bot_left[62] x3_net2 row_on_detect_bot[9]
+ row_off_detect_bot[8] openDVS_pixel2x2_bot
x3_x1185 dac_config_3 dac_config_5 col_event_rst_bot_left[61] dac_config_4
+ row_on_detect_bot[8] dac_config_0 dac_config_1 row_off_detect_bot[9] x3_net3
+ dac_config_2 vdda1 vssa1 vssc1 col_event_rst_bot_left[60] x3_net4 row_on_detect_bot[9]
+ row_off_detect_bot[8] openDVS_pixel2x2_bot
x3_x1186 dac_config_3 dac_config_5 col_event_rst_bot_left[59] dac_config_4
+ row_on_detect_bot[8] dac_config_0 dac_config_1 row_off_detect_bot[9] x3_net5
+ dac_config_2 vdda1 vssa1 vssc1 col_event_rst_bot_left[58] x3_net6 row_on_detect_bot[9]
+ row_off_detect_bot[8] openDVS_pixel2x2_bot
x3_x1187 dac_config_3 dac_config_5 col_event_rst_bot_left[57] dac_config_4
+ row_on_detect_bot[8] dac_config_0 dac_config_1 row_off_detect_bot[9] x3_net7
+ dac_config_2 vdda1 vssa1 vssc1 col_event_rst_bot_left[56] x3_net8 row_on_detect_bot[9]
+ row_off_detect_bot[8] openDVS_pixel2x2_bot
x3_x1188 dac_config_3 dac_config_5 col_event_rst_bot_left[55] dac_config_4
+ row_on_detect_bot[8] dac_config_0 dac_config_1 row_off_detect_bot[9] x3_net9
+ dac_config_2 vdda1 vssa1 vssc1 col_event_rst_bot_left[54] x3_net10 row_on_detect_bot[9]
+ row_off_detect_bot[8] openDVS_pixel2x2_bot
x3_x1189 dac_config_3 dac_config_5 col_event_rst_bot_left[53] dac_config_4
+ row_on_detect_bot[8] dac_config_0 dac_config_1 row_off_detect_bot[9] x3_net11
+ dac_config_2 vdda1 vssa1 vssc1 col_event_rst_bot_left[52] x3_net12 row_on_detect_bot[9]
+ row_off_detect_bot[8] openDVS_pixel2x2_bot
x3_x1190 dac_config_3 dac_config_5 col_event_rst_bot_left[51] dac_config_4
+ row_on_detect_bot[8] dac_config_0 dac_config_1 row_off_detect_bot[9] x3_net13
+ dac_config_2 vdda1 vssa1 vssc1 col_event_rst_bot_left[50] x3_net14 row_on_detect_bot[9]
+ row_off_detect_bot[8] openDVS_pixel2x2_bot
x3_x1191 dac_config_3 dac_config_5 col_event_rst_bot_left[49] dac_config_4
+ row_on_detect_bot[8] dac_config_0 dac_config_1 row_off_detect_bot[9] x3_net15
+ dac_config_2 vdda1 vssa1 vssc1 col_event_rst_bot_left[48] x3_net16 row_on_detect_bot[9]
+ row_off_detect_bot[8] openDVS_pixel2x2_bot
x3_x1192 dac_config_3 dac_config_5 col_event_rst_bot_left[47] dac_config_4
+ row_on_detect_bot[8] dac_config_0 dac_config_1 row_off_detect_bot[9] x3_net17
+ dac_config_2 vdda1 vssa1 vssc1 col_event_rst_bot_left[46] x3_net18 row_on_detect_bot[9]
+ row_off_detect_bot[8] openDVS_pixel2x2_bot
x3_x1193 dac_config_3 dac_config_5 col_event_rst_bot_left[45] dac_config_4
+ row_on_detect_bot[8] dac_config_0 dac_config_1 row_off_detect_bot[9] x3_net19
+ dac_config_2 vdda1 vssa1 vssc1 col_event_rst_bot_left[44] x3_net20 row_on_detect_bot[9]
+ row_off_detect_bot[8] openDVS_pixel2x2_bot
x3_x1194 dac_config_3 dac_config_5 col_event_rst_bot_left[43] dac_config_4
+ row_on_detect_bot[8] dac_config_0 dac_config_1 row_off_detect_bot[9] x3_net21
+ dac_config_2 vdda1 vssa1 vssc1 col_event_rst_bot_left[42] x3_net22 row_on_detect_bot[9]
+ row_off_detect_bot[8] openDVS_pixel2x2_bot
x3_x1195 dac_config_3 dac_config_5 col_event_rst_bot_left[41] dac_config_4
+ row_on_detect_bot[8] dac_config_0 dac_config_1 row_off_detect_bot[9] x3_net23
+ dac_config_2 vdda1 vssa1 vssc1 col_event_rst_bot_left[40] x3_net24 row_on_detect_bot[9]
+ row_off_detect_bot[8] openDVS_pixel2x2_bot
x3_x1196 dac_config_3 dac_config_5 col_event_rst_bot_left[39] dac_config_4
+ row_on_detect_bot[8] dac_config_0 dac_config_1 row_off_detect_bot[9] x3_net25
+ dac_config_2 vdda1 vssa1 vssc1 col_event_rst_bot_left[38] x3_net26 row_on_detect_bot[9]
+ row_off_detect_bot[8] openDVS_pixel2x2_bot
x3_x1197 dac_config_3 dac_config_5 col_event_rst_bot_left[37] dac_config_4
+ row_on_detect_bot[8] dac_config_0 dac_config_1 row_off_detect_bot[9] x3_net27
+ dac_config_2 vdda1 vssa1 vssc1 col_event_rst_bot_left[36] x3_net28 row_on_detect_bot[9]
+ row_off_detect_bot[8] openDVS_pixel2x2_bot
x3_x1198 dac_config_3 dac_config_5 col_event_rst_bot_left[35] dac_config_4
+ row_on_detect_bot[8] dac_config_0 dac_config_1 row_off_detect_bot[9] x3_net29
+ dac_config_2 vdda1 vssa1 vssc1 col_event_rst_bot_left[34] x3_net30 row_on_detect_bot[9]
+ row_off_detect_bot[8] openDVS_pixel2x2_bot
x3_x1199 dac_config_3 dac_config_5 col_event_rst_bot_left[33] dac_config_4
+ row_on_detect_bot[8] dac_config_0 dac_config_1 row_off_detect_bot[9] x3_net31
+ dac_config_2 vdda1 vssa1 vssc1 col_event_rst_bot_left[32] x3_net32 row_on_detect_bot[9]
+ row_off_detect_bot[8] openDVS_pixel2x2_bot
x3_x1200 dac_config_3 dac_config_5 col_event_rst_bot_left[31] dac_config_4
+ row_on_detect_bot[8] dac_config_0 dac_config_1 row_off_detect_bot[9] x3_net33
+ dac_config_2 vdda1 vssa1 vssc1 col_event_rst_bot_left[30] x3_net34 row_on_detect_bot[9]
+ row_off_detect_bot[8] openDVS_pixel2x2_bot
x3_x1201 dac_config_3 dac_config_5 col_event_rst_bot_left[29] dac_config_4
+ row_on_detect_bot[8] dac_config_0 dac_config_1 row_off_detect_bot[9] x3_net35
+ dac_config_2 vdda1 vssa1 vssc1 col_event_rst_bot_left[28] x3_net36 row_on_detect_bot[9]
+ row_off_detect_bot[8] openDVS_pixel2x2_bot
x3_x1202 dac_config_3 dac_config_5 col_event_rst_bot_left[27] dac_config_4
+ row_on_detect_bot[8] dac_config_0 dac_config_1 row_off_detect_bot[9] x3_net37
+ dac_config_2 vdda1 vssa1 vssc1 col_event_rst_bot_left[26] x3_net38 row_on_detect_bot[9]
+ row_off_detect_bot[8] openDVS_pixel2x2_bot
x3_x1203 dac_config_3 dac_config_5 col_event_rst_bot_left[25] dac_config_4
+ row_on_detect_bot[8] dac_config_0 dac_config_1 row_off_detect_bot[9] x3_net39
+ dac_config_2 vdda1 vssa1 vssc1 col_event_rst_bot_left[24] x3_net40 row_on_detect_bot[9]
+ row_off_detect_bot[8] openDVS_pixel2x2_bot
x3_x1204 dac_config_3 dac_config_5 col_event_rst_bot_left[23] dac_config_4
+ row_on_detect_bot[8] dac_config_0 dac_config_1 row_off_detect_bot[9] x3_net41
+ dac_config_2 vdda1 vssa1 vssc1 col_event_rst_bot_left[22] x3_net42 row_on_detect_bot[9]
+ row_off_detect_bot[8] openDVS_pixel2x2_bot
x3_x1205 dac_config_3 dac_config_5 col_event_rst_bot_left[21] dac_config_4
+ row_on_detect_bot[8] dac_config_0 dac_config_1 row_off_detect_bot[9] x3_net43
+ dac_config_2 vdda1 vssa1 vssc1 col_event_rst_bot_left[20] x3_net44 row_on_detect_bot[9]
+ row_off_detect_bot[8] openDVS_pixel2x2_bot
x3_x1206 dac_config_3 dac_config_5 col_event_rst_bot_left[19] dac_config_4
+ row_on_detect_bot[8] dac_config_0 dac_config_1 row_off_detect_bot[9] x3_net45
+ dac_config_2 vdda1 vssa1 vssc1 col_event_rst_bot_left[18] x3_net46 row_on_detect_bot[9]
+ row_off_detect_bot[8] openDVS_pixel2x2_bot
x3_x1207 dac_config_3 dac_config_5 col_event_rst_bot_left[17] dac_config_4
+ row_on_detect_bot[8] dac_config_0 dac_config_1 row_off_detect_bot[9] x3_net47
+ dac_config_2 vdda1 vssa1 vssc1 col_event_rst_bot_left[16] x3_net48 row_on_detect_bot[9]
+ row_off_detect_bot[8] openDVS_pixel2x2_bot
x3_x1208 dac_config_3 dac_config_5 col_event_rst_bot_left[15] dac_config_4
+ row_on_detect_bot[8] dac_config_0 dac_config_1 row_off_detect_bot[9] x3_net49
+ dac_config_2 vdda1 vssa1 vssc1 col_event_rst_bot_left[14] x3_net50 row_on_detect_bot[9]
+ row_off_detect_bot[8] openDVS_pixel2x2_bot
x3_x1209 dac_config_3 dac_config_5 col_event_rst_bot_left[13] dac_config_4
+ row_on_detect_bot[8] dac_config_0 dac_config_1 row_off_detect_bot[9] x3_net51
+ dac_config_2 vdda1 vssa1 vssc1 col_event_rst_bot_left[12] x3_net52 row_on_detect_bot[9]
+ row_off_detect_bot[8] openDVS_pixel2x2_bot
x3_x1210 dac_config_3 dac_config_5 col_event_rst_bot_left[11] dac_config_4
+ row_on_detect_bot[8] dac_config_0 dac_config_1 row_off_detect_bot[9] x3_net53
+ dac_config_2 vdda1 vssa1 vssc1 col_event_rst_bot_left[10] x3_net54 row_on_detect_bot[9]
+ row_off_detect_bot[8] openDVS_pixel2x2_bot
x3_x1211 dac_config_3 dac_config_5 col_event_rst_bot_left[9] dac_config_4
+ row_on_detect_bot[8] dac_config_0 dac_config_1 row_off_detect_bot[9] x3_net55
+ dac_config_2 vdda1 vssa1 vssc1 col_event_rst_bot_left[8] x3_net56 row_on_detect_bot[9]
+ row_off_detect_bot[8] openDVS_pixel2x2_bot
x3_x1212 dac_config_3 dac_config_5 col_event_rst_bot_left[7] dac_config_4
+ row_on_detect_bot[8] dac_config_0 dac_config_1 row_off_detect_bot[9] x3_net57
+ dac_config_2 vdda1 vssa1 vssc1 col_event_rst_bot_left[6] x3_net58 row_on_detect_bot[9]
+ row_off_detect_bot[8] openDVS_pixel2x2_bot
x3_x1213 dac_config_3 dac_config_5 col_event_rst_bot_left[5] dac_config_4
+ row_on_detect_bot[8] dac_config_0 dac_config_1 row_off_detect_bot[9] x3_net59
+ dac_config_2 vdda1 vssa1 vssc1 col_event_rst_bot_left[4] x3_net60 row_on_detect_bot[9]
+ row_off_detect_bot[8] openDVS_pixel2x2_bot
x3_x1214 dac_config_3 dac_config_5 col_event_rst_bot_left[3] dac_config_4
+ row_on_detect_bot[8] dac_config_0 dac_config_1 row_off_detect_bot[9] x3_net61
+ dac_config_2 vdda1 vssa1 vssc1 col_event_rst_bot_left[2] x3_net62 row_on_detect_bot[9]
+ row_off_detect_bot[8] openDVS_pixel2x2_bot
x3_x1215 dac_config_3 dac_config_5 col_event_rst_bot_left[1] dac_config_4
+ row_on_detect_bot[8] dac_config_0 dac_config_1 row_off_detect_bot[9] x3_net63
+ dac_config_2 vdda1 vssa1 vssc1 col_event_rst_bot_left[0] x3_net64 row_on_detect_bot[9]
+ row_off_detect_bot[8] openDVS_pixel2x2_bot
x3_x1216 dac_config_3 dac_config_5 col_event_rst_bot_left[63] dac_config_4
+ row_on_detect_bot[10] dac_config_0 dac_config_1 row_off_detect_bot[11] x3_net1
+ dac_config_2 vdda1 vssa1 vssc1 col_event_rst_bot_left[62] x3_net2 row_on_detect_bot[11]
+ row_off_detect_bot[10] openDVS_pixel2x2_bot
x3_x1217 dac_config_3 dac_config_5 col_event_rst_bot_left[61] dac_config_4
+ row_on_detect_bot[10] dac_config_0 dac_config_1 row_off_detect_bot[11] x3_net3
+ dac_config_2 vdda1 vssa1 vssc1 col_event_rst_bot_left[60] x3_net4 row_on_detect_bot[11]
+ row_off_detect_bot[10] openDVS_pixel2x2_bot
x3_x1218 dac_config_3 dac_config_5 col_event_rst_bot_left[59] dac_config_4
+ row_on_detect_bot[10] dac_config_0 dac_config_1 row_off_detect_bot[11] x3_net5
+ dac_config_2 vdda1 vssa1 vssc1 col_event_rst_bot_left[58] x3_net6 row_on_detect_bot[11]
+ row_off_detect_bot[10] openDVS_pixel2x2_bot
x3_x1219 dac_config_3 dac_config_5 col_event_rst_bot_left[57] dac_config_4
+ row_on_detect_bot[10] dac_config_0 dac_config_1 row_off_detect_bot[11] x3_net7
+ dac_config_2 vdda1 vssa1 vssc1 col_event_rst_bot_left[56] x3_net8 row_on_detect_bot[11]
+ row_off_detect_bot[10] openDVS_pixel2x2_bot
x3_x1220 dac_config_3 dac_config_5 col_event_rst_bot_left[55] dac_config_4
+ row_on_detect_bot[10] dac_config_0 dac_config_1 row_off_detect_bot[11] x3_net9
+ dac_config_2 vdda1 vssa1 vssc1 col_event_rst_bot_left[54] x3_net10 row_on_detect_bot[11]
+ row_off_detect_bot[10] openDVS_pixel2x2_bot
x3_x1221 dac_config_3 dac_config_5 col_event_rst_bot_left[53] dac_config_4
+ row_on_detect_bot[10] dac_config_0 dac_config_1 row_off_detect_bot[11] x3_net11
+ dac_config_2 vdda1 vssa1 vssc1 col_event_rst_bot_left[52] x3_net12 row_on_detect_bot[11]
+ row_off_detect_bot[10] openDVS_pixel2x2_bot
x3_x1222 dac_config_3 dac_config_5 col_event_rst_bot_left[51] dac_config_4
+ row_on_detect_bot[10] dac_config_0 dac_config_1 row_off_detect_bot[11] x3_net13
+ dac_config_2 vdda1 vssa1 vssc1 col_event_rst_bot_left[50] x3_net14 row_on_detect_bot[11]
+ row_off_detect_bot[10] openDVS_pixel2x2_bot
x3_x1223 dac_config_3 dac_config_5 col_event_rst_bot_left[49] dac_config_4
+ row_on_detect_bot[10] dac_config_0 dac_config_1 row_off_detect_bot[11] x3_net15
+ dac_config_2 vdda1 vssa1 vssc1 col_event_rst_bot_left[48] x3_net16 row_on_detect_bot[11]
+ row_off_detect_bot[10] openDVS_pixel2x2_bot
x3_x1224 dac_config_3 dac_config_5 col_event_rst_bot_left[47] dac_config_4
+ row_on_detect_bot[10] dac_config_0 dac_config_1 row_off_detect_bot[11] x3_net17
+ dac_config_2 vdda1 vssa1 vssc1 col_event_rst_bot_left[46] x3_net18 row_on_detect_bot[11]
+ row_off_detect_bot[10] openDVS_pixel2x2_bot
x3_x1225 dac_config_3 dac_config_5 col_event_rst_bot_left[45] dac_config_4
+ row_on_detect_bot[10] dac_config_0 dac_config_1 row_off_detect_bot[11] x3_net19
+ dac_config_2 vdda1 vssa1 vssc1 col_event_rst_bot_left[44] x3_net20 row_on_detect_bot[11]
+ row_off_detect_bot[10] openDVS_pixel2x2_bot
x3_x1226 dac_config_3 dac_config_5 col_event_rst_bot_left[43] dac_config_4
+ row_on_detect_bot[10] dac_config_0 dac_config_1 row_off_detect_bot[11] x3_net21
+ dac_config_2 vdda1 vssa1 vssc1 col_event_rst_bot_left[42] x3_net22 row_on_detect_bot[11]
+ row_off_detect_bot[10] openDVS_pixel2x2_bot
x3_x1227 dac_config_3 dac_config_5 col_event_rst_bot_left[41] dac_config_4
+ row_on_detect_bot[10] dac_config_0 dac_config_1 row_off_detect_bot[11] x3_net23
+ dac_config_2 vdda1 vssa1 vssc1 col_event_rst_bot_left[40] x3_net24 row_on_detect_bot[11]
+ row_off_detect_bot[10] openDVS_pixel2x2_bot
x3_x1228 dac_config_3 dac_config_5 col_event_rst_bot_left[39] dac_config_4
+ row_on_detect_bot[10] dac_config_0 dac_config_1 row_off_detect_bot[11] x3_net25
+ dac_config_2 vdda1 vssa1 vssc1 col_event_rst_bot_left[38] x3_net26 row_on_detect_bot[11]
+ row_off_detect_bot[10] openDVS_pixel2x2_bot
x3_x1229 dac_config_3 dac_config_5 col_event_rst_bot_left[37] dac_config_4
+ row_on_detect_bot[10] dac_config_0 dac_config_1 row_off_detect_bot[11] x3_net27
+ dac_config_2 vdda1 vssa1 vssc1 col_event_rst_bot_left[36] x3_net28 row_on_detect_bot[11]
+ row_off_detect_bot[10] openDVS_pixel2x2_bot
x3_x1230 dac_config_3 dac_config_5 col_event_rst_bot_left[35] dac_config_4
+ row_on_detect_bot[10] dac_config_0 dac_config_1 row_off_detect_bot[11] x3_net29
+ dac_config_2 vdda1 vssa1 vssc1 col_event_rst_bot_left[34] x3_net30 row_on_detect_bot[11]
+ row_off_detect_bot[10] openDVS_pixel2x2_bot
x3_x1231 dac_config_3 dac_config_5 col_event_rst_bot_left[33] dac_config_4
+ row_on_detect_bot[10] dac_config_0 dac_config_1 row_off_detect_bot[11] x3_net31
+ dac_config_2 vdda1 vssa1 vssc1 col_event_rst_bot_left[32] x3_net32 row_on_detect_bot[11]
+ row_off_detect_bot[10] openDVS_pixel2x2_bot
x3_x1232 dac_config_3 dac_config_5 col_event_rst_bot_left[31] dac_config_4
+ row_on_detect_bot[10] dac_config_0 dac_config_1 row_off_detect_bot[11] x3_net33
+ dac_config_2 vdda1 vssa1 vssc1 col_event_rst_bot_left[30] x3_net34 row_on_detect_bot[11]
+ row_off_detect_bot[10] openDVS_pixel2x2_bot
x3_x1233 dac_config_3 dac_config_5 col_event_rst_bot_left[29] dac_config_4
+ row_on_detect_bot[10] dac_config_0 dac_config_1 row_off_detect_bot[11] x3_net35
+ dac_config_2 vdda1 vssa1 vssc1 col_event_rst_bot_left[28] x3_net36 row_on_detect_bot[11]
+ row_off_detect_bot[10] openDVS_pixel2x2_bot
x3_x1234 dac_config_3 dac_config_5 col_event_rst_bot_left[27] dac_config_4
+ row_on_detect_bot[10] dac_config_0 dac_config_1 row_off_detect_bot[11] x3_net37
+ dac_config_2 vdda1 vssa1 vssc1 col_event_rst_bot_left[26] x3_net38 row_on_detect_bot[11]
+ row_off_detect_bot[10] openDVS_pixel2x2_bot
x3_x1235 dac_config_3 dac_config_5 col_event_rst_bot_left[25] dac_config_4
+ row_on_detect_bot[10] dac_config_0 dac_config_1 row_off_detect_bot[11] x3_net39
+ dac_config_2 vdda1 vssa1 vssc1 col_event_rst_bot_left[24] x3_net40 row_on_detect_bot[11]
+ row_off_detect_bot[10] openDVS_pixel2x2_bot
x3_x1236 dac_config_3 dac_config_5 col_event_rst_bot_left[23] dac_config_4
+ row_on_detect_bot[10] dac_config_0 dac_config_1 row_off_detect_bot[11] x3_net41
+ dac_config_2 vdda1 vssa1 vssc1 col_event_rst_bot_left[22] x3_net42 row_on_detect_bot[11]
+ row_off_detect_bot[10] openDVS_pixel2x2_bot
x3_x1237 dac_config_3 dac_config_5 col_event_rst_bot_left[21] dac_config_4
+ row_on_detect_bot[10] dac_config_0 dac_config_1 row_off_detect_bot[11] x3_net43
+ dac_config_2 vdda1 vssa1 vssc1 col_event_rst_bot_left[20] x3_net44 row_on_detect_bot[11]
+ row_off_detect_bot[10] openDVS_pixel2x2_bot
x3_x1238 dac_config_3 dac_config_5 col_event_rst_bot_left[19] dac_config_4
+ row_on_detect_bot[10] dac_config_0 dac_config_1 row_off_detect_bot[11] x3_net45
+ dac_config_2 vdda1 vssa1 vssc1 col_event_rst_bot_left[18] x3_net46 row_on_detect_bot[11]
+ row_off_detect_bot[10] openDVS_pixel2x2_bot
x3_x1239 dac_config_3 dac_config_5 col_event_rst_bot_left[17] dac_config_4
+ row_on_detect_bot[10] dac_config_0 dac_config_1 row_off_detect_bot[11] x3_net47
+ dac_config_2 vdda1 vssa1 vssc1 col_event_rst_bot_left[16] x3_net48 row_on_detect_bot[11]
+ row_off_detect_bot[10] openDVS_pixel2x2_bot
x3_x1240 dac_config_3 dac_config_5 col_event_rst_bot_left[15] dac_config_4
+ row_on_detect_bot[10] dac_config_0 dac_config_1 row_off_detect_bot[11] x3_net49
+ dac_config_2 vdda1 vssa1 vssc1 col_event_rst_bot_left[14] x3_net50 row_on_detect_bot[11]
+ row_off_detect_bot[10] openDVS_pixel2x2_bot
x3_x1241 dac_config_3 dac_config_5 col_event_rst_bot_left[13] dac_config_4
+ row_on_detect_bot[10] dac_config_0 dac_config_1 row_off_detect_bot[11] x3_net51
+ dac_config_2 vdda1 vssa1 vssc1 col_event_rst_bot_left[12] x3_net52 row_on_detect_bot[11]
+ row_off_detect_bot[10] openDVS_pixel2x2_bot
x3_x1242 dac_config_3 dac_config_5 col_event_rst_bot_left[11] dac_config_4
+ row_on_detect_bot[10] dac_config_0 dac_config_1 row_off_detect_bot[11] x3_net53
+ dac_config_2 vdda1 vssa1 vssc1 col_event_rst_bot_left[10] x3_net54 row_on_detect_bot[11]
+ row_off_detect_bot[10] openDVS_pixel2x2_bot
x3_x1243 dac_config_3 dac_config_5 col_event_rst_bot_left[9] dac_config_4
+ row_on_detect_bot[10] dac_config_0 dac_config_1 row_off_detect_bot[11] x3_net55
+ dac_config_2 vdda1 vssa1 vssc1 col_event_rst_bot_left[8] x3_net56 row_on_detect_bot[11]
+ row_off_detect_bot[10] openDVS_pixel2x2_bot
x3_x1244 dac_config_3 dac_config_5 col_event_rst_bot_left[7] dac_config_4
+ row_on_detect_bot[10] dac_config_0 dac_config_1 row_off_detect_bot[11] x3_net57
+ dac_config_2 vdda1 vssa1 vssc1 col_event_rst_bot_left[6] x3_net58 row_on_detect_bot[11]
+ row_off_detect_bot[10] openDVS_pixel2x2_bot
x3_x1245 dac_config_3 dac_config_5 col_event_rst_bot_left[5] dac_config_4
+ row_on_detect_bot[10] dac_config_0 dac_config_1 row_off_detect_bot[11] x3_net59
+ dac_config_2 vdda1 vssa1 vssc1 col_event_rst_bot_left[4] x3_net60 row_on_detect_bot[11]
+ row_off_detect_bot[10] openDVS_pixel2x2_bot
x3_x1246 dac_config_3 dac_config_5 col_event_rst_bot_left[3] dac_config_4
+ row_on_detect_bot[10] dac_config_0 dac_config_1 row_off_detect_bot[11] x3_net61
+ dac_config_2 vdda1 vssa1 vssc1 col_event_rst_bot_left[2] x3_net62 row_on_detect_bot[11]
+ row_off_detect_bot[10] openDVS_pixel2x2_bot
x3_x1247 dac_config_3 dac_config_5 col_event_rst_bot_left[1] dac_config_4
+ row_on_detect_bot[10] dac_config_0 dac_config_1 row_off_detect_bot[11] x3_net63
+ dac_config_2 vdda1 vssa1 vssc1 col_event_rst_bot_left[0] x3_net64 row_on_detect_bot[11]
+ row_off_detect_bot[10] openDVS_pixel2x2_bot
x3_x1248 dac_config_3 dac_config_5 col_event_rst_bot_left[63] dac_config_4
+ row_on_detect_bot[12] dac_config_0 dac_config_1 row_off_detect_bot[13] x3_net1
+ dac_config_2 vdda1 vssa1 vssc1 col_event_rst_bot_left[62] x3_net2 row_on_detect_bot[13]
+ row_off_detect_bot[12] openDVS_pixel2x2_bot
x3_x1249 dac_config_3 dac_config_5 col_event_rst_bot_left[61] dac_config_4
+ row_on_detect_bot[12] dac_config_0 dac_config_1 row_off_detect_bot[13] x3_net3
+ dac_config_2 vdda1 vssa1 vssc1 col_event_rst_bot_left[60] x3_net4 row_on_detect_bot[13]
+ row_off_detect_bot[12] openDVS_pixel2x2_bot
x3_x1250 dac_config_3 dac_config_5 col_event_rst_bot_left[59] dac_config_4
+ row_on_detect_bot[12] dac_config_0 dac_config_1 row_off_detect_bot[13] x3_net5
+ dac_config_2 vdda1 vssa1 vssc1 col_event_rst_bot_left[58] x3_net6 row_on_detect_bot[13]
+ row_off_detect_bot[12] openDVS_pixel2x2_bot
x3_x1251 dac_config_3 dac_config_5 col_event_rst_bot_left[57] dac_config_4
+ row_on_detect_bot[12] dac_config_0 dac_config_1 row_off_detect_bot[13] x3_net7
+ dac_config_2 vdda1 vssa1 vssc1 col_event_rst_bot_left[56] x3_net8 row_on_detect_bot[13]
+ row_off_detect_bot[12] openDVS_pixel2x2_bot
x3_x1252 dac_config_3 dac_config_5 col_event_rst_bot_left[55] dac_config_4
+ row_on_detect_bot[12] dac_config_0 dac_config_1 row_off_detect_bot[13] x3_net9
+ dac_config_2 vdda1 vssa1 vssc1 col_event_rst_bot_left[54] x3_net10 row_on_detect_bot[13]
+ row_off_detect_bot[12] openDVS_pixel2x2_bot
x3_x1253 dac_config_3 dac_config_5 col_event_rst_bot_left[53] dac_config_4
+ row_on_detect_bot[12] dac_config_0 dac_config_1 row_off_detect_bot[13] x3_net11
+ dac_config_2 vdda1 vssa1 vssc1 col_event_rst_bot_left[52] x3_net12 row_on_detect_bot[13]
+ row_off_detect_bot[12] openDVS_pixel2x2_bot
x3_x1254 dac_config_3 dac_config_5 col_event_rst_bot_left[51] dac_config_4
+ row_on_detect_bot[12] dac_config_0 dac_config_1 row_off_detect_bot[13] x3_net13
+ dac_config_2 vdda1 vssa1 vssc1 col_event_rst_bot_left[50] x3_net14 row_on_detect_bot[13]
+ row_off_detect_bot[12] openDVS_pixel2x2_bot
x3_x1255 dac_config_3 dac_config_5 col_event_rst_bot_left[49] dac_config_4
+ row_on_detect_bot[12] dac_config_0 dac_config_1 row_off_detect_bot[13] x3_net15
+ dac_config_2 vdda1 vssa1 vssc1 col_event_rst_bot_left[48] x3_net16 row_on_detect_bot[13]
+ row_off_detect_bot[12] openDVS_pixel2x2_bot
x3_x1256 dac_config_3 dac_config_5 col_event_rst_bot_left[47] dac_config_4
+ row_on_detect_bot[12] dac_config_0 dac_config_1 row_off_detect_bot[13] x3_net17
+ dac_config_2 vdda1 vssa1 vssc1 col_event_rst_bot_left[46] x3_net18 row_on_detect_bot[13]
+ row_off_detect_bot[12] openDVS_pixel2x2_bot
x3_x1257 dac_config_3 dac_config_5 col_event_rst_bot_left[45] dac_config_4
+ row_on_detect_bot[12] dac_config_0 dac_config_1 row_off_detect_bot[13] x3_net19
+ dac_config_2 vdda1 vssa1 vssc1 col_event_rst_bot_left[44] x3_net20 row_on_detect_bot[13]
+ row_off_detect_bot[12] openDVS_pixel2x2_bot
x3_x1258 dac_config_3 dac_config_5 col_event_rst_bot_left[43] dac_config_4
+ row_on_detect_bot[12] dac_config_0 dac_config_1 row_off_detect_bot[13] x3_net21
+ dac_config_2 vdda1 vssa1 vssc1 col_event_rst_bot_left[42] x3_net22 row_on_detect_bot[13]
+ row_off_detect_bot[12] openDVS_pixel2x2_bot
x3_x1259 dac_config_3 dac_config_5 col_event_rst_bot_left[41] dac_config_4
+ row_on_detect_bot[12] dac_config_0 dac_config_1 row_off_detect_bot[13] x3_net23
+ dac_config_2 vdda1 vssa1 vssc1 col_event_rst_bot_left[40] x3_net24 row_on_detect_bot[13]
+ row_off_detect_bot[12] openDVS_pixel2x2_bot
x3_x1260 dac_config_3 dac_config_5 col_event_rst_bot_left[39] dac_config_4
+ row_on_detect_bot[12] dac_config_0 dac_config_1 row_off_detect_bot[13] x3_net25
+ dac_config_2 vdda1 vssa1 vssc1 col_event_rst_bot_left[38] x3_net26 row_on_detect_bot[13]
+ row_off_detect_bot[12] openDVS_pixel2x2_bot
x3_x1261 dac_config_3 dac_config_5 col_event_rst_bot_left[37] dac_config_4
+ row_on_detect_bot[12] dac_config_0 dac_config_1 row_off_detect_bot[13] x3_net27
+ dac_config_2 vdda1 vssa1 vssc1 col_event_rst_bot_left[36] x3_net28 row_on_detect_bot[13]
+ row_off_detect_bot[12] openDVS_pixel2x2_bot
x3_x1262 dac_config_3 dac_config_5 col_event_rst_bot_left[35] dac_config_4
+ row_on_detect_bot[12] dac_config_0 dac_config_1 row_off_detect_bot[13] x3_net29
+ dac_config_2 vdda1 vssa1 vssc1 col_event_rst_bot_left[34] x3_net30 row_on_detect_bot[13]
+ row_off_detect_bot[12] openDVS_pixel2x2_bot
x3_x1263 dac_config_3 dac_config_5 col_event_rst_bot_left[33] dac_config_4
+ row_on_detect_bot[12] dac_config_0 dac_config_1 row_off_detect_bot[13] x3_net31
+ dac_config_2 vdda1 vssa1 vssc1 col_event_rst_bot_left[32] x3_net32 row_on_detect_bot[13]
+ row_off_detect_bot[12] openDVS_pixel2x2_bot
x3_x1264 dac_config_3 dac_config_5 col_event_rst_bot_left[31] dac_config_4
+ row_on_detect_bot[12] dac_config_0 dac_config_1 row_off_detect_bot[13] x3_net33
+ dac_config_2 vdda1 vssa1 vssc1 col_event_rst_bot_left[30] x3_net34 row_on_detect_bot[13]
+ row_off_detect_bot[12] openDVS_pixel2x2_bot
x3_x1265 dac_config_3 dac_config_5 col_event_rst_bot_left[29] dac_config_4
+ row_on_detect_bot[12] dac_config_0 dac_config_1 row_off_detect_bot[13] x3_net35
+ dac_config_2 vdda1 vssa1 vssc1 col_event_rst_bot_left[28] x3_net36 row_on_detect_bot[13]
+ row_off_detect_bot[12] openDVS_pixel2x2_bot
x3_x1266 dac_config_3 dac_config_5 col_event_rst_bot_left[27] dac_config_4
+ row_on_detect_bot[12] dac_config_0 dac_config_1 row_off_detect_bot[13] x3_net37
+ dac_config_2 vdda1 vssa1 vssc1 col_event_rst_bot_left[26] x3_net38 row_on_detect_bot[13]
+ row_off_detect_bot[12] openDVS_pixel2x2_bot
x3_x1267 dac_config_3 dac_config_5 col_event_rst_bot_left[25] dac_config_4
+ row_on_detect_bot[12] dac_config_0 dac_config_1 row_off_detect_bot[13] x3_net39
+ dac_config_2 vdda1 vssa1 vssc1 col_event_rst_bot_left[24] x3_net40 row_on_detect_bot[13]
+ row_off_detect_bot[12] openDVS_pixel2x2_bot
x3_x1268 dac_config_3 dac_config_5 col_event_rst_bot_left[23] dac_config_4
+ row_on_detect_bot[12] dac_config_0 dac_config_1 row_off_detect_bot[13] x3_net41
+ dac_config_2 vdda1 vssa1 vssc1 col_event_rst_bot_left[22] x3_net42 row_on_detect_bot[13]
+ row_off_detect_bot[12] openDVS_pixel2x2_bot
x3_x1269 dac_config_3 dac_config_5 col_event_rst_bot_left[21] dac_config_4
+ row_on_detect_bot[12] dac_config_0 dac_config_1 row_off_detect_bot[13] x3_net43
+ dac_config_2 vdda1 vssa1 vssc1 col_event_rst_bot_left[20] x3_net44 row_on_detect_bot[13]
+ row_off_detect_bot[12] openDVS_pixel2x2_bot
x3_x1270 dac_config_3 dac_config_5 col_event_rst_bot_left[19] dac_config_4
+ row_on_detect_bot[12] dac_config_0 dac_config_1 row_off_detect_bot[13] x3_net45
+ dac_config_2 vdda1 vssa1 vssc1 col_event_rst_bot_left[18] x3_net46 row_on_detect_bot[13]
+ row_off_detect_bot[12] openDVS_pixel2x2_bot
x3_x1271 dac_config_3 dac_config_5 col_event_rst_bot_left[17] dac_config_4
+ row_on_detect_bot[12] dac_config_0 dac_config_1 row_off_detect_bot[13] x3_net47
+ dac_config_2 vdda1 vssa1 vssc1 col_event_rst_bot_left[16] x3_net48 row_on_detect_bot[13]
+ row_off_detect_bot[12] openDVS_pixel2x2_bot
x3_x1272 dac_config_3 dac_config_5 col_event_rst_bot_left[15] dac_config_4
+ row_on_detect_bot[12] dac_config_0 dac_config_1 row_off_detect_bot[13] x3_net49
+ dac_config_2 vdda1 vssa1 vssc1 col_event_rst_bot_left[14] x3_net50 row_on_detect_bot[13]
+ row_off_detect_bot[12] openDVS_pixel2x2_bot
x3_x1273 dac_config_3 dac_config_5 col_event_rst_bot_left[13] dac_config_4
+ row_on_detect_bot[12] dac_config_0 dac_config_1 row_off_detect_bot[13] x3_net51
+ dac_config_2 vdda1 vssa1 vssc1 col_event_rst_bot_left[12] x3_net52 row_on_detect_bot[13]
+ row_off_detect_bot[12] openDVS_pixel2x2_bot
x3_x1274 dac_config_3 dac_config_5 col_event_rst_bot_left[11] dac_config_4
+ row_on_detect_bot[12] dac_config_0 dac_config_1 row_off_detect_bot[13] x3_net53
+ dac_config_2 vdda1 vssa1 vssc1 col_event_rst_bot_left[10] x3_net54 row_on_detect_bot[13]
+ row_off_detect_bot[12] openDVS_pixel2x2_bot
x3_x1275 dac_config_3 dac_config_5 col_event_rst_bot_left[9] dac_config_4
+ row_on_detect_bot[12] dac_config_0 dac_config_1 row_off_detect_bot[13] x3_net55
+ dac_config_2 vdda1 vssa1 vssc1 col_event_rst_bot_left[8] x3_net56 row_on_detect_bot[13]
+ row_off_detect_bot[12] openDVS_pixel2x2_bot
x3_x1276 dac_config_3 dac_config_5 col_event_rst_bot_left[7] dac_config_4
+ row_on_detect_bot[12] dac_config_0 dac_config_1 row_off_detect_bot[13] x3_net57
+ dac_config_2 vdda1 vssa1 vssc1 col_event_rst_bot_left[6] x3_net58 row_on_detect_bot[13]
+ row_off_detect_bot[12] openDVS_pixel2x2_bot
x3_x1277 dac_config_3 dac_config_5 col_event_rst_bot_left[5] dac_config_4
+ row_on_detect_bot[12] dac_config_0 dac_config_1 row_off_detect_bot[13] x3_net59
+ dac_config_2 vdda1 vssa1 vssc1 col_event_rst_bot_left[4] x3_net60 row_on_detect_bot[13]
+ row_off_detect_bot[12] openDVS_pixel2x2_bot
x3_x1278 dac_config_3 dac_config_5 col_event_rst_bot_left[3] dac_config_4
+ row_on_detect_bot[12] dac_config_0 dac_config_1 row_off_detect_bot[13] x3_net61
+ dac_config_2 vdda1 vssa1 vssc1 col_event_rst_bot_left[2] x3_net62 row_on_detect_bot[13]
+ row_off_detect_bot[12] openDVS_pixel2x2_bot
x3_x1279 dac_config_3 dac_config_5 col_event_rst_bot_left[1] dac_config_4
+ row_on_detect_bot[12] dac_config_0 dac_config_1 row_off_detect_bot[13] x3_net63
+ dac_config_2 vdda1 vssa1 vssc1 col_event_rst_bot_left[0] x3_net64 row_on_detect_bot[13]
+ row_off_detect_bot[12] openDVS_pixel2x2_bot
x3_x1280 dac_config_3 dac_config_5 col_event_rst_bot_left[63] dac_config_4
+ row_on_detect_bot[14] dac_config_0 dac_config_1 row_off_detect_bot[15] x3_net1
+ dac_config_2 vdda1 vssa1 vssc1 col_event_rst_bot_left[62] x3_net2 row_on_detect_bot[15]
+ row_off_detect_bot[14] openDVS_pixel2x2_bot
x3_x1281 dac_config_3 dac_config_5 col_event_rst_bot_left[61] dac_config_4
+ row_on_detect_bot[14] dac_config_0 dac_config_1 row_off_detect_bot[15] x3_net3
+ dac_config_2 vdda1 vssa1 vssc1 col_event_rst_bot_left[60] x3_net4 row_on_detect_bot[15]
+ row_off_detect_bot[14] openDVS_pixel2x2_bot
x3_x1282 dac_config_3 dac_config_5 col_event_rst_bot_left[59] dac_config_4
+ row_on_detect_bot[14] dac_config_0 dac_config_1 row_off_detect_bot[15] x3_net5
+ dac_config_2 vdda1 vssa1 vssc1 col_event_rst_bot_left[58] x3_net6 row_on_detect_bot[15]
+ row_off_detect_bot[14] openDVS_pixel2x2_bot
x3_x1283 dac_config_3 dac_config_5 col_event_rst_bot_left[57] dac_config_4
+ row_on_detect_bot[14] dac_config_0 dac_config_1 row_off_detect_bot[15] x3_net7
+ dac_config_2 vdda1 vssa1 vssc1 col_event_rst_bot_left[56] x3_net8 row_on_detect_bot[15]
+ row_off_detect_bot[14] openDVS_pixel2x2_bot
x3_x1284 dac_config_3 dac_config_5 col_event_rst_bot_left[55] dac_config_4
+ row_on_detect_bot[14] dac_config_0 dac_config_1 row_off_detect_bot[15] x3_net9
+ dac_config_2 vdda1 vssa1 vssc1 col_event_rst_bot_left[54] x3_net10 row_on_detect_bot[15]
+ row_off_detect_bot[14] openDVS_pixel2x2_bot
x3_x1285 dac_config_3 dac_config_5 col_event_rst_bot_left[53] dac_config_4
+ row_on_detect_bot[14] dac_config_0 dac_config_1 row_off_detect_bot[15] x3_net11
+ dac_config_2 vdda1 vssa1 vssc1 col_event_rst_bot_left[52] x3_net12 row_on_detect_bot[15]
+ row_off_detect_bot[14] openDVS_pixel2x2_bot
x3_x1286 dac_config_3 dac_config_5 col_event_rst_bot_left[51] dac_config_4
+ row_on_detect_bot[14] dac_config_0 dac_config_1 row_off_detect_bot[15] x3_net13
+ dac_config_2 vdda1 vssa1 vssc1 col_event_rst_bot_left[50] x3_net14 row_on_detect_bot[15]
+ row_off_detect_bot[14] openDVS_pixel2x2_bot
x3_x1287 dac_config_3 dac_config_5 col_event_rst_bot_left[49] dac_config_4
+ row_on_detect_bot[14] dac_config_0 dac_config_1 row_off_detect_bot[15] x3_net15
+ dac_config_2 vdda1 vssa1 vssc1 col_event_rst_bot_left[48] x3_net16 row_on_detect_bot[15]
+ row_off_detect_bot[14] openDVS_pixel2x2_bot
x3_x1288 dac_config_3 dac_config_5 col_event_rst_bot_left[47] dac_config_4
+ row_on_detect_bot[14] dac_config_0 dac_config_1 row_off_detect_bot[15] x3_net17
+ dac_config_2 vdda1 vssa1 vssc1 col_event_rst_bot_left[46] x3_net18 row_on_detect_bot[15]
+ row_off_detect_bot[14] openDVS_pixel2x2_bot
x3_x1289 dac_config_3 dac_config_5 col_event_rst_bot_left[45] dac_config_4
+ row_on_detect_bot[14] dac_config_0 dac_config_1 row_off_detect_bot[15] x3_net19
+ dac_config_2 vdda1 vssa1 vssc1 col_event_rst_bot_left[44] x3_net20 row_on_detect_bot[15]
+ row_off_detect_bot[14] openDVS_pixel2x2_bot
x3_x1290 dac_config_3 dac_config_5 col_event_rst_bot_left[43] dac_config_4
+ row_on_detect_bot[14] dac_config_0 dac_config_1 row_off_detect_bot[15] x3_net21
+ dac_config_2 vdda1 vssa1 vssc1 col_event_rst_bot_left[42] x3_net22 row_on_detect_bot[15]
+ row_off_detect_bot[14] openDVS_pixel2x2_bot
x3_x1291 dac_config_3 dac_config_5 col_event_rst_bot_left[41] dac_config_4
+ row_on_detect_bot[14] dac_config_0 dac_config_1 row_off_detect_bot[15] x3_net23
+ dac_config_2 vdda1 vssa1 vssc1 col_event_rst_bot_left[40] x3_net24 row_on_detect_bot[15]
+ row_off_detect_bot[14] openDVS_pixel2x2_bot
x3_x1292 dac_config_3 dac_config_5 col_event_rst_bot_left[39] dac_config_4
+ row_on_detect_bot[14] dac_config_0 dac_config_1 row_off_detect_bot[15] x3_net25
+ dac_config_2 vdda1 vssa1 vssc1 col_event_rst_bot_left[38] x3_net26 row_on_detect_bot[15]
+ row_off_detect_bot[14] openDVS_pixel2x2_bot
x3_x1293 dac_config_3 dac_config_5 col_event_rst_bot_left[37] dac_config_4
+ row_on_detect_bot[14] dac_config_0 dac_config_1 row_off_detect_bot[15] x3_net27
+ dac_config_2 vdda1 vssa1 vssc1 col_event_rst_bot_left[36] x3_net28 row_on_detect_bot[15]
+ row_off_detect_bot[14] openDVS_pixel2x2_bot
x3_x1294 dac_config_3 dac_config_5 col_event_rst_bot_left[35] dac_config_4
+ row_on_detect_bot[14] dac_config_0 dac_config_1 row_off_detect_bot[15] x3_net29
+ dac_config_2 vdda1 vssa1 vssc1 col_event_rst_bot_left[34] x3_net30 row_on_detect_bot[15]
+ row_off_detect_bot[14] openDVS_pixel2x2_bot
x3_x1295 dac_config_3 dac_config_5 col_event_rst_bot_left[33] dac_config_4
+ row_on_detect_bot[14] dac_config_0 dac_config_1 row_off_detect_bot[15] x3_net31
+ dac_config_2 vdda1 vssa1 vssc1 col_event_rst_bot_left[32] x3_net32 row_on_detect_bot[15]
+ row_off_detect_bot[14] openDVS_pixel2x2_bot
x3_x1296 dac_config_3 dac_config_5 col_event_rst_bot_left[31] dac_config_4
+ row_on_detect_bot[14] dac_config_0 dac_config_1 row_off_detect_bot[15] x3_net33
+ dac_config_2 vdda1 vssa1 vssc1 col_event_rst_bot_left[30] x3_net34 row_on_detect_bot[15]
+ row_off_detect_bot[14] openDVS_pixel2x2_bot
x3_x1297 dac_config_3 dac_config_5 col_event_rst_bot_left[29] dac_config_4
+ row_on_detect_bot[14] dac_config_0 dac_config_1 row_off_detect_bot[15] x3_net35
+ dac_config_2 vdda1 vssa1 vssc1 col_event_rst_bot_left[28] x3_net36 row_on_detect_bot[15]
+ row_off_detect_bot[14] openDVS_pixel2x2_bot
x3_x1298 dac_config_3 dac_config_5 col_event_rst_bot_left[27] dac_config_4
+ row_on_detect_bot[14] dac_config_0 dac_config_1 row_off_detect_bot[15] x3_net37
+ dac_config_2 vdda1 vssa1 vssc1 col_event_rst_bot_left[26] x3_net38 row_on_detect_bot[15]
+ row_off_detect_bot[14] openDVS_pixel2x2_bot
x3_x1299 dac_config_3 dac_config_5 col_event_rst_bot_left[25] dac_config_4
+ row_on_detect_bot[14] dac_config_0 dac_config_1 row_off_detect_bot[15] x3_net39
+ dac_config_2 vdda1 vssa1 vssc1 col_event_rst_bot_left[24] x3_net40 row_on_detect_bot[15]
+ row_off_detect_bot[14] openDVS_pixel2x2_bot
x3_x1300 dac_config_3 dac_config_5 col_event_rst_bot_left[23] dac_config_4
+ row_on_detect_bot[14] dac_config_0 dac_config_1 row_off_detect_bot[15] x3_net41
+ dac_config_2 vdda1 vssa1 vssc1 col_event_rst_bot_left[22] x3_net42 row_on_detect_bot[15]
+ row_off_detect_bot[14] openDVS_pixel2x2_bot
x3_x1301 dac_config_3 dac_config_5 col_event_rst_bot_left[21] dac_config_4
+ row_on_detect_bot[14] dac_config_0 dac_config_1 row_off_detect_bot[15] x3_net43
+ dac_config_2 vdda1 vssa1 vssc1 col_event_rst_bot_left[20] x3_net44 row_on_detect_bot[15]
+ row_off_detect_bot[14] openDVS_pixel2x2_bot
x3_x1302 dac_config_3 dac_config_5 col_event_rst_bot_left[19] dac_config_4
+ row_on_detect_bot[14] dac_config_0 dac_config_1 row_off_detect_bot[15] x3_net45
+ dac_config_2 vdda1 vssa1 vssc1 col_event_rst_bot_left[18] x3_net46 row_on_detect_bot[15]
+ row_off_detect_bot[14] openDVS_pixel2x2_bot
x3_x1303 dac_config_3 dac_config_5 col_event_rst_bot_left[17] dac_config_4
+ row_on_detect_bot[14] dac_config_0 dac_config_1 row_off_detect_bot[15] x3_net47
+ dac_config_2 vdda1 vssa1 vssc1 col_event_rst_bot_left[16] x3_net48 row_on_detect_bot[15]
+ row_off_detect_bot[14] openDVS_pixel2x2_bot
x3_x1304 dac_config_3 dac_config_5 col_event_rst_bot_left[15] dac_config_4
+ row_on_detect_bot[14] dac_config_0 dac_config_1 row_off_detect_bot[15] x3_net49
+ dac_config_2 vdda1 vssa1 vssc1 col_event_rst_bot_left[14] x3_net50 row_on_detect_bot[15]
+ row_off_detect_bot[14] openDVS_pixel2x2_bot
x3_x1305 dac_config_3 dac_config_5 col_event_rst_bot_left[13] dac_config_4
+ row_on_detect_bot[14] dac_config_0 dac_config_1 row_off_detect_bot[15] x3_net51
+ dac_config_2 vdda1 vssa1 vssc1 col_event_rst_bot_left[12] x3_net52 row_on_detect_bot[15]
+ row_off_detect_bot[14] openDVS_pixel2x2_bot
x3_x1306 dac_config_3 dac_config_5 col_event_rst_bot_left[11] dac_config_4
+ row_on_detect_bot[14] dac_config_0 dac_config_1 row_off_detect_bot[15] x3_net53
+ dac_config_2 vdda1 vssa1 vssc1 col_event_rst_bot_left[10] x3_net54 row_on_detect_bot[15]
+ row_off_detect_bot[14] openDVS_pixel2x2_bot
x3_x1307 dac_config_3 dac_config_5 col_event_rst_bot_left[9] dac_config_4
+ row_on_detect_bot[14] dac_config_0 dac_config_1 row_off_detect_bot[15] x3_net55
+ dac_config_2 vdda1 vssa1 vssc1 col_event_rst_bot_left[8] x3_net56 row_on_detect_bot[15]
+ row_off_detect_bot[14] openDVS_pixel2x2_bot
x3_x1308 dac_config_3 dac_config_5 col_event_rst_bot_left[7] dac_config_4
+ row_on_detect_bot[14] dac_config_0 dac_config_1 row_off_detect_bot[15] x3_net57
+ dac_config_2 vdda1 vssa1 vssc1 col_event_rst_bot_left[6] x3_net58 row_on_detect_bot[15]
+ row_off_detect_bot[14] openDVS_pixel2x2_bot
x3_x1309 dac_config_3 dac_config_5 col_event_rst_bot_left[5] dac_config_4
+ row_on_detect_bot[14] dac_config_0 dac_config_1 row_off_detect_bot[15] x3_net59
+ dac_config_2 vdda1 vssa1 vssc1 col_event_rst_bot_left[4] x3_net60 row_on_detect_bot[15]
+ row_off_detect_bot[14] openDVS_pixel2x2_bot
x3_x1310 dac_config_3 dac_config_5 col_event_rst_bot_left[3] dac_config_4
+ row_on_detect_bot[14] dac_config_0 dac_config_1 row_off_detect_bot[15] x3_net61
+ dac_config_2 vdda1 vssa1 vssc1 col_event_rst_bot_left[2] x3_net62 row_on_detect_bot[15]
+ row_off_detect_bot[14] openDVS_pixel2x2_bot
x3_x1311 dac_config_3 dac_config_5 col_event_rst_bot_left[1] dac_config_4
+ row_on_detect_bot[14] dac_config_0 dac_config_1 row_off_detect_bot[15] x3_net63
+ dac_config_2 vdda1 vssa1 vssc1 col_event_rst_bot_left[0] x3_net64 row_on_detect_bot[15]
+ row_off_detect_bot[14] openDVS_pixel2x2_bot
x3_x1312 dac_config_3 dac_config_5 col_event_rst_bot_left[63] dac_config_4
+ row_on_detect_bot[16] dac_config_0 dac_config_1 row_off_detect_bot[17] x3_net1
+ dac_config_2 vdda1 vssa1 vssc1 col_event_rst_bot_left[62] x3_net2 row_on_detect_bot[17]
+ row_off_detect_bot[16] openDVS_pixel2x2_bot
x3_x1313 dac_config_3 dac_config_5 col_event_rst_bot_left[61] dac_config_4
+ row_on_detect_bot[16] dac_config_0 dac_config_1 row_off_detect_bot[17] x3_net3
+ dac_config_2 vdda1 vssa1 vssc1 col_event_rst_bot_left[60] x3_net4 row_on_detect_bot[17]
+ row_off_detect_bot[16] openDVS_pixel2x2_bot
x3_x1314 dac_config_3 dac_config_5 col_event_rst_bot_left[59] dac_config_4
+ row_on_detect_bot[16] dac_config_0 dac_config_1 row_off_detect_bot[17] x3_net5
+ dac_config_2 vdda1 vssa1 vssc1 col_event_rst_bot_left[58] x3_net6 row_on_detect_bot[17]
+ row_off_detect_bot[16] openDVS_pixel2x2_bot
x3_x1315 dac_config_3 dac_config_5 col_event_rst_bot_left[57] dac_config_4
+ row_on_detect_bot[16] dac_config_0 dac_config_1 row_off_detect_bot[17] x3_net7
+ dac_config_2 vdda1 vssa1 vssc1 col_event_rst_bot_left[56] x3_net8 row_on_detect_bot[17]
+ row_off_detect_bot[16] openDVS_pixel2x2_bot
x3_x1316 dac_config_3 dac_config_5 col_event_rst_bot_left[55] dac_config_4
+ row_on_detect_bot[16] dac_config_0 dac_config_1 row_off_detect_bot[17] x3_net9
+ dac_config_2 vdda1 vssa1 vssc1 col_event_rst_bot_left[54] x3_net10 row_on_detect_bot[17]
+ row_off_detect_bot[16] openDVS_pixel2x2_bot
x3_x1317 dac_config_3 dac_config_5 col_event_rst_bot_left[53] dac_config_4
+ row_on_detect_bot[16] dac_config_0 dac_config_1 row_off_detect_bot[17] x3_net11
+ dac_config_2 vdda1 vssa1 vssc1 col_event_rst_bot_left[52] x3_net12 row_on_detect_bot[17]
+ row_off_detect_bot[16] openDVS_pixel2x2_bot
x3_x1318 dac_config_3 dac_config_5 col_event_rst_bot_left[51] dac_config_4
+ row_on_detect_bot[16] dac_config_0 dac_config_1 row_off_detect_bot[17] x3_net13
+ dac_config_2 vdda1 vssa1 vssc1 col_event_rst_bot_left[50] x3_net14 row_on_detect_bot[17]
+ row_off_detect_bot[16] openDVS_pixel2x2_bot
x3_x1319 dac_config_3 dac_config_5 col_event_rst_bot_left[49] dac_config_4
+ row_on_detect_bot[16] dac_config_0 dac_config_1 row_off_detect_bot[17] x3_net15
+ dac_config_2 vdda1 vssa1 vssc1 col_event_rst_bot_left[48] x3_net16 row_on_detect_bot[17]
+ row_off_detect_bot[16] openDVS_pixel2x2_bot
x3_x1320 dac_config_3 dac_config_5 col_event_rst_bot_left[47] dac_config_4
+ row_on_detect_bot[16] dac_config_0 dac_config_1 row_off_detect_bot[17] x3_net17
+ dac_config_2 vdda1 vssa1 vssc1 col_event_rst_bot_left[46] x3_net18 row_on_detect_bot[17]
+ row_off_detect_bot[16] openDVS_pixel2x2_bot
x3_x1321 dac_config_3 dac_config_5 col_event_rst_bot_left[45] dac_config_4
+ row_on_detect_bot[16] dac_config_0 dac_config_1 row_off_detect_bot[17] x3_net19
+ dac_config_2 vdda1 vssa1 vssc1 col_event_rst_bot_left[44] x3_net20 row_on_detect_bot[17]
+ row_off_detect_bot[16] openDVS_pixel2x2_bot
x3_x1322 dac_config_3 dac_config_5 col_event_rst_bot_left[43] dac_config_4
+ row_on_detect_bot[16] dac_config_0 dac_config_1 row_off_detect_bot[17] x3_net21
+ dac_config_2 vdda1 vssa1 vssc1 col_event_rst_bot_left[42] x3_net22 row_on_detect_bot[17]
+ row_off_detect_bot[16] openDVS_pixel2x2_bot
x3_x1323 dac_config_3 dac_config_5 col_event_rst_bot_left[41] dac_config_4
+ row_on_detect_bot[16] dac_config_0 dac_config_1 row_off_detect_bot[17] x3_net23
+ dac_config_2 vdda1 vssa1 vssc1 col_event_rst_bot_left[40] x3_net24 row_on_detect_bot[17]
+ row_off_detect_bot[16] openDVS_pixel2x2_bot
x3_x1324 dac_config_3 dac_config_5 col_event_rst_bot_left[39] dac_config_4
+ row_on_detect_bot[16] dac_config_0 dac_config_1 row_off_detect_bot[17] x3_net25
+ dac_config_2 vdda1 vssa1 vssc1 col_event_rst_bot_left[38] x3_net26 row_on_detect_bot[17]
+ row_off_detect_bot[16] openDVS_pixel2x2_bot
x3_x1325 dac_config_3 dac_config_5 col_event_rst_bot_left[37] dac_config_4
+ row_on_detect_bot[16] dac_config_0 dac_config_1 row_off_detect_bot[17] x3_net27
+ dac_config_2 vdda1 vssa1 vssc1 col_event_rst_bot_left[36] x3_net28 row_on_detect_bot[17]
+ row_off_detect_bot[16] openDVS_pixel2x2_bot
x3_x1326 dac_config_3 dac_config_5 col_event_rst_bot_left[35] dac_config_4
+ row_on_detect_bot[16] dac_config_0 dac_config_1 row_off_detect_bot[17] x3_net29
+ dac_config_2 vdda1 vssa1 vssc1 col_event_rst_bot_left[34] x3_net30 row_on_detect_bot[17]
+ row_off_detect_bot[16] openDVS_pixel2x2_bot
x3_x1327 dac_config_3 dac_config_5 col_event_rst_bot_left[33] dac_config_4
+ row_on_detect_bot[16] dac_config_0 dac_config_1 row_off_detect_bot[17] x3_net31
+ dac_config_2 vdda1 vssa1 vssc1 col_event_rst_bot_left[32] x3_net32 row_on_detect_bot[17]
+ row_off_detect_bot[16] openDVS_pixel2x2_bot
x3_x1328 dac_config_3 dac_config_5 col_event_rst_bot_left[31] dac_config_4
+ row_on_detect_bot[16] dac_config_0 dac_config_1 row_off_detect_bot[17] x3_net33
+ dac_config_2 vdda1 vssa1 vssc1 col_event_rst_bot_left[30] x3_net34 row_on_detect_bot[17]
+ row_off_detect_bot[16] openDVS_pixel2x2_bot
x3_x1329 dac_config_3 dac_config_5 col_event_rst_bot_left[29] dac_config_4
+ row_on_detect_bot[16] dac_config_0 dac_config_1 row_off_detect_bot[17] x3_net35
+ dac_config_2 vdda1 vssa1 vssc1 col_event_rst_bot_left[28] x3_net36 row_on_detect_bot[17]
+ row_off_detect_bot[16] openDVS_pixel2x2_bot
x3_x1330 dac_config_3 dac_config_5 col_event_rst_bot_left[27] dac_config_4
+ row_on_detect_bot[16] dac_config_0 dac_config_1 row_off_detect_bot[17] x3_net37
+ dac_config_2 vdda1 vssa1 vssc1 col_event_rst_bot_left[26] x3_net38 row_on_detect_bot[17]
+ row_off_detect_bot[16] openDVS_pixel2x2_bot
x3_x1331 dac_config_3 dac_config_5 col_event_rst_bot_left[25] dac_config_4
+ row_on_detect_bot[16] dac_config_0 dac_config_1 row_off_detect_bot[17] x3_net39
+ dac_config_2 vdda1 vssa1 vssc1 col_event_rst_bot_left[24] x3_net40 row_on_detect_bot[17]
+ row_off_detect_bot[16] openDVS_pixel2x2_bot
x3_x1332 dac_config_3 dac_config_5 col_event_rst_bot_left[23] dac_config_4
+ row_on_detect_bot[16] dac_config_0 dac_config_1 row_off_detect_bot[17] x3_net41
+ dac_config_2 vdda1 vssa1 vssc1 col_event_rst_bot_left[22] x3_net42 row_on_detect_bot[17]
+ row_off_detect_bot[16] openDVS_pixel2x2_bot
x3_x1333 dac_config_3 dac_config_5 col_event_rst_bot_left[21] dac_config_4
+ row_on_detect_bot[16] dac_config_0 dac_config_1 row_off_detect_bot[17] x3_net43
+ dac_config_2 vdda1 vssa1 vssc1 col_event_rst_bot_left[20] x3_net44 row_on_detect_bot[17]
+ row_off_detect_bot[16] openDVS_pixel2x2_bot
x3_x1334 dac_config_3 dac_config_5 col_event_rst_bot_left[19] dac_config_4
+ row_on_detect_bot[16] dac_config_0 dac_config_1 row_off_detect_bot[17] x3_net45
+ dac_config_2 vdda1 vssa1 vssc1 col_event_rst_bot_left[18] x3_net46 row_on_detect_bot[17]
+ row_off_detect_bot[16] openDVS_pixel2x2_bot
x3_x1335 dac_config_3 dac_config_5 col_event_rst_bot_left[17] dac_config_4
+ row_on_detect_bot[16] dac_config_0 dac_config_1 row_off_detect_bot[17] x3_net47
+ dac_config_2 vdda1 vssa1 vssc1 col_event_rst_bot_left[16] x3_net48 row_on_detect_bot[17]
+ row_off_detect_bot[16] openDVS_pixel2x2_bot
x3_x1336 dac_config_3 dac_config_5 col_event_rst_bot_left[15] dac_config_4
+ row_on_detect_bot[16] dac_config_0 dac_config_1 row_off_detect_bot[17] x3_net49
+ dac_config_2 vdda1 vssa1 vssc1 col_event_rst_bot_left[14] x3_net50 row_on_detect_bot[17]
+ row_off_detect_bot[16] openDVS_pixel2x2_bot
x3_x1337 dac_config_3 dac_config_5 col_event_rst_bot_left[13] dac_config_4
+ row_on_detect_bot[16] dac_config_0 dac_config_1 row_off_detect_bot[17] x3_net51
+ dac_config_2 vdda1 vssa1 vssc1 col_event_rst_bot_left[12] x3_net52 row_on_detect_bot[17]
+ row_off_detect_bot[16] openDVS_pixel2x2_bot
x3_x1338 dac_config_3 dac_config_5 col_event_rst_bot_left[11] dac_config_4
+ row_on_detect_bot[16] dac_config_0 dac_config_1 row_off_detect_bot[17] x3_net53
+ dac_config_2 vdda1 vssa1 vssc1 col_event_rst_bot_left[10] x3_net54 row_on_detect_bot[17]
+ row_off_detect_bot[16] openDVS_pixel2x2_bot
x3_x1339 dac_config_3 dac_config_5 col_event_rst_bot_left[9] dac_config_4
+ row_on_detect_bot[16] dac_config_0 dac_config_1 row_off_detect_bot[17] x3_net55
+ dac_config_2 vdda1 vssa1 vssc1 col_event_rst_bot_left[8] x3_net56 row_on_detect_bot[17]
+ row_off_detect_bot[16] openDVS_pixel2x2_bot
x3_x1340 dac_config_3 dac_config_5 col_event_rst_bot_left[7] dac_config_4
+ row_on_detect_bot[16] dac_config_0 dac_config_1 row_off_detect_bot[17] x3_net57
+ dac_config_2 vdda1 vssa1 vssc1 col_event_rst_bot_left[6] x3_net58 row_on_detect_bot[17]
+ row_off_detect_bot[16] openDVS_pixel2x2_bot
x3_x1341 dac_config_3 dac_config_5 col_event_rst_bot_left[5] dac_config_4
+ row_on_detect_bot[16] dac_config_0 dac_config_1 row_off_detect_bot[17] x3_net59
+ dac_config_2 vdda1 vssa1 vssc1 col_event_rst_bot_left[4] x3_net60 row_on_detect_bot[17]
+ row_off_detect_bot[16] openDVS_pixel2x2_bot
x3_x1342 dac_config_3 dac_config_5 col_event_rst_bot_left[3] dac_config_4
+ row_on_detect_bot[16] dac_config_0 dac_config_1 row_off_detect_bot[17] x3_net61
+ dac_config_2 vdda1 vssa1 vssc1 col_event_rst_bot_left[2] x3_net62 row_on_detect_bot[17]
+ row_off_detect_bot[16] openDVS_pixel2x2_bot
x3_x1343 dac_config_3 dac_config_5 col_event_rst_bot_left[1] dac_config_4
+ row_on_detect_bot[16] dac_config_0 dac_config_1 row_off_detect_bot[17] x3_net63
+ dac_config_2 vdda1 vssa1 vssc1 col_event_rst_bot_left[0] x3_net64 row_on_detect_bot[17]
+ row_off_detect_bot[16] openDVS_pixel2x2_bot
x3_x1344 dac_config_3 dac_config_5 col_event_rst_bot_left[63] dac_config_4
+ row_on_detect_bot[18] dac_config_0 dac_config_1 row_off_detect_bot[19] x3_net1
+ dac_config_2 vdda1 vssa1 vssc1 col_event_rst_bot_left[62] x3_net2 row_on_detect_bot[19]
+ row_off_detect_bot[18] openDVS_pixel2x2_bot
x3_x1345 dac_config_3 dac_config_5 col_event_rst_bot_left[61] dac_config_4
+ row_on_detect_bot[18] dac_config_0 dac_config_1 row_off_detect_bot[19] x3_net3
+ dac_config_2 vdda1 vssa1 vssc1 col_event_rst_bot_left[60] x3_net4 row_on_detect_bot[19]
+ row_off_detect_bot[18] openDVS_pixel2x2_bot
x3_x1346 dac_config_3 dac_config_5 col_event_rst_bot_left[59] dac_config_4
+ row_on_detect_bot[18] dac_config_0 dac_config_1 row_off_detect_bot[19] x3_net5
+ dac_config_2 vdda1 vssa1 vssc1 col_event_rst_bot_left[58] x3_net6 row_on_detect_bot[19]
+ row_off_detect_bot[18] openDVS_pixel2x2_bot
x3_x1347 dac_config_3 dac_config_5 col_event_rst_bot_left[57] dac_config_4
+ row_on_detect_bot[18] dac_config_0 dac_config_1 row_off_detect_bot[19] x3_net7
+ dac_config_2 vdda1 vssa1 vssc1 col_event_rst_bot_left[56] x3_net8 row_on_detect_bot[19]
+ row_off_detect_bot[18] openDVS_pixel2x2_bot
x3_x1348 dac_config_3 dac_config_5 col_event_rst_bot_left[55] dac_config_4
+ row_on_detect_bot[18] dac_config_0 dac_config_1 row_off_detect_bot[19] x3_net9
+ dac_config_2 vdda1 vssa1 vssc1 col_event_rst_bot_left[54] x3_net10 row_on_detect_bot[19]
+ row_off_detect_bot[18] openDVS_pixel2x2_bot
x3_x1349 dac_config_3 dac_config_5 col_event_rst_bot_left[53] dac_config_4
+ row_on_detect_bot[18] dac_config_0 dac_config_1 row_off_detect_bot[19] x3_net11
+ dac_config_2 vdda1 vssa1 vssc1 col_event_rst_bot_left[52] x3_net12 row_on_detect_bot[19]
+ row_off_detect_bot[18] openDVS_pixel2x2_bot
x3_x1350 dac_config_3 dac_config_5 col_event_rst_bot_left[51] dac_config_4
+ row_on_detect_bot[18] dac_config_0 dac_config_1 row_off_detect_bot[19] x3_net13
+ dac_config_2 vdda1 vssa1 vssc1 col_event_rst_bot_left[50] x3_net14 row_on_detect_bot[19]
+ row_off_detect_bot[18] openDVS_pixel2x2_bot
x3_x1351 dac_config_3 dac_config_5 col_event_rst_bot_left[49] dac_config_4
+ row_on_detect_bot[18] dac_config_0 dac_config_1 row_off_detect_bot[19] x3_net15
+ dac_config_2 vdda1 vssa1 vssc1 col_event_rst_bot_left[48] x3_net16 row_on_detect_bot[19]
+ row_off_detect_bot[18] openDVS_pixel2x2_bot
x3_x1352 dac_config_3 dac_config_5 col_event_rst_bot_left[47] dac_config_4
+ row_on_detect_bot[18] dac_config_0 dac_config_1 row_off_detect_bot[19] x3_net17
+ dac_config_2 vdda1 vssa1 vssc1 col_event_rst_bot_left[46] x3_net18 row_on_detect_bot[19]
+ row_off_detect_bot[18] openDVS_pixel2x2_bot
x3_x1353 dac_config_3 dac_config_5 col_event_rst_bot_left[45] dac_config_4
+ row_on_detect_bot[18] dac_config_0 dac_config_1 row_off_detect_bot[19] x3_net19
+ dac_config_2 vdda1 vssa1 vssc1 col_event_rst_bot_left[44] x3_net20 row_on_detect_bot[19]
+ row_off_detect_bot[18] openDVS_pixel2x2_bot
x3_x1354 dac_config_3 dac_config_5 col_event_rst_bot_left[43] dac_config_4
+ row_on_detect_bot[18] dac_config_0 dac_config_1 row_off_detect_bot[19] x3_net21
+ dac_config_2 vdda1 vssa1 vssc1 col_event_rst_bot_left[42] x3_net22 row_on_detect_bot[19]
+ row_off_detect_bot[18] openDVS_pixel2x2_bot
x3_x1355 dac_config_3 dac_config_5 col_event_rst_bot_left[41] dac_config_4
+ row_on_detect_bot[18] dac_config_0 dac_config_1 row_off_detect_bot[19] x3_net23
+ dac_config_2 vdda1 vssa1 vssc1 col_event_rst_bot_left[40] x3_net24 row_on_detect_bot[19]
+ row_off_detect_bot[18] openDVS_pixel2x2_bot
x3_x1356 dac_config_3 dac_config_5 col_event_rst_bot_left[39] dac_config_4
+ row_on_detect_bot[18] dac_config_0 dac_config_1 row_off_detect_bot[19] x3_net25
+ dac_config_2 vdda1 vssa1 vssc1 col_event_rst_bot_left[38] x3_net26 row_on_detect_bot[19]
+ row_off_detect_bot[18] openDVS_pixel2x2_bot
x3_x1357 dac_config_3 dac_config_5 col_event_rst_bot_left[37] dac_config_4
+ row_on_detect_bot[18] dac_config_0 dac_config_1 row_off_detect_bot[19] x3_net27
+ dac_config_2 vdda1 vssa1 vssc1 col_event_rst_bot_left[36] x3_net28 row_on_detect_bot[19]
+ row_off_detect_bot[18] openDVS_pixel2x2_bot
x3_x1358 dac_config_3 dac_config_5 col_event_rst_bot_left[35] dac_config_4
+ row_on_detect_bot[18] dac_config_0 dac_config_1 row_off_detect_bot[19] x3_net29
+ dac_config_2 vdda1 vssa1 vssc1 col_event_rst_bot_left[34] x3_net30 row_on_detect_bot[19]
+ row_off_detect_bot[18] openDVS_pixel2x2_bot
x3_x1359 dac_config_3 dac_config_5 col_event_rst_bot_left[33] dac_config_4
+ row_on_detect_bot[18] dac_config_0 dac_config_1 row_off_detect_bot[19] x3_net31
+ dac_config_2 vdda1 vssa1 vssc1 col_event_rst_bot_left[32] x3_net32 row_on_detect_bot[19]
+ row_off_detect_bot[18] openDVS_pixel2x2_bot
x3_x1360 dac_config_3 dac_config_5 col_event_rst_bot_left[31] dac_config_4
+ row_on_detect_bot[18] dac_config_0 dac_config_1 row_off_detect_bot[19] x3_net33
+ dac_config_2 vdda1 vssa1 vssc1 col_event_rst_bot_left[30] x3_net34 row_on_detect_bot[19]
+ row_off_detect_bot[18] openDVS_pixel2x2_bot
x3_x1361 dac_config_3 dac_config_5 col_event_rst_bot_left[29] dac_config_4
+ row_on_detect_bot[18] dac_config_0 dac_config_1 row_off_detect_bot[19] x3_net35
+ dac_config_2 vdda1 vssa1 vssc1 col_event_rst_bot_left[28] x3_net36 row_on_detect_bot[19]
+ row_off_detect_bot[18] openDVS_pixel2x2_bot
x3_x1362 dac_config_3 dac_config_5 col_event_rst_bot_left[27] dac_config_4
+ row_on_detect_bot[18] dac_config_0 dac_config_1 row_off_detect_bot[19] x3_net37
+ dac_config_2 vdda1 vssa1 vssc1 col_event_rst_bot_left[26] x3_net38 row_on_detect_bot[19]
+ row_off_detect_bot[18] openDVS_pixel2x2_bot
x3_x1363 dac_config_3 dac_config_5 col_event_rst_bot_left[25] dac_config_4
+ row_on_detect_bot[18] dac_config_0 dac_config_1 row_off_detect_bot[19] x3_net39
+ dac_config_2 vdda1 vssa1 vssc1 col_event_rst_bot_left[24] x3_net40 row_on_detect_bot[19]
+ row_off_detect_bot[18] openDVS_pixel2x2_bot
x3_x1364 dac_config_3 dac_config_5 col_event_rst_bot_left[23] dac_config_4
+ row_on_detect_bot[18] dac_config_0 dac_config_1 row_off_detect_bot[19] x3_net41
+ dac_config_2 vdda1 vssa1 vssc1 col_event_rst_bot_left[22] x3_net42 row_on_detect_bot[19]
+ row_off_detect_bot[18] openDVS_pixel2x2_bot
x3_x1365 dac_config_3 dac_config_5 col_event_rst_bot_left[21] dac_config_4
+ row_on_detect_bot[18] dac_config_0 dac_config_1 row_off_detect_bot[19] x3_net43
+ dac_config_2 vdda1 vssa1 vssc1 col_event_rst_bot_left[20] x3_net44 row_on_detect_bot[19]
+ row_off_detect_bot[18] openDVS_pixel2x2_bot
x3_x1366 dac_config_3 dac_config_5 col_event_rst_bot_left[19] dac_config_4
+ row_on_detect_bot[18] dac_config_0 dac_config_1 row_off_detect_bot[19] x3_net45
+ dac_config_2 vdda1 vssa1 vssc1 col_event_rst_bot_left[18] x3_net46 row_on_detect_bot[19]
+ row_off_detect_bot[18] openDVS_pixel2x2_bot
x3_x1367 dac_config_3 dac_config_5 col_event_rst_bot_left[17] dac_config_4
+ row_on_detect_bot[18] dac_config_0 dac_config_1 row_off_detect_bot[19] x3_net47
+ dac_config_2 vdda1 vssa1 vssc1 col_event_rst_bot_left[16] x3_net48 row_on_detect_bot[19]
+ row_off_detect_bot[18] openDVS_pixel2x2_bot
x3_x1368 dac_config_3 dac_config_5 col_event_rst_bot_left[15] dac_config_4
+ row_on_detect_bot[18] dac_config_0 dac_config_1 row_off_detect_bot[19] x3_net49
+ dac_config_2 vdda1 vssa1 vssc1 col_event_rst_bot_left[14] x3_net50 row_on_detect_bot[19]
+ row_off_detect_bot[18] openDVS_pixel2x2_bot
x3_x1369 dac_config_3 dac_config_5 col_event_rst_bot_left[13] dac_config_4
+ row_on_detect_bot[18] dac_config_0 dac_config_1 row_off_detect_bot[19] x3_net51
+ dac_config_2 vdda1 vssa1 vssc1 col_event_rst_bot_left[12] x3_net52 row_on_detect_bot[19]
+ row_off_detect_bot[18] openDVS_pixel2x2_bot
x3_x1370 dac_config_3 dac_config_5 col_event_rst_bot_left[11] dac_config_4
+ row_on_detect_bot[18] dac_config_0 dac_config_1 row_off_detect_bot[19] x3_net53
+ dac_config_2 vdda1 vssa1 vssc1 col_event_rst_bot_left[10] x3_net54 row_on_detect_bot[19]
+ row_off_detect_bot[18] openDVS_pixel2x2_bot
x3_x1371 dac_config_3 dac_config_5 col_event_rst_bot_left[9] dac_config_4
+ row_on_detect_bot[18] dac_config_0 dac_config_1 row_off_detect_bot[19] x3_net55
+ dac_config_2 vdda1 vssa1 vssc1 col_event_rst_bot_left[8] x3_net56 row_on_detect_bot[19]
+ row_off_detect_bot[18] openDVS_pixel2x2_bot
x3_x1372 dac_config_3 dac_config_5 col_event_rst_bot_left[7] dac_config_4
+ row_on_detect_bot[18] dac_config_0 dac_config_1 row_off_detect_bot[19] x3_net57
+ dac_config_2 vdda1 vssa1 vssc1 col_event_rst_bot_left[6] x3_net58 row_on_detect_bot[19]
+ row_off_detect_bot[18] openDVS_pixel2x2_bot
x3_x1373 dac_config_3 dac_config_5 col_event_rst_bot_left[5] dac_config_4
+ row_on_detect_bot[18] dac_config_0 dac_config_1 row_off_detect_bot[19] x3_net59
+ dac_config_2 vdda1 vssa1 vssc1 col_event_rst_bot_left[4] x3_net60 row_on_detect_bot[19]
+ row_off_detect_bot[18] openDVS_pixel2x2_bot
x3_x1374 dac_config_3 dac_config_5 col_event_rst_bot_left[3] dac_config_4
+ row_on_detect_bot[18] dac_config_0 dac_config_1 row_off_detect_bot[19] x3_net61
+ dac_config_2 vdda1 vssa1 vssc1 col_event_rst_bot_left[2] x3_net62 row_on_detect_bot[19]
+ row_off_detect_bot[18] openDVS_pixel2x2_bot
x3_x1375 dac_config_3 dac_config_5 col_event_rst_bot_left[1] dac_config_4
+ row_on_detect_bot[18] dac_config_0 dac_config_1 row_off_detect_bot[19] x3_net63
+ dac_config_2 vdda1 vssa1 vssc1 col_event_rst_bot_left[0] x3_net64 row_on_detect_bot[19]
+ row_off_detect_bot[18] openDVS_pixel2x2_bot
x3_x1376 dac_config_3 dac_config_5 col_event_rst_bot_left[63] dac_config_4
+ row_on_detect_bot[20] dac_config_0 dac_config_1 row_off_detect_bot[21] x3_net1
+ dac_config_2 vdda1 vssa1 vssc1 col_event_rst_bot_left[62] x3_net2 row_on_detect_bot[21]
+ row_off_detect_bot[20] openDVS_pixel2x2_bot
x3_x1377 dac_config_3 dac_config_5 col_event_rst_bot_left[61] dac_config_4
+ row_on_detect_bot[20] dac_config_0 dac_config_1 row_off_detect_bot[21] x3_net3
+ dac_config_2 vdda1 vssa1 vssc1 col_event_rst_bot_left[60] x3_net4 row_on_detect_bot[21]
+ row_off_detect_bot[20] openDVS_pixel2x2_bot
x3_x1378 dac_config_3 dac_config_5 col_event_rst_bot_left[59] dac_config_4
+ row_on_detect_bot[20] dac_config_0 dac_config_1 row_off_detect_bot[21] x3_net5
+ dac_config_2 vdda1 vssa1 vssc1 col_event_rst_bot_left[58] x3_net6 row_on_detect_bot[21]
+ row_off_detect_bot[20] openDVS_pixel2x2_bot
x3_x1379 dac_config_3 dac_config_5 col_event_rst_bot_left[57] dac_config_4
+ row_on_detect_bot[20] dac_config_0 dac_config_1 row_off_detect_bot[21] x3_net7
+ dac_config_2 vdda1 vssa1 vssc1 col_event_rst_bot_left[56] x3_net8 row_on_detect_bot[21]
+ row_off_detect_bot[20] openDVS_pixel2x2_bot
x3_x1380 dac_config_3 dac_config_5 col_event_rst_bot_left[55] dac_config_4
+ row_on_detect_bot[20] dac_config_0 dac_config_1 row_off_detect_bot[21] x3_net9
+ dac_config_2 vdda1 vssa1 vssc1 col_event_rst_bot_left[54] x3_net10 row_on_detect_bot[21]
+ row_off_detect_bot[20] openDVS_pixel2x2_bot
x3_x1381 dac_config_3 dac_config_5 col_event_rst_bot_left[53] dac_config_4
+ row_on_detect_bot[20] dac_config_0 dac_config_1 row_off_detect_bot[21] x3_net11
+ dac_config_2 vdda1 vssa1 vssc1 col_event_rst_bot_left[52] x3_net12 row_on_detect_bot[21]
+ row_off_detect_bot[20] openDVS_pixel2x2_bot
x3_x1382 dac_config_3 dac_config_5 col_event_rst_bot_left[51] dac_config_4
+ row_on_detect_bot[20] dac_config_0 dac_config_1 row_off_detect_bot[21] x3_net13
+ dac_config_2 vdda1 vssa1 vssc1 col_event_rst_bot_left[50] x3_net14 row_on_detect_bot[21]
+ row_off_detect_bot[20] openDVS_pixel2x2_bot
x3_x1383 dac_config_3 dac_config_5 col_event_rst_bot_left[49] dac_config_4
+ row_on_detect_bot[20] dac_config_0 dac_config_1 row_off_detect_bot[21] x3_net15
+ dac_config_2 vdda1 vssa1 vssc1 col_event_rst_bot_left[48] x3_net16 row_on_detect_bot[21]
+ row_off_detect_bot[20] openDVS_pixel2x2_bot
x3_x1384 dac_config_3 dac_config_5 col_event_rst_bot_left[47] dac_config_4
+ row_on_detect_bot[20] dac_config_0 dac_config_1 row_off_detect_bot[21] x3_net17
+ dac_config_2 vdda1 vssa1 vssc1 col_event_rst_bot_left[46] x3_net18 row_on_detect_bot[21]
+ row_off_detect_bot[20] openDVS_pixel2x2_bot
x3_x1385 dac_config_3 dac_config_5 col_event_rst_bot_left[45] dac_config_4
+ row_on_detect_bot[20] dac_config_0 dac_config_1 row_off_detect_bot[21] x3_net19
+ dac_config_2 vdda1 vssa1 vssc1 col_event_rst_bot_left[44] x3_net20 row_on_detect_bot[21]
+ row_off_detect_bot[20] openDVS_pixel2x2_bot
x3_x1386 dac_config_3 dac_config_5 col_event_rst_bot_left[43] dac_config_4
+ row_on_detect_bot[20] dac_config_0 dac_config_1 row_off_detect_bot[21] x3_net21
+ dac_config_2 vdda1 vssa1 vssc1 col_event_rst_bot_left[42] x3_net22 row_on_detect_bot[21]
+ row_off_detect_bot[20] openDVS_pixel2x2_bot
x3_x1387 dac_config_3 dac_config_5 col_event_rst_bot_left[41] dac_config_4
+ row_on_detect_bot[20] dac_config_0 dac_config_1 row_off_detect_bot[21] x3_net23
+ dac_config_2 vdda1 vssa1 vssc1 col_event_rst_bot_left[40] x3_net24 row_on_detect_bot[21]
+ row_off_detect_bot[20] openDVS_pixel2x2_bot
x3_x1388 dac_config_3 dac_config_5 col_event_rst_bot_left[39] dac_config_4
+ row_on_detect_bot[20] dac_config_0 dac_config_1 row_off_detect_bot[21] x3_net25
+ dac_config_2 vdda1 vssa1 vssc1 col_event_rst_bot_left[38] x3_net26 row_on_detect_bot[21]
+ row_off_detect_bot[20] openDVS_pixel2x2_bot
x3_x1389 dac_config_3 dac_config_5 col_event_rst_bot_left[37] dac_config_4
+ row_on_detect_bot[20] dac_config_0 dac_config_1 row_off_detect_bot[21] x3_net27
+ dac_config_2 vdda1 vssa1 vssc1 col_event_rst_bot_left[36] x3_net28 row_on_detect_bot[21]
+ row_off_detect_bot[20] openDVS_pixel2x2_bot
x3_x1390 dac_config_3 dac_config_5 col_event_rst_bot_left[35] dac_config_4
+ row_on_detect_bot[20] dac_config_0 dac_config_1 row_off_detect_bot[21] x3_net29
+ dac_config_2 vdda1 vssa1 vssc1 col_event_rst_bot_left[34] x3_net30 row_on_detect_bot[21]
+ row_off_detect_bot[20] openDVS_pixel2x2_bot
x3_x1391 dac_config_3 dac_config_5 col_event_rst_bot_left[33] dac_config_4
+ row_on_detect_bot[20] dac_config_0 dac_config_1 row_off_detect_bot[21] x3_net31
+ dac_config_2 vdda1 vssa1 vssc1 col_event_rst_bot_left[32] x3_net32 row_on_detect_bot[21]
+ row_off_detect_bot[20] openDVS_pixel2x2_bot
x3_x1392 dac_config_3 dac_config_5 col_event_rst_bot_left[31] dac_config_4
+ row_on_detect_bot[20] dac_config_0 dac_config_1 row_off_detect_bot[21] x3_net33
+ dac_config_2 vdda1 vssa1 vssc1 col_event_rst_bot_left[30] x3_net34 row_on_detect_bot[21]
+ row_off_detect_bot[20] openDVS_pixel2x2_bot
x3_x1393 dac_config_3 dac_config_5 col_event_rst_bot_left[29] dac_config_4
+ row_on_detect_bot[20] dac_config_0 dac_config_1 row_off_detect_bot[21] x3_net35
+ dac_config_2 vdda1 vssa1 vssc1 col_event_rst_bot_left[28] x3_net36 row_on_detect_bot[21]
+ row_off_detect_bot[20] openDVS_pixel2x2_bot
x3_x1394 dac_config_3 dac_config_5 col_event_rst_bot_left[27] dac_config_4
+ row_on_detect_bot[20] dac_config_0 dac_config_1 row_off_detect_bot[21] x3_net37
+ dac_config_2 vdda1 vssa1 vssc1 col_event_rst_bot_left[26] x3_net38 row_on_detect_bot[21]
+ row_off_detect_bot[20] openDVS_pixel2x2_bot
x3_x1395 dac_config_3 dac_config_5 col_event_rst_bot_left[25] dac_config_4
+ row_on_detect_bot[20] dac_config_0 dac_config_1 row_off_detect_bot[21] x3_net39
+ dac_config_2 vdda1 vssa1 vssc1 col_event_rst_bot_left[24] x3_net40 row_on_detect_bot[21]
+ row_off_detect_bot[20] openDVS_pixel2x2_bot
x3_x1396 dac_config_3 dac_config_5 col_event_rst_bot_left[23] dac_config_4
+ row_on_detect_bot[20] dac_config_0 dac_config_1 row_off_detect_bot[21] x3_net41
+ dac_config_2 vdda1 vssa1 vssc1 col_event_rst_bot_left[22] x3_net42 row_on_detect_bot[21]
+ row_off_detect_bot[20] openDVS_pixel2x2_bot
x3_x1397 dac_config_3 dac_config_5 col_event_rst_bot_left[21] dac_config_4
+ row_on_detect_bot[20] dac_config_0 dac_config_1 row_off_detect_bot[21] x3_net43
+ dac_config_2 vdda1 vssa1 vssc1 col_event_rst_bot_left[20] x3_net44 row_on_detect_bot[21]
+ row_off_detect_bot[20] openDVS_pixel2x2_bot
x3_x1398 dac_config_3 dac_config_5 col_event_rst_bot_left[19] dac_config_4
+ row_on_detect_bot[20] dac_config_0 dac_config_1 row_off_detect_bot[21] x3_net45
+ dac_config_2 vdda1 vssa1 vssc1 col_event_rst_bot_left[18] x3_net46 row_on_detect_bot[21]
+ row_off_detect_bot[20] openDVS_pixel2x2_bot
x3_x1399 dac_config_3 dac_config_5 col_event_rst_bot_left[17] dac_config_4
+ row_on_detect_bot[20] dac_config_0 dac_config_1 row_off_detect_bot[21] x3_net47
+ dac_config_2 vdda1 vssa1 vssc1 col_event_rst_bot_left[16] x3_net48 row_on_detect_bot[21]
+ row_off_detect_bot[20] openDVS_pixel2x2_bot
x3_x1400 dac_config_3 dac_config_5 col_event_rst_bot_left[15] dac_config_4
+ row_on_detect_bot[20] dac_config_0 dac_config_1 row_off_detect_bot[21] x3_net49
+ dac_config_2 vdda1 vssa1 vssc1 col_event_rst_bot_left[14] x3_net50 row_on_detect_bot[21]
+ row_off_detect_bot[20] openDVS_pixel2x2_bot
x3_x1401 dac_config_3 dac_config_5 col_event_rst_bot_left[13] dac_config_4
+ row_on_detect_bot[20] dac_config_0 dac_config_1 row_off_detect_bot[21] x3_net51
+ dac_config_2 vdda1 vssa1 vssc1 col_event_rst_bot_left[12] x3_net52 row_on_detect_bot[21]
+ row_off_detect_bot[20] openDVS_pixel2x2_bot
x3_x1402 dac_config_3 dac_config_5 col_event_rst_bot_left[11] dac_config_4
+ row_on_detect_bot[20] dac_config_0 dac_config_1 row_off_detect_bot[21] x3_net53
+ dac_config_2 vdda1 vssa1 vssc1 col_event_rst_bot_left[10] x3_net54 row_on_detect_bot[21]
+ row_off_detect_bot[20] openDVS_pixel2x2_bot
x3_x1403 dac_config_3 dac_config_5 col_event_rst_bot_left[9] dac_config_4
+ row_on_detect_bot[20] dac_config_0 dac_config_1 row_off_detect_bot[21] x3_net55
+ dac_config_2 vdda1 vssa1 vssc1 col_event_rst_bot_left[8] x3_net56 row_on_detect_bot[21]
+ row_off_detect_bot[20] openDVS_pixel2x2_bot
x3_x1404 dac_config_3 dac_config_5 col_event_rst_bot_left[7] dac_config_4
+ row_on_detect_bot[20] dac_config_0 dac_config_1 row_off_detect_bot[21] x3_net57
+ dac_config_2 vdda1 vssa1 vssc1 col_event_rst_bot_left[6] x3_net58 row_on_detect_bot[21]
+ row_off_detect_bot[20] openDVS_pixel2x2_bot
x3_x1405 dac_config_3 dac_config_5 col_event_rst_bot_left[5] dac_config_4
+ row_on_detect_bot[20] dac_config_0 dac_config_1 row_off_detect_bot[21] x3_net59
+ dac_config_2 vdda1 vssa1 vssc1 col_event_rst_bot_left[4] x3_net60 row_on_detect_bot[21]
+ row_off_detect_bot[20] openDVS_pixel2x2_bot
x3_x1406 dac_config_3 dac_config_5 col_event_rst_bot_left[3] dac_config_4
+ row_on_detect_bot[20] dac_config_0 dac_config_1 row_off_detect_bot[21] x3_net61
+ dac_config_2 vdda1 vssa1 vssc1 col_event_rst_bot_left[2] x3_net62 row_on_detect_bot[21]
+ row_off_detect_bot[20] openDVS_pixel2x2_bot
x3_x1407 dac_config_3 dac_config_5 col_event_rst_bot_left[1] dac_config_4
+ row_on_detect_bot[20] dac_config_0 dac_config_1 row_off_detect_bot[21] x3_net63
+ dac_config_2 vdda1 vssa1 vssc1 col_event_rst_bot_left[0] x3_net64 row_on_detect_bot[21]
+ row_off_detect_bot[20] openDVS_pixel2x2_bot
x3_x1408 dac_config_3 dac_config_5 col_event_rst_bot_left[63] dac_config_4
+ row_on_detect_bot[22] dac_config_0 dac_config_1 row_off_detect_bot[23] x3_net1
+ dac_config_2 vdda1 vssa1 vssc1 col_event_rst_bot_left[62] x3_net2 row_on_detect_bot[23]
+ row_off_detect_bot[22] openDVS_pixel2x2_bot
x3_x1409 dac_config_3 dac_config_5 col_event_rst_bot_left[61] dac_config_4
+ row_on_detect_bot[22] dac_config_0 dac_config_1 row_off_detect_bot[23] x3_net3
+ dac_config_2 vdda1 vssa1 vssc1 col_event_rst_bot_left[60] x3_net4 row_on_detect_bot[23]
+ row_off_detect_bot[22] openDVS_pixel2x2_bot
x3_x1410 dac_config_3 dac_config_5 col_event_rst_bot_left[59] dac_config_4
+ row_on_detect_bot[22] dac_config_0 dac_config_1 row_off_detect_bot[23] x3_net5
+ dac_config_2 vdda1 vssa1 vssc1 col_event_rst_bot_left[58] x3_net6 row_on_detect_bot[23]
+ row_off_detect_bot[22] openDVS_pixel2x2_bot
x3_x1411 dac_config_3 dac_config_5 col_event_rst_bot_left[57] dac_config_4
+ row_on_detect_bot[22] dac_config_0 dac_config_1 row_off_detect_bot[23] x3_net7
+ dac_config_2 vdda1 vssa1 vssc1 col_event_rst_bot_left[56] x3_net8 row_on_detect_bot[23]
+ row_off_detect_bot[22] openDVS_pixel2x2_bot
x3_x1412 dac_config_3 dac_config_5 col_event_rst_bot_left[55] dac_config_4
+ row_on_detect_bot[22] dac_config_0 dac_config_1 row_off_detect_bot[23] x3_net9
+ dac_config_2 vdda1 vssa1 vssc1 col_event_rst_bot_left[54] x3_net10 row_on_detect_bot[23]
+ row_off_detect_bot[22] openDVS_pixel2x2_bot
x3_x1413 dac_config_3 dac_config_5 col_event_rst_bot_left[53] dac_config_4
+ row_on_detect_bot[22] dac_config_0 dac_config_1 row_off_detect_bot[23] x3_net11
+ dac_config_2 vdda1 vssa1 vssc1 col_event_rst_bot_left[52] x3_net12 row_on_detect_bot[23]
+ row_off_detect_bot[22] openDVS_pixel2x2_bot
x3_x1414 dac_config_3 dac_config_5 col_event_rst_bot_left[51] dac_config_4
+ row_on_detect_bot[22] dac_config_0 dac_config_1 row_off_detect_bot[23] x3_net13
+ dac_config_2 vdda1 vssa1 vssc1 col_event_rst_bot_left[50] x3_net14 row_on_detect_bot[23]
+ row_off_detect_bot[22] openDVS_pixel2x2_bot
x3_x1415 dac_config_3 dac_config_5 col_event_rst_bot_left[49] dac_config_4
+ row_on_detect_bot[22] dac_config_0 dac_config_1 row_off_detect_bot[23] x3_net15
+ dac_config_2 vdda1 vssa1 vssc1 col_event_rst_bot_left[48] x3_net16 row_on_detect_bot[23]
+ row_off_detect_bot[22] openDVS_pixel2x2_bot
x3_x1416 dac_config_3 dac_config_5 col_event_rst_bot_left[47] dac_config_4
+ row_on_detect_bot[22] dac_config_0 dac_config_1 row_off_detect_bot[23] x3_net17
+ dac_config_2 vdda1 vssa1 vssc1 col_event_rst_bot_left[46] x3_net18 row_on_detect_bot[23]
+ row_off_detect_bot[22] openDVS_pixel2x2_bot
x3_x1417 dac_config_3 dac_config_5 col_event_rst_bot_left[45] dac_config_4
+ row_on_detect_bot[22] dac_config_0 dac_config_1 row_off_detect_bot[23] x3_net19
+ dac_config_2 vdda1 vssa1 vssc1 col_event_rst_bot_left[44] x3_net20 row_on_detect_bot[23]
+ row_off_detect_bot[22] openDVS_pixel2x2_bot
x3_x1418 dac_config_3 dac_config_5 col_event_rst_bot_left[43] dac_config_4
+ row_on_detect_bot[22] dac_config_0 dac_config_1 row_off_detect_bot[23] x3_net21
+ dac_config_2 vdda1 vssa1 vssc1 col_event_rst_bot_left[42] x3_net22 row_on_detect_bot[23]
+ row_off_detect_bot[22] openDVS_pixel2x2_bot
x3_x1419 dac_config_3 dac_config_5 col_event_rst_bot_left[41] dac_config_4
+ row_on_detect_bot[22] dac_config_0 dac_config_1 row_off_detect_bot[23] x3_net23
+ dac_config_2 vdda1 vssa1 vssc1 col_event_rst_bot_left[40] x3_net24 row_on_detect_bot[23]
+ row_off_detect_bot[22] openDVS_pixel2x2_bot
x3_x1420 dac_config_3 dac_config_5 col_event_rst_bot_left[39] dac_config_4
+ row_on_detect_bot[22] dac_config_0 dac_config_1 row_off_detect_bot[23] x3_net25
+ dac_config_2 vdda1 vssa1 vssc1 col_event_rst_bot_left[38] x3_net26 row_on_detect_bot[23]
+ row_off_detect_bot[22] openDVS_pixel2x2_bot
x3_x1421 dac_config_3 dac_config_5 col_event_rst_bot_left[37] dac_config_4
+ row_on_detect_bot[22] dac_config_0 dac_config_1 row_off_detect_bot[23] x3_net27
+ dac_config_2 vdda1 vssa1 vssc1 col_event_rst_bot_left[36] x3_net28 row_on_detect_bot[23]
+ row_off_detect_bot[22] openDVS_pixel2x2_bot
x3_x1422 dac_config_3 dac_config_5 col_event_rst_bot_left[35] dac_config_4
+ row_on_detect_bot[22] dac_config_0 dac_config_1 row_off_detect_bot[23] x3_net29
+ dac_config_2 vdda1 vssa1 vssc1 col_event_rst_bot_left[34] x3_net30 row_on_detect_bot[23]
+ row_off_detect_bot[22] openDVS_pixel2x2_bot
x3_x1423 dac_config_3 dac_config_5 col_event_rst_bot_left[33] dac_config_4
+ row_on_detect_bot[22] dac_config_0 dac_config_1 row_off_detect_bot[23] x3_net31
+ dac_config_2 vdda1 vssa1 vssc1 col_event_rst_bot_left[32] x3_net32 row_on_detect_bot[23]
+ row_off_detect_bot[22] openDVS_pixel2x2_bot
x3_x1424 dac_config_3 dac_config_5 col_event_rst_bot_left[31] dac_config_4
+ row_on_detect_bot[22] dac_config_0 dac_config_1 row_off_detect_bot[23] x3_net33
+ dac_config_2 vdda1 vssa1 vssc1 col_event_rst_bot_left[30] x3_net34 row_on_detect_bot[23]
+ row_off_detect_bot[22] openDVS_pixel2x2_bot
x3_x1425 dac_config_3 dac_config_5 col_event_rst_bot_left[29] dac_config_4
+ row_on_detect_bot[22] dac_config_0 dac_config_1 row_off_detect_bot[23] x3_net35
+ dac_config_2 vdda1 vssa1 vssc1 col_event_rst_bot_left[28] x3_net36 row_on_detect_bot[23]
+ row_off_detect_bot[22] openDVS_pixel2x2_bot
x3_x1426 dac_config_3 dac_config_5 col_event_rst_bot_left[27] dac_config_4
+ row_on_detect_bot[22] dac_config_0 dac_config_1 row_off_detect_bot[23] x3_net37
+ dac_config_2 vdda1 vssa1 vssc1 col_event_rst_bot_left[26] x3_net38 row_on_detect_bot[23]
+ row_off_detect_bot[22] openDVS_pixel2x2_bot
x3_x1427 dac_config_3 dac_config_5 col_event_rst_bot_left[25] dac_config_4
+ row_on_detect_bot[22] dac_config_0 dac_config_1 row_off_detect_bot[23] x3_net39
+ dac_config_2 vdda1 vssa1 vssc1 col_event_rst_bot_left[24] x3_net40 row_on_detect_bot[23]
+ row_off_detect_bot[22] openDVS_pixel2x2_bot
x3_x1428 dac_config_3 dac_config_5 col_event_rst_bot_left[23] dac_config_4
+ row_on_detect_bot[22] dac_config_0 dac_config_1 row_off_detect_bot[23] x3_net41
+ dac_config_2 vdda1 vssa1 vssc1 col_event_rst_bot_left[22] x3_net42 row_on_detect_bot[23]
+ row_off_detect_bot[22] openDVS_pixel2x2_bot
x3_x1429 dac_config_3 dac_config_5 col_event_rst_bot_left[21] dac_config_4
+ row_on_detect_bot[22] dac_config_0 dac_config_1 row_off_detect_bot[23] x3_net43
+ dac_config_2 vdda1 vssa1 vssc1 col_event_rst_bot_left[20] x3_net44 row_on_detect_bot[23]
+ row_off_detect_bot[22] openDVS_pixel2x2_bot
x3_x1430 dac_config_3 dac_config_5 col_event_rst_bot_left[19] dac_config_4
+ row_on_detect_bot[22] dac_config_0 dac_config_1 row_off_detect_bot[23] x3_net45
+ dac_config_2 vdda1 vssa1 vssc1 col_event_rst_bot_left[18] x3_net46 row_on_detect_bot[23]
+ row_off_detect_bot[22] openDVS_pixel2x2_bot
x3_x1431 dac_config_3 dac_config_5 col_event_rst_bot_left[17] dac_config_4
+ row_on_detect_bot[22] dac_config_0 dac_config_1 row_off_detect_bot[23] x3_net47
+ dac_config_2 vdda1 vssa1 vssc1 col_event_rst_bot_left[16] x3_net48 row_on_detect_bot[23]
+ row_off_detect_bot[22] openDVS_pixel2x2_bot
x3_x1432 dac_config_3 dac_config_5 col_event_rst_bot_left[15] dac_config_4
+ row_on_detect_bot[22] dac_config_0 dac_config_1 row_off_detect_bot[23] x3_net49
+ dac_config_2 vdda1 vssa1 vssc1 col_event_rst_bot_left[14] x3_net50 row_on_detect_bot[23]
+ row_off_detect_bot[22] openDVS_pixel2x2_bot
x3_x1433 dac_config_3 dac_config_5 col_event_rst_bot_left[13] dac_config_4
+ row_on_detect_bot[22] dac_config_0 dac_config_1 row_off_detect_bot[23] x3_net51
+ dac_config_2 vdda1 vssa1 vssc1 col_event_rst_bot_left[12] x3_net52 row_on_detect_bot[23]
+ row_off_detect_bot[22] openDVS_pixel2x2_bot
x3_x1434 dac_config_3 dac_config_5 col_event_rst_bot_left[11] dac_config_4
+ row_on_detect_bot[22] dac_config_0 dac_config_1 row_off_detect_bot[23] x3_net53
+ dac_config_2 vdda1 vssa1 vssc1 col_event_rst_bot_left[10] x3_net54 row_on_detect_bot[23]
+ row_off_detect_bot[22] openDVS_pixel2x2_bot
x3_x1435 dac_config_3 dac_config_5 col_event_rst_bot_left[9] dac_config_4
+ row_on_detect_bot[22] dac_config_0 dac_config_1 row_off_detect_bot[23] x3_net55
+ dac_config_2 vdda1 vssa1 vssc1 col_event_rst_bot_left[8] x3_net56 row_on_detect_bot[23]
+ row_off_detect_bot[22] openDVS_pixel2x2_bot
x3_x1436 dac_config_3 dac_config_5 col_event_rst_bot_left[7] dac_config_4
+ row_on_detect_bot[22] dac_config_0 dac_config_1 row_off_detect_bot[23] x3_net57
+ dac_config_2 vdda1 vssa1 vssc1 col_event_rst_bot_left[6] x3_net58 row_on_detect_bot[23]
+ row_off_detect_bot[22] openDVS_pixel2x2_bot
x3_x1437 dac_config_3 dac_config_5 col_event_rst_bot_left[5] dac_config_4
+ row_on_detect_bot[22] dac_config_0 dac_config_1 row_off_detect_bot[23] x3_net59
+ dac_config_2 vdda1 vssa1 vssc1 col_event_rst_bot_left[4] x3_net60 row_on_detect_bot[23]
+ row_off_detect_bot[22] openDVS_pixel2x2_bot
x3_x1438 dac_config_3 dac_config_5 col_event_rst_bot_left[3] dac_config_4
+ row_on_detect_bot[22] dac_config_0 dac_config_1 row_off_detect_bot[23] x3_net61
+ dac_config_2 vdda1 vssa1 vssc1 col_event_rst_bot_left[2] x3_net62 row_on_detect_bot[23]
+ row_off_detect_bot[22] openDVS_pixel2x2_bot
x3_x1439 dac_config_3 dac_config_5 col_event_rst_bot_left[1] dac_config_4
+ row_on_detect_bot[22] dac_config_0 dac_config_1 row_off_detect_bot[23] x3_net63
+ dac_config_2 vdda1 vssa1 vssc1 col_event_rst_bot_left[0] x3_net64 row_on_detect_bot[23]
+ row_off_detect_bot[22] openDVS_pixel2x2_bot
x3_x1440 dac_config_3 dac_config_5 col_event_rst_bot_left[63] dac_config_4
+ row_on_detect_bot[24] dac_config_0 dac_config_1 row_off_detect_bot[25] x3_net1
+ dac_config_2 vdda1 vssa1 vssc1 col_event_rst_bot_left[62] x3_net2 row_on_detect_bot[25]
+ row_off_detect_bot[24] openDVS_pixel2x2_bot
x3_x1441 dac_config_3 dac_config_5 col_event_rst_bot_left[61] dac_config_4
+ row_on_detect_bot[24] dac_config_0 dac_config_1 row_off_detect_bot[25] x3_net3
+ dac_config_2 vdda1 vssa1 vssc1 col_event_rst_bot_left[60] x3_net4 row_on_detect_bot[25]
+ row_off_detect_bot[24] openDVS_pixel2x2_bot
x3_x1442 dac_config_3 dac_config_5 col_event_rst_bot_left[59] dac_config_4
+ row_on_detect_bot[24] dac_config_0 dac_config_1 row_off_detect_bot[25] x3_net5
+ dac_config_2 vdda1 vssa1 vssc1 col_event_rst_bot_left[58] x3_net6 row_on_detect_bot[25]
+ row_off_detect_bot[24] openDVS_pixel2x2_bot
x3_x1443 dac_config_3 dac_config_5 col_event_rst_bot_left[57] dac_config_4
+ row_on_detect_bot[24] dac_config_0 dac_config_1 row_off_detect_bot[25] x3_net7
+ dac_config_2 vdda1 vssa1 vssc1 col_event_rst_bot_left[56] x3_net8 row_on_detect_bot[25]
+ row_off_detect_bot[24] openDVS_pixel2x2_bot
x3_x1444 dac_config_3 dac_config_5 col_event_rst_bot_left[55] dac_config_4
+ row_on_detect_bot[24] dac_config_0 dac_config_1 row_off_detect_bot[25] x3_net9
+ dac_config_2 vdda1 vssa1 vssc1 col_event_rst_bot_left[54] x3_net10 row_on_detect_bot[25]
+ row_off_detect_bot[24] openDVS_pixel2x2_bot
x3_x1445 dac_config_3 dac_config_5 col_event_rst_bot_left[53] dac_config_4
+ row_on_detect_bot[24] dac_config_0 dac_config_1 row_off_detect_bot[25] x3_net11
+ dac_config_2 vdda1 vssa1 vssc1 col_event_rst_bot_left[52] x3_net12 row_on_detect_bot[25]
+ row_off_detect_bot[24] openDVS_pixel2x2_bot
x3_x1446 dac_config_3 dac_config_5 col_event_rst_bot_left[51] dac_config_4
+ row_on_detect_bot[24] dac_config_0 dac_config_1 row_off_detect_bot[25] x3_net13
+ dac_config_2 vdda1 vssa1 vssc1 col_event_rst_bot_left[50] x3_net14 row_on_detect_bot[25]
+ row_off_detect_bot[24] openDVS_pixel2x2_bot
x3_x1447 dac_config_3 dac_config_5 col_event_rst_bot_left[49] dac_config_4
+ row_on_detect_bot[24] dac_config_0 dac_config_1 row_off_detect_bot[25] x3_net15
+ dac_config_2 vdda1 vssa1 vssc1 col_event_rst_bot_left[48] x3_net16 row_on_detect_bot[25]
+ row_off_detect_bot[24] openDVS_pixel2x2_bot
x3_x1448 dac_config_3 dac_config_5 col_event_rst_bot_left[47] dac_config_4
+ row_on_detect_bot[24] dac_config_0 dac_config_1 row_off_detect_bot[25] x3_net17
+ dac_config_2 vdda1 vssa1 vssc1 col_event_rst_bot_left[46] x3_net18 row_on_detect_bot[25]
+ row_off_detect_bot[24] openDVS_pixel2x2_bot
x3_x1449 dac_config_3 dac_config_5 col_event_rst_bot_left[45] dac_config_4
+ row_on_detect_bot[24] dac_config_0 dac_config_1 row_off_detect_bot[25] x3_net19
+ dac_config_2 vdda1 vssa1 vssc1 col_event_rst_bot_left[44] x3_net20 row_on_detect_bot[25]
+ row_off_detect_bot[24] openDVS_pixel2x2_bot
x3_x1450 dac_config_3 dac_config_5 col_event_rst_bot_left[43] dac_config_4
+ row_on_detect_bot[24] dac_config_0 dac_config_1 row_off_detect_bot[25] x3_net21
+ dac_config_2 vdda1 vssa1 vssc1 col_event_rst_bot_left[42] x3_net22 row_on_detect_bot[25]
+ row_off_detect_bot[24] openDVS_pixel2x2_bot
x3_x1451 dac_config_3 dac_config_5 col_event_rst_bot_left[41] dac_config_4
+ row_on_detect_bot[24] dac_config_0 dac_config_1 row_off_detect_bot[25] x3_net23
+ dac_config_2 vdda1 vssa1 vssc1 col_event_rst_bot_left[40] x3_net24 row_on_detect_bot[25]
+ row_off_detect_bot[24] openDVS_pixel2x2_bot
x3_x1452 dac_config_3 dac_config_5 col_event_rst_bot_left[39] dac_config_4
+ row_on_detect_bot[24] dac_config_0 dac_config_1 row_off_detect_bot[25] x3_net25
+ dac_config_2 vdda1 vssa1 vssc1 col_event_rst_bot_left[38] x3_net26 row_on_detect_bot[25]
+ row_off_detect_bot[24] openDVS_pixel2x2_bot
x3_x1453 dac_config_3 dac_config_5 col_event_rst_bot_left[37] dac_config_4
+ row_on_detect_bot[24] dac_config_0 dac_config_1 row_off_detect_bot[25] x3_net27
+ dac_config_2 vdda1 vssa1 vssc1 col_event_rst_bot_left[36] x3_net28 row_on_detect_bot[25]
+ row_off_detect_bot[24] openDVS_pixel2x2_bot
x3_x1454 dac_config_3 dac_config_5 col_event_rst_bot_left[35] dac_config_4
+ row_on_detect_bot[24] dac_config_0 dac_config_1 row_off_detect_bot[25] x3_net29
+ dac_config_2 vdda1 vssa1 vssc1 col_event_rst_bot_left[34] x3_net30 row_on_detect_bot[25]
+ row_off_detect_bot[24] openDVS_pixel2x2_bot
x3_x1455 dac_config_3 dac_config_5 col_event_rst_bot_left[33] dac_config_4
+ row_on_detect_bot[24] dac_config_0 dac_config_1 row_off_detect_bot[25] x3_net31
+ dac_config_2 vdda1 vssa1 vssc1 col_event_rst_bot_left[32] x3_net32 row_on_detect_bot[25]
+ row_off_detect_bot[24] openDVS_pixel2x2_bot
x3_x1456 dac_config_3 dac_config_5 col_event_rst_bot_left[31] dac_config_4
+ row_on_detect_bot[24] dac_config_0 dac_config_1 row_off_detect_bot[25] x3_net33
+ dac_config_2 vdda1 vssa1 vssc1 col_event_rst_bot_left[30] x3_net34 row_on_detect_bot[25]
+ row_off_detect_bot[24] openDVS_pixel2x2_bot
x3_x1457 dac_config_3 dac_config_5 col_event_rst_bot_left[29] dac_config_4
+ row_on_detect_bot[24] dac_config_0 dac_config_1 row_off_detect_bot[25] x3_net35
+ dac_config_2 vdda1 vssa1 vssc1 col_event_rst_bot_left[28] x3_net36 row_on_detect_bot[25]
+ row_off_detect_bot[24] openDVS_pixel2x2_bot
x3_x1458 dac_config_3 dac_config_5 col_event_rst_bot_left[27] dac_config_4
+ row_on_detect_bot[24] dac_config_0 dac_config_1 row_off_detect_bot[25] x3_net37
+ dac_config_2 vdda1 vssa1 vssc1 col_event_rst_bot_left[26] x3_net38 row_on_detect_bot[25]
+ row_off_detect_bot[24] openDVS_pixel2x2_bot
x3_x1459 dac_config_3 dac_config_5 col_event_rst_bot_left[25] dac_config_4
+ row_on_detect_bot[24] dac_config_0 dac_config_1 row_off_detect_bot[25] x3_net39
+ dac_config_2 vdda1 vssa1 vssc1 col_event_rst_bot_left[24] x3_net40 row_on_detect_bot[25]
+ row_off_detect_bot[24] openDVS_pixel2x2_bot
x3_x1460 dac_config_3 dac_config_5 col_event_rst_bot_left[23] dac_config_4
+ row_on_detect_bot[24] dac_config_0 dac_config_1 row_off_detect_bot[25] x3_net41
+ dac_config_2 vdda1 vssa1 vssc1 col_event_rst_bot_left[22] x3_net42 row_on_detect_bot[25]
+ row_off_detect_bot[24] openDVS_pixel2x2_bot
x3_x1461 dac_config_3 dac_config_5 col_event_rst_bot_left[21] dac_config_4
+ row_on_detect_bot[24] dac_config_0 dac_config_1 row_off_detect_bot[25] x3_net43
+ dac_config_2 vdda1 vssa1 vssc1 col_event_rst_bot_left[20] x3_net44 row_on_detect_bot[25]
+ row_off_detect_bot[24] openDVS_pixel2x2_bot
x3_x1462 dac_config_3 dac_config_5 col_event_rst_bot_left[19] dac_config_4
+ row_on_detect_bot[24] dac_config_0 dac_config_1 row_off_detect_bot[25] x3_net45
+ dac_config_2 vdda1 vssa1 vssc1 col_event_rst_bot_left[18] x3_net46 row_on_detect_bot[25]
+ row_off_detect_bot[24] openDVS_pixel2x2_bot
x3_x1463 dac_config_3 dac_config_5 col_event_rst_bot_left[17] dac_config_4
+ row_on_detect_bot[24] dac_config_0 dac_config_1 row_off_detect_bot[25] x3_net47
+ dac_config_2 vdda1 vssa1 vssc1 col_event_rst_bot_left[16] x3_net48 row_on_detect_bot[25]
+ row_off_detect_bot[24] openDVS_pixel2x2_bot
x3_x1464 dac_config_3 dac_config_5 col_event_rst_bot_left[15] dac_config_4
+ row_on_detect_bot[24] dac_config_0 dac_config_1 row_off_detect_bot[25] x3_net49
+ dac_config_2 vdda1 vssa1 vssc1 col_event_rst_bot_left[14] x3_net50 row_on_detect_bot[25]
+ row_off_detect_bot[24] openDVS_pixel2x2_bot
x3_x1465 dac_config_3 dac_config_5 col_event_rst_bot_left[13] dac_config_4
+ row_on_detect_bot[24] dac_config_0 dac_config_1 row_off_detect_bot[25] x3_net51
+ dac_config_2 vdda1 vssa1 vssc1 col_event_rst_bot_left[12] x3_net52 row_on_detect_bot[25]
+ row_off_detect_bot[24] openDVS_pixel2x2_bot
x3_x1466 dac_config_3 dac_config_5 col_event_rst_bot_left[11] dac_config_4
+ row_on_detect_bot[24] dac_config_0 dac_config_1 row_off_detect_bot[25] x3_net53
+ dac_config_2 vdda1 vssa1 vssc1 col_event_rst_bot_left[10] x3_net54 row_on_detect_bot[25]
+ row_off_detect_bot[24] openDVS_pixel2x2_bot
x3_x1467 dac_config_3 dac_config_5 col_event_rst_bot_left[9] dac_config_4
+ row_on_detect_bot[24] dac_config_0 dac_config_1 row_off_detect_bot[25] x3_net55
+ dac_config_2 vdda1 vssa1 vssc1 col_event_rst_bot_left[8] x3_net56 row_on_detect_bot[25]
+ row_off_detect_bot[24] openDVS_pixel2x2_bot
x3_x1468 dac_config_3 dac_config_5 col_event_rst_bot_left[7] dac_config_4
+ row_on_detect_bot[24] dac_config_0 dac_config_1 row_off_detect_bot[25] x3_net57
+ dac_config_2 vdda1 vssa1 vssc1 col_event_rst_bot_left[6] x3_net58 row_on_detect_bot[25]
+ row_off_detect_bot[24] openDVS_pixel2x2_bot
x3_x1469 dac_config_3 dac_config_5 col_event_rst_bot_left[5] dac_config_4
+ row_on_detect_bot[24] dac_config_0 dac_config_1 row_off_detect_bot[25] x3_net59
+ dac_config_2 vdda1 vssa1 vssc1 col_event_rst_bot_left[4] x3_net60 row_on_detect_bot[25]
+ row_off_detect_bot[24] openDVS_pixel2x2_bot
x3_x1470 dac_config_3 dac_config_5 col_event_rst_bot_left[3] dac_config_4
+ row_on_detect_bot[24] dac_config_0 dac_config_1 row_off_detect_bot[25] x3_net61
+ dac_config_2 vdda1 vssa1 vssc1 col_event_rst_bot_left[2] x3_net62 row_on_detect_bot[25]
+ row_off_detect_bot[24] openDVS_pixel2x2_bot
x3_x1471 dac_config_3 dac_config_5 col_event_rst_bot_left[1] dac_config_4
+ row_on_detect_bot[24] dac_config_0 dac_config_1 row_off_detect_bot[25] x3_net63
+ dac_config_2 vdda1 vssa1 vssc1 col_event_rst_bot_left[0] x3_net64 row_on_detect_bot[25]
+ row_off_detect_bot[24] openDVS_pixel2x2_bot
x3_x1472 dac_config_3 dac_config_5 col_event_rst_bot_left[63] dac_config_4
+ row_on_detect_bot[26] dac_config_0 dac_config_1 row_off_detect_bot[27] x3_net1
+ dac_config_2 vdda1 vssa1 vssc1 col_event_rst_bot_left[62] x3_net2 row_on_detect_bot[27]
+ row_off_detect_bot[26] openDVS_pixel2x2_bot
x3_x1473 dac_config_3 dac_config_5 col_event_rst_bot_left[61] dac_config_4
+ row_on_detect_bot[26] dac_config_0 dac_config_1 row_off_detect_bot[27] x3_net3
+ dac_config_2 vdda1 vssa1 vssc1 col_event_rst_bot_left[60] x3_net4 row_on_detect_bot[27]
+ row_off_detect_bot[26] openDVS_pixel2x2_bot
x3_x1474 dac_config_3 dac_config_5 col_event_rst_bot_left[59] dac_config_4
+ row_on_detect_bot[26] dac_config_0 dac_config_1 row_off_detect_bot[27] x3_net5
+ dac_config_2 vdda1 vssa1 vssc1 col_event_rst_bot_left[58] x3_net6 row_on_detect_bot[27]
+ row_off_detect_bot[26] openDVS_pixel2x2_bot
x3_x1475 dac_config_3 dac_config_5 col_event_rst_bot_left[57] dac_config_4
+ row_on_detect_bot[26] dac_config_0 dac_config_1 row_off_detect_bot[27] x3_net7
+ dac_config_2 vdda1 vssa1 vssc1 col_event_rst_bot_left[56] x3_net8 row_on_detect_bot[27]
+ row_off_detect_bot[26] openDVS_pixel2x2_bot
x3_x1476 dac_config_3 dac_config_5 col_event_rst_bot_left[55] dac_config_4
+ row_on_detect_bot[26] dac_config_0 dac_config_1 row_off_detect_bot[27] x3_net9
+ dac_config_2 vdda1 vssa1 vssc1 col_event_rst_bot_left[54] x3_net10 row_on_detect_bot[27]
+ row_off_detect_bot[26] openDVS_pixel2x2_bot
x3_x1477 dac_config_3 dac_config_5 col_event_rst_bot_left[53] dac_config_4
+ row_on_detect_bot[26] dac_config_0 dac_config_1 row_off_detect_bot[27] x3_net11
+ dac_config_2 vdda1 vssa1 vssc1 col_event_rst_bot_left[52] x3_net12 row_on_detect_bot[27]
+ row_off_detect_bot[26] openDVS_pixel2x2_bot
x3_x1478 dac_config_3 dac_config_5 col_event_rst_bot_left[51] dac_config_4
+ row_on_detect_bot[26] dac_config_0 dac_config_1 row_off_detect_bot[27] x3_net13
+ dac_config_2 vdda1 vssa1 vssc1 col_event_rst_bot_left[50] x3_net14 row_on_detect_bot[27]
+ row_off_detect_bot[26] openDVS_pixel2x2_bot
x3_x1479 dac_config_3 dac_config_5 col_event_rst_bot_left[49] dac_config_4
+ row_on_detect_bot[26] dac_config_0 dac_config_1 row_off_detect_bot[27] x3_net15
+ dac_config_2 vdda1 vssa1 vssc1 col_event_rst_bot_left[48] x3_net16 row_on_detect_bot[27]
+ row_off_detect_bot[26] openDVS_pixel2x2_bot
x3_x1480 dac_config_3 dac_config_5 col_event_rst_bot_left[47] dac_config_4
+ row_on_detect_bot[26] dac_config_0 dac_config_1 row_off_detect_bot[27] x3_net17
+ dac_config_2 vdda1 vssa1 vssc1 col_event_rst_bot_left[46] x3_net18 row_on_detect_bot[27]
+ row_off_detect_bot[26] openDVS_pixel2x2_bot
x3_x1481 dac_config_3 dac_config_5 col_event_rst_bot_left[45] dac_config_4
+ row_on_detect_bot[26] dac_config_0 dac_config_1 row_off_detect_bot[27] x3_net19
+ dac_config_2 vdda1 vssa1 vssc1 col_event_rst_bot_left[44] x3_net20 row_on_detect_bot[27]
+ row_off_detect_bot[26] openDVS_pixel2x2_bot
x3_x1482 dac_config_3 dac_config_5 col_event_rst_bot_left[43] dac_config_4
+ row_on_detect_bot[26] dac_config_0 dac_config_1 row_off_detect_bot[27] x3_net21
+ dac_config_2 vdda1 vssa1 vssc1 col_event_rst_bot_left[42] x3_net22 row_on_detect_bot[27]
+ row_off_detect_bot[26] openDVS_pixel2x2_bot
x3_x1483 dac_config_3 dac_config_5 col_event_rst_bot_left[41] dac_config_4
+ row_on_detect_bot[26] dac_config_0 dac_config_1 row_off_detect_bot[27] x3_net23
+ dac_config_2 vdda1 vssa1 vssc1 col_event_rst_bot_left[40] x3_net24 row_on_detect_bot[27]
+ row_off_detect_bot[26] openDVS_pixel2x2_bot
x3_x1484 dac_config_3 dac_config_5 col_event_rst_bot_left[39] dac_config_4
+ row_on_detect_bot[26] dac_config_0 dac_config_1 row_off_detect_bot[27] x3_net25
+ dac_config_2 vdda1 vssa1 vssc1 col_event_rst_bot_left[38] x3_net26 row_on_detect_bot[27]
+ row_off_detect_bot[26] openDVS_pixel2x2_bot
x3_x1485 dac_config_3 dac_config_5 col_event_rst_bot_left[37] dac_config_4
+ row_on_detect_bot[26] dac_config_0 dac_config_1 row_off_detect_bot[27] x3_net27
+ dac_config_2 vdda1 vssa1 vssc1 col_event_rst_bot_left[36] x3_net28 row_on_detect_bot[27]
+ row_off_detect_bot[26] openDVS_pixel2x2_bot
x3_x1486 dac_config_3 dac_config_5 col_event_rst_bot_left[35] dac_config_4
+ row_on_detect_bot[26] dac_config_0 dac_config_1 row_off_detect_bot[27] x3_net29
+ dac_config_2 vdda1 vssa1 vssc1 col_event_rst_bot_left[34] x3_net30 row_on_detect_bot[27]
+ row_off_detect_bot[26] openDVS_pixel2x2_bot
x3_x1487 dac_config_3 dac_config_5 col_event_rst_bot_left[33] dac_config_4
+ row_on_detect_bot[26] dac_config_0 dac_config_1 row_off_detect_bot[27] x3_net31
+ dac_config_2 vdda1 vssa1 vssc1 col_event_rst_bot_left[32] x3_net32 row_on_detect_bot[27]
+ row_off_detect_bot[26] openDVS_pixel2x2_bot
x3_x1488 dac_config_3 dac_config_5 col_event_rst_bot_left[31] dac_config_4
+ row_on_detect_bot[26] dac_config_0 dac_config_1 row_off_detect_bot[27] x3_net33
+ dac_config_2 vdda1 vssa1 vssc1 col_event_rst_bot_left[30] x3_net34 row_on_detect_bot[27]
+ row_off_detect_bot[26] openDVS_pixel2x2_bot
x3_x1489 dac_config_3 dac_config_5 col_event_rst_bot_left[29] dac_config_4
+ row_on_detect_bot[26] dac_config_0 dac_config_1 row_off_detect_bot[27] x3_net35
+ dac_config_2 vdda1 vssa1 vssc1 col_event_rst_bot_left[28] x3_net36 row_on_detect_bot[27]
+ row_off_detect_bot[26] openDVS_pixel2x2_bot
x3_x1490 dac_config_3 dac_config_5 col_event_rst_bot_left[27] dac_config_4
+ row_on_detect_bot[26] dac_config_0 dac_config_1 row_off_detect_bot[27] x3_net37
+ dac_config_2 vdda1 vssa1 vssc1 col_event_rst_bot_left[26] x3_net38 row_on_detect_bot[27]
+ row_off_detect_bot[26] openDVS_pixel2x2_bot
x3_x1491 dac_config_3 dac_config_5 col_event_rst_bot_left[25] dac_config_4
+ row_on_detect_bot[26] dac_config_0 dac_config_1 row_off_detect_bot[27] x3_net39
+ dac_config_2 vdda1 vssa1 vssc1 col_event_rst_bot_left[24] x3_net40 row_on_detect_bot[27]
+ row_off_detect_bot[26] openDVS_pixel2x2_bot
x3_x1492 dac_config_3 dac_config_5 col_event_rst_bot_left[23] dac_config_4
+ row_on_detect_bot[26] dac_config_0 dac_config_1 row_off_detect_bot[27] x3_net41
+ dac_config_2 vdda1 vssa1 vssc1 col_event_rst_bot_left[22] x3_net42 row_on_detect_bot[27]
+ row_off_detect_bot[26] openDVS_pixel2x2_bot
x3_x1493 dac_config_3 dac_config_5 col_event_rst_bot_left[21] dac_config_4
+ row_on_detect_bot[26] dac_config_0 dac_config_1 row_off_detect_bot[27] x3_net43
+ dac_config_2 vdda1 vssa1 vssc1 col_event_rst_bot_left[20] x3_net44 row_on_detect_bot[27]
+ row_off_detect_bot[26] openDVS_pixel2x2_bot
x3_x1494 dac_config_3 dac_config_5 col_event_rst_bot_left[19] dac_config_4
+ row_on_detect_bot[26] dac_config_0 dac_config_1 row_off_detect_bot[27] x3_net45
+ dac_config_2 vdda1 vssa1 vssc1 col_event_rst_bot_left[18] x3_net46 row_on_detect_bot[27]
+ row_off_detect_bot[26] openDVS_pixel2x2_bot
x3_x1495 dac_config_3 dac_config_5 col_event_rst_bot_left[17] dac_config_4
+ row_on_detect_bot[26] dac_config_0 dac_config_1 row_off_detect_bot[27] x3_net47
+ dac_config_2 vdda1 vssa1 vssc1 col_event_rst_bot_left[16] x3_net48 row_on_detect_bot[27]
+ row_off_detect_bot[26] openDVS_pixel2x2_bot
x3_x1496 dac_config_3 dac_config_5 col_event_rst_bot_left[15] dac_config_4
+ row_on_detect_bot[26] dac_config_0 dac_config_1 row_off_detect_bot[27] x3_net49
+ dac_config_2 vdda1 vssa1 vssc1 col_event_rst_bot_left[14] x3_net50 row_on_detect_bot[27]
+ row_off_detect_bot[26] openDVS_pixel2x2_bot
x3_x1497 dac_config_3 dac_config_5 col_event_rst_bot_left[13] dac_config_4
+ row_on_detect_bot[26] dac_config_0 dac_config_1 row_off_detect_bot[27] x3_net51
+ dac_config_2 vdda1 vssa1 vssc1 col_event_rst_bot_left[12] x3_net52 row_on_detect_bot[27]
+ row_off_detect_bot[26] openDVS_pixel2x2_bot
x3_x1498 dac_config_3 dac_config_5 col_event_rst_bot_left[11] dac_config_4
+ row_on_detect_bot[26] dac_config_0 dac_config_1 row_off_detect_bot[27] x3_net53
+ dac_config_2 vdda1 vssa1 vssc1 col_event_rst_bot_left[10] x3_net54 row_on_detect_bot[27]
+ row_off_detect_bot[26] openDVS_pixel2x2_bot
x3_x1499 dac_config_3 dac_config_5 col_event_rst_bot_left[9] dac_config_4
+ row_on_detect_bot[26] dac_config_0 dac_config_1 row_off_detect_bot[27] x3_net55
+ dac_config_2 vdda1 vssa1 vssc1 col_event_rst_bot_left[8] x3_net56 row_on_detect_bot[27]
+ row_off_detect_bot[26] openDVS_pixel2x2_bot
x3_x1500 dac_config_3 dac_config_5 col_event_rst_bot_left[7] dac_config_4
+ row_on_detect_bot[26] dac_config_0 dac_config_1 row_off_detect_bot[27] x3_net57
+ dac_config_2 vdda1 vssa1 vssc1 col_event_rst_bot_left[6] x3_net58 row_on_detect_bot[27]
+ row_off_detect_bot[26] openDVS_pixel2x2_bot
x3_x1501 dac_config_3 dac_config_5 col_event_rst_bot_left[5] dac_config_4
+ row_on_detect_bot[26] dac_config_0 dac_config_1 row_off_detect_bot[27] x3_net59
+ dac_config_2 vdda1 vssa1 vssc1 col_event_rst_bot_left[4] x3_net60 row_on_detect_bot[27]
+ row_off_detect_bot[26] openDVS_pixel2x2_bot
x3_x1502 dac_config_3 dac_config_5 col_event_rst_bot_left[3] dac_config_4
+ row_on_detect_bot[26] dac_config_0 dac_config_1 row_off_detect_bot[27] x3_net61
+ dac_config_2 vdda1 vssa1 vssc1 col_event_rst_bot_left[2] x3_net62 row_on_detect_bot[27]
+ row_off_detect_bot[26] openDVS_pixel2x2_bot
x3_x1503 dac_config_3 dac_config_5 col_event_rst_bot_left[1] dac_config_4
+ row_on_detect_bot[26] dac_config_0 dac_config_1 row_off_detect_bot[27] x3_net63
+ dac_config_2 vdda1 vssa1 vssc1 col_event_rst_bot_left[0] x3_net64 row_on_detect_bot[27]
+ row_off_detect_bot[26] openDVS_pixel2x2_bot
x3_x1504 dac_config_3 dac_config_5 col_event_rst_bot_left[63] dac_config_4
+ row_on_detect_bot[28] dac_config_0 dac_config_1 row_off_detect_bot[29] x3_net1
+ dac_config_2 vdda1 vssa1 vssc1 col_event_rst_bot_left[62] x3_net2 row_on_detect_bot[29]
+ row_off_detect_bot[28] openDVS_pixel2x2_bot
x3_x1505 dac_config_3 dac_config_5 col_event_rst_bot_left[61] dac_config_4
+ row_on_detect_bot[28] dac_config_0 dac_config_1 row_off_detect_bot[29] x3_net3
+ dac_config_2 vdda1 vssa1 vssc1 col_event_rst_bot_left[60] x3_net4 row_on_detect_bot[29]
+ row_off_detect_bot[28] openDVS_pixel2x2_bot
x3_x1506 dac_config_3 dac_config_5 col_event_rst_bot_left[59] dac_config_4
+ row_on_detect_bot[28] dac_config_0 dac_config_1 row_off_detect_bot[29] x3_net5
+ dac_config_2 vdda1 vssa1 vssc1 col_event_rst_bot_left[58] x3_net6 row_on_detect_bot[29]
+ row_off_detect_bot[28] openDVS_pixel2x2_bot
x3_x1507 dac_config_3 dac_config_5 col_event_rst_bot_left[57] dac_config_4
+ row_on_detect_bot[28] dac_config_0 dac_config_1 row_off_detect_bot[29] x3_net7
+ dac_config_2 vdda1 vssa1 vssc1 col_event_rst_bot_left[56] x3_net8 row_on_detect_bot[29]
+ row_off_detect_bot[28] openDVS_pixel2x2_bot
x3_x1508 dac_config_3 dac_config_5 col_event_rst_bot_left[55] dac_config_4
+ row_on_detect_bot[28] dac_config_0 dac_config_1 row_off_detect_bot[29] x3_net9
+ dac_config_2 vdda1 vssa1 vssc1 col_event_rst_bot_left[54] x3_net10 row_on_detect_bot[29]
+ row_off_detect_bot[28] openDVS_pixel2x2_bot
x3_x1509 dac_config_3 dac_config_5 col_event_rst_bot_left[53] dac_config_4
+ row_on_detect_bot[28] dac_config_0 dac_config_1 row_off_detect_bot[29] x3_net11
+ dac_config_2 vdda1 vssa1 vssc1 col_event_rst_bot_left[52] x3_net12 row_on_detect_bot[29]
+ row_off_detect_bot[28] openDVS_pixel2x2_bot
x3_x1510 dac_config_3 dac_config_5 col_event_rst_bot_left[51] dac_config_4
+ row_on_detect_bot[28] dac_config_0 dac_config_1 row_off_detect_bot[29] x3_net13
+ dac_config_2 vdda1 vssa1 vssc1 col_event_rst_bot_left[50] x3_net14 row_on_detect_bot[29]
+ row_off_detect_bot[28] openDVS_pixel2x2_bot
x3_x1511 dac_config_3 dac_config_5 col_event_rst_bot_left[49] dac_config_4
+ row_on_detect_bot[28] dac_config_0 dac_config_1 row_off_detect_bot[29] x3_net15
+ dac_config_2 vdda1 vssa1 vssc1 col_event_rst_bot_left[48] x3_net16 row_on_detect_bot[29]
+ row_off_detect_bot[28] openDVS_pixel2x2_bot
x3_x1512 dac_config_3 dac_config_5 col_event_rst_bot_left[47] dac_config_4
+ row_on_detect_bot[28] dac_config_0 dac_config_1 row_off_detect_bot[29] x3_net17
+ dac_config_2 vdda1 vssa1 vssc1 col_event_rst_bot_left[46] x3_net18 row_on_detect_bot[29]
+ row_off_detect_bot[28] openDVS_pixel2x2_bot
x3_x1513 dac_config_3 dac_config_5 col_event_rst_bot_left[45] dac_config_4
+ row_on_detect_bot[28] dac_config_0 dac_config_1 row_off_detect_bot[29] x3_net19
+ dac_config_2 vdda1 vssa1 vssc1 col_event_rst_bot_left[44] x3_net20 row_on_detect_bot[29]
+ row_off_detect_bot[28] openDVS_pixel2x2_bot
x3_x1514 dac_config_3 dac_config_5 col_event_rst_bot_left[43] dac_config_4
+ row_on_detect_bot[28] dac_config_0 dac_config_1 row_off_detect_bot[29] x3_net21
+ dac_config_2 vdda1 vssa1 vssc1 col_event_rst_bot_left[42] x3_net22 row_on_detect_bot[29]
+ row_off_detect_bot[28] openDVS_pixel2x2_bot
x3_x1515 dac_config_3 dac_config_5 col_event_rst_bot_left[41] dac_config_4
+ row_on_detect_bot[28] dac_config_0 dac_config_1 row_off_detect_bot[29] x3_net23
+ dac_config_2 vdda1 vssa1 vssc1 col_event_rst_bot_left[40] x3_net24 row_on_detect_bot[29]
+ row_off_detect_bot[28] openDVS_pixel2x2_bot
x3_x1516 dac_config_3 dac_config_5 col_event_rst_bot_left[39] dac_config_4
+ row_on_detect_bot[28] dac_config_0 dac_config_1 row_off_detect_bot[29] x3_net25
+ dac_config_2 vdda1 vssa1 vssc1 col_event_rst_bot_left[38] x3_net26 row_on_detect_bot[29]
+ row_off_detect_bot[28] openDVS_pixel2x2_bot
x3_x1517 dac_config_3 dac_config_5 col_event_rst_bot_left[37] dac_config_4
+ row_on_detect_bot[28] dac_config_0 dac_config_1 row_off_detect_bot[29] x3_net27
+ dac_config_2 vdda1 vssa1 vssc1 col_event_rst_bot_left[36] x3_net28 row_on_detect_bot[29]
+ row_off_detect_bot[28] openDVS_pixel2x2_bot
x3_x1518 dac_config_3 dac_config_5 col_event_rst_bot_left[35] dac_config_4
+ row_on_detect_bot[28] dac_config_0 dac_config_1 row_off_detect_bot[29] x3_net29
+ dac_config_2 vdda1 vssa1 vssc1 col_event_rst_bot_left[34] x3_net30 row_on_detect_bot[29]
+ row_off_detect_bot[28] openDVS_pixel2x2_bot
x3_x1519 dac_config_3 dac_config_5 col_event_rst_bot_left[33] dac_config_4
+ row_on_detect_bot[28] dac_config_0 dac_config_1 row_off_detect_bot[29] x3_net31
+ dac_config_2 vdda1 vssa1 vssc1 col_event_rst_bot_left[32] x3_net32 row_on_detect_bot[29]
+ row_off_detect_bot[28] openDVS_pixel2x2_bot
x3_x1520 dac_config_3 dac_config_5 col_event_rst_bot_left[31] dac_config_4
+ row_on_detect_bot[28] dac_config_0 dac_config_1 row_off_detect_bot[29] x3_net33
+ dac_config_2 vdda1 vssa1 vssc1 col_event_rst_bot_left[30] x3_net34 row_on_detect_bot[29]
+ row_off_detect_bot[28] openDVS_pixel2x2_bot
x3_x1521 dac_config_3 dac_config_5 col_event_rst_bot_left[29] dac_config_4
+ row_on_detect_bot[28] dac_config_0 dac_config_1 row_off_detect_bot[29] x3_net35
+ dac_config_2 vdda1 vssa1 vssc1 col_event_rst_bot_left[28] x3_net36 row_on_detect_bot[29]
+ row_off_detect_bot[28] openDVS_pixel2x2_bot
x3_x1522 dac_config_3 dac_config_5 col_event_rst_bot_left[27] dac_config_4
+ row_on_detect_bot[28] dac_config_0 dac_config_1 row_off_detect_bot[29] x3_net37
+ dac_config_2 vdda1 vssa1 vssc1 col_event_rst_bot_left[26] x3_net38 row_on_detect_bot[29]
+ row_off_detect_bot[28] openDVS_pixel2x2_bot
x3_x1523 dac_config_3 dac_config_5 col_event_rst_bot_left[25] dac_config_4
+ row_on_detect_bot[28] dac_config_0 dac_config_1 row_off_detect_bot[29] x3_net39
+ dac_config_2 vdda1 vssa1 vssc1 col_event_rst_bot_left[24] x3_net40 row_on_detect_bot[29]
+ row_off_detect_bot[28] openDVS_pixel2x2_bot
x3_x1524 dac_config_3 dac_config_5 col_event_rst_bot_left[23] dac_config_4
+ row_on_detect_bot[28] dac_config_0 dac_config_1 row_off_detect_bot[29] x3_net41
+ dac_config_2 vdda1 vssa1 vssc1 col_event_rst_bot_left[22] x3_net42 row_on_detect_bot[29]
+ row_off_detect_bot[28] openDVS_pixel2x2_bot
x3_x1525 dac_config_3 dac_config_5 col_event_rst_bot_left[21] dac_config_4
+ row_on_detect_bot[28] dac_config_0 dac_config_1 row_off_detect_bot[29] x3_net43
+ dac_config_2 vdda1 vssa1 vssc1 col_event_rst_bot_left[20] x3_net44 row_on_detect_bot[29]
+ row_off_detect_bot[28] openDVS_pixel2x2_bot
x3_x1526 dac_config_3 dac_config_5 col_event_rst_bot_left[19] dac_config_4
+ row_on_detect_bot[28] dac_config_0 dac_config_1 row_off_detect_bot[29] x3_net45
+ dac_config_2 vdda1 vssa1 vssc1 col_event_rst_bot_left[18] x3_net46 row_on_detect_bot[29]
+ row_off_detect_bot[28] openDVS_pixel2x2_bot
x3_x1527 dac_config_3 dac_config_5 col_event_rst_bot_left[17] dac_config_4
+ row_on_detect_bot[28] dac_config_0 dac_config_1 row_off_detect_bot[29] x3_net47
+ dac_config_2 vdda1 vssa1 vssc1 col_event_rst_bot_left[16] x3_net48 row_on_detect_bot[29]
+ row_off_detect_bot[28] openDVS_pixel2x2_bot
x3_x1528 dac_config_3 dac_config_5 col_event_rst_bot_left[15] dac_config_4
+ row_on_detect_bot[28] dac_config_0 dac_config_1 row_off_detect_bot[29] x3_net49
+ dac_config_2 vdda1 vssa1 vssc1 col_event_rst_bot_left[14] x3_net50 row_on_detect_bot[29]
+ row_off_detect_bot[28] openDVS_pixel2x2_bot
x3_x1529 dac_config_3 dac_config_5 col_event_rst_bot_left[13] dac_config_4
+ row_on_detect_bot[28] dac_config_0 dac_config_1 row_off_detect_bot[29] x3_net51
+ dac_config_2 vdda1 vssa1 vssc1 col_event_rst_bot_left[12] x3_net52 row_on_detect_bot[29]
+ row_off_detect_bot[28] openDVS_pixel2x2_bot
x3_x1530 dac_config_3 dac_config_5 col_event_rst_bot_left[11] dac_config_4
+ row_on_detect_bot[28] dac_config_0 dac_config_1 row_off_detect_bot[29] x3_net53
+ dac_config_2 vdda1 vssa1 vssc1 col_event_rst_bot_left[10] x3_net54 row_on_detect_bot[29]
+ row_off_detect_bot[28] openDVS_pixel2x2_bot
x3_x1531 dac_config_3 dac_config_5 col_event_rst_bot_left[9] dac_config_4
+ row_on_detect_bot[28] dac_config_0 dac_config_1 row_off_detect_bot[29] x3_net55
+ dac_config_2 vdda1 vssa1 vssc1 col_event_rst_bot_left[8] x3_net56 row_on_detect_bot[29]
+ row_off_detect_bot[28] openDVS_pixel2x2_bot
x3_x1532 dac_config_3 dac_config_5 col_event_rst_bot_left[7] dac_config_4
+ row_on_detect_bot[28] dac_config_0 dac_config_1 row_off_detect_bot[29] x3_net57
+ dac_config_2 vdda1 vssa1 vssc1 col_event_rst_bot_left[6] x3_net58 row_on_detect_bot[29]
+ row_off_detect_bot[28] openDVS_pixel2x2_bot
x3_x1533 dac_config_3 dac_config_5 col_event_rst_bot_left[5] dac_config_4
+ row_on_detect_bot[28] dac_config_0 dac_config_1 row_off_detect_bot[29] x3_net59
+ dac_config_2 vdda1 vssa1 vssc1 col_event_rst_bot_left[4] x3_net60 row_on_detect_bot[29]
+ row_off_detect_bot[28] openDVS_pixel2x2_bot
x3_x1534 dac_config_3 dac_config_5 col_event_rst_bot_left[3] dac_config_4
+ row_on_detect_bot[28] dac_config_0 dac_config_1 row_off_detect_bot[29] x3_net61
+ dac_config_2 vdda1 vssa1 vssc1 col_event_rst_bot_left[2] x3_net62 row_on_detect_bot[29]
+ row_off_detect_bot[28] openDVS_pixel2x2_bot
x3_x1535 dac_config_3 dac_config_5 col_event_rst_bot_left[1] dac_config_4
+ row_on_detect_bot[28] dac_config_0 dac_config_1 row_off_detect_bot[29] x3_net63
+ dac_config_2 vdda1 vssa1 vssc1 col_event_rst_bot_left[0] x3_net64 row_on_detect_bot[29]
+ row_off_detect_bot[28] openDVS_pixel2x2_bot
x3_x1536 dac_config_3 dac_config_5 col_event_rst_bot_left[63] dac_config_4
+ row_on_detect_bot[30] dac_config_0 dac_config_1 row_off_detect_bot[31] x3_net1
+ dac_config_2 vdda1 vssa1 vssc1 col_event_rst_bot_left[62] x3_net2 row_on_detect_bot[31]
+ row_off_detect_bot[30] openDVS_pixel2x2_bot
x3_x1537 dac_config_3 dac_config_5 col_event_rst_bot_left[61] dac_config_4
+ row_on_detect_bot[30] dac_config_0 dac_config_1 row_off_detect_bot[31] x3_net3
+ dac_config_2 vdda1 vssa1 vssc1 col_event_rst_bot_left[60] x3_net4 row_on_detect_bot[31]
+ row_off_detect_bot[30] openDVS_pixel2x2_bot
x3_x1538 dac_config_3 dac_config_5 col_event_rst_bot_left[59] dac_config_4
+ row_on_detect_bot[30] dac_config_0 dac_config_1 row_off_detect_bot[31] x3_net5
+ dac_config_2 vdda1 vssa1 vssc1 col_event_rst_bot_left[58] x3_net6 row_on_detect_bot[31]
+ row_off_detect_bot[30] openDVS_pixel2x2_bot
x3_x1539 dac_config_3 dac_config_5 col_event_rst_bot_left[57] dac_config_4
+ row_on_detect_bot[30] dac_config_0 dac_config_1 row_off_detect_bot[31] x3_net7
+ dac_config_2 vdda1 vssa1 vssc1 col_event_rst_bot_left[56] x3_net8 row_on_detect_bot[31]
+ row_off_detect_bot[30] openDVS_pixel2x2_bot
x3_x1540 dac_config_3 dac_config_5 col_event_rst_bot_left[55] dac_config_4
+ row_on_detect_bot[30] dac_config_0 dac_config_1 row_off_detect_bot[31] x3_net9
+ dac_config_2 vdda1 vssa1 vssc1 col_event_rst_bot_left[54] x3_net10 row_on_detect_bot[31]
+ row_off_detect_bot[30] openDVS_pixel2x2_bot
x3_x1541 dac_config_3 dac_config_5 col_event_rst_bot_left[53] dac_config_4
+ row_on_detect_bot[30] dac_config_0 dac_config_1 row_off_detect_bot[31] x3_net11
+ dac_config_2 vdda1 vssa1 vssc1 col_event_rst_bot_left[52] x3_net12 row_on_detect_bot[31]
+ row_off_detect_bot[30] openDVS_pixel2x2_bot
x3_x1542 dac_config_3 dac_config_5 col_event_rst_bot_left[51] dac_config_4
+ row_on_detect_bot[30] dac_config_0 dac_config_1 row_off_detect_bot[31] x3_net13
+ dac_config_2 vdda1 vssa1 vssc1 col_event_rst_bot_left[50] x3_net14 row_on_detect_bot[31]
+ row_off_detect_bot[30] openDVS_pixel2x2_bot
x3_x1543 dac_config_3 dac_config_5 col_event_rst_bot_left[49] dac_config_4
+ row_on_detect_bot[30] dac_config_0 dac_config_1 row_off_detect_bot[31] x3_net15
+ dac_config_2 vdda1 vssa1 vssc1 col_event_rst_bot_left[48] x3_net16 row_on_detect_bot[31]
+ row_off_detect_bot[30] openDVS_pixel2x2_bot
x3_x1544 dac_config_3 dac_config_5 col_event_rst_bot_left[47] dac_config_4
+ row_on_detect_bot[30] dac_config_0 dac_config_1 row_off_detect_bot[31] x3_net17
+ dac_config_2 vdda1 vssa1 vssc1 col_event_rst_bot_left[46] x3_net18 row_on_detect_bot[31]
+ row_off_detect_bot[30] openDVS_pixel2x2_bot
x3_x1545 dac_config_3 dac_config_5 col_event_rst_bot_left[45] dac_config_4
+ row_on_detect_bot[30] dac_config_0 dac_config_1 row_off_detect_bot[31] x3_net19
+ dac_config_2 vdda1 vssa1 vssc1 col_event_rst_bot_left[44] x3_net20 row_on_detect_bot[31]
+ row_off_detect_bot[30] openDVS_pixel2x2_bot
x3_x1546 dac_config_3 dac_config_5 col_event_rst_bot_left[43] dac_config_4
+ row_on_detect_bot[30] dac_config_0 dac_config_1 row_off_detect_bot[31] x3_net21
+ dac_config_2 vdda1 vssa1 vssc1 col_event_rst_bot_left[42] x3_net22 row_on_detect_bot[31]
+ row_off_detect_bot[30] openDVS_pixel2x2_bot
x3_x1547 dac_config_3 dac_config_5 col_event_rst_bot_left[41] dac_config_4
+ row_on_detect_bot[30] dac_config_0 dac_config_1 row_off_detect_bot[31] x3_net23
+ dac_config_2 vdda1 vssa1 vssc1 col_event_rst_bot_left[40] x3_net24 row_on_detect_bot[31]
+ row_off_detect_bot[30] openDVS_pixel2x2_bot
x3_x1548 dac_config_3 dac_config_5 col_event_rst_bot_left[39] dac_config_4
+ row_on_detect_bot[30] dac_config_0 dac_config_1 row_off_detect_bot[31] x3_net25
+ dac_config_2 vdda1 vssa1 vssc1 col_event_rst_bot_left[38] x3_net26 row_on_detect_bot[31]
+ row_off_detect_bot[30] openDVS_pixel2x2_bot
x3_x1549 dac_config_3 dac_config_5 col_event_rst_bot_left[37] dac_config_4
+ row_on_detect_bot[30] dac_config_0 dac_config_1 row_off_detect_bot[31] x3_net27
+ dac_config_2 vdda1 vssa1 vssc1 col_event_rst_bot_left[36] x3_net28 row_on_detect_bot[31]
+ row_off_detect_bot[30] openDVS_pixel2x2_bot
x3_x1550 dac_config_3 dac_config_5 col_event_rst_bot_left[35] dac_config_4
+ row_on_detect_bot[30] dac_config_0 dac_config_1 row_off_detect_bot[31] x3_net29
+ dac_config_2 vdda1 vssa1 vssc1 col_event_rst_bot_left[34] x3_net30 row_on_detect_bot[31]
+ row_off_detect_bot[30] openDVS_pixel2x2_bot
x3_x1551 dac_config_3 dac_config_5 col_event_rst_bot_left[33] dac_config_4
+ row_on_detect_bot[30] dac_config_0 dac_config_1 row_off_detect_bot[31] x3_net31
+ dac_config_2 vdda1 vssa1 vssc1 col_event_rst_bot_left[32] x3_net32 row_on_detect_bot[31]
+ row_off_detect_bot[30] openDVS_pixel2x2_bot
x3_x1552 dac_config_3 dac_config_5 col_event_rst_bot_left[31] dac_config_4
+ row_on_detect_bot[30] dac_config_0 dac_config_1 row_off_detect_bot[31] x3_net33
+ dac_config_2 vdda1 vssa1 vssc1 col_event_rst_bot_left[30] x3_net34 row_on_detect_bot[31]
+ row_off_detect_bot[30] openDVS_pixel2x2_bot
x3_x1553 dac_config_3 dac_config_5 col_event_rst_bot_left[29] dac_config_4
+ row_on_detect_bot[30] dac_config_0 dac_config_1 row_off_detect_bot[31] x3_net35
+ dac_config_2 vdda1 vssa1 vssc1 col_event_rst_bot_left[28] x3_net36 row_on_detect_bot[31]
+ row_off_detect_bot[30] openDVS_pixel2x2_bot
x3_x1554 dac_config_3 dac_config_5 col_event_rst_bot_left[27] dac_config_4
+ row_on_detect_bot[30] dac_config_0 dac_config_1 row_off_detect_bot[31] x3_net37
+ dac_config_2 vdda1 vssa1 vssc1 col_event_rst_bot_left[26] x3_net38 row_on_detect_bot[31]
+ row_off_detect_bot[30] openDVS_pixel2x2_bot
x3_x1555 dac_config_3 dac_config_5 col_event_rst_bot_left[25] dac_config_4
+ row_on_detect_bot[30] dac_config_0 dac_config_1 row_off_detect_bot[31] x3_net39
+ dac_config_2 vdda1 vssa1 vssc1 col_event_rst_bot_left[24] x3_net40 row_on_detect_bot[31]
+ row_off_detect_bot[30] openDVS_pixel2x2_bot
x3_x1556 dac_config_3 dac_config_5 col_event_rst_bot_left[23] dac_config_4
+ row_on_detect_bot[30] dac_config_0 dac_config_1 row_off_detect_bot[31] x3_net41
+ dac_config_2 vdda1 vssa1 vssc1 col_event_rst_bot_left[22] x3_net42 row_on_detect_bot[31]
+ row_off_detect_bot[30] openDVS_pixel2x2_bot
x3_x1557 dac_config_3 dac_config_5 col_event_rst_bot_left[21] dac_config_4
+ row_on_detect_bot[30] dac_config_0 dac_config_1 row_off_detect_bot[31] x3_net43
+ dac_config_2 vdda1 vssa1 vssc1 col_event_rst_bot_left[20] x3_net44 row_on_detect_bot[31]
+ row_off_detect_bot[30] openDVS_pixel2x2_bot
x3_x1558 dac_config_3 dac_config_5 col_event_rst_bot_left[19] dac_config_4
+ row_on_detect_bot[30] dac_config_0 dac_config_1 row_off_detect_bot[31] x3_net45
+ dac_config_2 vdda1 vssa1 vssc1 col_event_rst_bot_left[18] x3_net46 row_on_detect_bot[31]
+ row_off_detect_bot[30] openDVS_pixel2x2_bot
x3_x1559 dac_config_3 dac_config_5 col_event_rst_bot_left[17] dac_config_4
+ row_on_detect_bot[30] dac_config_0 dac_config_1 row_off_detect_bot[31] x3_net47
+ dac_config_2 vdda1 vssa1 vssc1 col_event_rst_bot_left[16] x3_net48 row_on_detect_bot[31]
+ row_off_detect_bot[30] openDVS_pixel2x2_bot
x3_x1560 dac_config_3 dac_config_5 col_event_rst_bot_left[15] dac_config_4
+ row_on_detect_bot[30] dac_config_0 dac_config_1 row_off_detect_bot[31] x3_net49
+ dac_config_2 vdda1 vssa1 vssc1 col_event_rst_bot_left[14] x3_net50 row_on_detect_bot[31]
+ row_off_detect_bot[30] openDVS_pixel2x2_bot
x3_x1561 dac_config_3 dac_config_5 col_event_rst_bot_left[13] dac_config_4
+ row_on_detect_bot[30] dac_config_0 dac_config_1 row_off_detect_bot[31] x3_net51
+ dac_config_2 vdda1 vssa1 vssc1 col_event_rst_bot_left[12] x3_net52 row_on_detect_bot[31]
+ row_off_detect_bot[30] openDVS_pixel2x2_bot
x3_x1562 dac_config_3 dac_config_5 col_event_rst_bot_left[11] dac_config_4
+ row_on_detect_bot[30] dac_config_0 dac_config_1 row_off_detect_bot[31] x3_net53
+ dac_config_2 vdda1 vssa1 vssc1 col_event_rst_bot_left[10] x3_net54 row_on_detect_bot[31]
+ row_off_detect_bot[30] openDVS_pixel2x2_bot
x3_x1563 dac_config_3 dac_config_5 col_event_rst_bot_left[9] dac_config_4
+ row_on_detect_bot[30] dac_config_0 dac_config_1 row_off_detect_bot[31] x3_net55
+ dac_config_2 vdda1 vssa1 vssc1 col_event_rst_bot_left[8] x3_net56 row_on_detect_bot[31]
+ row_off_detect_bot[30] openDVS_pixel2x2_bot
x3_x1564 dac_config_3 dac_config_5 col_event_rst_bot_left[7] dac_config_4
+ row_on_detect_bot[30] dac_config_0 dac_config_1 row_off_detect_bot[31] x3_net57
+ dac_config_2 vdda1 vssa1 vssc1 col_event_rst_bot_left[6] x3_net58 row_on_detect_bot[31]
+ row_off_detect_bot[30] openDVS_pixel2x2_bot
x3_x1565 dac_config_3 dac_config_5 col_event_rst_bot_left[5] dac_config_4
+ row_on_detect_bot[30] dac_config_0 dac_config_1 row_off_detect_bot[31] x3_net59
+ dac_config_2 vdda1 vssa1 vssc1 col_event_rst_bot_left[4] x3_net60 row_on_detect_bot[31]
+ row_off_detect_bot[30] openDVS_pixel2x2_bot
x3_x1566 dac_config_3 dac_config_5 col_event_rst_bot_left[3] dac_config_4
+ row_on_detect_bot[30] dac_config_0 dac_config_1 row_off_detect_bot[31] x3_net61
+ dac_config_2 vdda1 vssa1 vssc1 col_event_rst_bot_left[2] x3_net62 row_on_detect_bot[31]
+ row_off_detect_bot[30] openDVS_pixel2x2_bot
x3_x1567 dac_config_3 dac_config_5 col_event_rst_bot_left[1] dac_config_4
+ row_on_detect_bot[30] dac_config_0 dac_config_1 row_off_detect_bot[31] x3_net63
+ dac_config_2 vdda1 vssa1 vssc1 col_event_rst_bot_left[0] x3_net64 row_on_detect_bot[31]
+ row_off_detect_bot[30] openDVS_pixel2x2_bot
x3_x1568 dac_config_3 dac_config_5 col_event_rst_bot_left[63] dac_config_4
+ row_on_detect_bot[32] dac_config_0 dac_config_1 row_off_detect_bot[33] x3_net1
+ dac_config_2 vdda1 vssa1 vssc1 col_event_rst_bot_left[62] x3_net2 row_on_detect_bot[33]
+ row_off_detect_bot[32] openDVS_pixel2x2_bot
x3_x1569 dac_config_3 dac_config_5 col_event_rst_bot_left[61] dac_config_4
+ row_on_detect_bot[32] dac_config_0 dac_config_1 row_off_detect_bot[33] x3_net3
+ dac_config_2 vdda1 vssa1 vssc1 col_event_rst_bot_left[60] x3_net4 row_on_detect_bot[33]
+ row_off_detect_bot[32] openDVS_pixel2x2_bot
x3_x1570 dac_config_3 dac_config_5 col_event_rst_bot_left[59] dac_config_4
+ row_on_detect_bot[32] dac_config_0 dac_config_1 row_off_detect_bot[33] x3_net5
+ dac_config_2 vdda1 vssa1 vssc1 col_event_rst_bot_left[58] x3_net6 row_on_detect_bot[33]
+ row_off_detect_bot[32] openDVS_pixel2x2_bot
x3_x1571 dac_config_3 dac_config_5 col_event_rst_bot_left[57] dac_config_4
+ row_on_detect_bot[32] dac_config_0 dac_config_1 row_off_detect_bot[33] x3_net7
+ dac_config_2 vdda1 vssa1 vssc1 col_event_rst_bot_left[56] x3_net8 row_on_detect_bot[33]
+ row_off_detect_bot[32] openDVS_pixel2x2_bot
x3_x1572 dac_config_3 dac_config_5 col_event_rst_bot_left[55] dac_config_4
+ row_on_detect_bot[32] dac_config_0 dac_config_1 row_off_detect_bot[33] x3_net9
+ dac_config_2 vdda1 vssa1 vssc1 col_event_rst_bot_left[54] x3_net10 row_on_detect_bot[33]
+ row_off_detect_bot[32] openDVS_pixel2x2_bot
x3_x1573 dac_config_3 dac_config_5 col_event_rst_bot_left[53] dac_config_4
+ row_on_detect_bot[32] dac_config_0 dac_config_1 row_off_detect_bot[33] x3_net11
+ dac_config_2 vdda1 vssa1 vssc1 col_event_rst_bot_left[52] x3_net12 row_on_detect_bot[33]
+ row_off_detect_bot[32] openDVS_pixel2x2_bot
x3_x1574 dac_config_3 dac_config_5 col_event_rst_bot_left[51] dac_config_4
+ row_on_detect_bot[32] dac_config_0 dac_config_1 row_off_detect_bot[33] x3_net13
+ dac_config_2 vdda1 vssa1 vssc1 col_event_rst_bot_left[50] x3_net14 row_on_detect_bot[33]
+ row_off_detect_bot[32] openDVS_pixel2x2_bot
x3_x1575 dac_config_3 dac_config_5 col_event_rst_bot_left[49] dac_config_4
+ row_on_detect_bot[32] dac_config_0 dac_config_1 row_off_detect_bot[33] x3_net15
+ dac_config_2 vdda1 vssa1 vssc1 col_event_rst_bot_left[48] x3_net16 row_on_detect_bot[33]
+ row_off_detect_bot[32] openDVS_pixel2x2_bot
x3_x1576 dac_config_3 dac_config_5 col_event_rst_bot_left[47] dac_config_4
+ row_on_detect_bot[32] dac_config_0 dac_config_1 row_off_detect_bot[33] x3_net17
+ dac_config_2 vdda1 vssa1 vssc1 col_event_rst_bot_left[46] x3_net18 row_on_detect_bot[33]
+ row_off_detect_bot[32] openDVS_pixel2x2_bot
x3_x1577 dac_config_3 dac_config_5 col_event_rst_bot_left[45] dac_config_4
+ row_on_detect_bot[32] dac_config_0 dac_config_1 row_off_detect_bot[33] x3_net19
+ dac_config_2 vdda1 vssa1 vssc1 col_event_rst_bot_left[44] x3_net20 row_on_detect_bot[33]
+ row_off_detect_bot[32] openDVS_pixel2x2_bot
x3_x1578 dac_config_3 dac_config_5 col_event_rst_bot_left[43] dac_config_4
+ row_on_detect_bot[32] dac_config_0 dac_config_1 row_off_detect_bot[33] x3_net21
+ dac_config_2 vdda1 vssa1 vssc1 col_event_rst_bot_left[42] x3_net22 row_on_detect_bot[33]
+ row_off_detect_bot[32] openDVS_pixel2x2_bot
x3_x1579 dac_config_3 dac_config_5 col_event_rst_bot_left[41] dac_config_4
+ row_on_detect_bot[32] dac_config_0 dac_config_1 row_off_detect_bot[33] x3_net23
+ dac_config_2 vdda1 vssa1 vssc1 col_event_rst_bot_left[40] x3_net24 row_on_detect_bot[33]
+ row_off_detect_bot[32] openDVS_pixel2x2_bot
x3_x1580 dac_config_3 dac_config_5 col_event_rst_bot_left[39] dac_config_4
+ row_on_detect_bot[32] dac_config_0 dac_config_1 row_off_detect_bot[33] x3_net25
+ dac_config_2 vdda1 vssa1 vssc1 col_event_rst_bot_left[38] x3_net26 row_on_detect_bot[33]
+ row_off_detect_bot[32] openDVS_pixel2x2_bot
x3_x1581 dac_config_3 dac_config_5 col_event_rst_bot_left[37] dac_config_4
+ row_on_detect_bot[32] dac_config_0 dac_config_1 row_off_detect_bot[33] x3_net27
+ dac_config_2 vdda1 vssa1 vssc1 col_event_rst_bot_left[36] x3_net28 row_on_detect_bot[33]
+ row_off_detect_bot[32] openDVS_pixel2x2_bot
x3_x1582 dac_config_3 dac_config_5 col_event_rst_bot_left[35] dac_config_4
+ row_on_detect_bot[32] dac_config_0 dac_config_1 row_off_detect_bot[33] x3_net29
+ dac_config_2 vdda1 vssa1 vssc1 col_event_rst_bot_left[34] x3_net30 row_on_detect_bot[33]
+ row_off_detect_bot[32] openDVS_pixel2x2_bot
x3_x1583 dac_config_3 dac_config_5 col_event_rst_bot_left[33] dac_config_4
+ row_on_detect_bot[32] dac_config_0 dac_config_1 row_off_detect_bot[33] x3_net31
+ dac_config_2 vdda1 vssa1 vssc1 col_event_rst_bot_left[32] x3_net32 row_on_detect_bot[33]
+ row_off_detect_bot[32] openDVS_pixel2x2_bot
x3_x1584 dac_config_3 dac_config_5 col_event_rst_bot_left[31] dac_config_4
+ row_on_detect_bot[32] dac_config_0 dac_config_1 row_off_detect_bot[33] x3_net33
+ dac_config_2 vdda1 vssa1 vssc1 col_event_rst_bot_left[30] x3_net34 row_on_detect_bot[33]
+ row_off_detect_bot[32] openDVS_pixel2x2_bot
x3_x1585 dac_config_3 dac_config_5 col_event_rst_bot_left[29] dac_config_4
+ row_on_detect_bot[32] dac_config_0 dac_config_1 row_off_detect_bot[33] x3_net35
+ dac_config_2 vdda1 vssa1 vssc1 col_event_rst_bot_left[28] x3_net36 row_on_detect_bot[33]
+ row_off_detect_bot[32] openDVS_pixel2x2_bot
x3_x1586 dac_config_3 dac_config_5 col_event_rst_bot_left[27] dac_config_4
+ row_on_detect_bot[32] dac_config_0 dac_config_1 row_off_detect_bot[33] x3_net37
+ dac_config_2 vdda1 vssa1 vssc1 col_event_rst_bot_left[26] x3_net38 row_on_detect_bot[33]
+ row_off_detect_bot[32] openDVS_pixel2x2_bot
x3_x1587 dac_config_3 dac_config_5 col_event_rst_bot_left[25] dac_config_4
+ row_on_detect_bot[32] dac_config_0 dac_config_1 row_off_detect_bot[33] x3_net39
+ dac_config_2 vdda1 vssa1 vssc1 col_event_rst_bot_left[24] x3_net40 row_on_detect_bot[33]
+ row_off_detect_bot[32] openDVS_pixel2x2_bot
x3_x1588 dac_config_3 dac_config_5 col_event_rst_bot_left[23] dac_config_4
+ row_on_detect_bot[32] dac_config_0 dac_config_1 row_off_detect_bot[33] x3_net41
+ dac_config_2 vdda1 vssa1 vssc1 col_event_rst_bot_left[22] x3_net42 row_on_detect_bot[33]
+ row_off_detect_bot[32] openDVS_pixel2x2_bot
x3_x1589 dac_config_3 dac_config_5 col_event_rst_bot_left[21] dac_config_4
+ row_on_detect_bot[32] dac_config_0 dac_config_1 row_off_detect_bot[33] x3_net43
+ dac_config_2 vdda1 vssa1 vssc1 col_event_rst_bot_left[20] x3_net44 row_on_detect_bot[33]
+ row_off_detect_bot[32] openDVS_pixel2x2_bot
x3_x1590 dac_config_3 dac_config_5 col_event_rst_bot_left[19] dac_config_4
+ row_on_detect_bot[32] dac_config_0 dac_config_1 row_off_detect_bot[33] x3_net45
+ dac_config_2 vdda1 vssa1 vssc1 col_event_rst_bot_left[18] x3_net46 row_on_detect_bot[33]
+ row_off_detect_bot[32] openDVS_pixel2x2_bot
x3_x1591 dac_config_3 dac_config_5 col_event_rst_bot_left[17] dac_config_4
+ row_on_detect_bot[32] dac_config_0 dac_config_1 row_off_detect_bot[33] x3_net47
+ dac_config_2 vdda1 vssa1 vssc1 col_event_rst_bot_left[16] x3_net48 row_on_detect_bot[33]
+ row_off_detect_bot[32] openDVS_pixel2x2_bot
x3_x1592 dac_config_3 dac_config_5 col_event_rst_bot_left[15] dac_config_4
+ row_on_detect_bot[32] dac_config_0 dac_config_1 row_off_detect_bot[33] x3_net49
+ dac_config_2 vdda1 vssa1 vssc1 col_event_rst_bot_left[14] x3_net50 row_on_detect_bot[33]
+ row_off_detect_bot[32] openDVS_pixel2x2_bot
x3_x1593 dac_config_3 dac_config_5 col_event_rst_bot_left[13] dac_config_4
+ row_on_detect_bot[32] dac_config_0 dac_config_1 row_off_detect_bot[33] x3_net51
+ dac_config_2 vdda1 vssa1 vssc1 col_event_rst_bot_left[12] x3_net52 row_on_detect_bot[33]
+ row_off_detect_bot[32] openDVS_pixel2x2_bot
x3_x1594 dac_config_3 dac_config_5 col_event_rst_bot_left[11] dac_config_4
+ row_on_detect_bot[32] dac_config_0 dac_config_1 row_off_detect_bot[33] x3_net53
+ dac_config_2 vdda1 vssa1 vssc1 col_event_rst_bot_left[10] x3_net54 row_on_detect_bot[33]
+ row_off_detect_bot[32] openDVS_pixel2x2_bot
x3_x1595 dac_config_3 dac_config_5 col_event_rst_bot_left[9] dac_config_4
+ row_on_detect_bot[32] dac_config_0 dac_config_1 row_off_detect_bot[33] x3_net55
+ dac_config_2 vdda1 vssa1 vssc1 col_event_rst_bot_left[8] x3_net56 row_on_detect_bot[33]
+ row_off_detect_bot[32] openDVS_pixel2x2_bot
x3_x1596 dac_config_3 dac_config_5 col_event_rst_bot_left[7] dac_config_4
+ row_on_detect_bot[32] dac_config_0 dac_config_1 row_off_detect_bot[33] x3_net57
+ dac_config_2 vdda1 vssa1 vssc1 col_event_rst_bot_left[6] x3_net58 row_on_detect_bot[33]
+ row_off_detect_bot[32] openDVS_pixel2x2_bot
x3_x1597 dac_config_3 dac_config_5 col_event_rst_bot_left[5] dac_config_4
+ row_on_detect_bot[32] dac_config_0 dac_config_1 row_off_detect_bot[33] x3_net59
+ dac_config_2 vdda1 vssa1 vssc1 col_event_rst_bot_left[4] x3_net60 row_on_detect_bot[33]
+ row_off_detect_bot[32] openDVS_pixel2x2_bot
x3_x1598 dac_config_3 dac_config_5 col_event_rst_bot_left[3] dac_config_4
+ row_on_detect_bot[32] dac_config_0 dac_config_1 row_off_detect_bot[33] x3_net61
+ dac_config_2 vdda1 vssa1 vssc1 col_event_rst_bot_left[2] x3_net62 row_on_detect_bot[33]
+ row_off_detect_bot[32] openDVS_pixel2x2_bot
x3_x1599 dac_config_3 dac_config_5 col_event_rst_bot_left[1] dac_config_4
+ row_on_detect_bot[32] dac_config_0 dac_config_1 row_off_detect_bot[33] x3_net63
+ dac_config_2 vdda1 vssa1 vssc1 col_event_rst_bot_left[0] x3_net64 row_on_detect_bot[33]
+ row_off_detect_bot[32] openDVS_pixel2x2_bot
x3_x1600 dac_config_3 dac_config_5 col_event_rst_bot_left[63] dac_config_4
+ row_on_detect_bot[34] dac_config_0 dac_config_1 row_off_detect_bot[35] x3_net1
+ dac_config_2 vdda1 vssa1 vssc1 col_event_rst_bot_left[62] x3_net2 row_on_detect_bot[35]
+ row_off_detect_bot[34] openDVS_pixel2x2_bot
x3_x1601 dac_config_3 dac_config_5 col_event_rst_bot_left[61] dac_config_4
+ row_on_detect_bot[34] dac_config_0 dac_config_1 row_off_detect_bot[35] x3_net3
+ dac_config_2 vdda1 vssa1 vssc1 col_event_rst_bot_left[60] x3_net4 row_on_detect_bot[35]
+ row_off_detect_bot[34] openDVS_pixel2x2_bot
x3_x1602 dac_config_3 dac_config_5 col_event_rst_bot_left[59] dac_config_4
+ row_on_detect_bot[34] dac_config_0 dac_config_1 row_off_detect_bot[35] x3_net5
+ dac_config_2 vdda1 vssa1 vssc1 col_event_rst_bot_left[58] x3_net6 row_on_detect_bot[35]
+ row_off_detect_bot[34] openDVS_pixel2x2_bot
x3_x1603 dac_config_3 dac_config_5 col_event_rst_bot_left[57] dac_config_4
+ row_on_detect_bot[34] dac_config_0 dac_config_1 row_off_detect_bot[35] x3_net7
+ dac_config_2 vdda1 vssa1 vssc1 col_event_rst_bot_left[56] x3_net8 row_on_detect_bot[35]
+ row_off_detect_bot[34] openDVS_pixel2x2_bot
x3_x1604 dac_config_3 dac_config_5 col_event_rst_bot_left[55] dac_config_4
+ row_on_detect_bot[34] dac_config_0 dac_config_1 row_off_detect_bot[35] x3_net9
+ dac_config_2 vdda1 vssa1 vssc1 col_event_rst_bot_left[54] x3_net10 row_on_detect_bot[35]
+ row_off_detect_bot[34] openDVS_pixel2x2_bot
x3_x1605 dac_config_3 dac_config_5 col_event_rst_bot_left[53] dac_config_4
+ row_on_detect_bot[34] dac_config_0 dac_config_1 row_off_detect_bot[35] x3_net11
+ dac_config_2 vdda1 vssa1 vssc1 col_event_rst_bot_left[52] x3_net12 row_on_detect_bot[35]
+ row_off_detect_bot[34] openDVS_pixel2x2_bot
x3_x1606 dac_config_3 dac_config_5 col_event_rst_bot_left[51] dac_config_4
+ row_on_detect_bot[34] dac_config_0 dac_config_1 row_off_detect_bot[35] x3_net13
+ dac_config_2 vdda1 vssa1 vssc1 col_event_rst_bot_left[50] x3_net14 row_on_detect_bot[35]
+ row_off_detect_bot[34] openDVS_pixel2x2_bot
x3_x1607 dac_config_3 dac_config_5 col_event_rst_bot_left[49] dac_config_4
+ row_on_detect_bot[34] dac_config_0 dac_config_1 row_off_detect_bot[35] x3_net15
+ dac_config_2 vdda1 vssa1 vssc1 col_event_rst_bot_left[48] x3_net16 row_on_detect_bot[35]
+ row_off_detect_bot[34] openDVS_pixel2x2_bot
x3_x1608 dac_config_3 dac_config_5 col_event_rst_bot_left[47] dac_config_4
+ row_on_detect_bot[34] dac_config_0 dac_config_1 row_off_detect_bot[35] x3_net17
+ dac_config_2 vdda1 vssa1 vssc1 col_event_rst_bot_left[46] x3_net18 row_on_detect_bot[35]
+ row_off_detect_bot[34] openDVS_pixel2x2_bot
x3_x1609 dac_config_3 dac_config_5 col_event_rst_bot_left[45] dac_config_4
+ row_on_detect_bot[34] dac_config_0 dac_config_1 row_off_detect_bot[35] x3_net19
+ dac_config_2 vdda1 vssa1 vssc1 col_event_rst_bot_left[44] x3_net20 row_on_detect_bot[35]
+ row_off_detect_bot[34] openDVS_pixel2x2_bot
x3_x1610 dac_config_3 dac_config_5 col_event_rst_bot_left[43] dac_config_4
+ row_on_detect_bot[34] dac_config_0 dac_config_1 row_off_detect_bot[35] x3_net21
+ dac_config_2 vdda1 vssa1 vssc1 col_event_rst_bot_left[42] x3_net22 row_on_detect_bot[35]
+ row_off_detect_bot[34] openDVS_pixel2x2_bot
x3_x1611 dac_config_3 dac_config_5 col_event_rst_bot_left[41] dac_config_4
+ row_on_detect_bot[34] dac_config_0 dac_config_1 row_off_detect_bot[35] x3_net23
+ dac_config_2 vdda1 vssa1 vssc1 col_event_rst_bot_left[40] x3_net24 row_on_detect_bot[35]
+ row_off_detect_bot[34] openDVS_pixel2x2_bot
x3_x1612 dac_config_3 dac_config_5 col_event_rst_bot_left[39] dac_config_4
+ row_on_detect_bot[34] dac_config_0 dac_config_1 row_off_detect_bot[35] x3_net25
+ dac_config_2 vdda1 vssa1 vssc1 col_event_rst_bot_left[38] x3_net26 row_on_detect_bot[35]
+ row_off_detect_bot[34] openDVS_pixel2x2_bot
x3_x1613 dac_config_3 dac_config_5 col_event_rst_bot_left[37] dac_config_4
+ row_on_detect_bot[34] dac_config_0 dac_config_1 row_off_detect_bot[35] x3_net27
+ dac_config_2 vdda1 vssa1 vssc1 col_event_rst_bot_left[36] x3_net28 row_on_detect_bot[35]
+ row_off_detect_bot[34] openDVS_pixel2x2_bot
x3_x1614 dac_config_3 dac_config_5 col_event_rst_bot_left[35] dac_config_4
+ row_on_detect_bot[34] dac_config_0 dac_config_1 row_off_detect_bot[35] x3_net29
+ dac_config_2 vdda1 vssa1 vssc1 col_event_rst_bot_left[34] x3_net30 row_on_detect_bot[35]
+ row_off_detect_bot[34] openDVS_pixel2x2_bot
x3_x1615 dac_config_3 dac_config_5 col_event_rst_bot_left[33] dac_config_4
+ row_on_detect_bot[34] dac_config_0 dac_config_1 row_off_detect_bot[35] x3_net31
+ dac_config_2 vdda1 vssa1 vssc1 col_event_rst_bot_left[32] x3_net32 row_on_detect_bot[35]
+ row_off_detect_bot[34] openDVS_pixel2x2_bot
x3_x1616 dac_config_3 dac_config_5 col_event_rst_bot_left[31] dac_config_4
+ row_on_detect_bot[34] dac_config_0 dac_config_1 row_off_detect_bot[35] x3_net33
+ dac_config_2 vdda1 vssa1 vssc1 col_event_rst_bot_left[30] x3_net34 row_on_detect_bot[35]
+ row_off_detect_bot[34] openDVS_pixel2x2_bot
x3_x1617 dac_config_3 dac_config_5 col_event_rst_bot_left[29] dac_config_4
+ row_on_detect_bot[34] dac_config_0 dac_config_1 row_off_detect_bot[35] x3_net35
+ dac_config_2 vdda1 vssa1 vssc1 col_event_rst_bot_left[28] x3_net36 row_on_detect_bot[35]
+ row_off_detect_bot[34] openDVS_pixel2x2_bot
x3_x1618 dac_config_3 dac_config_5 col_event_rst_bot_left[27] dac_config_4
+ row_on_detect_bot[34] dac_config_0 dac_config_1 row_off_detect_bot[35] x3_net37
+ dac_config_2 vdda1 vssa1 vssc1 col_event_rst_bot_left[26] x3_net38 row_on_detect_bot[35]
+ row_off_detect_bot[34] openDVS_pixel2x2_bot
x3_x1619 dac_config_3 dac_config_5 col_event_rst_bot_left[25] dac_config_4
+ row_on_detect_bot[34] dac_config_0 dac_config_1 row_off_detect_bot[35] x3_net39
+ dac_config_2 vdda1 vssa1 vssc1 col_event_rst_bot_left[24] x3_net40 row_on_detect_bot[35]
+ row_off_detect_bot[34] openDVS_pixel2x2_bot
x3_x1620 dac_config_3 dac_config_5 col_event_rst_bot_left[23] dac_config_4
+ row_on_detect_bot[34] dac_config_0 dac_config_1 row_off_detect_bot[35] x3_net41
+ dac_config_2 vdda1 vssa1 vssc1 col_event_rst_bot_left[22] x3_net42 row_on_detect_bot[35]
+ row_off_detect_bot[34] openDVS_pixel2x2_bot
x3_x1621 dac_config_3 dac_config_5 col_event_rst_bot_left[21] dac_config_4
+ row_on_detect_bot[34] dac_config_0 dac_config_1 row_off_detect_bot[35] x3_net43
+ dac_config_2 vdda1 vssa1 vssc1 col_event_rst_bot_left[20] x3_net44 row_on_detect_bot[35]
+ row_off_detect_bot[34] openDVS_pixel2x2_bot
x3_x1622 dac_config_3 dac_config_5 col_event_rst_bot_left[19] dac_config_4
+ row_on_detect_bot[34] dac_config_0 dac_config_1 row_off_detect_bot[35] x3_net45
+ dac_config_2 vdda1 vssa1 vssc1 col_event_rst_bot_left[18] x3_net46 row_on_detect_bot[35]
+ row_off_detect_bot[34] openDVS_pixel2x2_bot
x3_x1623 dac_config_3 dac_config_5 col_event_rst_bot_left[17] dac_config_4
+ row_on_detect_bot[34] dac_config_0 dac_config_1 row_off_detect_bot[35] x3_net47
+ dac_config_2 vdda1 vssa1 vssc1 col_event_rst_bot_left[16] x3_net48 row_on_detect_bot[35]
+ row_off_detect_bot[34] openDVS_pixel2x2_bot
x3_x1624 dac_config_3 dac_config_5 col_event_rst_bot_left[15] dac_config_4
+ row_on_detect_bot[34] dac_config_0 dac_config_1 row_off_detect_bot[35] x3_net49
+ dac_config_2 vdda1 vssa1 vssc1 col_event_rst_bot_left[14] x3_net50 row_on_detect_bot[35]
+ row_off_detect_bot[34] openDVS_pixel2x2_bot
x3_x1625 dac_config_3 dac_config_5 col_event_rst_bot_left[13] dac_config_4
+ row_on_detect_bot[34] dac_config_0 dac_config_1 row_off_detect_bot[35] x3_net51
+ dac_config_2 vdda1 vssa1 vssc1 col_event_rst_bot_left[12] x3_net52 row_on_detect_bot[35]
+ row_off_detect_bot[34] openDVS_pixel2x2_bot
x3_x1626 dac_config_3 dac_config_5 col_event_rst_bot_left[11] dac_config_4
+ row_on_detect_bot[34] dac_config_0 dac_config_1 row_off_detect_bot[35] x3_net53
+ dac_config_2 vdda1 vssa1 vssc1 col_event_rst_bot_left[10] x3_net54 row_on_detect_bot[35]
+ row_off_detect_bot[34] openDVS_pixel2x2_bot
x3_x1627 dac_config_3 dac_config_5 col_event_rst_bot_left[9] dac_config_4
+ row_on_detect_bot[34] dac_config_0 dac_config_1 row_off_detect_bot[35] x3_net55
+ dac_config_2 vdda1 vssa1 vssc1 col_event_rst_bot_left[8] x3_net56 row_on_detect_bot[35]
+ row_off_detect_bot[34] openDVS_pixel2x2_bot
x3_x1628 dac_config_3 dac_config_5 col_event_rst_bot_left[7] dac_config_4
+ row_on_detect_bot[34] dac_config_0 dac_config_1 row_off_detect_bot[35] x3_net57
+ dac_config_2 vdda1 vssa1 vssc1 col_event_rst_bot_left[6] x3_net58 row_on_detect_bot[35]
+ row_off_detect_bot[34] openDVS_pixel2x2_bot
x3_x1629 dac_config_3 dac_config_5 col_event_rst_bot_left[5] dac_config_4
+ row_on_detect_bot[34] dac_config_0 dac_config_1 row_off_detect_bot[35] x3_net59
+ dac_config_2 vdda1 vssa1 vssc1 col_event_rst_bot_left[4] x3_net60 row_on_detect_bot[35]
+ row_off_detect_bot[34] openDVS_pixel2x2_bot
x3_x1630 dac_config_3 dac_config_5 col_event_rst_bot_left[3] dac_config_4
+ row_on_detect_bot[34] dac_config_0 dac_config_1 row_off_detect_bot[35] x3_net61
+ dac_config_2 vdda1 vssa1 vssc1 col_event_rst_bot_left[2] x3_net62 row_on_detect_bot[35]
+ row_off_detect_bot[34] openDVS_pixel2x2_bot
x3_x1631 dac_config_3 dac_config_5 col_event_rst_bot_left[1] dac_config_4
+ row_on_detect_bot[34] dac_config_0 dac_config_1 row_off_detect_bot[35] x3_net63
+ dac_config_2 vdda1 vssa1 vssc1 col_event_rst_bot_left[0] x3_net64 row_on_detect_bot[35]
+ row_off_detect_bot[34] openDVS_pixel2x2_bot
x3_x1632 dac_config_3 dac_config_5 col_event_rst_bot_left[63] dac_config_4
+ row_on_detect_bot[36] dac_config_0 dac_config_1 row_off_detect_bot[37] x3_net1
+ dac_config_2 vdda1 vssa1 vssc1 col_event_rst_bot_left[62] x3_net2 row_on_detect_bot[37]
+ row_off_detect_bot[36] openDVS_pixel2x2_bot
x3_x1633 dac_config_3 dac_config_5 col_event_rst_bot_left[61] dac_config_4
+ row_on_detect_bot[36] dac_config_0 dac_config_1 row_off_detect_bot[37] x3_net3
+ dac_config_2 vdda1 vssa1 vssc1 col_event_rst_bot_left[60] x3_net4 row_on_detect_bot[37]
+ row_off_detect_bot[36] openDVS_pixel2x2_bot
x3_x1634 dac_config_3 dac_config_5 col_event_rst_bot_left[59] dac_config_4
+ row_on_detect_bot[36] dac_config_0 dac_config_1 row_off_detect_bot[37] x3_net5
+ dac_config_2 vdda1 vssa1 vssc1 col_event_rst_bot_left[58] x3_net6 row_on_detect_bot[37]
+ row_off_detect_bot[36] openDVS_pixel2x2_bot
x3_x1635 dac_config_3 dac_config_5 col_event_rst_bot_left[57] dac_config_4
+ row_on_detect_bot[36] dac_config_0 dac_config_1 row_off_detect_bot[37] x3_net7
+ dac_config_2 vdda1 vssa1 vssc1 col_event_rst_bot_left[56] x3_net8 row_on_detect_bot[37]
+ row_off_detect_bot[36] openDVS_pixel2x2_bot
x3_x1636 dac_config_3 dac_config_5 col_event_rst_bot_left[55] dac_config_4
+ row_on_detect_bot[36] dac_config_0 dac_config_1 row_off_detect_bot[37] x3_net9
+ dac_config_2 vdda1 vssa1 vssc1 col_event_rst_bot_left[54] x3_net10 row_on_detect_bot[37]
+ row_off_detect_bot[36] openDVS_pixel2x2_bot
x3_x1637 dac_config_3 dac_config_5 col_event_rst_bot_left[53] dac_config_4
+ row_on_detect_bot[36] dac_config_0 dac_config_1 row_off_detect_bot[37] x3_net11
+ dac_config_2 vdda1 vssa1 vssc1 col_event_rst_bot_left[52] x3_net12 row_on_detect_bot[37]
+ row_off_detect_bot[36] openDVS_pixel2x2_bot
x3_x1638 dac_config_3 dac_config_5 col_event_rst_bot_left[51] dac_config_4
+ row_on_detect_bot[36] dac_config_0 dac_config_1 row_off_detect_bot[37] x3_net13
+ dac_config_2 vdda1 vssa1 vssc1 col_event_rst_bot_left[50] x3_net14 row_on_detect_bot[37]
+ row_off_detect_bot[36] openDVS_pixel2x2_bot
x3_x1639 dac_config_3 dac_config_5 col_event_rst_bot_left[49] dac_config_4
+ row_on_detect_bot[36] dac_config_0 dac_config_1 row_off_detect_bot[37] x3_net15
+ dac_config_2 vdda1 vssa1 vssc1 col_event_rst_bot_left[48] x3_net16 row_on_detect_bot[37]
+ row_off_detect_bot[36] openDVS_pixel2x2_bot
x3_x1640 dac_config_3 dac_config_5 col_event_rst_bot_left[47] dac_config_4
+ row_on_detect_bot[36] dac_config_0 dac_config_1 row_off_detect_bot[37] x3_net17
+ dac_config_2 vdda1 vssa1 vssc1 col_event_rst_bot_left[46] x3_net18 row_on_detect_bot[37]
+ row_off_detect_bot[36] openDVS_pixel2x2_bot
x3_x1641 dac_config_3 dac_config_5 col_event_rst_bot_left[45] dac_config_4
+ row_on_detect_bot[36] dac_config_0 dac_config_1 row_off_detect_bot[37] x3_net19
+ dac_config_2 vdda1 vssa1 vssc1 col_event_rst_bot_left[44] x3_net20 row_on_detect_bot[37]
+ row_off_detect_bot[36] openDVS_pixel2x2_bot
x3_x1642 dac_config_3 dac_config_5 col_event_rst_bot_left[43] dac_config_4
+ row_on_detect_bot[36] dac_config_0 dac_config_1 row_off_detect_bot[37] x3_net21
+ dac_config_2 vdda1 vssa1 vssc1 col_event_rst_bot_left[42] x3_net22 row_on_detect_bot[37]
+ row_off_detect_bot[36] openDVS_pixel2x2_bot
x3_x1643 dac_config_3 dac_config_5 col_event_rst_bot_left[41] dac_config_4
+ row_on_detect_bot[36] dac_config_0 dac_config_1 row_off_detect_bot[37] x3_net23
+ dac_config_2 vdda1 vssa1 vssc1 col_event_rst_bot_left[40] x3_net24 row_on_detect_bot[37]
+ row_off_detect_bot[36] openDVS_pixel2x2_bot
x3_x1644 dac_config_3 dac_config_5 col_event_rst_bot_left[39] dac_config_4
+ row_on_detect_bot[36] dac_config_0 dac_config_1 row_off_detect_bot[37] x3_net25
+ dac_config_2 vdda1 vssa1 vssc1 col_event_rst_bot_left[38] x3_net26 row_on_detect_bot[37]
+ row_off_detect_bot[36] openDVS_pixel2x2_bot
x3_x1645 dac_config_3 dac_config_5 col_event_rst_bot_left[37] dac_config_4
+ row_on_detect_bot[36] dac_config_0 dac_config_1 row_off_detect_bot[37] x3_net27
+ dac_config_2 vdda1 vssa1 vssc1 col_event_rst_bot_left[36] x3_net28 row_on_detect_bot[37]
+ row_off_detect_bot[36] openDVS_pixel2x2_bot
x3_x1646 dac_config_3 dac_config_5 col_event_rst_bot_left[35] dac_config_4
+ row_on_detect_bot[36] dac_config_0 dac_config_1 row_off_detect_bot[37] x3_net29
+ dac_config_2 vdda1 vssa1 vssc1 col_event_rst_bot_left[34] x3_net30 row_on_detect_bot[37]
+ row_off_detect_bot[36] openDVS_pixel2x2_bot
x3_x1647 dac_config_3 dac_config_5 col_event_rst_bot_left[33] dac_config_4
+ row_on_detect_bot[36] dac_config_0 dac_config_1 row_off_detect_bot[37] x3_net31
+ dac_config_2 vdda1 vssa1 vssc1 col_event_rst_bot_left[32] x3_net32 row_on_detect_bot[37]
+ row_off_detect_bot[36] openDVS_pixel2x2_bot
x3_x1648 dac_config_3 dac_config_5 col_event_rst_bot_left[31] dac_config_4
+ row_on_detect_bot[36] dac_config_0 dac_config_1 row_off_detect_bot[37] x3_net33
+ dac_config_2 vdda1 vssa1 vssc1 col_event_rst_bot_left[30] x3_net34 row_on_detect_bot[37]
+ row_off_detect_bot[36] openDVS_pixel2x2_bot
x3_x1649 dac_config_3 dac_config_5 col_event_rst_bot_left[29] dac_config_4
+ row_on_detect_bot[36] dac_config_0 dac_config_1 row_off_detect_bot[37] x3_net35
+ dac_config_2 vdda1 vssa1 vssc1 col_event_rst_bot_left[28] x3_net36 row_on_detect_bot[37]
+ row_off_detect_bot[36] openDVS_pixel2x2_bot
x3_x1650 dac_config_3 dac_config_5 col_event_rst_bot_left[27] dac_config_4
+ row_on_detect_bot[36] dac_config_0 dac_config_1 row_off_detect_bot[37] x3_net37
+ dac_config_2 vdda1 vssa1 vssc1 col_event_rst_bot_left[26] x3_net38 row_on_detect_bot[37]
+ row_off_detect_bot[36] openDVS_pixel2x2_bot
x3_x1651 dac_config_3 dac_config_5 col_event_rst_bot_left[25] dac_config_4
+ row_on_detect_bot[36] dac_config_0 dac_config_1 row_off_detect_bot[37] x3_net39
+ dac_config_2 vdda1 vssa1 vssc1 col_event_rst_bot_left[24] x3_net40 row_on_detect_bot[37]
+ row_off_detect_bot[36] openDVS_pixel2x2_bot
x3_x1652 dac_config_3 dac_config_5 col_event_rst_bot_left[23] dac_config_4
+ row_on_detect_bot[36] dac_config_0 dac_config_1 row_off_detect_bot[37] x3_net41
+ dac_config_2 vdda1 vssa1 vssc1 col_event_rst_bot_left[22] x3_net42 row_on_detect_bot[37]
+ row_off_detect_bot[36] openDVS_pixel2x2_bot
x3_x1653 dac_config_3 dac_config_5 col_event_rst_bot_left[21] dac_config_4
+ row_on_detect_bot[36] dac_config_0 dac_config_1 row_off_detect_bot[37] x3_net43
+ dac_config_2 vdda1 vssa1 vssc1 col_event_rst_bot_left[20] x3_net44 row_on_detect_bot[37]
+ row_off_detect_bot[36] openDVS_pixel2x2_bot
x3_x1654 dac_config_3 dac_config_5 col_event_rst_bot_left[19] dac_config_4
+ row_on_detect_bot[36] dac_config_0 dac_config_1 row_off_detect_bot[37] x3_net45
+ dac_config_2 vdda1 vssa1 vssc1 col_event_rst_bot_left[18] x3_net46 row_on_detect_bot[37]
+ row_off_detect_bot[36] openDVS_pixel2x2_bot
x3_x1655 dac_config_3 dac_config_5 col_event_rst_bot_left[17] dac_config_4
+ row_on_detect_bot[36] dac_config_0 dac_config_1 row_off_detect_bot[37] x3_net47
+ dac_config_2 vdda1 vssa1 vssc1 col_event_rst_bot_left[16] x3_net48 row_on_detect_bot[37]
+ row_off_detect_bot[36] openDVS_pixel2x2_bot
x3_x1656 dac_config_3 dac_config_5 col_event_rst_bot_left[15] dac_config_4
+ row_on_detect_bot[36] dac_config_0 dac_config_1 row_off_detect_bot[37] x3_net49
+ dac_config_2 vdda1 vssa1 vssc1 col_event_rst_bot_left[14] x3_net50 row_on_detect_bot[37]
+ row_off_detect_bot[36] openDVS_pixel2x2_bot
x3_x1657 dac_config_3 dac_config_5 col_event_rst_bot_left[13] dac_config_4
+ row_on_detect_bot[36] dac_config_0 dac_config_1 row_off_detect_bot[37] x3_net51
+ dac_config_2 vdda1 vssa1 vssc1 col_event_rst_bot_left[12] x3_net52 row_on_detect_bot[37]
+ row_off_detect_bot[36] openDVS_pixel2x2_bot
x3_x1658 dac_config_3 dac_config_5 col_event_rst_bot_left[11] dac_config_4
+ row_on_detect_bot[36] dac_config_0 dac_config_1 row_off_detect_bot[37] x3_net53
+ dac_config_2 vdda1 vssa1 vssc1 col_event_rst_bot_left[10] x3_net54 row_on_detect_bot[37]
+ row_off_detect_bot[36] openDVS_pixel2x2_bot
x3_x1659 dac_config_3 dac_config_5 col_event_rst_bot_left[9] dac_config_4
+ row_on_detect_bot[36] dac_config_0 dac_config_1 row_off_detect_bot[37] x3_net55
+ dac_config_2 vdda1 vssa1 vssc1 col_event_rst_bot_left[8] x3_net56 row_on_detect_bot[37]
+ row_off_detect_bot[36] openDVS_pixel2x2_bot
x3_x1660 dac_config_3 dac_config_5 col_event_rst_bot_left[7] dac_config_4
+ row_on_detect_bot[36] dac_config_0 dac_config_1 row_off_detect_bot[37] x3_net57
+ dac_config_2 vdda1 vssa1 vssc1 col_event_rst_bot_left[6] x3_net58 row_on_detect_bot[37]
+ row_off_detect_bot[36] openDVS_pixel2x2_bot
x3_x1661 dac_config_3 dac_config_5 col_event_rst_bot_left[5] dac_config_4
+ row_on_detect_bot[36] dac_config_0 dac_config_1 row_off_detect_bot[37] x3_net59
+ dac_config_2 vdda1 vssa1 vssc1 col_event_rst_bot_left[4] x3_net60 row_on_detect_bot[37]
+ row_off_detect_bot[36] openDVS_pixel2x2_bot
x3_x1662 dac_config_3 dac_config_5 col_event_rst_bot_left[3] dac_config_4
+ row_on_detect_bot[36] dac_config_0 dac_config_1 row_off_detect_bot[37] x3_net61
+ dac_config_2 vdda1 vssa1 vssc1 col_event_rst_bot_left[2] x3_net62 row_on_detect_bot[37]
+ row_off_detect_bot[36] openDVS_pixel2x2_bot
x3_x1663 dac_config_3 dac_config_5 col_event_rst_bot_left[1] dac_config_4
+ row_on_detect_bot[36] dac_config_0 dac_config_1 row_off_detect_bot[37] x3_net63
+ dac_config_2 vdda1 vssa1 vssc1 col_event_rst_bot_left[0] x3_net64 row_on_detect_bot[37]
+ row_off_detect_bot[36] openDVS_pixel2x2_bot
x3_x1664 dac_config_3 dac_config_5 col_event_rst_bot_left[63] dac_config_4
+ row_on_detect_bot[38] dac_config_0 dac_config_1 row_off_detect_bot[39] x3_net1
+ dac_config_2 vdda1 vssa1 vssc1 col_event_rst_bot_left[62] x3_net2 row_on_detect_bot[39]
+ row_off_detect_bot[38] openDVS_pixel2x2_bot
x3_x1665 dac_config_3 dac_config_5 col_event_rst_bot_left[61] dac_config_4
+ row_on_detect_bot[38] dac_config_0 dac_config_1 row_off_detect_bot[39] x3_net3
+ dac_config_2 vdda1 vssa1 vssc1 col_event_rst_bot_left[60] x3_net4 row_on_detect_bot[39]
+ row_off_detect_bot[38] openDVS_pixel2x2_bot
x3_x1666 dac_config_3 dac_config_5 col_event_rst_bot_left[59] dac_config_4
+ row_on_detect_bot[38] dac_config_0 dac_config_1 row_off_detect_bot[39] x3_net5
+ dac_config_2 vdda1 vssa1 vssc1 col_event_rst_bot_left[58] x3_net6 row_on_detect_bot[39]
+ row_off_detect_bot[38] openDVS_pixel2x2_bot
x3_x1667 dac_config_3 dac_config_5 col_event_rst_bot_left[57] dac_config_4
+ row_on_detect_bot[38] dac_config_0 dac_config_1 row_off_detect_bot[39] x3_net7
+ dac_config_2 vdda1 vssa1 vssc1 col_event_rst_bot_left[56] x3_net8 row_on_detect_bot[39]
+ row_off_detect_bot[38] openDVS_pixel2x2_bot
x3_x1668 dac_config_3 dac_config_5 col_event_rst_bot_left[55] dac_config_4
+ row_on_detect_bot[38] dac_config_0 dac_config_1 row_off_detect_bot[39] x3_net9
+ dac_config_2 vdda1 vssa1 vssc1 col_event_rst_bot_left[54] x3_net10 row_on_detect_bot[39]
+ row_off_detect_bot[38] openDVS_pixel2x2_bot
x3_x1669 dac_config_3 dac_config_5 col_event_rst_bot_left[53] dac_config_4
+ row_on_detect_bot[38] dac_config_0 dac_config_1 row_off_detect_bot[39] x3_net11
+ dac_config_2 vdda1 vssa1 vssc1 col_event_rst_bot_left[52] x3_net12 row_on_detect_bot[39]
+ row_off_detect_bot[38] openDVS_pixel2x2_bot
x3_x1670 dac_config_3 dac_config_5 col_event_rst_bot_left[51] dac_config_4
+ row_on_detect_bot[38] dac_config_0 dac_config_1 row_off_detect_bot[39] x3_net13
+ dac_config_2 vdda1 vssa1 vssc1 col_event_rst_bot_left[50] x3_net14 row_on_detect_bot[39]
+ row_off_detect_bot[38] openDVS_pixel2x2_bot
x3_x1671 dac_config_3 dac_config_5 col_event_rst_bot_left[49] dac_config_4
+ row_on_detect_bot[38] dac_config_0 dac_config_1 row_off_detect_bot[39] x3_net15
+ dac_config_2 vdda1 vssa1 vssc1 col_event_rst_bot_left[48] x3_net16 row_on_detect_bot[39]
+ row_off_detect_bot[38] openDVS_pixel2x2_bot
x3_x1672 dac_config_3 dac_config_5 col_event_rst_bot_left[47] dac_config_4
+ row_on_detect_bot[38] dac_config_0 dac_config_1 row_off_detect_bot[39] x3_net17
+ dac_config_2 vdda1 vssa1 vssc1 col_event_rst_bot_left[46] x3_net18 row_on_detect_bot[39]
+ row_off_detect_bot[38] openDVS_pixel2x2_bot
x3_x1673 dac_config_3 dac_config_5 col_event_rst_bot_left[45] dac_config_4
+ row_on_detect_bot[38] dac_config_0 dac_config_1 row_off_detect_bot[39] x3_net19
+ dac_config_2 vdda1 vssa1 vssc1 col_event_rst_bot_left[44] x3_net20 row_on_detect_bot[39]
+ row_off_detect_bot[38] openDVS_pixel2x2_bot
x3_x1674 dac_config_3 dac_config_5 col_event_rst_bot_left[43] dac_config_4
+ row_on_detect_bot[38] dac_config_0 dac_config_1 row_off_detect_bot[39] x3_net21
+ dac_config_2 vdda1 vssa1 vssc1 col_event_rst_bot_left[42] x3_net22 row_on_detect_bot[39]
+ row_off_detect_bot[38] openDVS_pixel2x2_bot
x3_x1675 dac_config_3 dac_config_5 col_event_rst_bot_left[41] dac_config_4
+ row_on_detect_bot[38] dac_config_0 dac_config_1 row_off_detect_bot[39] x3_net23
+ dac_config_2 vdda1 vssa1 vssc1 col_event_rst_bot_left[40] x3_net24 row_on_detect_bot[39]
+ row_off_detect_bot[38] openDVS_pixel2x2_bot
x3_x1676 dac_config_3 dac_config_5 col_event_rst_bot_left[39] dac_config_4
+ row_on_detect_bot[38] dac_config_0 dac_config_1 row_off_detect_bot[39] x3_net25
+ dac_config_2 vdda1 vssa1 vssc1 col_event_rst_bot_left[38] x3_net26 row_on_detect_bot[39]
+ row_off_detect_bot[38] openDVS_pixel2x2_bot
x3_x1677 dac_config_3 dac_config_5 col_event_rst_bot_left[37] dac_config_4
+ row_on_detect_bot[38] dac_config_0 dac_config_1 row_off_detect_bot[39] x3_net27
+ dac_config_2 vdda1 vssa1 vssc1 col_event_rst_bot_left[36] x3_net28 row_on_detect_bot[39]
+ row_off_detect_bot[38] openDVS_pixel2x2_bot
x3_x1678 dac_config_3 dac_config_5 col_event_rst_bot_left[35] dac_config_4
+ row_on_detect_bot[38] dac_config_0 dac_config_1 row_off_detect_bot[39] x3_net29
+ dac_config_2 vdda1 vssa1 vssc1 col_event_rst_bot_left[34] x3_net30 row_on_detect_bot[39]
+ row_off_detect_bot[38] openDVS_pixel2x2_bot
x3_x1679 dac_config_3 dac_config_5 col_event_rst_bot_left[33] dac_config_4
+ row_on_detect_bot[38] dac_config_0 dac_config_1 row_off_detect_bot[39] x3_net31
+ dac_config_2 vdda1 vssa1 vssc1 col_event_rst_bot_left[32] x3_net32 row_on_detect_bot[39]
+ row_off_detect_bot[38] openDVS_pixel2x2_bot
x3_x1680 dac_config_3 dac_config_5 col_event_rst_bot_left[31] dac_config_4
+ row_on_detect_bot[38] dac_config_0 dac_config_1 row_off_detect_bot[39] x3_net33
+ dac_config_2 vdda1 vssa1 vssc1 col_event_rst_bot_left[30] x3_net34 row_on_detect_bot[39]
+ row_off_detect_bot[38] openDVS_pixel2x2_bot
x3_x1681 dac_config_3 dac_config_5 col_event_rst_bot_left[29] dac_config_4
+ row_on_detect_bot[38] dac_config_0 dac_config_1 row_off_detect_bot[39] x3_net35
+ dac_config_2 vdda1 vssa1 vssc1 col_event_rst_bot_left[28] x3_net36 row_on_detect_bot[39]
+ row_off_detect_bot[38] openDVS_pixel2x2_bot
x3_x1682 dac_config_3 dac_config_5 col_event_rst_bot_left[27] dac_config_4
+ row_on_detect_bot[38] dac_config_0 dac_config_1 row_off_detect_bot[39] x3_net37
+ dac_config_2 vdda1 vssa1 vssc1 col_event_rst_bot_left[26] x3_net38 row_on_detect_bot[39]
+ row_off_detect_bot[38] openDVS_pixel2x2_bot
x3_x1683 dac_config_3 dac_config_5 col_event_rst_bot_left[25] dac_config_4
+ row_on_detect_bot[38] dac_config_0 dac_config_1 row_off_detect_bot[39] x3_net39
+ dac_config_2 vdda1 vssa1 vssc1 col_event_rst_bot_left[24] x3_net40 row_on_detect_bot[39]
+ row_off_detect_bot[38] openDVS_pixel2x2_bot
x3_x1684 dac_config_3 dac_config_5 col_event_rst_bot_left[23] dac_config_4
+ row_on_detect_bot[38] dac_config_0 dac_config_1 row_off_detect_bot[39] x3_net41
+ dac_config_2 vdda1 vssa1 vssc1 col_event_rst_bot_left[22] x3_net42 row_on_detect_bot[39]
+ row_off_detect_bot[38] openDVS_pixel2x2_bot
x3_x1685 dac_config_3 dac_config_5 col_event_rst_bot_left[21] dac_config_4
+ row_on_detect_bot[38] dac_config_0 dac_config_1 row_off_detect_bot[39] x3_net43
+ dac_config_2 vdda1 vssa1 vssc1 col_event_rst_bot_left[20] x3_net44 row_on_detect_bot[39]
+ row_off_detect_bot[38] openDVS_pixel2x2_bot
x3_x1686 dac_config_3 dac_config_5 col_event_rst_bot_left[19] dac_config_4
+ row_on_detect_bot[38] dac_config_0 dac_config_1 row_off_detect_bot[39] x3_net45
+ dac_config_2 vdda1 vssa1 vssc1 col_event_rst_bot_left[18] x3_net46 row_on_detect_bot[39]
+ row_off_detect_bot[38] openDVS_pixel2x2_bot
x3_x1687 dac_config_3 dac_config_5 col_event_rst_bot_left[17] dac_config_4
+ row_on_detect_bot[38] dac_config_0 dac_config_1 row_off_detect_bot[39] x3_net47
+ dac_config_2 vdda1 vssa1 vssc1 col_event_rst_bot_left[16] x3_net48 row_on_detect_bot[39]
+ row_off_detect_bot[38] openDVS_pixel2x2_bot
x3_x1688 dac_config_3 dac_config_5 col_event_rst_bot_left[15] dac_config_4
+ row_on_detect_bot[38] dac_config_0 dac_config_1 row_off_detect_bot[39] x3_net49
+ dac_config_2 vdda1 vssa1 vssc1 col_event_rst_bot_left[14] x3_net50 row_on_detect_bot[39]
+ row_off_detect_bot[38] openDVS_pixel2x2_bot
x3_x1689 dac_config_3 dac_config_5 col_event_rst_bot_left[13] dac_config_4
+ row_on_detect_bot[38] dac_config_0 dac_config_1 row_off_detect_bot[39] x3_net51
+ dac_config_2 vdda1 vssa1 vssc1 col_event_rst_bot_left[12] x3_net52 row_on_detect_bot[39]
+ row_off_detect_bot[38] openDVS_pixel2x2_bot
x3_x1690 dac_config_3 dac_config_5 col_event_rst_bot_left[11] dac_config_4
+ row_on_detect_bot[38] dac_config_0 dac_config_1 row_off_detect_bot[39] x3_net53
+ dac_config_2 vdda1 vssa1 vssc1 col_event_rst_bot_left[10] x3_net54 row_on_detect_bot[39]
+ row_off_detect_bot[38] openDVS_pixel2x2_bot
x3_x1691 dac_config_3 dac_config_5 col_event_rst_bot_left[9] dac_config_4
+ row_on_detect_bot[38] dac_config_0 dac_config_1 row_off_detect_bot[39] x3_net55
+ dac_config_2 vdda1 vssa1 vssc1 col_event_rst_bot_left[8] x3_net56 row_on_detect_bot[39]
+ row_off_detect_bot[38] openDVS_pixel2x2_bot
x3_x1692 dac_config_3 dac_config_5 col_event_rst_bot_left[7] dac_config_4
+ row_on_detect_bot[38] dac_config_0 dac_config_1 row_off_detect_bot[39] x3_net57
+ dac_config_2 vdda1 vssa1 vssc1 col_event_rst_bot_left[6] x3_net58 row_on_detect_bot[39]
+ row_off_detect_bot[38] openDVS_pixel2x2_bot
x3_x1693 dac_config_3 dac_config_5 col_event_rst_bot_left[5] dac_config_4
+ row_on_detect_bot[38] dac_config_0 dac_config_1 row_off_detect_bot[39] x3_net59
+ dac_config_2 vdda1 vssa1 vssc1 col_event_rst_bot_left[4] x3_net60 row_on_detect_bot[39]
+ row_off_detect_bot[38] openDVS_pixel2x2_bot
x3_x1694 dac_config_3 dac_config_5 col_event_rst_bot_left[3] dac_config_4
+ row_on_detect_bot[38] dac_config_0 dac_config_1 row_off_detect_bot[39] x3_net61
+ dac_config_2 vdda1 vssa1 vssc1 col_event_rst_bot_left[2] x3_net62 row_on_detect_bot[39]
+ row_off_detect_bot[38] openDVS_pixel2x2_bot
x3_x1695 dac_config_3 dac_config_5 col_event_rst_bot_left[1] dac_config_4
+ row_on_detect_bot[38] dac_config_0 dac_config_1 row_off_detect_bot[39] x3_net63
+ dac_config_2 vdda1 vssa1 vssc1 col_event_rst_bot_left[0] x3_net64 row_on_detect_bot[39]
+ row_off_detect_bot[38] openDVS_pixel2x2_bot
x3_x1696 dac_config_3 dac_config_5 col_event_rst_bot_left[63] dac_config_4
+ row_on_detect_bot[40] dac_config_0 dac_config_1 row_off_detect_bot[41] x3_net1
+ dac_config_2 vdda1 vssa1 vssc1 col_event_rst_bot_left[62] x3_net2 row_on_detect_bot[41]
+ row_off_detect_bot[40] openDVS_pixel2x2_bot
x3_x1697 dac_config_3 dac_config_5 col_event_rst_bot_left[61] dac_config_4
+ row_on_detect_bot[40] dac_config_0 dac_config_1 row_off_detect_bot[41] x3_net3
+ dac_config_2 vdda1 vssa1 vssc1 col_event_rst_bot_left[60] x3_net4 row_on_detect_bot[41]
+ row_off_detect_bot[40] openDVS_pixel2x2_bot
x3_x1698 dac_config_3 dac_config_5 col_event_rst_bot_left[59] dac_config_4
+ row_on_detect_bot[40] dac_config_0 dac_config_1 row_off_detect_bot[41] x3_net5
+ dac_config_2 vdda1 vssa1 vssc1 col_event_rst_bot_left[58] x3_net6 row_on_detect_bot[41]
+ row_off_detect_bot[40] openDVS_pixel2x2_bot
x3_x1699 dac_config_3 dac_config_5 col_event_rst_bot_left[57] dac_config_4
+ row_on_detect_bot[40] dac_config_0 dac_config_1 row_off_detect_bot[41] x3_net7
+ dac_config_2 vdda1 vssa1 vssc1 col_event_rst_bot_left[56] x3_net8 row_on_detect_bot[41]
+ row_off_detect_bot[40] openDVS_pixel2x2_bot
x3_x1700 dac_config_3 dac_config_5 col_event_rst_bot_left[55] dac_config_4
+ row_on_detect_bot[40] dac_config_0 dac_config_1 row_off_detect_bot[41] x3_net9
+ dac_config_2 vdda1 vssa1 vssc1 col_event_rst_bot_left[54] x3_net10 row_on_detect_bot[41]
+ row_off_detect_bot[40] openDVS_pixel2x2_bot
x3_x1701 dac_config_3 dac_config_5 col_event_rst_bot_left[53] dac_config_4
+ row_on_detect_bot[40] dac_config_0 dac_config_1 row_off_detect_bot[41] x3_net11
+ dac_config_2 vdda1 vssa1 vssc1 col_event_rst_bot_left[52] x3_net12 row_on_detect_bot[41]
+ row_off_detect_bot[40] openDVS_pixel2x2_bot
x3_x1702 dac_config_3 dac_config_5 col_event_rst_bot_left[51] dac_config_4
+ row_on_detect_bot[40] dac_config_0 dac_config_1 row_off_detect_bot[41] x3_net13
+ dac_config_2 vdda1 vssa1 vssc1 col_event_rst_bot_left[50] x3_net14 row_on_detect_bot[41]
+ row_off_detect_bot[40] openDVS_pixel2x2_bot
x3_x1703 dac_config_3 dac_config_5 col_event_rst_bot_left[49] dac_config_4
+ row_on_detect_bot[40] dac_config_0 dac_config_1 row_off_detect_bot[41] x3_net15
+ dac_config_2 vdda1 vssa1 vssc1 col_event_rst_bot_left[48] x3_net16 row_on_detect_bot[41]
+ row_off_detect_bot[40] openDVS_pixel2x2_bot
x3_x1704 dac_config_3 dac_config_5 col_event_rst_bot_left[47] dac_config_4
+ row_on_detect_bot[40] dac_config_0 dac_config_1 row_off_detect_bot[41] x3_net17
+ dac_config_2 vdda1 vssa1 vssc1 col_event_rst_bot_left[46] x3_net18 row_on_detect_bot[41]
+ row_off_detect_bot[40] openDVS_pixel2x2_bot
x3_x1705 dac_config_3 dac_config_5 col_event_rst_bot_left[45] dac_config_4
+ row_on_detect_bot[40] dac_config_0 dac_config_1 row_off_detect_bot[41] x3_net19
+ dac_config_2 vdda1 vssa1 vssc1 col_event_rst_bot_left[44] x3_net20 row_on_detect_bot[41]
+ row_off_detect_bot[40] openDVS_pixel2x2_bot
x3_x1706 dac_config_3 dac_config_5 col_event_rst_bot_left[43] dac_config_4
+ row_on_detect_bot[40] dac_config_0 dac_config_1 row_off_detect_bot[41] x3_net21
+ dac_config_2 vdda1 vssa1 vssc1 col_event_rst_bot_left[42] x3_net22 row_on_detect_bot[41]
+ row_off_detect_bot[40] openDVS_pixel2x2_bot
x3_x1707 dac_config_3 dac_config_5 col_event_rst_bot_left[41] dac_config_4
+ row_on_detect_bot[40] dac_config_0 dac_config_1 row_off_detect_bot[41] x3_net23
+ dac_config_2 vdda1 vssa1 vssc1 col_event_rst_bot_left[40] x3_net24 row_on_detect_bot[41]
+ row_off_detect_bot[40] openDVS_pixel2x2_bot
x3_x1708 dac_config_3 dac_config_5 col_event_rst_bot_left[39] dac_config_4
+ row_on_detect_bot[40] dac_config_0 dac_config_1 row_off_detect_bot[41] x3_net25
+ dac_config_2 vdda1 vssa1 vssc1 col_event_rst_bot_left[38] x3_net26 row_on_detect_bot[41]
+ row_off_detect_bot[40] openDVS_pixel2x2_bot
x3_x1709 dac_config_3 dac_config_5 col_event_rst_bot_left[37] dac_config_4
+ row_on_detect_bot[40] dac_config_0 dac_config_1 row_off_detect_bot[41] x3_net27
+ dac_config_2 vdda1 vssa1 vssc1 col_event_rst_bot_left[36] x3_net28 row_on_detect_bot[41]
+ row_off_detect_bot[40] openDVS_pixel2x2_bot
x3_x1710 dac_config_3 dac_config_5 col_event_rst_bot_left[35] dac_config_4
+ row_on_detect_bot[40] dac_config_0 dac_config_1 row_off_detect_bot[41] x3_net29
+ dac_config_2 vdda1 vssa1 vssc1 col_event_rst_bot_left[34] x3_net30 row_on_detect_bot[41]
+ row_off_detect_bot[40] openDVS_pixel2x2_bot
x3_x1711 dac_config_3 dac_config_5 col_event_rst_bot_left[33] dac_config_4
+ row_on_detect_bot[40] dac_config_0 dac_config_1 row_off_detect_bot[41] x3_net31
+ dac_config_2 vdda1 vssa1 vssc1 col_event_rst_bot_left[32] x3_net32 row_on_detect_bot[41]
+ row_off_detect_bot[40] openDVS_pixel2x2_bot
x3_x1712 dac_config_3 dac_config_5 col_event_rst_bot_left[31] dac_config_4
+ row_on_detect_bot[40] dac_config_0 dac_config_1 row_off_detect_bot[41] x3_net33
+ dac_config_2 vdda1 vssa1 vssc1 col_event_rst_bot_left[30] x3_net34 row_on_detect_bot[41]
+ row_off_detect_bot[40] openDVS_pixel2x2_bot
x3_x1713 dac_config_3 dac_config_5 col_event_rst_bot_left[29] dac_config_4
+ row_on_detect_bot[40] dac_config_0 dac_config_1 row_off_detect_bot[41] x3_net35
+ dac_config_2 vdda1 vssa1 vssc1 col_event_rst_bot_left[28] x3_net36 row_on_detect_bot[41]
+ row_off_detect_bot[40] openDVS_pixel2x2_bot
x3_x1714 dac_config_3 dac_config_5 col_event_rst_bot_left[27] dac_config_4
+ row_on_detect_bot[40] dac_config_0 dac_config_1 row_off_detect_bot[41] x3_net37
+ dac_config_2 vdda1 vssa1 vssc1 col_event_rst_bot_left[26] x3_net38 row_on_detect_bot[41]
+ row_off_detect_bot[40] openDVS_pixel2x2_bot
x3_x1715 dac_config_3 dac_config_5 col_event_rst_bot_left[25] dac_config_4
+ row_on_detect_bot[40] dac_config_0 dac_config_1 row_off_detect_bot[41] x3_net39
+ dac_config_2 vdda1 vssa1 vssc1 col_event_rst_bot_left[24] x3_net40 row_on_detect_bot[41]
+ row_off_detect_bot[40] openDVS_pixel2x2_bot
x3_x1716 dac_config_3 dac_config_5 col_event_rst_bot_left[23] dac_config_4
+ row_on_detect_bot[40] dac_config_0 dac_config_1 row_off_detect_bot[41] x3_net41
+ dac_config_2 vdda1 vssa1 vssc1 col_event_rst_bot_left[22] x3_net42 row_on_detect_bot[41]
+ row_off_detect_bot[40] openDVS_pixel2x2_bot
x3_x1717 dac_config_3 dac_config_5 col_event_rst_bot_left[21] dac_config_4
+ row_on_detect_bot[40] dac_config_0 dac_config_1 row_off_detect_bot[41] x3_net43
+ dac_config_2 vdda1 vssa1 vssc1 col_event_rst_bot_left[20] x3_net44 row_on_detect_bot[41]
+ row_off_detect_bot[40] openDVS_pixel2x2_bot
x3_x1718 dac_config_3 dac_config_5 col_event_rst_bot_left[19] dac_config_4
+ row_on_detect_bot[40] dac_config_0 dac_config_1 row_off_detect_bot[41] x3_net45
+ dac_config_2 vdda1 vssa1 vssc1 col_event_rst_bot_left[18] x3_net46 row_on_detect_bot[41]
+ row_off_detect_bot[40] openDVS_pixel2x2_bot
x3_x1719 dac_config_3 dac_config_5 col_event_rst_bot_left[17] dac_config_4
+ row_on_detect_bot[40] dac_config_0 dac_config_1 row_off_detect_bot[41] x3_net47
+ dac_config_2 vdda1 vssa1 vssc1 col_event_rst_bot_left[16] x3_net48 row_on_detect_bot[41]
+ row_off_detect_bot[40] openDVS_pixel2x2_bot
x3_x1720 dac_config_3 dac_config_5 col_event_rst_bot_left[15] dac_config_4
+ row_on_detect_bot[40] dac_config_0 dac_config_1 row_off_detect_bot[41] x3_net49
+ dac_config_2 vdda1 vssa1 vssc1 col_event_rst_bot_left[14] x3_net50 row_on_detect_bot[41]
+ row_off_detect_bot[40] openDVS_pixel2x2_bot
x3_x1721 dac_config_3 dac_config_5 col_event_rst_bot_left[13] dac_config_4
+ row_on_detect_bot[40] dac_config_0 dac_config_1 row_off_detect_bot[41] x3_net51
+ dac_config_2 vdda1 vssa1 vssc1 col_event_rst_bot_left[12] x3_net52 row_on_detect_bot[41]
+ row_off_detect_bot[40] openDVS_pixel2x2_bot
x3_x1722 dac_config_3 dac_config_5 col_event_rst_bot_left[11] dac_config_4
+ row_on_detect_bot[40] dac_config_0 dac_config_1 row_off_detect_bot[41] x3_net53
+ dac_config_2 vdda1 vssa1 vssc1 col_event_rst_bot_left[10] x3_net54 row_on_detect_bot[41]
+ row_off_detect_bot[40] openDVS_pixel2x2_bot
x3_x1723 dac_config_3 dac_config_5 col_event_rst_bot_left[9] dac_config_4
+ row_on_detect_bot[40] dac_config_0 dac_config_1 row_off_detect_bot[41] x3_net55
+ dac_config_2 vdda1 vssa1 vssc1 col_event_rst_bot_left[8] x3_net56 row_on_detect_bot[41]
+ row_off_detect_bot[40] openDVS_pixel2x2_bot
x3_x1724 dac_config_3 dac_config_5 col_event_rst_bot_left[7] dac_config_4
+ row_on_detect_bot[40] dac_config_0 dac_config_1 row_off_detect_bot[41] x3_net57
+ dac_config_2 vdda1 vssa1 vssc1 col_event_rst_bot_left[6] x3_net58 row_on_detect_bot[41]
+ row_off_detect_bot[40] openDVS_pixel2x2_bot
x3_x1725 dac_config_3 dac_config_5 col_event_rst_bot_left[5] dac_config_4
+ row_on_detect_bot[40] dac_config_0 dac_config_1 row_off_detect_bot[41] x3_net59
+ dac_config_2 vdda1 vssa1 vssc1 col_event_rst_bot_left[4] x3_net60 row_on_detect_bot[41]
+ row_off_detect_bot[40] openDVS_pixel2x2_bot
x3_x1726 dac_config_3 dac_config_5 col_event_rst_bot_left[3] dac_config_4
+ row_on_detect_bot[40] dac_config_0 dac_config_1 row_off_detect_bot[41] x3_net61
+ dac_config_2 vdda1 vssa1 vssc1 col_event_rst_bot_left[2] x3_net62 row_on_detect_bot[41]
+ row_off_detect_bot[40] openDVS_pixel2x2_bot
x3_x1727 dac_config_3 dac_config_5 col_event_rst_bot_left[1] dac_config_4
+ row_on_detect_bot[40] dac_config_0 dac_config_1 row_off_detect_bot[41] x3_net63
+ dac_config_2 vdda1 vssa1 vssc1 col_event_rst_bot_left[0] x3_net64 row_on_detect_bot[41]
+ row_off_detect_bot[40] openDVS_pixel2x2_bot
x3_x1728 dac_config_3 dac_config_5 col_event_rst_bot_left[63] dac_config_4
+ row_on_detect_bot[42] dac_config_0 dac_config_1 row_off_detect_bot[43] x3_net1
+ dac_config_2 vdda1 vssa1 vssc1 col_event_rst_bot_left[62] x3_net2 row_on_detect_bot[43]
+ row_off_detect_bot[42] openDVS_pixel2x2_bot
x3_x1729 dac_config_3 dac_config_5 col_event_rst_bot_left[61] dac_config_4
+ row_on_detect_bot[42] dac_config_0 dac_config_1 row_off_detect_bot[43] x3_net3
+ dac_config_2 vdda1 vssa1 vssc1 col_event_rst_bot_left[60] x3_net4 row_on_detect_bot[43]
+ row_off_detect_bot[42] openDVS_pixel2x2_bot
x3_x1730 dac_config_3 dac_config_5 col_event_rst_bot_left[59] dac_config_4
+ row_on_detect_bot[42] dac_config_0 dac_config_1 row_off_detect_bot[43] x3_net5
+ dac_config_2 vdda1 vssa1 vssc1 col_event_rst_bot_left[58] x3_net6 row_on_detect_bot[43]
+ row_off_detect_bot[42] openDVS_pixel2x2_bot
x3_x1731 dac_config_3 dac_config_5 col_event_rst_bot_left[57] dac_config_4
+ row_on_detect_bot[42] dac_config_0 dac_config_1 row_off_detect_bot[43] x3_net7
+ dac_config_2 vdda1 vssa1 vssc1 col_event_rst_bot_left[56] x3_net8 row_on_detect_bot[43]
+ row_off_detect_bot[42] openDVS_pixel2x2_bot
x3_x1732 dac_config_3 dac_config_5 col_event_rst_bot_left[55] dac_config_4
+ row_on_detect_bot[42] dac_config_0 dac_config_1 row_off_detect_bot[43] x3_net9
+ dac_config_2 vdda1 vssa1 vssc1 col_event_rst_bot_left[54] x3_net10 row_on_detect_bot[43]
+ row_off_detect_bot[42] openDVS_pixel2x2_bot
x3_x1733 dac_config_3 dac_config_5 col_event_rst_bot_left[53] dac_config_4
+ row_on_detect_bot[42] dac_config_0 dac_config_1 row_off_detect_bot[43] x3_net11
+ dac_config_2 vdda1 vssa1 vssc1 col_event_rst_bot_left[52] x3_net12 row_on_detect_bot[43]
+ row_off_detect_bot[42] openDVS_pixel2x2_bot
x3_x1734 dac_config_3 dac_config_5 col_event_rst_bot_left[51] dac_config_4
+ row_on_detect_bot[42] dac_config_0 dac_config_1 row_off_detect_bot[43] x3_net13
+ dac_config_2 vdda1 vssa1 vssc1 col_event_rst_bot_left[50] x3_net14 row_on_detect_bot[43]
+ row_off_detect_bot[42] openDVS_pixel2x2_bot
x3_x1735 dac_config_3 dac_config_5 col_event_rst_bot_left[49] dac_config_4
+ row_on_detect_bot[42] dac_config_0 dac_config_1 row_off_detect_bot[43] x3_net15
+ dac_config_2 vdda1 vssa1 vssc1 col_event_rst_bot_left[48] x3_net16 row_on_detect_bot[43]
+ row_off_detect_bot[42] openDVS_pixel2x2_bot
x3_x1736 dac_config_3 dac_config_5 col_event_rst_bot_left[47] dac_config_4
+ row_on_detect_bot[42] dac_config_0 dac_config_1 row_off_detect_bot[43] x3_net17
+ dac_config_2 vdda1 vssa1 vssc1 col_event_rst_bot_left[46] x3_net18 row_on_detect_bot[43]
+ row_off_detect_bot[42] openDVS_pixel2x2_bot
x3_x1737 dac_config_3 dac_config_5 col_event_rst_bot_left[45] dac_config_4
+ row_on_detect_bot[42] dac_config_0 dac_config_1 row_off_detect_bot[43] x3_net19
+ dac_config_2 vdda1 vssa1 vssc1 col_event_rst_bot_left[44] x3_net20 row_on_detect_bot[43]
+ row_off_detect_bot[42] openDVS_pixel2x2_bot
x3_x1738 dac_config_3 dac_config_5 col_event_rst_bot_left[43] dac_config_4
+ row_on_detect_bot[42] dac_config_0 dac_config_1 row_off_detect_bot[43] x3_net21
+ dac_config_2 vdda1 vssa1 vssc1 col_event_rst_bot_left[42] x3_net22 row_on_detect_bot[43]
+ row_off_detect_bot[42] openDVS_pixel2x2_bot
x3_x1739 dac_config_3 dac_config_5 col_event_rst_bot_left[41] dac_config_4
+ row_on_detect_bot[42] dac_config_0 dac_config_1 row_off_detect_bot[43] x3_net23
+ dac_config_2 vdda1 vssa1 vssc1 col_event_rst_bot_left[40] x3_net24 row_on_detect_bot[43]
+ row_off_detect_bot[42] openDVS_pixel2x2_bot
x3_x1740 dac_config_3 dac_config_5 col_event_rst_bot_left[39] dac_config_4
+ row_on_detect_bot[42] dac_config_0 dac_config_1 row_off_detect_bot[43] x3_net25
+ dac_config_2 vdda1 vssa1 vssc1 col_event_rst_bot_left[38] x3_net26 row_on_detect_bot[43]
+ row_off_detect_bot[42] openDVS_pixel2x2_bot
x3_x1741 dac_config_3 dac_config_5 col_event_rst_bot_left[37] dac_config_4
+ row_on_detect_bot[42] dac_config_0 dac_config_1 row_off_detect_bot[43] x3_net27
+ dac_config_2 vdda1 vssa1 vssc1 col_event_rst_bot_left[36] x3_net28 row_on_detect_bot[43]
+ row_off_detect_bot[42] openDVS_pixel2x2_bot
x3_x1742 dac_config_3 dac_config_5 col_event_rst_bot_left[35] dac_config_4
+ row_on_detect_bot[42] dac_config_0 dac_config_1 row_off_detect_bot[43] x3_net29
+ dac_config_2 vdda1 vssa1 vssc1 col_event_rst_bot_left[34] x3_net30 row_on_detect_bot[43]
+ row_off_detect_bot[42] openDVS_pixel2x2_bot
x3_x1743 dac_config_3 dac_config_5 col_event_rst_bot_left[33] dac_config_4
+ row_on_detect_bot[42] dac_config_0 dac_config_1 row_off_detect_bot[43] x3_net31
+ dac_config_2 vdda1 vssa1 vssc1 col_event_rst_bot_left[32] x3_net32 row_on_detect_bot[43]
+ row_off_detect_bot[42] openDVS_pixel2x2_bot
x3_x1744 dac_config_3 dac_config_5 col_event_rst_bot_left[31] dac_config_4
+ row_on_detect_bot[42] dac_config_0 dac_config_1 row_off_detect_bot[43] x3_net33
+ dac_config_2 vdda1 vssa1 vssc1 col_event_rst_bot_left[30] x3_net34 row_on_detect_bot[43]
+ row_off_detect_bot[42] openDVS_pixel2x2_bot
x3_x1745 dac_config_3 dac_config_5 col_event_rst_bot_left[29] dac_config_4
+ row_on_detect_bot[42] dac_config_0 dac_config_1 row_off_detect_bot[43] x3_net35
+ dac_config_2 vdda1 vssa1 vssc1 col_event_rst_bot_left[28] x3_net36 row_on_detect_bot[43]
+ row_off_detect_bot[42] openDVS_pixel2x2_bot
x3_x1746 dac_config_3 dac_config_5 col_event_rst_bot_left[27] dac_config_4
+ row_on_detect_bot[42] dac_config_0 dac_config_1 row_off_detect_bot[43] x3_net37
+ dac_config_2 vdda1 vssa1 vssc1 col_event_rst_bot_left[26] x3_net38 row_on_detect_bot[43]
+ row_off_detect_bot[42] openDVS_pixel2x2_bot
x3_x1747 dac_config_3 dac_config_5 col_event_rst_bot_left[25] dac_config_4
+ row_on_detect_bot[42] dac_config_0 dac_config_1 row_off_detect_bot[43] x3_net39
+ dac_config_2 vdda1 vssa1 vssc1 col_event_rst_bot_left[24] x3_net40 row_on_detect_bot[43]
+ row_off_detect_bot[42] openDVS_pixel2x2_bot
x3_x1748 dac_config_3 dac_config_5 col_event_rst_bot_left[23] dac_config_4
+ row_on_detect_bot[42] dac_config_0 dac_config_1 row_off_detect_bot[43] x3_net41
+ dac_config_2 vdda1 vssa1 vssc1 col_event_rst_bot_left[22] x3_net42 row_on_detect_bot[43]
+ row_off_detect_bot[42] openDVS_pixel2x2_bot
x3_x1749 dac_config_3 dac_config_5 col_event_rst_bot_left[21] dac_config_4
+ row_on_detect_bot[42] dac_config_0 dac_config_1 row_off_detect_bot[43] x3_net43
+ dac_config_2 vdda1 vssa1 vssc1 col_event_rst_bot_left[20] x3_net44 row_on_detect_bot[43]
+ row_off_detect_bot[42] openDVS_pixel2x2_bot
x3_x1750 dac_config_3 dac_config_5 col_event_rst_bot_left[19] dac_config_4
+ row_on_detect_bot[42] dac_config_0 dac_config_1 row_off_detect_bot[43] x3_net45
+ dac_config_2 vdda1 vssa1 vssc1 col_event_rst_bot_left[18] x3_net46 row_on_detect_bot[43]
+ row_off_detect_bot[42] openDVS_pixel2x2_bot
x3_x1751 dac_config_3 dac_config_5 col_event_rst_bot_left[17] dac_config_4
+ row_on_detect_bot[42] dac_config_0 dac_config_1 row_off_detect_bot[43] x3_net47
+ dac_config_2 vdda1 vssa1 vssc1 col_event_rst_bot_left[16] x3_net48 row_on_detect_bot[43]
+ row_off_detect_bot[42] openDVS_pixel2x2_bot
x3_x1752 dac_config_3 dac_config_5 col_event_rst_bot_left[15] dac_config_4
+ row_on_detect_bot[42] dac_config_0 dac_config_1 row_off_detect_bot[43] x3_net49
+ dac_config_2 vdda1 vssa1 vssc1 col_event_rst_bot_left[14] x3_net50 row_on_detect_bot[43]
+ row_off_detect_bot[42] openDVS_pixel2x2_bot
x3_x1753 dac_config_3 dac_config_5 col_event_rst_bot_left[13] dac_config_4
+ row_on_detect_bot[42] dac_config_0 dac_config_1 row_off_detect_bot[43] x3_net51
+ dac_config_2 vdda1 vssa1 vssc1 col_event_rst_bot_left[12] x3_net52 row_on_detect_bot[43]
+ row_off_detect_bot[42] openDVS_pixel2x2_bot
x3_x1754 dac_config_3 dac_config_5 col_event_rst_bot_left[11] dac_config_4
+ row_on_detect_bot[42] dac_config_0 dac_config_1 row_off_detect_bot[43] x3_net53
+ dac_config_2 vdda1 vssa1 vssc1 col_event_rst_bot_left[10] x3_net54 row_on_detect_bot[43]
+ row_off_detect_bot[42] openDVS_pixel2x2_bot
x3_x1755 dac_config_3 dac_config_5 col_event_rst_bot_left[9] dac_config_4
+ row_on_detect_bot[42] dac_config_0 dac_config_1 row_off_detect_bot[43] x3_net55
+ dac_config_2 vdda1 vssa1 vssc1 col_event_rst_bot_left[8] x3_net56 row_on_detect_bot[43]
+ row_off_detect_bot[42] openDVS_pixel2x2_bot
x3_x1756 dac_config_3 dac_config_5 col_event_rst_bot_left[7] dac_config_4
+ row_on_detect_bot[42] dac_config_0 dac_config_1 row_off_detect_bot[43] x3_net57
+ dac_config_2 vdda1 vssa1 vssc1 col_event_rst_bot_left[6] x3_net58 row_on_detect_bot[43]
+ row_off_detect_bot[42] openDVS_pixel2x2_bot
x3_x1757 dac_config_3 dac_config_5 col_event_rst_bot_left[5] dac_config_4
+ row_on_detect_bot[42] dac_config_0 dac_config_1 row_off_detect_bot[43] x3_net59
+ dac_config_2 vdda1 vssa1 vssc1 col_event_rst_bot_left[4] x3_net60 row_on_detect_bot[43]
+ row_off_detect_bot[42] openDVS_pixel2x2_bot
x3_x1758 dac_config_3 dac_config_5 col_event_rst_bot_left[3] dac_config_4
+ row_on_detect_bot[42] dac_config_0 dac_config_1 row_off_detect_bot[43] x3_net61
+ dac_config_2 vdda1 vssa1 vssc1 col_event_rst_bot_left[2] x3_net62 row_on_detect_bot[43]
+ row_off_detect_bot[42] openDVS_pixel2x2_bot
x3_x1759 dac_config_3 dac_config_5 col_event_rst_bot_left[1] dac_config_4
+ row_on_detect_bot[42] dac_config_0 dac_config_1 row_off_detect_bot[43] x3_net63
+ dac_config_2 vdda1 vssa1 vssc1 col_event_rst_bot_left[0] x3_net64 row_on_detect_bot[43]
+ row_off_detect_bot[42] openDVS_pixel2x2_bot
x3_x1760 dac_config_3 dac_config_5 col_event_rst_bot_left[63] dac_config_4
+ row_on_detect_bot[44] dac_config_0 dac_config_1 row_off_detect_bot[45] x3_net1
+ dac_config_2 vdda1 vssa1 vssc1 col_event_rst_bot_left[62] x3_net2 row_on_detect_bot[45]
+ row_off_detect_bot[44] openDVS_pixel2x2_bot
x3_x1761 dac_config_3 dac_config_5 col_event_rst_bot_left[61] dac_config_4
+ row_on_detect_bot[44] dac_config_0 dac_config_1 row_off_detect_bot[45] x3_net3
+ dac_config_2 vdda1 vssa1 vssc1 col_event_rst_bot_left[60] x3_net4 row_on_detect_bot[45]
+ row_off_detect_bot[44] openDVS_pixel2x2_bot
x3_x1762 dac_config_3 dac_config_5 col_event_rst_bot_left[59] dac_config_4
+ row_on_detect_bot[44] dac_config_0 dac_config_1 row_off_detect_bot[45] x3_net5
+ dac_config_2 vdda1 vssa1 vssc1 col_event_rst_bot_left[58] x3_net6 row_on_detect_bot[45]
+ row_off_detect_bot[44] openDVS_pixel2x2_bot
x3_x1763 dac_config_3 dac_config_5 col_event_rst_bot_left[57] dac_config_4
+ row_on_detect_bot[44] dac_config_0 dac_config_1 row_off_detect_bot[45] x3_net7
+ dac_config_2 vdda1 vssa1 vssc1 col_event_rst_bot_left[56] x3_net8 row_on_detect_bot[45]
+ row_off_detect_bot[44] openDVS_pixel2x2_bot
x3_x1764 dac_config_3 dac_config_5 col_event_rst_bot_left[55] dac_config_4
+ row_on_detect_bot[44] dac_config_0 dac_config_1 row_off_detect_bot[45] x3_net9
+ dac_config_2 vdda1 vssa1 vssc1 col_event_rst_bot_left[54] x3_net10 row_on_detect_bot[45]
+ row_off_detect_bot[44] openDVS_pixel2x2_bot
x3_x1765 dac_config_3 dac_config_5 col_event_rst_bot_left[53] dac_config_4
+ row_on_detect_bot[44] dac_config_0 dac_config_1 row_off_detect_bot[45] x3_net11
+ dac_config_2 vdda1 vssa1 vssc1 col_event_rst_bot_left[52] x3_net12 row_on_detect_bot[45]
+ row_off_detect_bot[44] openDVS_pixel2x2_bot
x3_x1766 dac_config_3 dac_config_5 col_event_rst_bot_left[51] dac_config_4
+ row_on_detect_bot[44] dac_config_0 dac_config_1 row_off_detect_bot[45] x3_net13
+ dac_config_2 vdda1 vssa1 vssc1 col_event_rst_bot_left[50] x3_net14 row_on_detect_bot[45]
+ row_off_detect_bot[44] openDVS_pixel2x2_bot
x3_x1767 dac_config_3 dac_config_5 col_event_rst_bot_left[49] dac_config_4
+ row_on_detect_bot[44] dac_config_0 dac_config_1 row_off_detect_bot[45] x3_net15
+ dac_config_2 vdda1 vssa1 vssc1 col_event_rst_bot_left[48] x3_net16 row_on_detect_bot[45]
+ row_off_detect_bot[44] openDVS_pixel2x2_bot
x3_x1768 dac_config_3 dac_config_5 col_event_rst_bot_left[47] dac_config_4
+ row_on_detect_bot[44] dac_config_0 dac_config_1 row_off_detect_bot[45] x3_net17
+ dac_config_2 vdda1 vssa1 vssc1 col_event_rst_bot_left[46] x3_net18 row_on_detect_bot[45]
+ row_off_detect_bot[44] openDVS_pixel2x2_bot
x3_x1769 dac_config_3 dac_config_5 col_event_rst_bot_left[45] dac_config_4
+ row_on_detect_bot[44] dac_config_0 dac_config_1 row_off_detect_bot[45] x3_net19
+ dac_config_2 vdda1 vssa1 vssc1 col_event_rst_bot_left[44] x3_net20 row_on_detect_bot[45]
+ row_off_detect_bot[44] openDVS_pixel2x2_bot
x3_x1770 dac_config_3 dac_config_5 col_event_rst_bot_left[43] dac_config_4
+ row_on_detect_bot[44] dac_config_0 dac_config_1 row_off_detect_bot[45] x3_net21
+ dac_config_2 vdda1 vssa1 vssc1 col_event_rst_bot_left[42] x3_net22 row_on_detect_bot[45]
+ row_off_detect_bot[44] openDVS_pixel2x2_bot
x3_x1771 dac_config_3 dac_config_5 col_event_rst_bot_left[41] dac_config_4
+ row_on_detect_bot[44] dac_config_0 dac_config_1 row_off_detect_bot[45] x3_net23
+ dac_config_2 vdda1 vssa1 vssc1 col_event_rst_bot_left[40] x3_net24 row_on_detect_bot[45]
+ row_off_detect_bot[44] openDVS_pixel2x2_bot
x3_x1772 dac_config_3 dac_config_5 col_event_rst_bot_left[39] dac_config_4
+ row_on_detect_bot[44] dac_config_0 dac_config_1 row_off_detect_bot[45] x3_net25
+ dac_config_2 vdda1 vssa1 vssc1 col_event_rst_bot_left[38] x3_net26 row_on_detect_bot[45]
+ row_off_detect_bot[44] openDVS_pixel2x2_bot
x3_x1773 dac_config_3 dac_config_5 col_event_rst_bot_left[37] dac_config_4
+ row_on_detect_bot[44] dac_config_0 dac_config_1 row_off_detect_bot[45] x3_net27
+ dac_config_2 vdda1 vssa1 vssc1 col_event_rst_bot_left[36] x3_net28 row_on_detect_bot[45]
+ row_off_detect_bot[44] openDVS_pixel2x2_bot
x3_x1774 dac_config_3 dac_config_5 col_event_rst_bot_left[35] dac_config_4
+ row_on_detect_bot[44] dac_config_0 dac_config_1 row_off_detect_bot[45] x3_net29
+ dac_config_2 vdda1 vssa1 vssc1 col_event_rst_bot_left[34] x3_net30 row_on_detect_bot[45]
+ row_off_detect_bot[44] openDVS_pixel2x2_bot
x3_x1775 dac_config_3 dac_config_5 col_event_rst_bot_left[33] dac_config_4
+ row_on_detect_bot[44] dac_config_0 dac_config_1 row_off_detect_bot[45] x3_net31
+ dac_config_2 vdda1 vssa1 vssc1 col_event_rst_bot_left[32] x3_net32 row_on_detect_bot[45]
+ row_off_detect_bot[44] openDVS_pixel2x2_bot
x3_x1776 dac_config_3 dac_config_5 col_event_rst_bot_left[31] dac_config_4
+ row_on_detect_bot[44] dac_config_0 dac_config_1 row_off_detect_bot[45] x3_net33
+ dac_config_2 vdda1 vssa1 vssc1 col_event_rst_bot_left[30] x3_net34 row_on_detect_bot[45]
+ row_off_detect_bot[44] openDVS_pixel2x2_bot
x3_x1777 dac_config_3 dac_config_5 col_event_rst_bot_left[29] dac_config_4
+ row_on_detect_bot[44] dac_config_0 dac_config_1 row_off_detect_bot[45] x3_net35
+ dac_config_2 vdda1 vssa1 vssc1 col_event_rst_bot_left[28] x3_net36 row_on_detect_bot[45]
+ row_off_detect_bot[44] openDVS_pixel2x2_bot
x3_x1778 dac_config_3 dac_config_5 col_event_rst_bot_left[27] dac_config_4
+ row_on_detect_bot[44] dac_config_0 dac_config_1 row_off_detect_bot[45] x3_net37
+ dac_config_2 vdda1 vssa1 vssc1 col_event_rst_bot_left[26] x3_net38 row_on_detect_bot[45]
+ row_off_detect_bot[44] openDVS_pixel2x2_bot
x3_x1779 dac_config_3 dac_config_5 col_event_rst_bot_left[25] dac_config_4
+ row_on_detect_bot[44] dac_config_0 dac_config_1 row_off_detect_bot[45] x3_net39
+ dac_config_2 vdda1 vssa1 vssc1 col_event_rst_bot_left[24] x3_net40 row_on_detect_bot[45]
+ row_off_detect_bot[44] openDVS_pixel2x2_bot
x3_x1780 dac_config_3 dac_config_5 col_event_rst_bot_left[23] dac_config_4
+ row_on_detect_bot[44] dac_config_0 dac_config_1 row_off_detect_bot[45] x3_net41
+ dac_config_2 vdda1 vssa1 vssc1 col_event_rst_bot_left[22] x3_net42 row_on_detect_bot[45]
+ row_off_detect_bot[44] openDVS_pixel2x2_bot
x3_x1781 dac_config_3 dac_config_5 col_event_rst_bot_left[21] dac_config_4
+ row_on_detect_bot[44] dac_config_0 dac_config_1 row_off_detect_bot[45] x3_net43
+ dac_config_2 vdda1 vssa1 vssc1 col_event_rst_bot_left[20] x3_net44 row_on_detect_bot[45]
+ row_off_detect_bot[44] openDVS_pixel2x2_bot
x3_x1782 dac_config_3 dac_config_5 col_event_rst_bot_left[19] dac_config_4
+ row_on_detect_bot[44] dac_config_0 dac_config_1 row_off_detect_bot[45] x3_net45
+ dac_config_2 vdda1 vssa1 vssc1 col_event_rst_bot_left[18] x3_net46 row_on_detect_bot[45]
+ row_off_detect_bot[44] openDVS_pixel2x2_bot
x3_x1783 dac_config_3 dac_config_5 col_event_rst_bot_left[17] dac_config_4
+ row_on_detect_bot[44] dac_config_0 dac_config_1 row_off_detect_bot[45] x3_net47
+ dac_config_2 vdda1 vssa1 vssc1 col_event_rst_bot_left[16] x3_net48 row_on_detect_bot[45]
+ row_off_detect_bot[44] openDVS_pixel2x2_bot
x3_x1784 dac_config_3 dac_config_5 col_event_rst_bot_left[15] dac_config_4
+ row_on_detect_bot[44] dac_config_0 dac_config_1 row_off_detect_bot[45] x3_net49
+ dac_config_2 vdda1 vssa1 vssc1 col_event_rst_bot_left[14] x3_net50 row_on_detect_bot[45]
+ row_off_detect_bot[44] openDVS_pixel2x2_bot
x3_x1785 dac_config_3 dac_config_5 col_event_rst_bot_left[13] dac_config_4
+ row_on_detect_bot[44] dac_config_0 dac_config_1 row_off_detect_bot[45] x3_net51
+ dac_config_2 vdda1 vssa1 vssc1 col_event_rst_bot_left[12] x3_net52 row_on_detect_bot[45]
+ row_off_detect_bot[44] openDVS_pixel2x2_bot
x3_x1786 dac_config_3 dac_config_5 col_event_rst_bot_left[11] dac_config_4
+ row_on_detect_bot[44] dac_config_0 dac_config_1 row_off_detect_bot[45] x3_net53
+ dac_config_2 vdda1 vssa1 vssc1 col_event_rst_bot_left[10] x3_net54 row_on_detect_bot[45]
+ row_off_detect_bot[44] openDVS_pixel2x2_bot
x3_x1787 dac_config_3 dac_config_5 col_event_rst_bot_left[9] dac_config_4
+ row_on_detect_bot[44] dac_config_0 dac_config_1 row_off_detect_bot[45] x3_net55
+ dac_config_2 vdda1 vssa1 vssc1 col_event_rst_bot_left[8] x3_net56 row_on_detect_bot[45]
+ row_off_detect_bot[44] openDVS_pixel2x2_bot
x3_x1788 dac_config_3 dac_config_5 col_event_rst_bot_left[7] dac_config_4
+ row_on_detect_bot[44] dac_config_0 dac_config_1 row_off_detect_bot[45] x3_net57
+ dac_config_2 vdda1 vssa1 vssc1 col_event_rst_bot_left[6] x3_net58 row_on_detect_bot[45]
+ row_off_detect_bot[44] openDVS_pixel2x2_bot
x3_x1789 dac_config_3 dac_config_5 col_event_rst_bot_left[5] dac_config_4
+ row_on_detect_bot[44] dac_config_0 dac_config_1 row_off_detect_bot[45] x3_net59
+ dac_config_2 vdda1 vssa1 vssc1 col_event_rst_bot_left[4] x3_net60 row_on_detect_bot[45]
+ row_off_detect_bot[44] openDVS_pixel2x2_bot
x3_x1790 dac_config_3 dac_config_5 col_event_rst_bot_left[3] dac_config_4
+ row_on_detect_bot[44] dac_config_0 dac_config_1 row_off_detect_bot[45] x3_net61
+ dac_config_2 vdda1 vssa1 vssc1 col_event_rst_bot_left[2] x3_net62 row_on_detect_bot[45]
+ row_off_detect_bot[44] openDVS_pixel2x2_bot
x3_x1791 dac_config_3 dac_config_5 col_event_rst_bot_left[1] dac_config_4
+ row_on_detect_bot[44] dac_config_0 dac_config_1 row_off_detect_bot[45] x3_net63
+ dac_config_2 vdda1 vssa1 vssc1 col_event_rst_bot_left[0] x3_net64 row_on_detect_bot[45]
+ row_off_detect_bot[44] openDVS_pixel2x2_bot
x3_x1792 dac_config_3 dac_config_5 col_event_rst_bot_left[63] dac_config_4
+ row_on_detect_bot[46] dac_config_0 dac_config_1 row_off_detect_bot[47] x3_net1
+ dac_config_2 vdda1 vssa1 vssc1 col_event_rst_bot_left[62] x3_net2 row_on_detect_bot[47]
+ row_off_detect_bot[46] openDVS_pixel2x2_bot
x3_x1793 dac_config_3 dac_config_5 col_event_rst_bot_left[61] dac_config_4
+ row_on_detect_bot[46] dac_config_0 dac_config_1 row_off_detect_bot[47] x3_net3
+ dac_config_2 vdda1 vssa1 vssc1 col_event_rst_bot_left[60] x3_net4 row_on_detect_bot[47]
+ row_off_detect_bot[46] openDVS_pixel2x2_bot
x3_x1794 dac_config_3 dac_config_5 col_event_rst_bot_left[59] dac_config_4
+ row_on_detect_bot[46] dac_config_0 dac_config_1 row_off_detect_bot[47] x3_net5
+ dac_config_2 vdda1 vssa1 vssc1 col_event_rst_bot_left[58] x3_net6 row_on_detect_bot[47]
+ row_off_detect_bot[46] openDVS_pixel2x2_bot
x3_x1795 dac_config_3 dac_config_5 col_event_rst_bot_left[57] dac_config_4
+ row_on_detect_bot[46] dac_config_0 dac_config_1 row_off_detect_bot[47] x3_net7
+ dac_config_2 vdda1 vssa1 vssc1 col_event_rst_bot_left[56] x3_net8 row_on_detect_bot[47]
+ row_off_detect_bot[46] openDVS_pixel2x2_bot
x3_x1796 dac_config_3 dac_config_5 col_event_rst_bot_left[55] dac_config_4
+ row_on_detect_bot[46] dac_config_0 dac_config_1 row_off_detect_bot[47] x3_net9
+ dac_config_2 vdda1 vssa1 vssc1 col_event_rst_bot_left[54] x3_net10 row_on_detect_bot[47]
+ row_off_detect_bot[46] openDVS_pixel2x2_bot
x3_x1797 dac_config_3 dac_config_5 col_event_rst_bot_left[53] dac_config_4
+ row_on_detect_bot[46] dac_config_0 dac_config_1 row_off_detect_bot[47] x3_net11
+ dac_config_2 vdda1 vssa1 vssc1 col_event_rst_bot_left[52] x3_net12 row_on_detect_bot[47]
+ row_off_detect_bot[46] openDVS_pixel2x2_bot
x3_x1798 dac_config_3 dac_config_5 col_event_rst_bot_left[51] dac_config_4
+ row_on_detect_bot[46] dac_config_0 dac_config_1 row_off_detect_bot[47] x3_net13
+ dac_config_2 vdda1 vssa1 vssc1 col_event_rst_bot_left[50] x3_net14 row_on_detect_bot[47]
+ row_off_detect_bot[46] openDVS_pixel2x2_bot
x3_x1799 dac_config_3 dac_config_5 col_event_rst_bot_left[49] dac_config_4
+ row_on_detect_bot[46] dac_config_0 dac_config_1 row_off_detect_bot[47] x3_net15
+ dac_config_2 vdda1 vssa1 vssc1 col_event_rst_bot_left[48] x3_net16 row_on_detect_bot[47]
+ row_off_detect_bot[46] openDVS_pixel2x2_bot
x3_x1800 dac_config_3 dac_config_5 col_event_rst_bot_left[47] dac_config_4
+ row_on_detect_bot[46] dac_config_0 dac_config_1 row_off_detect_bot[47] x3_net17
+ dac_config_2 vdda1 vssa1 vssc1 col_event_rst_bot_left[46] x3_net18 row_on_detect_bot[47]
+ row_off_detect_bot[46] openDVS_pixel2x2_bot
x3_x1801 dac_config_3 dac_config_5 col_event_rst_bot_left[45] dac_config_4
+ row_on_detect_bot[46] dac_config_0 dac_config_1 row_off_detect_bot[47] x3_net19
+ dac_config_2 vdda1 vssa1 vssc1 col_event_rst_bot_left[44] x3_net20 row_on_detect_bot[47]
+ row_off_detect_bot[46] openDVS_pixel2x2_bot
x3_x1802 dac_config_3 dac_config_5 col_event_rst_bot_left[43] dac_config_4
+ row_on_detect_bot[46] dac_config_0 dac_config_1 row_off_detect_bot[47] x3_net21
+ dac_config_2 vdda1 vssa1 vssc1 col_event_rst_bot_left[42] x3_net22 row_on_detect_bot[47]
+ row_off_detect_bot[46] openDVS_pixel2x2_bot
x3_x1803 dac_config_3 dac_config_5 col_event_rst_bot_left[41] dac_config_4
+ row_on_detect_bot[46] dac_config_0 dac_config_1 row_off_detect_bot[47] x3_net23
+ dac_config_2 vdda1 vssa1 vssc1 col_event_rst_bot_left[40] x3_net24 row_on_detect_bot[47]
+ row_off_detect_bot[46] openDVS_pixel2x2_bot
x3_x1804 dac_config_3 dac_config_5 col_event_rst_bot_left[39] dac_config_4
+ row_on_detect_bot[46] dac_config_0 dac_config_1 row_off_detect_bot[47] x3_net25
+ dac_config_2 vdda1 vssa1 vssc1 col_event_rst_bot_left[38] x3_net26 row_on_detect_bot[47]
+ row_off_detect_bot[46] openDVS_pixel2x2_bot
x3_x1805 dac_config_3 dac_config_5 col_event_rst_bot_left[37] dac_config_4
+ row_on_detect_bot[46] dac_config_0 dac_config_1 row_off_detect_bot[47] x3_net27
+ dac_config_2 vdda1 vssa1 vssc1 col_event_rst_bot_left[36] x3_net28 row_on_detect_bot[47]
+ row_off_detect_bot[46] openDVS_pixel2x2_bot
x3_x1806 dac_config_3 dac_config_5 col_event_rst_bot_left[35] dac_config_4
+ row_on_detect_bot[46] dac_config_0 dac_config_1 row_off_detect_bot[47] x3_net29
+ dac_config_2 vdda1 vssa1 vssc1 col_event_rst_bot_left[34] x3_net30 row_on_detect_bot[47]
+ row_off_detect_bot[46] openDVS_pixel2x2_bot
x3_x1807 dac_config_3 dac_config_5 col_event_rst_bot_left[33] dac_config_4
+ row_on_detect_bot[46] dac_config_0 dac_config_1 row_off_detect_bot[47] x3_net31
+ dac_config_2 vdda1 vssa1 vssc1 col_event_rst_bot_left[32] x3_net32 row_on_detect_bot[47]
+ row_off_detect_bot[46] openDVS_pixel2x2_bot
x3_x1808 dac_config_3 dac_config_5 col_event_rst_bot_left[31] dac_config_4
+ row_on_detect_bot[46] dac_config_0 dac_config_1 row_off_detect_bot[47] x3_net33
+ dac_config_2 vdda1 vssa1 vssc1 col_event_rst_bot_left[30] x3_net34 row_on_detect_bot[47]
+ row_off_detect_bot[46] openDVS_pixel2x2_bot
x3_x1809 dac_config_3 dac_config_5 col_event_rst_bot_left[29] dac_config_4
+ row_on_detect_bot[46] dac_config_0 dac_config_1 row_off_detect_bot[47] x3_net35
+ dac_config_2 vdda1 vssa1 vssc1 col_event_rst_bot_left[28] x3_net36 row_on_detect_bot[47]
+ row_off_detect_bot[46] openDVS_pixel2x2_bot
x3_x1810 dac_config_3 dac_config_5 col_event_rst_bot_left[27] dac_config_4
+ row_on_detect_bot[46] dac_config_0 dac_config_1 row_off_detect_bot[47] x3_net37
+ dac_config_2 vdda1 vssa1 vssc1 col_event_rst_bot_left[26] x3_net38 row_on_detect_bot[47]
+ row_off_detect_bot[46] openDVS_pixel2x2_bot
x3_x1811 dac_config_3 dac_config_5 col_event_rst_bot_left[25] dac_config_4
+ row_on_detect_bot[46] dac_config_0 dac_config_1 row_off_detect_bot[47] x3_net39
+ dac_config_2 vdda1 vssa1 vssc1 col_event_rst_bot_left[24] x3_net40 row_on_detect_bot[47]
+ row_off_detect_bot[46] openDVS_pixel2x2_bot
x3_x1812 dac_config_3 dac_config_5 col_event_rst_bot_left[23] dac_config_4
+ row_on_detect_bot[46] dac_config_0 dac_config_1 row_off_detect_bot[47] x3_net41
+ dac_config_2 vdda1 vssa1 vssc1 col_event_rst_bot_left[22] x3_net42 row_on_detect_bot[47]
+ row_off_detect_bot[46] openDVS_pixel2x2_bot
x3_x1813 dac_config_3 dac_config_5 col_event_rst_bot_left[21] dac_config_4
+ row_on_detect_bot[46] dac_config_0 dac_config_1 row_off_detect_bot[47] x3_net43
+ dac_config_2 vdda1 vssa1 vssc1 col_event_rst_bot_left[20] x3_net44 row_on_detect_bot[47]
+ row_off_detect_bot[46] openDVS_pixel2x2_bot
x3_x1814 dac_config_3 dac_config_5 col_event_rst_bot_left[19] dac_config_4
+ row_on_detect_bot[46] dac_config_0 dac_config_1 row_off_detect_bot[47] x3_net45
+ dac_config_2 vdda1 vssa1 vssc1 col_event_rst_bot_left[18] x3_net46 row_on_detect_bot[47]
+ row_off_detect_bot[46] openDVS_pixel2x2_bot
x3_x1815 dac_config_3 dac_config_5 col_event_rst_bot_left[17] dac_config_4
+ row_on_detect_bot[46] dac_config_0 dac_config_1 row_off_detect_bot[47] x3_net47
+ dac_config_2 vdda1 vssa1 vssc1 col_event_rst_bot_left[16] x3_net48 row_on_detect_bot[47]
+ row_off_detect_bot[46] openDVS_pixel2x2_bot
x3_x1816 dac_config_3 dac_config_5 col_event_rst_bot_left[15] dac_config_4
+ row_on_detect_bot[46] dac_config_0 dac_config_1 row_off_detect_bot[47] x3_net49
+ dac_config_2 vdda1 vssa1 vssc1 col_event_rst_bot_left[14] x3_net50 row_on_detect_bot[47]
+ row_off_detect_bot[46] openDVS_pixel2x2_bot
x3_x1817 dac_config_3 dac_config_5 col_event_rst_bot_left[13] dac_config_4
+ row_on_detect_bot[46] dac_config_0 dac_config_1 row_off_detect_bot[47] x3_net51
+ dac_config_2 vdda1 vssa1 vssc1 col_event_rst_bot_left[12] x3_net52 row_on_detect_bot[47]
+ row_off_detect_bot[46] openDVS_pixel2x2_bot
x3_x1818 dac_config_3 dac_config_5 col_event_rst_bot_left[11] dac_config_4
+ row_on_detect_bot[46] dac_config_0 dac_config_1 row_off_detect_bot[47] x3_net53
+ dac_config_2 vdda1 vssa1 vssc1 col_event_rst_bot_left[10] x3_net54 row_on_detect_bot[47]
+ row_off_detect_bot[46] openDVS_pixel2x2_bot
x3_x1819 dac_config_3 dac_config_5 col_event_rst_bot_left[9] dac_config_4
+ row_on_detect_bot[46] dac_config_0 dac_config_1 row_off_detect_bot[47] x3_net55
+ dac_config_2 vdda1 vssa1 vssc1 col_event_rst_bot_left[8] x3_net56 row_on_detect_bot[47]
+ row_off_detect_bot[46] openDVS_pixel2x2_bot
x3_x1820 dac_config_3 dac_config_5 col_event_rst_bot_left[7] dac_config_4
+ row_on_detect_bot[46] dac_config_0 dac_config_1 row_off_detect_bot[47] x3_net57
+ dac_config_2 vdda1 vssa1 vssc1 col_event_rst_bot_left[6] x3_net58 row_on_detect_bot[47]
+ row_off_detect_bot[46] openDVS_pixel2x2_bot
x3_x1821 dac_config_3 dac_config_5 col_event_rst_bot_left[5] dac_config_4
+ row_on_detect_bot[46] dac_config_0 dac_config_1 row_off_detect_bot[47] x3_net59
+ dac_config_2 vdda1 vssa1 vssc1 col_event_rst_bot_left[4] x3_net60 row_on_detect_bot[47]
+ row_off_detect_bot[46] openDVS_pixel2x2_bot
x3_x1822 dac_config_3 dac_config_5 col_event_rst_bot_left[3] dac_config_4
+ row_on_detect_bot[46] dac_config_0 dac_config_1 row_off_detect_bot[47] x3_net61
+ dac_config_2 vdda1 vssa1 vssc1 col_event_rst_bot_left[2] x3_net62 row_on_detect_bot[47]
+ row_off_detect_bot[46] openDVS_pixel2x2_bot
x3_x1823 dac_config_3 dac_config_5 col_event_rst_bot_left[1] dac_config_4
+ row_on_detect_bot[46] dac_config_0 dac_config_1 row_off_detect_bot[47] x3_net63
+ dac_config_2 vdda1 vssa1 vssc1 col_event_rst_bot_left[0] x3_net64 row_on_detect_bot[47]
+ row_off_detect_bot[46] openDVS_pixel2x2_bot
x3_x1824 dac_config_3 dac_config_5 col_event_rst_bot_left[63] dac_config_4
+ row_on_detect_bot[48] dac_config_0 dac_config_1 row_off_detect_bot[49] x3_net1
+ dac_config_2 vdda1 vssa1 vssc1 col_event_rst_bot_left[62] x3_net2 row_on_detect_bot[49]
+ row_off_detect_bot[48] openDVS_pixel2x2_bot
x3_x1825 dac_config_3 dac_config_5 col_event_rst_bot_left[61] dac_config_4
+ row_on_detect_bot[48] dac_config_0 dac_config_1 row_off_detect_bot[49] x3_net3
+ dac_config_2 vdda1 vssa1 vssc1 col_event_rst_bot_left[60] x3_net4 row_on_detect_bot[49]
+ row_off_detect_bot[48] openDVS_pixel2x2_bot
x3_x1826 dac_config_3 dac_config_5 col_event_rst_bot_left[59] dac_config_4
+ row_on_detect_bot[48] dac_config_0 dac_config_1 row_off_detect_bot[49] x3_net5
+ dac_config_2 vdda1 vssa1 vssc1 col_event_rst_bot_left[58] x3_net6 row_on_detect_bot[49]
+ row_off_detect_bot[48] openDVS_pixel2x2_bot
x3_x1827 dac_config_3 dac_config_5 col_event_rst_bot_left[57] dac_config_4
+ row_on_detect_bot[48] dac_config_0 dac_config_1 row_off_detect_bot[49] x3_net7
+ dac_config_2 vdda1 vssa1 vssc1 col_event_rst_bot_left[56] x3_net8 row_on_detect_bot[49]
+ row_off_detect_bot[48] openDVS_pixel2x2_bot
x3_x1828 dac_config_3 dac_config_5 col_event_rst_bot_left[55] dac_config_4
+ row_on_detect_bot[48] dac_config_0 dac_config_1 row_off_detect_bot[49] x3_net9
+ dac_config_2 vdda1 vssa1 vssc1 col_event_rst_bot_left[54] x3_net10 row_on_detect_bot[49]
+ row_off_detect_bot[48] openDVS_pixel2x2_bot
x3_x1829 dac_config_3 dac_config_5 col_event_rst_bot_left[53] dac_config_4
+ row_on_detect_bot[48] dac_config_0 dac_config_1 row_off_detect_bot[49] x3_net11
+ dac_config_2 vdda1 vssa1 vssc1 col_event_rst_bot_left[52] x3_net12 row_on_detect_bot[49]
+ row_off_detect_bot[48] openDVS_pixel2x2_bot
x3_x1830 dac_config_3 dac_config_5 col_event_rst_bot_left[51] dac_config_4
+ row_on_detect_bot[48] dac_config_0 dac_config_1 row_off_detect_bot[49] x3_net13
+ dac_config_2 vdda1 vssa1 vssc1 col_event_rst_bot_left[50] x3_net14 row_on_detect_bot[49]
+ row_off_detect_bot[48] openDVS_pixel2x2_bot
x3_x1831 dac_config_3 dac_config_5 col_event_rst_bot_left[49] dac_config_4
+ row_on_detect_bot[48] dac_config_0 dac_config_1 row_off_detect_bot[49] x3_net15
+ dac_config_2 vdda1 vssa1 vssc1 col_event_rst_bot_left[48] x3_net16 row_on_detect_bot[49]
+ row_off_detect_bot[48] openDVS_pixel2x2_bot
x3_x1832 dac_config_3 dac_config_5 col_event_rst_bot_left[47] dac_config_4
+ row_on_detect_bot[48] dac_config_0 dac_config_1 row_off_detect_bot[49] x3_net17
+ dac_config_2 vdda1 vssa1 vssc1 col_event_rst_bot_left[46] x3_net18 row_on_detect_bot[49]
+ row_off_detect_bot[48] openDVS_pixel2x2_bot
x3_x1833 dac_config_3 dac_config_5 col_event_rst_bot_left[45] dac_config_4
+ row_on_detect_bot[48] dac_config_0 dac_config_1 row_off_detect_bot[49] x3_net19
+ dac_config_2 vdda1 vssa1 vssc1 col_event_rst_bot_left[44] x3_net20 row_on_detect_bot[49]
+ row_off_detect_bot[48] openDVS_pixel2x2_bot
x3_x1834 dac_config_3 dac_config_5 col_event_rst_bot_left[43] dac_config_4
+ row_on_detect_bot[48] dac_config_0 dac_config_1 row_off_detect_bot[49] x3_net21
+ dac_config_2 vdda1 vssa1 vssc1 col_event_rst_bot_left[42] x3_net22 row_on_detect_bot[49]
+ row_off_detect_bot[48] openDVS_pixel2x2_bot
x3_x1835 dac_config_3 dac_config_5 col_event_rst_bot_left[41] dac_config_4
+ row_on_detect_bot[48] dac_config_0 dac_config_1 row_off_detect_bot[49] x3_net23
+ dac_config_2 vdda1 vssa1 vssc1 col_event_rst_bot_left[40] x3_net24 row_on_detect_bot[49]
+ row_off_detect_bot[48] openDVS_pixel2x2_bot
x3_x1836 dac_config_3 dac_config_5 col_event_rst_bot_left[39] dac_config_4
+ row_on_detect_bot[48] dac_config_0 dac_config_1 row_off_detect_bot[49] x3_net25
+ dac_config_2 vdda1 vssa1 vssc1 col_event_rst_bot_left[38] x3_net26 row_on_detect_bot[49]
+ row_off_detect_bot[48] openDVS_pixel2x2_bot
x3_x1837 dac_config_3 dac_config_5 col_event_rst_bot_left[37] dac_config_4
+ row_on_detect_bot[48] dac_config_0 dac_config_1 row_off_detect_bot[49] x3_net27
+ dac_config_2 vdda1 vssa1 vssc1 col_event_rst_bot_left[36] x3_net28 row_on_detect_bot[49]
+ row_off_detect_bot[48] openDVS_pixel2x2_bot
x3_x1838 dac_config_3 dac_config_5 col_event_rst_bot_left[35] dac_config_4
+ row_on_detect_bot[48] dac_config_0 dac_config_1 row_off_detect_bot[49] x3_net29
+ dac_config_2 vdda1 vssa1 vssc1 col_event_rst_bot_left[34] x3_net30 row_on_detect_bot[49]
+ row_off_detect_bot[48] openDVS_pixel2x2_bot
x3_x1839 dac_config_3 dac_config_5 col_event_rst_bot_left[33] dac_config_4
+ row_on_detect_bot[48] dac_config_0 dac_config_1 row_off_detect_bot[49] x3_net31
+ dac_config_2 vdda1 vssa1 vssc1 col_event_rst_bot_left[32] x3_net32 row_on_detect_bot[49]
+ row_off_detect_bot[48] openDVS_pixel2x2_bot
x3_x1840 dac_config_3 dac_config_5 col_event_rst_bot_left[31] dac_config_4
+ row_on_detect_bot[48] dac_config_0 dac_config_1 row_off_detect_bot[49] x3_net33
+ dac_config_2 vdda1 vssa1 vssc1 col_event_rst_bot_left[30] x3_net34 row_on_detect_bot[49]
+ row_off_detect_bot[48] openDVS_pixel2x2_bot
x3_x1841 dac_config_3 dac_config_5 col_event_rst_bot_left[29] dac_config_4
+ row_on_detect_bot[48] dac_config_0 dac_config_1 row_off_detect_bot[49] x3_net35
+ dac_config_2 vdda1 vssa1 vssc1 col_event_rst_bot_left[28] x3_net36 row_on_detect_bot[49]
+ row_off_detect_bot[48] openDVS_pixel2x2_bot
x3_x1842 dac_config_3 dac_config_5 col_event_rst_bot_left[27] dac_config_4
+ row_on_detect_bot[48] dac_config_0 dac_config_1 row_off_detect_bot[49] x3_net37
+ dac_config_2 vdda1 vssa1 vssc1 col_event_rst_bot_left[26] x3_net38 row_on_detect_bot[49]
+ row_off_detect_bot[48] openDVS_pixel2x2_bot
x3_x1843 dac_config_3 dac_config_5 col_event_rst_bot_left[25] dac_config_4
+ row_on_detect_bot[48] dac_config_0 dac_config_1 row_off_detect_bot[49] x3_net39
+ dac_config_2 vdda1 vssa1 vssc1 col_event_rst_bot_left[24] x3_net40 row_on_detect_bot[49]
+ row_off_detect_bot[48] openDVS_pixel2x2_bot
x3_x1844 dac_config_3 dac_config_5 col_event_rst_bot_left[23] dac_config_4
+ row_on_detect_bot[48] dac_config_0 dac_config_1 row_off_detect_bot[49] x3_net41
+ dac_config_2 vdda1 vssa1 vssc1 col_event_rst_bot_left[22] x3_net42 row_on_detect_bot[49]
+ row_off_detect_bot[48] openDVS_pixel2x2_bot
x3_x1845 dac_config_3 dac_config_5 col_event_rst_bot_left[21] dac_config_4
+ row_on_detect_bot[48] dac_config_0 dac_config_1 row_off_detect_bot[49] x3_net43
+ dac_config_2 vdda1 vssa1 vssc1 col_event_rst_bot_left[20] x3_net44 row_on_detect_bot[49]
+ row_off_detect_bot[48] openDVS_pixel2x2_bot
x3_x1846 dac_config_3 dac_config_5 col_event_rst_bot_left[19] dac_config_4
+ row_on_detect_bot[48] dac_config_0 dac_config_1 row_off_detect_bot[49] x3_net45
+ dac_config_2 vdda1 vssa1 vssc1 col_event_rst_bot_left[18] x3_net46 row_on_detect_bot[49]
+ row_off_detect_bot[48] openDVS_pixel2x2_bot
x3_x1847 dac_config_3 dac_config_5 col_event_rst_bot_left[17] dac_config_4
+ row_on_detect_bot[48] dac_config_0 dac_config_1 row_off_detect_bot[49] x3_net47
+ dac_config_2 vdda1 vssa1 vssc1 col_event_rst_bot_left[16] x3_net48 row_on_detect_bot[49]
+ row_off_detect_bot[48] openDVS_pixel2x2_bot
x3_x1848 dac_config_3 dac_config_5 col_event_rst_bot_left[15] dac_config_4
+ row_on_detect_bot[48] dac_config_0 dac_config_1 row_off_detect_bot[49] x3_net49
+ dac_config_2 vdda1 vssa1 vssc1 col_event_rst_bot_left[14] x3_net50 row_on_detect_bot[49]
+ row_off_detect_bot[48] openDVS_pixel2x2_bot
x3_x1849 dac_config_3 dac_config_5 col_event_rst_bot_left[13] dac_config_4
+ row_on_detect_bot[48] dac_config_0 dac_config_1 row_off_detect_bot[49] x3_net51
+ dac_config_2 vdda1 vssa1 vssc1 col_event_rst_bot_left[12] x3_net52 row_on_detect_bot[49]
+ row_off_detect_bot[48] openDVS_pixel2x2_bot
x3_x1850 dac_config_3 dac_config_5 col_event_rst_bot_left[11] dac_config_4
+ row_on_detect_bot[48] dac_config_0 dac_config_1 row_off_detect_bot[49] x3_net53
+ dac_config_2 vdda1 vssa1 vssc1 col_event_rst_bot_left[10] x3_net54 row_on_detect_bot[49]
+ row_off_detect_bot[48] openDVS_pixel2x2_bot
x3_x1851 dac_config_3 dac_config_5 col_event_rst_bot_left[9] dac_config_4
+ row_on_detect_bot[48] dac_config_0 dac_config_1 row_off_detect_bot[49] x3_net55
+ dac_config_2 vdda1 vssa1 vssc1 col_event_rst_bot_left[8] x3_net56 row_on_detect_bot[49]
+ row_off_detect_bot[48] openDVS_pixel2x2_bot
x3_x1852 dac_config_3 dac_config_5 col_event_rst_bot_left[7] dac_config_4
+ row_on_detect_bot[48] dac_config_0 dac_config_1 row_off_detect_bot[49] x3_net57
+ dac_config_2 vdda1 vssa1 vssc1 col_event_rst_bot_left[6] x3_net58 row_on_detect_bot[49]
+ row_off_detect_bot[48] openDVS_pixel2x2_bot
x3_x1853 dac_config_3 dac_config_5 col_event_rst_bot_left[5] dac_config_4
+ row_on_detect_bot[48] dac_config_0 dac_config_1 row_off_detect_bot[49] x3_net59
+ dac_config_2 vdda1 vssa1 vssc1 col_event_rst_bot_left[4] x3_net60 row_on_detect_bot[49]
+ row_off_detect_bot[48] openDVS_pixel2x2_bot
x3_x1854 dac_config_3 dac_config_5 col_event_rst_bot_left[3] dac_config_4
+ row_on_detect_bot[48] dac_config_0 dac_config_1 row_off_detect_bot[49] x3_net61
+ dac_config_2 vdda1 vssa1 vssc1 col_event_rst_bot_left[2] x3_net62 row_on_detect_bot[49]
+ row_off_detect_bot[48] openDVS_pixel2x2_bot
x3_x1855 dac_config_3 dac_config_5 col_event_rst_bot_left[1] dac_config_4
+ row_on_detect_bot[48] dac_config_0 dac_config_1 row_off_detect_bot[49] x3_net63
+ dac_config_2 vdda1 vssa1 vssc1 col_event_rst_bot_left[0] x3_net64 row_on_detect_bot[49]
+ row_off_detect_bot[48] openDVS_pixel2x2_bot
x3_x1856 dac_config_3 dac_config_5 col_event_rst_bot_left[63] dac_config_4
+ row_on_detect_bot[50] dac_config_0 dac_config_1 row_off_detect_bot[51] x3_net1
+ dac_config_2 vdda1 vssa1 vssc1 col_event_rst_bot_left[62] x3_net2 row_on_detect_bot[51]
+ row_off_detect_bot[50] openDVS_pixel2x2_bot
x3_x1857 dac_config_3 dac_config_5 col_event_rst_bot_left[61] dac_config_4
+ row_on_detect_bot[50] dac_config_0 dac_config_1 row_off_detect_bot[51] x3_net3
+ dac_config_2 vdda1 vssa1 vssc1 col_event_rst_bot_left[60] x3_net4 row_on_detect_bot[51]
+ row_off_detect_bot[50] openDVS_pixel2x2_bot
x3_x1858 dac_config_3 dac_config_5 col_event_rst_bot_left[59] dac_config_4
+ row_on_detect_bot[50] dac_config_0 dac_config_1 row_off_detect_bot[51] x3_net5
+ dac_config_2 vdda1 vssa1 vssc1 col_event_rst_bot_left[58] x3_net6 row_on_detect_bot[51]
+ row_off_detect_bot[50] openDVS_pixel2x2_bot
x3_x1859 dac_config_3 dac_config_5 col_event_rst_bot_left[57] dac_config_4
+ row_on_detect_bot[50] dac_config_0 dac_config_1 row_off_detect_bot[51] x3_net7
+ dac_config_2 vdda1 vssa1 vssc1 col_event_rst_bot_left[56] x3_net8 row_on_detect_bot[51]
+ row_off_detect_bot[50] openDVS_pixel2x2_bot
x3_x1860 dac_config_3 dac_config_5 col_event_rst_bot_left[55] dac_config_4
+ row_on_detect_bot[50] dac_config_0 dac_config_1 row_off_detect_bot[51] x3_net9
+ dac_config_2 vdda1 vssa1 vssc1 col_event_rst_bot_left[54] x3_net10 row_on_detect_bot[51]
+ row_off_detect_bot[50] openDVS_pixel2x2_bot
x3_x1861 dac_config_3 dac_config_5 col_event_rst_bot_left[53] dac_config_4
+ row_on_detect_bot[50] dac_config_0 dac_config_1 row_off_detect_bot[51] x3_net11
+ dac_config_2 vdda1 vssa1 vssc1 col_event_rst_bot_left[52] x3_net12 row_on_detect_bot[51]
+ row_off_detect_bot[50] openDVS_pixel2x2_bot
x3_x1862 dac_config_3 dac_config_5 col_event_rst_bot_left[51] dac_config_4
+ row_on_detect_bot[50] dac_config_0 dac_config_1 row_off_detect_bot[51] x3_net13
+ dac_config_2 vdda1 vssa1 vssc1 col_event_rst_bot_left[50] x3_net14 row_on_detect_bot[51]
+ row_off_detect_bot[50] openDVS_pixel2x2_bot
x3_x1863 dac_config_3 dac_config_5 col_event_rst_bot_left[49] dac_config_4
+ row_on_detect_bot[50] dac_config_0 dac_config_1 row_off_detect_bot[51] x3_net15
+ dac_config_2 vdda1 vssa1 vssc1 col_event_rst_bot_left[48] x3_net16 row_on_detect_bot[51]
+ row_off_detect_bot[50] openDVS_pixel2x2_bot
x3_x1864 dac_config_3 dac_config_5 col_event_rst_bot_left[47] dac_config_4
+ row_on_detect_bot[50] dac_config_0 dac_config_1 row_off_detect_bot[51] x3_net17
+ dac_config_2 vdda1 vssa1 vssc1 col_event_rst_bot_left[46] x3_net18 row_on_detect_bot[51]
+ row_off_detect_bot[50] openDVS_pixel2x2_bot
x3_x1865 dac_config_3 dac_config_5 col_event_rst_bot_left[45] dac_config_4
+ row_on_detect_bot[50] dac_config_0 dac_config_1 row_off_detect_bot[51] x3_net19
+ dac_config_2 vdda1 vssa1 vssc1 col_event_rst_bot_left[44] x3_net20 row_on_detect_bot[51]
+ row_off_detect_bot[50] openDVS_pixel2x2_bot
x3_x1866 dac_config_3 dac_config_5 col_event_rst_bot_left[43] dac_config_4
+ row_on_detect_bot[50] dac_config_0 dac_config_1 row_off_detect_bot[51] x3_net21
+ dac_config_2 vdda1 vssa1 vssc1 col_event_rst_bot_left[42] x3_net22 row_on_detect_bot[51]
+ row_off_detect_bot[50] openDVS_pixel2x2_bot
x3_x1867 dac_config_3 dac_config_5 col_event_rst_bot_left[41] dac_config_4
+ row_on_detect_bot[50] dac_config_0 dac_config_1 row_off_detect_bot[51] x3_net23
+ dac_config_2 vdda1 vssa1 vssc1 col_event_rst_bot_left[40] x3_net24 row_on_detect_bot[51]
+ row_off_detect_bot[50] openDVS_pixel2x2_bot
x3_x1868 dac_config_3 dac_config_5 col_event_rst_bot_left[39] dac_config_4
+ row_on_detect_bot[50] dac_config_0 dac_config_1 row_off_detect_bot[51] x3_net25
+ dac_config_2 vdda1 vssa1 vssc1 col_event_rst_bot_left[38] x3_net26 row_on_detect_bot[51]
+ row_off_detect_bot[50] openDVS_pixel2x2_bot
x3_x1869 dac_config_3 dac_config_5 col_event_rst_bot_left[37] dac_config_4
+ row_on_detect_bot[50] dac_config_0 dac_config_1 row_off_detect_bot[51] x3_net27
+ dac_config_2 vdda1 vssa1 vssc1 col_event_rst_bot_left[36] x3_net28 row_on_detect_bot[51]
+ row_off_detect_bot[50] openDVS_pixel2x2_bot
x3_x1870 dac_config_3 dac_config_5 col_event_rst_bot_left[35] dac_config_4
+ row_on_detect_bot[50] dac_config_0 dac_config_1 row_off_detect_bot[51] x3_net29
+ dac_config_2 vdda1 vssa1 vssc1 col_event_rst_bot_left[34] x3_net30 row_on_detect_bot[51]
+ row_off_detect_bot[50] openDVS_pixel2x2_bot
x3_x1871 dac_config_3 dac_config_5 col_event_rst_bot_left[33] dac_config_4
+ row_on_detect_bot[50] dac_config_0 dac_config_1 row_off_detect_bot[51] x3_net31
+ dac_config_2 vdda1 vssa1 vssc1 col_event_rst_bot_left[32] x3_net32 row_on_detect_bot[51]
+ row_off_detect_bot[50] openDVS_pixel2x2_bot
x3_x1872 dac_config_3 dac_config_5 col_event_rst_bot_left[31] dac_config_4
+ row_on_detect_bot[50] dac_config_0 dac_config_1 row_off_detect_bot[51] x3_net33
+ dac_config_2 vdda1 vssa1 vssc1 col_event_rst_bot_left[30] x3_net34 row_on_detect_bot[51]
+ row_off_detect_bot[50] openDVS_pixel2x2_bot
x3_x1873 dac_config_3 dac_config_5 col_event_rst_bot_left[29] dac_config_4
+ row_on_detect_bot[50] dac_config_0 dac_config_1 row_off_detect_bot[51] x3_net35
+ dac_config_2 vdda1 vssa1 vssc1 col_event_rst_bot_left[28] x3_net36 row_on_detect_bot[51]
+ row_off_detect_bot[50] openDVS_pixel2x2_bot
x3_x1874 dac_config_3 dac_config_5 col_event_rst_bot_left[27] dac_config_4
+ row_on_detect_bot[50] dac_config_0 dac_config_1 row_off_detect_bot[51] x3_net37
+ dac_config_2 vdda1 vssa1 vssc1 col_event_rst_bot_left[26] x3_net38 row_on_detect_bot[51]
+ row_off_detect_bot[50] openDVS_pixel2x2_bot
x3_x1875 dac_config_3 dac_config_5 col_event_rst_bot_left[25] dac_config_4
+ row_on_detect_bot[50] dac_config_0 dac_config_1 row_off_detect_bot[51] x3_net39
+ dac_config_2 vdda1 vssa1 vssc1 col_event_rst_bot_left[24] x3_net40 row_on_detect_bot[51]
+ row_off_detect_bot[50] openDVS_pixel2x2_bot
x3_x1876 dac_config_3 dac_config_5 col_event_rst_bot_left[23] dac_config_4
+ row_on_detect_bot[50] dac_config_0 dac_config_1 row_off_detect_bot[51] x3_net41
+ dac_config_2 vdda1 vssa1 vssc1 col_event_rst_bot_left[22] x3_net42 row_on_detect_bot[51]
+ row_off_detect_bot[50] openDVS_pixel2x2_bot
x3_x1877 dac_config_3 dac_config_5 col_event_rst_bot_left[21] dac_config_4
+ row_on_detect_bot[50] dac_config_0 dac_config_1 row_off_detect_bot[51] x3_net43
+ dac_config_2 vdda1 vssa1 vssc1 col_event_rst_bot_left[20] x3_net44 row_on_detect_bot[51]
+ row_off_detect_bot[50] openDVS_pixel2x2_bot
x3_x1878 dac_config_3 dac_config_5 col_event_rst_bot_left[19] dac_config_4
+ row_on_detect_bot[50] dac_config_0 dac_config_1 row_off_detect_bot[51] x3_net45
+ dac_config_2 vdda1 vssa1 vssc1 col_event_rst_bot_left[18] x3_net46 row_on_detect_bot[51]
+ row_off_detect_bot[50] openDVS_pixel2x2_bot
x3_x1879 dac_config_3 dac_config_5 col_event_rst_bot_left[17] dac_config_4
+ row_on_detect_bot[50] dac_config_0 dac_config_1 row_off_detect_bot[51] x3_net47
+ dac_config_2 vdda1 vssa1 vssc1 col_event_rst_bot_left[16] x3_net48 row_on_detect_bot[51]
+ row_off_detect_bot[50] openDVS_pixel2x2_bot
x3_x1880 dac_config_3 dac_config_5 col_event_rst_bot_left[15] dac_config_4
+ row_on_detect_bot[50] dac_config_0 dac_config_1 row_off_detect_bot[51] x3_net49
+ dac_config_2 vdda1 vssa1 vssc1 col_event_rst_bot_left[14] x3_net50 row_on_detect_bot[51]
+ row_off_detect_bot[50] openDVS_pixel2x2_bot
x3_x1881 dac_config_3 dac_config_5 col_event_rst_bot_left[13] dac_config_4
+ row_on_detect_bot[50] dac_config_0 dac_config_1 row_off_detect_bot[51] x3_net51
+ dac_config_2 vdda1 vssa1 vssc1 col_event_rst_bot_left[12] x3_net52 row_on_detect_bot[51]
+ row_off_detect_bot[50] openDVS_pixel2x2_bot
x3_x1882 dac_config_3 dac_config_5 col_event_rst_bot_left[11] dac_config_4
+ row_on_detect_bot[50] dac_config_0 dac_config_1 row_off_detect_bot[51] x3_net53
+ dac_config_2 vdda1 vssa1 vssc1 col_event_rst_bot_left[10] x3_net54 row_on_detect_bot[51]
+ row_off_detect_bot[50] openDVS_pixel2x2_bot
x3_x1883 dac_config_3 dac_config_5 col_event_rst_bot_left[9] dac_config_4
+ row_on_detect_bot[50] dac_config_0 dac_config_1 row_off_detect_bot[51] x3_net55
+ dac_config_2 vdda1 vssa1 vssc1 col_event_rst_bot_left[8] x3_net56 row_on_detect_bot[51]
+ row_off_detect_bot[50] openDVS_pixel2x2_bot
x3_x1884 dac_config_3 dac_config_5 col_event_rst_bot_left[7] dac_config_4
+ row_on_detect_bot[50] dac_config_0 dac_config_1 row_off_detect_bot[51] x3_net57
+ dac_config_2 vdda1 vssa1 vssc1 col_event_rst_bot_left[6] x3_net58 row_on_detect_bot[51]
+ row_off_detect_bot[50] openDVS_pixel2x2_bot
x3_x1885 dac_config_3 dac_config_5 col_event_rst_bot_left[5] dac_config_4
+ row_on_detect_bot[50] dac_config_0 dac_config_1 row_off_detect_bot[51] x3_net59
+ dac_config_2 vdda1 vssa1 vssc1 col_event_rst_bot_left[4] x3_net60 row_on_detect_bot[51]
+ row_off_detect_bot[50] openDVS_pixel2x2_bot
x3_x1886 dac_config_3 dac_config_5 col_event_rst_bot_left[3] dac_config_4
+ row_on_detect_bot[50] dac_config_0 dac_config_1 row_off_detect_bot[51] x3_net61
+ dac_config_2 vdda1 vssa1 vssc1 col_event_rst_bot_left[2] x3_net62 row_on_detect_bot[51]
+ row_off_detect_bot[50] openDVS_pixel2x2_bot
x3_x1887 dac_config_3 dac_config_5 col_event_rst_bot_left[1] dac_config_4
+ row_on_detect_bot[50] dac_config_0 dac_config_1 row_off_detect_bot[51] x3_net63
+ dac_config_2 vdda1 vssa1 vssc1 col_event_rst_bot_left[0] x3_net64 row_on_detect_bot[51]
+ row_off_detect_bot[50] openDVS_pixel2x2_bot
x3_x1888 dac_config_3 dac_config_5 col_event_rst_bot_left[63] dac_config_4
+ row_on_detect_bot[52] dac_config_0 dac_config_1 row_off_detect_bot[53] x3_net1
+ dac_config_2 vdda1 vssa1 vssc1 col_event_rst_bot_left[62] x3_net2 row_on_detect_bot[53]
+ row_off_detect_bot[52] openDVS_pixel2x2_bot
x3_x1889 dac_config_3 dac_config_5 col_event_rst_bot_left[61] dac_config_4
+ row_on_detect_bot[52] dac_config_0 dac_config_1 row_off_detect_bot[53] x3_net3
+ dac_config_2 vdda1 vssa1 vssc1 col_event_rst_bot_left[60] x3_net4 row_on_detect_bot[53]
+ row_off_detect_bot[52] openDVS_pixel2x2_bot
x3_x1890 dac_config_3 dac_config_5 col_event_rst_bot_left[59] dac_config_4
+ row_on_detect_bot[52] dac_config_0 dac_config_1 row_off_detect_bot[53] x3_net5
+ dac_config_2 vdda1 vssa1 vssc1 col_event_rst_bot_left[58] x3_net6 row_on_detect_bot[53]
+ row_off_detect_bot[52] openDVS_pixel2x2_bot
x3_x1891 dac_config_3 dac_config_5 col_event_rst_bot_left[57] dac_config_4
+ row_on_detect_bot[52] dac_config_0 dac_config_1 row_off_detect_bot[53] x3_net7
+ dac_config_2 vdda1 vssa1 vssc1 col_event_rst_bot_left[56] x3_net8 row_on_detect_bot[53]
+ row_off_detect_bot[52] openDVS_pixel2x2_bot
x3_x1892 dac_config_3 dac_config_5 col_event_rst_bot_left[55] dac_config_4
+ row_on_detect_bot[52] dac_config_0 dac_config_1 row_off_detect_bot[53] x3_net9
+ dac_config_2 vdda1 vssa1 vssc1 col_event_rst_bot_left[54] x3_net10 row_on_detect_bot[53]
+ row_off_detect_bot[52] openDVS_pixel2x2_bot
x3_x1893 dac_config_3 dac_config_5 col_event_rst_bot_left[53] dac_config_4
+ row_on_detect_bot[52] dac_config_0 dac_config_1 row_off_detect_bot[53] x3_net11
+ dac_config_2 vdda1 vssa1 vssc1 col_event_rst_bot_left[52] x3_net12 row_on_detect_bot[53]
+ row_off_detect_bot[52] openDVS_pixel2x2_bot
x3_x1894 dac_config_3 dac_config_5 col_event_rst_bot_left[51] dac_config_4
+ row_on_detect_bot[52] dac_config_0 dac_config_1 row_off_detect_bot[53] x3_net13
+ dac_config_2 vdda1 vssa1 vssc1 col_event_rst_bot_left[50] x3_net14 row_on_detect_bot[53]
+ row_off_detect_bot[52] openDVS_pixel2x2_bot
x3_x1895 dac_config_3 dac_config_5 col_event_rst_bot_left[49] dac_config_4
+ row_on_detect_bot[52] dac_config_0 dac_config_1 row_off_detect_bot[53] x3_net15
+ dac_config_2 vdda1 vssa1 vssc1 col_event_rst_bot_left[48] x3_net16 row_on_detect_bot[53]
+ row_off_detect_bot[52] openDVS_pixel2x2_bot
x3_x1896 dac_config_3 dac_config_5 col_event_rst_bot_left[47] dac_config_4
+ row_on_detect_bot[52] dac_config_0 dac_config_1 row_off_detect_bot[53] x3_net17
+ dac_config_2 vdda1 vssa1 vssc1 col_event_rst_bot_left[46] x3_net18 row_on_detect_bot[53]
+ row_off_detect_bot[52] openDVS_pixel2x2_bot
x3_x1897 dac_config_3 dac_config_5 col_event_rst_bot_left[45] dac_config_4
+ row_on_detect_bot[52] dac_config_0 dac_config_1 row_off_detect_bot[53] x3_net19
+ dac_config_2 vdda1 vssa1 vssc1 col_event_rst_bot_left[44] x3_net20 row_on_detect_bot[53]
+ row_off_detect_bot[52] openDVS_pixel2x2_bot
x3_x1898 dac_config_3 dac_config_5 col_event_rst_bot_left[43] dac_config_4
+ row_on_detect_bot[52] dac_config_0 dac_config_1 row_off_detect_bot[53] x3_net21
+ dac_config_2 vdda1 vssa1 vssc1 col_event_rst_bot_left[42] x3_net22 row_on_detect_bot[53]
+ row_off_detect_bot[52] openDVS_pixel2x2_bot
x3_x1899 dac_config_3 dac_config_5 col_event_rst_bot_left[41] dac_config_4
+ row_on_detect_bot[52] dac_config_0 dac_config_1 row_off_detect_bot[53] x3_net23
+ dac_config_2 vdda1 vssa1 vssc1 col_event_rst_bot_left[40] x3_net24 row_on_detect_bot[53]
+ row_off_detect_bot[52] openDVS_pixel2x2_bot
x3_x1900 dac_config_3 dac_config_5 col_event_rst_bot_left[39] dac_config_4
+ row_on_detect_bot[52] dac_config_0 dac_config_1 row_off_detect_bot[53] x3_net25
+ dac_config_2 vdda1 vssa1 vssc1 col_event_rst_bot_left[38] x3_net26 row_on_detect_bot[53]
+ row_off_detect_bot[52] openDVS_pixel2x2_bot
x3_x1901 dac_config_3 dac_config_5 col_event_rst_bot_left[37] dac_config_4
+ row_on_detect_bot[52] dac_config_0 dac_config_1 row_off_detect_bot[53] x3_net27
+ dac_config_2 vdda1 vssa1 vssc1 col_event_rst_bot_left[36] x3_net28 row_on_detect_bot[53]
+ row_off_detect_bot[52] openDVS_pixel2x2_bot
x3_x1902 dac_config_3 dac_config_5 col_event_rst_bot_left[35] dac_config_4
+ row_on_detect_bot[52] dac_config_0 dac_config_1 row_off_detect_bot[53] x3_net29
+ dac_config_2 vdda1 vssa1 vssc1 col_event_rst_bot_left[34] x3_net30 row_on_detect_bot[53]
+ row_off_detect_bot[52] openDVS_pixel2x2_bot
x3_x1903 dac_config_3 dac_config_5 col_event_rst_bot_left[33] dac_config_4
+ row_on_detect_bot[52] dac_config_0 dac_config_1 row_off_detect_bot[53] x3_net31
+ dac_config_2 vdda1 vssa1 vssc1 col_event_rst_bot_left[32] x3_net32 row_on_detect_bot[53]
+ row_off_detect_bot[52] openDVS_pixel2x2_bot
x3_x1904 dac_config_3 dac_config_5 col_event_rst_bot_left[31] dac_config_4
+ row_on_detect_bot[52] dac_config_0 dac_config_1 row_off_detect_bot[53] x3_net33
+ dac_config_2 vdda1 vssa1 vssc1 col_event_rst_bot_left[30] x3_net34 row_on_detect_bot[53]
+ row_off_detect_bot[52] openDVS_pixel2x2_bot
x3_x1905 dac_config_3 dac_config_5 col_event_rst_bot_left[29] dac_config_4
+ row_on_detect_bot[52] dac_config_0 dac_config_1 row_off_detect_bot[53] x3_net35
+ dac_config_2 vdda1 vssa1 vssc1 col_event_rst_bot_left[28] x3_net36 row_on_detect_bot[53]
+ row_off_detect_bot[52] openDVS_pixel2x2_bot
x3_x1906 dac_config_3 dac_config_5 col_event_rst_bot_left[27] dac_config_4
+ row_on_detect_bot[52] dac_config_0 dac_config_1 row_off_detect_bot[53] x3_net37
+ dac_config_2 vdda1 vssa1 vssc1 col_event_rst_bot_left[26] x3_net38 row_on_detect_bot[53]
+ row_off_detect_bot[52] openDVS_pixel2x2_bot
x3_x1907 dac_config_3 dac_config_5 col_event_rst_bot_left[25] dac_config_4
+ row_on_detect_bot[52] dac_config_0 dac_config_1 row_off_detect_bot[53] x3_net39
+ dac_config_2 vdda1 vssa1 vssc1 col_event_rst_bot_left[24] x3_net40 row_on_detect_bot[53]
+ row_off_detect_bot[52] openDVS_pixel2x2_bot
x3_x1908 dac_config_3 dac_config_5 col_event_rst_bot_left[23] dac_config_4
+ row_on_detect_bot[52] dac_config_0 dac_config_1 row_off_detect_bot[53] x3_net41
+ dac_config_2 vdda1 vssa1 vssc1 col_event_rst_bot_left[22] x3_net42 row_on_detect_bot[53]
+ row_off_detect_bot[52] openDVS_pixel2x2_bot
x3_x1909 dac_config_3 dac_config_5 col_event_rst_bot_left[21] dac_config_4
+ row_on_detect_bot[52] dac_config_0 dac_config_1 row_off_detect_bot[53] x3_net43
+ dac_config_2 vdda1 vssa1 vssc1 col_event_rst_bot_left[20] x3_net44 row_on_detect_bot[53]
+ row_off_detect_bot[52] openDVS_pixel2x2_bot
x3_x1910 dac_config_3 dac_config_5 col_event_rst_bot_left[19] dac_config_4
+ row_on_detect_bot[52] dac_config_0 dac_config_1 row_off_detect_bot[53] x3_net45
+ dac_config_2 vdda1 vssa1 vssc1 col_event_rst_bot_left[18] x3_net46 row_on_detect_bot[53]
+ row_off_detect_bot[52] openDVS_pixel2x2_bot
x3_x1911 dac_config_3 dac_config_5 col_event_rst_bot_left[17] dac_config_4
+ row_on_detect_bot[52] dac_config_0 dac_config_1 row_off_detect_bot[53] x3_net47
+ dac_config_2 vdda1 vssa1 vssc1 col_event_rst_bot_left[16] x3_net48 row_on_detect_bot[53]
+ row_off_detect_bot[52] openDVS_pixel2x2_bot
x3_x1912 dac_config_3 dac_config_5 col_event_rst_bot_left[15] dac_config_4
+ row_on_detect_bot[52] dac_config_0 dac_config_1 row_off_detect_bot[53] x3_net49
+ dac_config_2 vdda1 vssa1 vssc1 col_event_rst_bot_left[14] x3_net50 row_on_detect_bot[53]
+ row_off_detect_bot[52] openDVS_pixel2x2_bot
x3_x1913 dac_config_3 dac_config_5 col_event_rst_bot_left[13] dac_config_4
+ row_on_detect_bot[52] dac_config_0 dac_config_1 row_off_detect_bot[53] x3_net51
+ dac_config_2 vdda1 vssa1 vssc1 col_event_rst_bot_left[12] x3_net52 row_on_detect_bot[53]
+ row_off_detect_bot[52] openDVS_pixel2x2_bot
x3_x1914 dac_config_3 dac_config_5 col_event_rst_bot_left[11] dac_config_4
+ row_on_detect_bot[52] dac_config_0 dac_config_1 row_off_detect_bot[53] x3_net53
+ dac_config_2 vdda1 vssa1 vssc1 col_event_rst_bot_left[10] x3_net54 row_on_detect_bot[53]
+ row_off_detect_bot[52] openDVS_pixel2x2_bot
x3_x1915 dac_config_3 dac_config_5 col_event_rst_bot_left[9] dac_config_4
+ row_on_detect_bot[52] dac_config_0 dac_config_1 row_off_detect_bot[53] x3_net55
+ dac_config_2 vdda1 vssa1 vssc1 col_event_rst_bot_left[8] x3_net56 row_on_detect_bot[53]
+ row_off_detect_bot[52] openDVS_pixel2x2_bot
x3_x1916 dac_config_3 dac_config_5 col_event_rst_bot_left[7] dac_config_4
+ row_on_detect_bot[52] dac_config_0 dac_config_1 row_off_detect_bot[53] x3_net57
+ dac_config_2 vdda1 vssa1 vssc1 col_event_rst_bot_left[6] x3_net58 row_on_detect_bot[53]
+ row_off_detect_bot[52] openDVS_pixel2x2_bot
x3_x1917 dac_config_3 dac_config_5 col_event_rst_bot_left[5] dac_config_4
+ row_on_detect_bot[52] dac_config_0 dac_config_1 row_off_detect_bot[53] x3_net59
+ dac_config_2 vdda1 vssa1 vssc1 col_event_rst_bot_left[4] x3_net60 row_on_detect_bot[53]
+ row_off_detect_bot[52] openDVS_pixel2x2_bot
x3_x1918 dac_config_3 dac_config_5 col_event_rst_bot_left[3] dac_config_4
+ row_on_detect_bot[52] dac_config_0 dac_config_1 row_off_detect_bot[53] x3_net61
+ dac_config_2 vdda1 vssa1 vssc1 col_event_rst_bot_left[2] x3_net62 row_on_detect_bot[53]
+ row_off_detect_bot[52] openDVS_pixel2x2_bot
x3_x1919 dac_config_3 dac_config_5 col_event_rst_bot_left[1] dac_config_4
+ row_on_detect_bot[52] dac_config_0 dac_config_1 row_off_detect_bot[53] x3_net63
+ dac_config_2 vdda1 vssa1 vssc1 col_event_rst_bot_left[0] x3_net64 row_on_detect_bot[53]
+ row_off_detect_bot[52] openDVS_pixel2x2_bot
x3_x1920 dac_config_3 dac_config_5 col_event_rst_bot_left[63] dac_config_4
+ row_on_detect_bot[54] dac_config_0 dac_config_1 row_off_detect_bot[55] x3_net1
+ dac_config_2 vdda1 vssa1 vssc1 col_event_rst_bot_left[62] x3_net2 row_on_detect_bot[55]
+ row_off_detect_bot[54] openDVS_pixel2x2_bot
x3_x1921 dac_config_3 dac_config_5 col_event_rst_bot_left[61] dac_config_4
+ row_on_detect_bot[54] dac_config_0 dac_config_1 row_off_detect_bot[55] x3_net3
+ dac_config_2 vdda1 vssa1 vssc1 col_event_rst_bot_left[60] x3_net4 row_on_detect_bot[55]
+ row_off_detect_bot[54] openDVS_pixel2x2_bot
x3_x1922 dac_config_3 dac_config_5 col_event_rst_bot_left[59] dac_config_4
+ row_on_detect_bot[54] dac_config_0 dac_config_1 row_off_detect_bot[55] x3_net5
+ dac_config_2 vdda1 vssa1 vssc1 col_event_rst_bot_left[58] x3_net6 row_on_detect_bot[55]
+ row_off_detect_bot[54] openDVS_pixel2x2_bot
x3_x1923 dac_config_3 dac_config_5 col_event_rst_bot_left[57] dac_config_4
+ row_on_detect_bot[54] dac_config_0 dac_config_1 row_off_detect_bot[55] x3_net7
+ dac_config_2 vdda1 vssa1 vssc1 col_event_rst_bot_left[56] x3_net8 row_on_detect_bot[55]
+ row_off_detect_bot[54] openDVS_pixel2x2_bot
x3_x1924 dac_config_3 dac_config_5 col_event_rst_bot_left[55] dac_config_4
+ row_on_detect_bot[54] dac_config_0 dac_config_1 row_off_detect_bot[55] x3_net9
+ dac_config_2 vdda1 vssa1 vssc1 col_event_rst_bot_left[54] x3_net10 row_on_detect_bot[55]
+ row_off_detect_bot[54] openDVS_pixel2x2_bot
x3_x1925 dac_config_3 dac_config_5 col_event_rst_bot_left[53] dac_config_4
+ row_on_detect_bot[54] dac_config_0 dac_config_1 row_off_detect_bot[55] x3_net11
+ dac_config_2 vdda1 vssa1 vssc1 col_event_rst_bot_left[52] x3_net12 row_on_detect_bot[55]
+ row_off_detect_bot[54] openDVS_pixel2x2_bot
x3_x1926 dac_config_3 dac_config_5 col_event_rst_bot_left[51] dac_config_4
+ row_on_detect_bot[54] dac_config_0 dac_config_1 row_off_detect_bot[55] x3_net13
+ dac_config_2 vdda1 vssa1 vssc1 col_event_rst_bot_left[50] x3_net14 row_on_detect_bot[55]
+ row_off_detect_bot[54] openDVS_pixel2x2_bot
x3_x1927 dac_config_3 dac_config_5 col_event_rst_bot_left[49] dac_config_4
+ row_on_detect_bot[54] dac_config_0 dac_config_1 row_off_detect_bot[55] x3_net15
+ dac_config_2 vdda1 vssa1 vssc1 col_event_rst_bot_left[48] x3_net16 row_on_detect_bot[55]
+ row_off_detect_bot[54] openDVS_pixel2x2_bot
x3_x1928 dac_config_3 dac_config_5 col_event_rst_bot_left[47] dac_config_4
+ row_on_detect_bot[54] dac_config_0 dac_config_1 row_off_detect_bot[55] x3_net17
+ dac_config_2 vdda1 vssa1 vssc1 col_event_rst_bot_left[46] x3_net18 row_on_detect_bot[55]
+ row_off_detect_bot[54] openDVS_pixel2x2_bot
x3_x1929 dac_config_3 dac_config_5 col_event_rst_bot_left[45] dac_config_4
+ row_on_detect_bot[54] dac_config_0 dac_config_1 row_off_detect_bot[55] x3_net19
+ dac_config_2 vdda1 vssa1 vssc1 col_event_rst_bot_left[44] x3_net20 row_on_detect_bot[55]
+ row_off_detect_bot[54] openDVS_pixel2x2_bot
x3_x1930 dac_config_3 dac_config_5 col_event_rst_bot_left[43] dac_config_4
+ row_on_detect_bot[54] dac_config_0 dac_config_1 row_off_detect_bot[55] x3_net21
+ dac_config_2 vdda1 vssa1 vssc1 col_event_rst_bot_left[42] x3_net22 row_on_detect_bot[55]
+ row_off_detect_bot[54] openDVS_pixel2x2_bot
x3_x1931 dac_config_3 dac_config_5 col_event_rst_bot_left[41] dac_config_4
+ row_on_detect_bot[54] dac_config_0 dac_config_1 row_off_detect_bot[55] x3_net23
+ dac_config_2 vdda1 vssa1 vssc1 col_event_rst_bot_left[40] x3_net24 row_on_detect_bot[55]
+ row_off_detect_bot[54] openDVS_pixel2x2_bot
x3_x1932 dac_config_3 dac_config_5 col_event_rst_bot_left[39] dac_config_4
+ row_on_detect_bot[54] dac_config_0 dac_config_1 row_off_detect_bot[55] x3_net25
+ dac_config_2 vdda1 vssa1 vssc1 col_event_rst_bot_left[38] x3_net26 row_on_detect_bot[55]
+ row_off_detect_bot[54] openDVS_pixel2x2_bot
x3_x1933 dac_config_3 dac_config_5 col_event_rst_bot_left[37] dac_config_4
+ row_on_detect_bot[54] dac_config_0 dac_config_1 row_off_detect_bot[55] x3_net27
+ dac_config_2 vdda1 vssa1 vssc1 col_event_rst_bot_left[36] x3_net28 row_on_detect_bot[55]
+ row_off_detect_bot[54] openDVS_pixel2x2_bot
x3_x1934 dac_config_3 dac_config_5 col_event_rst_bot_left[35] dac_config_4
+ row_on_detect_bot[54] dac_config_0 dac_config_1 row_off_detect_bot[55] x3_net29
+ dac_config_2 vdda1 vssa1 vssc1 col_event_rst_bot_left[34] x3_net30 row_on_detect_bot[55]
+ row_off_detect_bot[54] openDVS_pixel2x2_bot
x3_x1935 dac_config_3 dac_config_5 col_event_rst_bot_left[33] dac_config_4
+ row_on_detect_bot[54] dac_config_0 dac_config_1 row_off_detect_bot[55] x3_net31
+ dac_config_2 vdda1 vssa1 vssc1 col_event_rst_bot_left[32] x3_net32 row_on_detect_bot[55]
+ row_off_detect_bot[54] openDVS_pixel2x2_bot
x3_x1936 dac_config_3 dac_config_5 col_event_rst_bot_left[31] dac_config_4
+ row_on_detect_bot[54] dac_config_0 dac_config_1 row_off_detect_bot[55] x3_net33
+ dac_config_2 vdda1 vssa1 vssc1 col_event_rst_bot_left[30] x3_net34 row_on_detect_bot[55]
+ row_off_detect_bot[54] openDVS_pixel2x2_bot
x3_x1937 dac_config_3 dac_config_5 col_event_rst_bot_left[29] dac_config_4
+ row_on_detect_bot[54] dac_config_0 dac_config_1 row_off_detect_bot[55] x3_net35
+ dac_config_2 vdda1 vssa1 vssc1 col_event_rst_bot_left[28] x3_net36 row_on_detect_bot[55]
+ row_off_detect_bot[54] openDVS_pixel2x2_bot
x3_x1938 dac_config_3 dac_config_5 col_event_rst_bot_left[27] dac_config_4
+ row_on_detect_bot[54] dac_config_0 dac_config_1 row_off_detect_bot[55] x3_net37
+ dac_config_2 vdda1 vssa1 vssc1 col_event_rst_bot_left[26] x3_net38 row_on_detect_bot[55]
+ row_off_detect_bot[54] openDVS_pixel2x2_bot
x3_x1939 dac_config_3 dac_config_5 col_event_rst_bot_left[25] dac_config_4
+ row_on_detect_bot[54] dac_config_0 dac_config_1 row_off_detect_bot[55] x3_net39
+ dac_config_2 vdda1 vssa1 vssc1 col_event_rst_bot_left[24] x3_net40 row_on_detect_bot[55]
+ row_off_detect_bot[54] openDVS_pixel2x2_bot
x3_x1940 dac_config_3 dac_config_5 col_event_rst_bot_left[23] dac_config_4
+ row_on_detect_bot[54] dac_config_0 dac_config_1 row_off_detect_bot[55] x3_net41
+ dac_config_2 vdda1 vssa1 vssc1 col_event_rst_bot_left[22] x3_net42 row_on_detect_bot[55]
+ row_off_detect_bot[54] openDVS_pixel2x2_bot
x3_x1941 dac_config_3 dac_config_5 col_event_rst_bot_left[21] dac_config_4
+ row_on_detect_bot[54] dac_config_0 dac_config_1 row_off_detect_bot[55] x3_net43
+ dac_config_2 vdda1 vssa1 vssc1 col_event_rst_bot_left[20] x3_net44 row_on_detect_bot[55]
+ row_off_detect_bot[54] openDVS_pixel2x2_bot
x3_x1942 dac_config_3 dac_config_5 col_event_rst_bot_left[19] dac_config_4
+ row_on_detect_bot[54] dac_config_0 dac_config_1 row_off_detect_bot[55] x3_net45
+ dac_config_2 vdda1 vssa1 vssc1 col_event_rst_bot_left[18] x3_net46 row_on_detect_bot[55]
+ row_off_detect_bot[54] openDVS_pixel2x2_bot
x3_x1943 dac_config_3 dac_config_5 col_event_rst_bot_left[17] dac_config_4
+ row_on_detect_bot[54] dac_config_0 dac_config_1 row_off_detect_bot[55] x3_net47
+ dac_config_2 vdda1 vssa1 vssc1 col_event_rst_bot_left[16] x3_net48 row_on_detect_bot[55]
+ row_off_detect_bot[54] openDVS_pixel2x2_bot
x3_x1944 dac_config_3 dac_config_5 col_event_rst_bot_left[15] dac_config_4
+ row_on_detect_bot[54] dac_config_0 dac_config_1 row_off_detect_bot[55] x3_net49
+ dac_config_2 vdda1 vssa1 vssc1 col_event_rst_bot_left[14] x3_net50 row_on_detect_bot[55]
+ row_off_detect_bot[54] openDVS_pixel2x2_bot
x3_x1945 dac_config_3 dac_config_5 col_event_rst_bot_left[13] dac_config_4
+ row_on_detect_bot[54] dac_config_0 dac_config_1 row_off_detect_bot[55] x3_net51
+ dac_config_2 vdda1 vssa1 vssc1 col_event_rst_bot_left[12] x3_net52 row_on_detect_bot[55]
+ row_off_detect_bot[54] openDVS_pixel2x2_bot
x3_x1946 dac_config_3 dac_config_5 col_event_rst_bot_left[11] dac_config_4
+ row_on_detect_bot[54] dac_config_0 dac_config_1 row_off_detect_bot[55] x3_net53
+ dac_config_2 vdda1 vssa1 vssc1 col_event_rst_bot_left[10] x3_net54 row_on_detect_bot[55]
+ row_off_detect_bot[54] openDVS_pixel2x2_bot
x3_x1947 dac_config_3 dac_config_5 col_event_rst_bot_left[9] dac_config_4
+ row_on_detect_bot[54] dac_config_0 dac_config_1 row_off_detect_bot[55] x3_net55
+ dac_config_2 vdda1 vssa1 vssc1 col_event_rst_bot_left[8] x3_net56 row_on_detect_bot[55]
+ row_off_detect_bot[54] openDVS_pixel2x2_bot
x3_x1948 dac_config_3 dac_config_5 col_event_rst_bot_left[7] dac_config_4
+ row_on_detect_bot[54] dac_config_0 dac_config_1 row_off_detect_bot[55] x3_net57
+ dac_config_2 vdda1 vssa1 vssc1 col_event_rst_bot_left[6] x3_net58 row_on_detect_bot[55]
+ row_off_detect_bot[54] openDVS_pixel2x2_bot
x3_x1949 dac_config_3 dac_config_5 col_event_rst_bot_left[5] dac_config_4
+ row_on_detect_bot[54] dac_config_0 dac_config_1 row_off_detect_bot[55] x3_net59
+ dac_config_2 vdda1 vssa1 vssc1 col_event_rst_bot_left[4] x3_net60 row_on_detect_bot[55]
+ row_off_detect_bot[54] openDVS_pixel2x2_bot
x3_x1950 dac_config_3 dac_config_5 col_event_rst_bot_left[3] dac_config_4
+ row_on_detect_bot[54] dac_config_0 dac_config_1 row_off_detect_bot[55] x3_net61
+ dac_config_2 vdda1 vssa1 vssc1 col_event_rst_bot_left[2] x3_net62 row_on_detect_bot[55]
+ row_off_detect_bot[54] openDVS_pixel2x2_bot
x3_x1951 dac_config_3 dac_config_5 col_event_rst_bot_left[1] dac_config_4
+ row_on_detect_bot[54] dac_config_0 dac_config_1 row_off_detect_bot[55] x3_net63
+ dac_config_2 vdda1 vssa1 vssc1 col_event_rst_bot_left[0] x3_net64 row_on_detect_bot[55]
+ row_off_detect_bot[54] openDVS_pixel2x2_bot
x3_x1952 dac_config_3 dac_config_5 col_event_rst_bot_left[63] dac_config_4
+ row_on_detect_bot[56] dac_config_0 dac_config_1 row_off_detect_bot[57] x3_net1
+ dac_config_2 vdda1 vssa1 vssc1 col_event_rst_bot_left[62] x3_net2 row_on_detect_bot[57]
+ row_off_detect_bot[56] openDVS_pixel2x2_bot
x3_x1953 dac_config_3 dac_config_5 col_event_rst_bot_left[61] dac_config_4
+ row_on_detect_bot[56] dac_config_0 dac_config_1 row_off_detect_bot[57] x3_net3
+ dac_config_2 vdda1 vssa1 vssc1 col_event_rst_bot_left[60] x3_net4 row_on_detect_bot[57]
+ row_off_detect_bot[56] openDVS_pixel2x2_bot
x3_x1954 dac_config_3 dac_config_5 col_event_rst_bot_left[59] dac_config_4
+ row_on_detect_bot[56] dac_config_0 dac_config_1 row_off_detect_bot[57] x3_net5
+ dac_config_2 vdda1 vssa1 vssc1 col_event_rst_bot_left[58] x3_net6 row_on_detect_bot[57]
+ row_off_detect_bot[56] openDVS_pixel2x2_bot
x3_x1955 dac_config_3 dac_config_5 col_event_rst_bot_left[57] dac_config_4
+ row_on_detect_bot[56] dac_config_0 dac_config_1 row_off_detect_bot[57] x3_net7
+ dac_config_2 vdda1 vssa1 vssc1 col_event_rst_bot_left[56] x3_net8 row_on_detect_bot[57]
+ row_off_detect_bot[56] openDVS_pixel2x2_bot
x3_x1956 dac_config_3 dac_config_5 col_event_rst_bot_left[55] dac_config_4
+ row_on_detect_bot[56] dac_config_0 dac_config_1 row_off_detect_bot[57] x3_net9
+ dac_config_2 vdda1 vssa1 vssc1 col_event_rst_bot_left[54] x3_net10 row_on_detect_bot[57]
+ row_off_detect_bot[56] openDVS_pixel2x2_bot
x3_x1957 dac_config_3 dac_config_5 col_event_rst_bot_left[53] dac_config_4
+ row_on_detect_bot[56] dac_config_0 dac_config_1 row_off_detect_bot[57] x3_net11
+ dac_config_2 vdda1 vssa1 vssc1 col_event_rst_bot_left[52] x3_net12 row_on_detect_bot[57]
+ row_off_detect_bot[56] openDVS_pixel2x2_bot
x3_x1958 dac_config_3 dac_config_5 col_event_rst_bot_left[51] dac_config_4
+ row_on_detect_bot[56] dac_config_0 dac_config_1 row_off_detect_bot[57] x3_net13
+ dac_config_2 vdda1 vssa1 vssc1 col_event_rst_bot_left[50] x3_net14 row_on_detect_bot[57]
+ row_off_detect_bot[56] openDVS_pixel2x2_bot
x3_x1959 dac_config_3 dac_config_5 col_event_rst_bot_left[49] dac_config_4
+ row_on_detect_bot[56] dac_config_0 dac_config_1 row_off_detect_bot[57] x3_net15
+ dac_config_2 vdda1 vssa1 vssc1 col_event_rst_bot_left[48] x3_net16 row_on_detect_bot[57]
+ row_off_detect_bot[56] openDVS_pixel2x2_bot
x3_x1960 dac_config_3 dac_config_5 col_event_rst_bot_left[47] dac_config_4
+ row_on_detect_bot[56] dac_config_0 dac_config_1 row_off_detect_bot[57] x3_net17
+ dac_config_2 vdda1 vssa1 vssc1 col_event_rst_bot_left[46] x3_net18 row_on_detect_bot[57]
+ row_off_detect_bot[56] openDVS_pixel2x2_bot
x3_x1961 dac_config_3 dac_config_5 col_event_rst_bot_left[45] dac_config_4
+ row_on_detect_bot[56] dac_config_0 dac_config_1 row_off_detect_bot[57] x3_net19
+ dac_config_2 vdda1 vssa1 vssc1 col_event_rst_bot_left[44] x3_net20 row_on_detect_bot[57]
+ row_off_detect_bot[56] openDVS_pixel2x2_bot
x3_x1962 dac_config_3 dac_config_5 col_event_rst_bot_left[43] dac_config_4
+ row_on_detect_bot[56] dac_config_0 dac_config_1 row_off_detect_bot[57] x3_net21
+ dac_config_2 vdda1 vssa1 vssc1 col_event_rst_bot_left[42] x3_net22 row_on_detect_bot[57]
+ row_off_detect_bot[56] openDVS_pixel2x2_bot
x3_x1963 dac_config_3 dac_config_5 col_event_rst_bot_left[41] dac_config_4
+ row_on_detect_bot[56] dac_config_0 dac_config_1 row_off_detect_bot[57] x3_net23
+ dac_config_2 vdda1 vssa1 vssc1 col_event_rst_bot_left[40] x3_net24 row_on_detect_bot[57]
+ row_off_detect_bot[56] openDVS_pixel2x2_bot
x3_x1964 dac_config_3 dac_config_5 col_event_rst_bot_left[39] dac_config_4
+ row_on_detect_bot[56] dac_config_0 dac_config_1 row_off_detect_bot[57] x3_net25
+ dac_config_2 vdda1 vssa1 vssc1 col_event_rst_bot_left[38] x3_net26 row_on_detect_bot[57]
+ row_off_detect_bot[56] openDVS_pixel2x2_bot
x3_x1965 dac_config_3 dac_config_5 col_event_rst_bot_left[37] dac_config_4
+ row_on_detect_bot[56] dac_config_0 dac_config_1 row_off_detect_bot[57] x3_net27
+ dac_config_2 vdda1 vssa1 vssc1 col_event_rst_bot_left[36] x3_net28 row_on_detect_bot[57]
+ row_off_detect_bot[56] openDVS_pixel2x2_bot
x3_x1966 dac_config_3 dac_config_5 col_event_rst_bot_left[35] dac_config_4
+ row_on_detect_bot[56] dac_config_0 dac_config_1 row_off_detect_bot[57] x3_net29
+ dac_config_2 vdda1 vssa1 vssc1 col_event_rst_bot_left[34] x3_net30 row_on_detect_bot[57]
+ row_off_detect_bot[56] openDVS_pixel2x2_bot
x3_x1967 dac_config_3 dac_config_5 col_event_rst_bot_left[33] dac_config_4
+ row_on_detect_bot[56] dac_config_0 dac_config_1 row_off_detect_bot[57] x3_net31
+ dac_config_2 vdda1 vssa1 vssc1 col_event_rst_bot_left[32] x3_net32 row_on_detect_bot[57]
+ row_off_detect_bot[56] openDVS_pixel2x2_bot
x3_x1968 dac_config_3 dac_config_5 col_event_rst_bot_left[31] dac_config_4
+ row_on_detect_bot[56] dac_config_0 dac_config_1 row_off_detect_bot[57] x3_net33
+ dac_config_2 vdda1 vssa1 vssc1 col_event_rst_bot_left[30] x3_net34 row_on_detect_bot[57]
+ row_off_detect_bot[56] openDVS_pixel2x2_bot
x3_x1969 dac_config_3 dac_config_5 col_event_rst_bot_left[29] dac_config_4
+ row_on_detect_bot[56] dac_config_0 dac_config_1 row_off_detect_bot[57] x3_net35
+ dac_config_2 vdda1 vssa1 vssc1 col_event_rst_bot_left[28] x3_net36 row_on_detect_bot[57]
+ row_off_detect_bot[56] openDVS_pixel2x2_bot
x3_x1970 dac_config_3 dac_config_5 col_event_rst_bot_left[27] dac_config_4
+ row_on_detect_bot[56] dac_config_0 dac_config_1 row_off_detect_bot[57] x3_net37
+ dac_config_2 vdda1 vssa1 vssc1 col_event_rst_bot_left[26] x3_net38 row_on_detect_bot[57]
+ row_off_detect_bot[56] openDVS_pixel2x2_bot
x3_x1971 dac_config_3 dac_config_5 col_event_rst_bot_left[25] dac_config_4
+ row_on_detect_bot[56] dac_config_0 dac_config_1 row_off_detect_bot[57] x3_net39
+ dac_config_2 vdda1 vssa1 vssc1 col_event_rst_bot_left[24] x3_net40 row_on_detect_bot[57]
+ row_off_detect_bot[56] openDVS_pixel2x2_bot
x3_x1972 dac_config_3 dac_config_5 col_event_rst_bot_left[23] dac_config_4
+ row_on_detect_bot[56] dac_config_0 dac_config_1 row_off_detect_bot[57] x3_net41
+ dac_config_2 vdda1 vssa1 vssc1 col_event_rst_bot_left[22] x3_net42 row_on_detect_bot[57]
+ row_off_detect_bot[56] openDVS_pixel2x2_bot
x3_x1973 dac_config_3 dac_config_5 col_event_rst_bot_left[21] dac_config_4
+ row_on_detect_bot[56] dac_config_0 dac_config_1 row_off_detect_bot[57] x3_net43
+ dac_config_2 vdda1 vssa1 vssc1 col_event_rst_bot_left[20] x3_net44 row_on_detect_bot[57]
+ row_off_detect_bot[56] openDVS_pixel2x2_bot
x3_x1974 dac_config_3 dac_config_5 col_event_rst_bot_left[19] dac_config_4
+ row_on_detect_bot[56] dac_config_0 dac_config_1 row_off_detect_bot[57] x3_net45
+ dac_config_2 vdda1 vssa1 vssc1 col_event_rst_bot_left[18] x3_net46 row_on_detect_bot[57]
+ row_off_detect_bot[56] openDVS_pixel2x2_bot
x3_x1975 dac_config_3 dac_config_5 col_event_rst_bot_left[17] dac_config_4
+ row_on_detect_bot[56] dac_config_0 dac_config_1 row_off_detect_bot[57] x3_net47
+ dac_config_2 vdda1 vssa1 vssc1 col_event_rst_bot_left[16] x3_net48 row_on_detect_bot[57]
+ row_off_detect_bot[56] openDVS_pixel2x2_bot
x3_x1976 dac_config_3 dac_config_5 col_event_rst_bot_left[15] dac_config_4
+ row_on_detect_bot[56] dac_config_0 dac_config_1 row_off_detect_bot[57] x3_net49
+ dac_config_2 vdda1 vssa1 vssc1 col_event_rst_bot_left[14] x3_net50 row_on_detect_bot[57]
+ row_off_detect_bot[56] openDVS_pixel2x2_bot
x3_x1977 dac_config_3 dac_config_5 col_event_rst_bot_left[13] dac_config_4
+ row_on_detect_bot[56] dac_config_0 dac_config_1 row_off_detect_bot[57] x3_net51
+ dac_config_2 vdda1 vssa1 vssc1 col_event_rst_bot_left[12] x3_net52 row_on_detect_bot[57]
+ row_off_detect_bot[56] openDVS_pixel2x2_bot
x3_x1978 dac_config_3 dac_config_5 col_event_rst_bot_left[11] dac_config_4
+ row_on_detect_bot[56] dac_config_0 dac_config_1 row_off_detect_bot[57] x3_net53
+ dac_config_2 vdda1 vssa1 vssc1 col_event_rst_bot_left[10] x3_net54 row_on_detect_bot[57]
+ row_off_detect_bot[56] openDVS_pixel2x2_bot
x3_x1979 dac_config_3 dac_config_5 col_event_rst_bot_left[9] dac_config_4
+ row_on_detect_bot[56] dac_config_0 dac_config_1 row_off_detect_bot[57] x3_net55
+ dac_config_2 vdda1 vssa1 vssc1 col_event_rst_bot_left[8] x3_net56 row_on_detect_bot[57]
+ row_off_detect_bot[56] openDVS_pixel2x2_bot
x3_x1980 dac_config_3 dac_config_5 col_event_rst_bot_left[7] dac_config_4
+ row_on_detect_bot[56] dac_config_0 dac_config_1 row_off_detect_bot[57] x3_net57
+ dac_config_2 vdda1 vssa1 vssc1 col_event_rst_bot_left[6] x3_net58 row_on_detect_bot[57]
+ row_off_detect_bot[56] openDVS_pixel2x2_bot
x3_x1981 dac_config_3 dac_config_5 col_event_rst_bot_left[5] dac_config_4
+ row_on_detect_bot[56] dac_config_0 dac_config_1 row_off_detect_bot[57] x3_net59
+ dac_config_2 vdda1 vssa1 vssc1 col_event_rst_bot_left[4] x3_net60 row_on_detect_bot[57]
+ row_off_detect_bot[56] openDVS_pixel2x2_bot
x3_x1982 dac_config_3 dac_config_5 col_event_rst_bot_left[3] dac_config_4
+ row_on_detect_bot[56] dac_config_0 dac_config_1 row_off_detect_bot[57] x3_net61
+ dac_config_2 vdda1 vssa1 vssc1 col_event_rst_bot_left[2] x3_net62 row_on_detect_bot[57]
+ row_off_detect_bot[56] openDVS_pixel2x2_bot
x3_x1983 dac_config_3 dac_config_5 col_event_rst_bot_left[1] dac_config_4
+ row_on_detect_bot[56] dac_config_0 dac_config_1 row_off_detect_bot[57] x3_net63
+ dac_config_2 vdda1 vssa1 vssc1 col_event_rst_bot_left[0] x3_net64 row_on_detect_bot[57]
+ row_off_detect_bot[56] openDVS_pixel2x2_bot
x3_x1984 dac_config_3 dac_config_5 col_event_rst_bot_left[63] dac_config_4
+ row_on_detect_bot[58] dac_config_0 dac_config_1 row_off_detect_bot[59] x3_net1
+ dac_config_2 vdda1 vssa1 vssc1 col_event_rst_bot_left[62] x3_net2 row_on_detect_bot[59]
+ row_off_detect_bot[58] openDVS_pixel2x2_bot
x3_x1985 dac_config_3 dac_config_5 col_event_rst_bot_left[61] dac_config_4
+ row_on_detect_bot[58] dac_config_0 dac_config_1 row_off_detect_bot[59] x3_net3
+ dac_config_2 vdda1 vssa1 vssc1 col_event_rst_bot_left[60] x3_net4 row_on_detect_bot[59]
+ row_off_detect_bot[58] openDVS_pixel2x2_bot
x3_x1986 dac_config_3 dac_config_5 col_event_rst_bot_left[59] dac_config_4
+ row_on_detect_bot[58] dac_config_0 dac_config_1 row_off_detect_bot[59] x3_net5
+ dac_config_2 vdda1 vssa1 vssc1 col_event_rst_bot_left[58] x3_net6 row_on_detect_bot[59]
+ row_off_detect_bot[58] openDVS_pixel2x2_bot
x3_x1987 dac_config_3 dac_config_5 col_event_rst_bot_left[57] dac_config_4
+ row_on_detect_bot[58] dac_config_0 dac_config_1 row_off_detect_bot[59] x3_net7
+ dac_config_2 vdda1 vssa1 vssc1 col_event_rst_bot_left[56] x3_net8 row_on_detect_bot[59]
+ row_off_detect_bot[58] openDVS_pixel2x2_bot
x3_x1988 dac_config_3 dac_config_5 col_event_rst_bot_left[55] dac_config_4
+ row_on_detect_bot[58] dac_config_0 dac_config_1 row_off_detect_bot[59] x3_net9
+ dac_config_2 vdda1 vssa1 vssc1 col_event_rst_bot_left[54] x3_net10 row_on_detect_bot[59]
+ row_off_detect_bot[58] openDVS_pixel2x2_bot
x3_x1989 dac_config_3 dac_config_5 col_event_rst_bot_left[53] dac_config_4
+ row_on_detect_bot[58] dac_config_0 dac_config_1 row_off_detect_bot[59] x3_net11
+ dac_config_2 vdda1 vssa1 vssc1 col_event_rst_bot_left[52] x3_net12 row_on_detect_bot[59]
+ row_off_detect_bot[58] openDVS_pixel2x2_bot
x3_x1990 dac_config_3 dac_config_5 col_event_rst_bot_left[51] dac_config_4
+ row_on_detect_bot[58] dac_config_0 dac_config_1 row_off_detect_bot[59] x3_net13
+ dac_config_2 vdda1 vssa1 vssc1 col_event_rst_bot_left[50] x3_net14 row_on_detect_bot[59]
+ row_off_detect_bot[58] openDVS_pixel2x2_bot
x3_x1991 dac_config_3 dac_config_5 col_event_rst_bot_left[49] dac_config_4
+ row_on_detect_bot[58] dac_config_0 dac_config_1 row_off_detect_bot[59] x3_net15
+ dac_config_2 vdda1 vssa1 vssc1 col_event_rst_bot_left[48] x3_net16 row_on_detect_bot[59]
+ row_off_detect_bot[58] openDVS_pixel2x2_bot
x3_x1992 dac_config_3 dac_config_5 col_event_rst_bot_left[47] dac_config_4
+ row_on_detect_bot[58] dac_config_0 dac_config_1 row_off_detect_bot[59] x3_net17
+ dac_config_2 vdda1 vssa1 vssc1 col_event_rst_bot_left[46] x3_net18 row_on_detect_bot[59]
+ row_off_detect_bot[58] openDVS_pixel2x2_bot
x3_x1993 dac_config_3 dac_config_5 col_event_rst_bot_left[45] dac_config_4
+ row_on_detect_bot[58] dac_config_0 dac_config_1 row_off_detect_bot[59] x3_net19
+ dac_config_2 vdda1 vssa1 vssc1 col_event_rst_bot_left[44] x3_net20 row_on_detect_bot[59]
+ row_off_detect_bot[58] openDVS_pixel2x2_bot
x3_x1994 dac_config_3 dac_config_5 col_event_rst_bot_left[43] dac_config_4
+ row_on_detect_bot[58] dac_config_0 dac_config_1 row_off_detect_bot[59] x3_net21
+ dac_config_2 vdda1 vssa1 vssc1 col_event_rst_bot_left[42] x3_net22 row_on_detect_bot[59]
+ row_off_detect_bot[58] openDVS_pixel2x2_bot
x3_x1995 dac_config_3 dac_config_5 col_event_rst_bot_left[41] dac_config_4
+ row_on_detect_bot[58] dac_config_0 dac_config_1 row_off_detect_bot[59] x3_net23
+ dac_config_2 vdda1 vssa1 vssc1 col_event_rst_bot_left[40] x3_net24 row_on_detect_bot[59]
+ row_off_detect_bot[58] openDVS_pixel2x2_bot
x3_x1996 dac_config_3 dac_config_5 col_event_rst_bot_left[39] dac_config_4
+ row_on_detect_bot[58] dac_config_0 dac_config_1 row_off_detect_bot[59] x3_net25
+ dac_config_2 vdda1 vssa1 vssc1 col_event_rst_bot_left[38] x3_net26 row_on_detect_bot[59]
+ row_off_detect_bot[58] openDVS_pixel2x2_bot
x3_x1997 dac_config_3 dac_config_5 col_event_rst_bot_left[37] dac_config_4
+ row_on_detect_bot[58] dac_config_0 dac_config_1 row_off_detect_bot[59] x3_net27
+ dac_config_2 vdda1 vssa1 vssc1 col_event_rst_bot_left[36] x3_net28 row_on_detect_bot[59]
+ row_off_detect_bot[58] openDVS_pixel2x2_bot
x3_x1998 dac_config_3 dac_config_5 col_event_rst_bot_left[35] dac_config_4
+ row_on_detect_bot[58] dac_config_0 dac_config_1 row_off_detect_bot[59] x3_net29
+ dac_config_2 vdda1 vssa1 vssc1 col_event_rst_bot_left[34] x3_net30 row_on_detect_bot[59]
+ row_off_detect_bot[58] openDVS_pixel2x2_bot
x3_x1999 dac_config_3 dac_config_5 col_event_rst_bot_left[33] dac_config_4
+ row_on_detect_bot[58] dac_config_0 dac_config_1 row_off_detect_bot[59] x3_net31
+ dac_config_2 vdda1 vssa1 vssc1 col_event_rst_bot_left[32] x3_net32 row_on_detect_bot[59]
+ row_off_detect_bot[58] openDVS_pixel2x2_bot
x3_x2000 dac_config_3 dac_config_5 col_event_rst_bot_left[31] dac_config_4
+ row_on_detect_bot[58] dac_config_0 dac_config_1 row_off_detect_bot[59] x3_net33
+ dac_config_2 vdda1 vssa1 vssc1 col_event_rst_bot_left[30] x3_net34 row_on_detect_bot[59]
+ row_off_detect_bot[58] openDVS_pixel2x2_bot
x3_x2001 dac_config_3 dac_config_5 col_event_rst_bot_left[29] dac_config_4
+ row_on_detect_bot[58] dac_config_0 dac_config_1 row_off_detect_bot[59] x3_net35
+ dac_config_2 vdda1 vssa1 vssc1 col_event_rst_bot_left[28] x3_net36 row_on_detect_bot[59]
+ row_off_detect_bot[58] openDVS_pixel2x2_bot
x3_x2002 dac_config_3 dac_config_5 col_event_rst_bot_left[27] dac_config_4
+ row_on_detect_bot[58] dac_config_0 dac_config_1 row_off_detect_bot[59] x3_net37
+ dac_config_2 vdda1 vssa1 vssc1 col_event_rst_bot_left[26] x3_net38 row_on_detect_bot[59]
+ row_off_detect_bot[58] openDVS_pixel2x2_bot
x3_x2003 dac_config_3 dac_config_5 col_event_rst_bot_left[25] dac_config_4
+ row_on_detect_bot[58] dac_config_0 dac_config_1 row_off_detect_bot[59] x3_net39
+ dac_config_2 vdda1 vssa1 vssc1 col_event_rst_bot_left[24] x3_net40 row_on_detect_bot[59]
+ row_off_detect_bot[58] openDVS_pixel2x2_bot
x3_x2004 dac_config_3 dac_config_5 col_event_rst_bot_left[23] dac_config_4
+ row_on_detect_bot[58] dac_config_0 dac_config_1 row_off_detect_bot[59] x3_net41
+ dac_config_2 vdda1 vssa1 vssc1 col_event_rst_bot_left[22] x3_net42 row_on_detect_bot[59]
+ row_off_detect_bot[58] openDVS_pixel2x2_bot
x3_x2005 dac_config_3 dac_config_5 col_event_rst_bot_left[21] dac_config_4
+ row_on_detect_bot[58] dac_config_0 dac_config_1 row_off_detect_bot[59] x3_net43
+ dac_config_2 vdda1 vssa1 vssc1 col_event_rst_bot_left[20] x3_net44 row_on_detect_bot[59]
+ row_off_detect_bot[58] openDVS_pixel2x2_bot
x3_x2006 dac_config_3 dac_config_5 col_event_rst_bot_left[19] dac_config_4
+ row_on_detect_bot[58] dac_config_0 dac_config_1 row_off_detect_bot[59] x3_net45
+ dac_config_2 vdda1 vssa1 vssc1 col_event_rst_bot_left[18] x3_net46 row_on_detect_bot[59]
+ row_off_detect_bot[58] openDVS_pixel2x2_bot
x3_x2007 dac_config_3 dac_config_5 col_event_rst_bot_left[17] dac_config_4
+ row_on_detect_bot[58] dac_config_0 dac_config_1 row_off_detect_bot[59] x3_net47
+ dac_config_2 vdda1 vssa1 vssc1 col_event_rst_bot_left[16] x3_net48 row_on_detect_bot[59]
+ row_off_detect_bot[58] openDVS_pixel2x2_bot
x3_x2008 dac_config_3 dac_config_5 col_event_rst_bot_left[15] dac_config_4
+ row_on_detect_bot[58] dac_config_0 dac_config_1 row_off_detect_bot[59] x3_net49
+ dac_config_2 vdda1 vssa1 vssc1 col_event_rst_bot_left[14] x3_net50 row_on_detect_bot[59]
+ row_off_detect_bot[58] openDVS_pixel2x2_bot
x3_x2009 dac_config_3 dac_config_5 col_event_rst_bot_left[13] dac_config_4
+ row_on_detect_bot[58] dac_config_0 dac_config_1 row_off_detect_bot[59] x3_net51
+ dac_config_2 vdda1 vssa1 vssc1 col_event_rst_bot_left[12] x3_net52 row_on_detect_bot[59]
+ row_off_detect_bot[58] openDVS_pixel2x2_bot
x3_x2010 dac_config_3 dac_config_5 col_event_rst_bot_left[11] dac_config_4
+ row_on_detect_bot[58] dac_config_0 dac_config_1 row_off_detect_bot[59] x3_net53
+ dac_config_2 vdda1 vssa1 vssc1 col_event_rst_bot_left[10] x3_net54 row_on_detect_bot[59]
+ row_off_detect_bot[58] openDVS_pixel2x2_bot
x3_x2011 dac_config_3 dac_config_5 col_event_rst_bot_left[9] dac_config_4
+ row_on_detect_bot[58] dac_config_0 dac_config_1 row_off_detect_bot[59] x3_net55
+ dac_config_2 vdda1 vssa1 vssc1 col_event_rst_bot_left[8] x3_net56 row_on_detect_bot[59]
+ row_off_detect_bot[58] openDVS_pixel2x2_bot
x3_x2012 dac_config_3 dac_config_5 col_event_rst_bot_left[7] dac_config_4
+ row_on_detect_bot[58] dac_config_0 dac_config_1 row_off_detect_bot[59] x3_net57
+ dac_config_2 vdda1 vssa1 vssc1 col_event_rst_bot_left[6] x3_net58 row_on_detect_bot[59]
+ row_off_detect_bot[58] openDVS_pixel2x2_bot
x3_x2013 dac_config_3 dac_config_5 col_event_rst_bot_left[5] dac_config_4
+ row_on_detect_bot[58] dac_config_0 dac_config_1 row_off_detect_bot[59] x3_net59
+ dac_config_2 vdda1 vssa1 vssc1 col_event_rst_bot_left[4] x3_net60 row_on_detect_bot[59]
+ row_off_detect_bot[58] openDVS_pixel2x2_bot
x3_x2014 dac_config_3 dac_config_5 col_event_rst_bot_left[3] dac_config_4
+ row_on_detect_bot[58] dac_config_0 dac_config_1 row_off_detect_bot[59] x3_net61
+ dac_config_2 vdda1 vssa1 vssc1 col_event_rst_bot_left[2] x3_net62 row_on_detect_bot[59]
+ row_off_detect_bot[58] openDVS_pixel2x2_bot
x3_x2015 dac_config_3 dac_config_5 col_event_rst_bot_left[1] dac_config_4
+ row_on_detect_bot[58] dac_config_0 dac_config_1 row_off_detect_bot[59] x3_net63
+ dac_config_2 vdda1 vssa1 vssc1 col_event_rst_bot_left[0] x3_net64 row_on_detect_bot[59]
+ row_off_detect_bot[58] openDVS_pixel2x2_bot
x3_x2016 dac_config_3 dac_config_5 col_event_rst_bot_left[63] dac_config_4
+ row_on_detect_bot[60] dac_config_0 dac_config_1 row_off_detect_bot[61] x3_net1
+ dac_config_2 vdda1 vssa1 vssc1 col_event_rst_bot_left[62] x3_net2 row_on_detect_bot[61]
+ row_off_detect_bot[60] openDVS_pixel2x2_bot
x3_x2017 dac_config_3 dac_config_5 col_event_rst_bot_left[61] dac_config_4
+ row_on_detect_bot[60] dac_config_0 dac_config_1 row_off_detect_bot[61] x3_net3
+ dac_config_2 vdda1 vssa1 vssc1 col_event_rst_bot_left[60] x3_net4 row_on_detect_bot[61]
+ row_off_detect_bot[60] openDVS_pixel2x2_bot
x3_x2018 dac_config_3 dac_config_5 col_event_rst_bot_left[59] dac_config_4
+ row_on_detect_bot[60] dac_config_0 dac_config_1 row_off_detect_bot[61] x3_net5
+ dac_config_2 vdda1 vssa1 vssc1 col_event_rst_bot_left[58] x3_net6 row_on_detect_bot[61]
+ row_off_detect_bot[60] openDVS_pixel2x2_bot
x3_x2019 dac_config_3 dac_config_5 col_event_rst_bot_left[57] dac_config_4
+ row_on_detect_bot[60] dac_config_0 dac_config_1 row_off_detect_bot[61] x3_net7
+ dac_config_2 vdda1 vssa1 vssc1 col_event_rst_bot_left[56] x3_net8 row_on_detect_bot[61]
+ row_off_detect_bot[60] openDVS_pixel2x2_bot
x3_x2020 dac_config_3 dac_config_5 col_event_rst_bot_left[55] dac_config_4
+ row_on_detect_bot[60] dac_config_0 dac_config_1 row_off_detect_bot[61] x3_net9
+ dac_config_2 vdda1 vssa1 vssc1 col_event_rst_bot_left[54] x3_net10 row_on_detect_bot[61]
+ row_off_detect_bot[60] openDVS_pixel2x2_bot
x3_x2021 dac_config_3 dac_config_5 col_event_rst_bot_left[53] dac_config_4
+ row_on_detect_bot[60] dac_config_0 dac_config_1 row_off_detect_bot[61] x3_net11
+ dac_config_2 vdda1 vssa1 vssc1 col_event_rst_bot_left[52] x3_net12 row_on_detect_bot[61]
+ row_off_detect_bot[60] openDVS_pixel2x2_bot
x3_x2022 dac_config_3 dac_config_5 col_event_rst_bot_left[51] dac_config_4
+ row_on_detect_bot[60] dac_config_0 dac_config_1 row_off_detect_bot[61] x3_net13
+ dac_config_2 vdda1 vssa1 vssc1 col_event_rst_bot_left[50] x3_net14 row_on_detect_bot[61]
+ row_off_detect_bot[60] openDVS_pixel2x2_bot
x3_x2023 dac_config_3 dac_config_5 col_event_rst_bot_left[49] dac_config_4
+ row_on_detect_bot[60] dac_config_0 dac_config_1 row_off_detect_bot[61] x3_net15
+ dac_config_2 vdda1 vssa1 vssc1 col_event_rst_bot_left[48] x3_net16 row_on_detect_bot[61]
+ row_off_detect_bot[60] openDVS_pixel2x2_bot
x3_x2024 dac_config_3 dac_config_5 col_event_rst_bot_left[47] dac_config_4
+ row_on_detect_bot[60] dac_config_0 dac_config_1 row_off_detect_bot[61] x3_net17
+ dac_config_2 vdda1 vssa1 vssc1 col_event_rst_bot_left[46] x3_net18 row_on_detect_bot[61]
+ row_off_detect_bot[60] openDVS_pixel2x2_bot
x3_x2025 dac_config_3 dac_config_5 col_event_rst_bot_left[45] dac_config_4
+ row_on_detect_bot[60] dac_config_0 dac_config_1 row_off_detect_bot[61] x3_net19
+ dac_config_2 vdda1 vssa1 vssc1 col_event_rst_bot_left[44] x3_net20 row_on_detect_bot[61]
+ row_off_detect_bot[60] openDVS_pixel2x2_bot
x3_x2026 dac_config_3 dac_config_5 col_event_rst_bot_left[43] dac_config_4
+ row_on_detect_bot[60] dac_config_0 dac_config_1 row_off_detect_bot[61] x3_net21
+ dac_config_2 vdda1 vssa1 vssc1 col_event_rst_bot_left[42] x3_net22 row_on_detect_bot[61]
+ row_off_detect_bot[60] openDVS_pixel2x2_bot
x3_x2027 dac_config_3 dac_config_5 col_event_rst_bot_left[41] dac_config_4
+ row_on_detect_bot[60] dac_config_0 dac_config_1 row_off_detect_bot[61] x3_net23
+ dac_config_2 vdda1 vssa1 vssc1 col_event_rst_bot_left[40] x3_net24 row_on_detect_bot[61]
+ row_off_detect_bot[60] openDVS_pixel2x2_bot
x3_x2028 dac_config_3 dac_config_5 col_event_rst_bot_left[39] dac_config_4
+ row_on_detect_bot[60] dac_config_0 dac_config_1 row_off_detect_bot[61] x3_net25
+ dac_config_2 vdda1 vssa1 vssc1 col_event_rst_bot_left[38] x3_net26 row_on_detect_bot[61]
+ row_off_detect_bot[60] openDVS_pixel2x2_bot
x3_x2029 dac_config_3 dac_config_5 col_event_rst_bot_left[37] dac_config_4
+ row_on_detect_bot[60] dac_config_0 dac_config_1 row_off_detect_bot[61] x3_net27
+ dac_config_2 vdda1 vssa1 vssc1 col_event_rst_bot_left[36] x3_net28 row_on_detect_bot[61]
+ row_off_detect_bot[60] openDVS_pixel2x2_bot
x3_x2030 dac_config_3 dac_config_5 col_event_rst_bot_left[35] dac_config_4
+ row_on_detect_bot[60] dac_config_0 dac_config_1 row_off_detect_bot[61] x3_net29
+ dac_config_2 vdda1 vssa1 vssc1 col_event_rst_bot_left[34] x3_net30 row_on_detect_bot[61]
+ row_off_detect_bot[60] openDVS_pixel2x2_bot
x3_x2031 dac_config_3 dac_config_5 col_event_rst_bot_left[33] dac_config_4
+ row_on_detect_bot[60] dac_config_0 dac_config_1 row_off_detect_bot[61] x3_net31
+ dac_config_2 vdda1 vssa1 vssc1 col_event_rst_bot_left[32] x3_net32 row_on_detect_bot[61]
+ row_off_detect_bot[60] openDVS_pixel2x2_bot
x3_x2032 dac_config_3 dac_config_5 col_event_rst_bot_left[31] dac_config_4
+ row_on_detect_bot[60] dac_config_0 dac_config_1 row_off_detect_bot[61] x3_net33
+ dac_config_2 vdda1 vssa1 vssc1 col_event_rst_bot_left[30] x3_net34 row_on_detect_bot[61]
+ row_off_detect_bot[60] openDVS_pixel2x2_bot
x3_x2033 dac_config_3 dac_config_5 col_event_rst_bot_left[29] dac_config_4
+ row_on_detect_bot[60] dac_config_0 dac_config_1 row_off_detect_bot[61] x3_net35
+ dac_config_2 vdda1 vssa1 vssc1 col_event_rst_bot_left[28] x3_net36 row_on_detect_bot[61]
+ row_off_detect_bot[60] openDVS_pixel2x2_bot
x3_x2034 dac_config_3 dac_config_5 col_event_rst_bot_left[27] dac_config_4
+ row_on_detect_bot[60] dac_config_0 dac_config_1 row_off_detect_bot[61] x3_net37
+ dac_config_2 vdda1 vssa1 vssc1 col_event_rst_bot_left[26] x3_net38 row_on_detect_bot[61]
+ row_off_detect_bot[60] openDVS_pixel2x2_bot
x3_x2035 dac_config_3 dac_config_5 col_event_rst_bot_left[25] dac_config_4
+ row_on_detect_bot[60] dac_config_0 dac_config_1 row_off_detect_bot[61] x3_net39
+ dac_config_2 vdda1 vssa1 vssc1 col_event_rst_bot_left[24] x3_net40 row_on_detect_bot[61]
+ row_off_detect_bot[60] openDVS_pixel2x2_bot
x3_x2036 dac_config_3 dac_config_5 col_event_rst_bot_left[23] dac_config_4
+ row_on_detect_bot[60] dac_config_0 dac_config_1 row_off_detect_bot[61] x3_net41
+ dac_config_2 vdda1 vssa1 vssc1 col_event_rst_bot_left[22] x3_net42 row_on_detect_bot[61]
+ row_off_detect_bot[60] openDVS_pixel2x2_bot
x3_x2037 dac_config_3 dac_config_5 col_event_rst_bot_left[21] dac_config_4
+ row_on_detect_bot[60] dac_config_0 dac_config_1 row_off_detect_bot[61] x3_net43
+ dac_config_2 vdda1 vssa1 vssc1 col_event_rst_bot_left[20] x3_net44 row_on_detect_bot[61]
+ row_off_detect_bot[60] openDVS_pixel2x2_bot
x3_x2038 dac_config_3 dac_config_5 col_event_rst_bot_left[19] dac_config_4
+ row_on_detect_bot[60] dac_config_0 dac_config_1 row_off_detect_bot[61] x3_net45
+ dac_config_2 vdda1 vssa1 vssc1 col_event_rst_bot_left[18] x3_net46 row_on_detect_bot[61]
+ row_off_detect_bot[60] openDVS_pixel2x2_bot
x3_x2039 dac_config_3 dac_config_5 col_event_rst_bot_left[17] dac_config_4
+ row_on_detect_bot[60] dac_config_0 dac_config_1 row_off_detect_bot[61] x3_net47
+ dac_config_2 vdda1 vssa1 vssc1 col_event_rst_bot_left[16] x3_net48 row_on_detect_bot[61]
+ row_off_detect_bot[60] openDVS_pixel2x2_bot
x3_x2040 dac_config_3 dac_config_5 col_event_rst_bot_left[15] dac_config_4
+ row_on_detect_bot[60] dac_config_0 dac_config_1 row_off_detect_bot[61] x3_net49
+ dac_config_2 vdda1 vssa1 vssc1 col_event_rst_bot_left[14] x3_net50 row_on_detect_bot[61]
+ row_off_detect_bot[60] openDVS_pixel2x2_bot
x3_x2041 dac_config_3 dac_config_5 col_event_rst_bot_left[13] dac_config_4
+ row_on_detect_bot[60] dac_config_0 dac_config_1 row_off_detect_bot[61] x3_net51
+ dac_config_2 vdda1 vssa1 vssc1 col_event_rst_bot_left[12] x3_net52 row_on_detect_bot[61]
+ row_off_detect_bot[60] openDVS_pixel2x2_bot
x3_x2042 dac_config_3 dac_config_5 col_event_rst_bot_left[11] dac_config_4
+ row_on_detect_bot[60] dac_config_0 dac_config_1 row_off_detect_bot[61] x3_net53
+ dac_config_2 vdda1 vssa1 vssc1 col_event_rst_bot_left[10] x3_net54 row_on_detect_bot[61]
+ row_off_detect_bot[60] openDVS_pixel2x2_bot
x3_x2043 dac_config_3 dac_config_5 col_event_rst_bot_left[9] dac_config_4
+ row_on_detect_bot[60] dac_config_0 dac_config_1 row_off_detect_bot[61] x3_net55
+ dac_config_2 vdda1 vssa1 vssc1 col_event_rst_bot_left[8] x3_net56 row_on_detect_bot[61]
+ row_off_detect_bot[60] openDVS_pixel2x2_bot
x3_x2044 dac_config_3 dac_config_5 col_event_rst_bot_left[7] dac_config_4
+ row_on_detect_bot[60] dac_config_0 dac_config_1 row_off_detect_bot[61] x3_net57
+ dac_config_2 vdda1 vssa1 vssc1 col_event_rst_bot_left[6] x3_net58 row_on_detect_bot[61]
+ row_off_detect_bot[60] openDVS_pixel2x2_bot
x3_x2045 dac_config_3 dac_config_5 col_event_rst_bot_left[5] dac_config_4
+ row_on_detect_bot[60] dac_config_0 dac_config_1 row_off_detect_bot[61] x3_net59
+ dac_config_2 vdda1 vssa1 vssc1 col_event_rst_bot_left[4] x3_net60 row_on_detect_bot[61]
+ row_off_detect_bot[60] openDVS_pixel2x2_bot
x3_x2046 dac_config_3 dac_config_5 col_event_rst_bot_left[3] dac_config_4
+ row_on_detect_bot[60] dac_config_0 dac_config_1 row_off_detect_bot[61] x3_net61
+ dac_config_2 vdda1 vssa1 vssc1 col_event_rst_bot_left[2] x3_net62 row_on_detect_bot[61]
+ row_off_detect_bot[60] openDVS_pixel2x2_bot
x3_x2047 dac_config_3 dac_config_5 col_event_rst_bot_left[1] dac_config_4
+ row_on_detect_bot[60] dac_config_0 dac_config_1 row_off_detect_bot[61] x3_net63
+ dac_config_2 vdda1 vssa1 vssc1 col_event_rst_bot_left[0] x3_net64 row_on_detect_bot[61]
+ row_off_detect_bot[60] openDVS_pixel2x2_bot
x3_x2048 dac_config_3 dac_config_5 col_event_rst_bot_left[63] dac_config_4
+ row_on_detect_bot[62] dac_config_0 dac_config_1 row_off_detect_bot[63] x3_net1
+ dac_config_2 vdda1 vssa1 vssc1 col_event_rst_bot_left[62] x3_net2 row_on_detect_bot[63]
+ row_off_detect_bot[62] openDVS_pixel2x2_bot
x3_x2049 dac_config_3 dac_config_5 col_event_rst_bot_left[61] dac_config_4
+ row_on_detect_bot[62] dac_config_0 dac_config_1 row_off_detect_bot[63] x3_net3
+ dac_config_2 vdda1 vssa1 vssc1 col_event_rst_bot_left[60] x3_net4 row_on_detect_bot[63]
+ row_off_detect_bot[62] openDVS_pixel2x2_bot
x3_x2050 dac_config_3 dac_config_5 col_event_rst_bot_left[59] dac_config_4
+ row_on_detect_bot[62] dac_config_0 dac_config_1 row_off_detect_bot[63] x3_net5
+ dac_config_2 vdda1 vssa1 vssc1 col_event_rst_bot_left[58] x3_net6 row_on_detect_bot[63]
+ row_off_detect_bot[62] openDVS_pixel2x2_bot
x3_x2051 dac_config_3 dac_config_5 col_event_rst_bot_left[57] dac_config_4
+ row_on_detect_bot[62] dac_config_0 dac_config_1 row_off_detect_bot[63] x3_net7
+ dac_config_2 vdda1 vssa1 vssc1 col_event_rst_bot_left[56] x3_net8 row_on_detect_bot[63]
+ row_off_detect_bot[62] openDVS_pixel2x2_bot
x3_x2052 dac_config_3 dac_config_5 col_event_rst_bot_left[55] dac_config_4
+ row_on_detect_bot[62] dac_config_0 dac_config_1 row_off_detect_bot[63] x3_net9
+ dac_config_2 vdda1 vssa1 vssc1 col_event_rst_bot_left[54] x3_net10 row_on_detect_bot[63]
+ row_off_detect_bot[62] openDVS_pixel2x2_bot
x3_x2053 dac_config_3 dac_config_5 col_event_rst_bot_left[53] dac_config_4
+ row_on_detect_bot[62] dac_config_0 dac_config_1 row_off_detect_bot[63] x3_net11
+ dac_config_2 vdda1 vssa1 vssc1 col_event_rst_bot_left[52] x3_net12 row_on_detect_bot[63]
+ row_off_detect_bot[62] openDVS_pixel2x2_bot
x3_x2054 dac_config_3 dac_config_5 col_event_rst_bot_left[51] dac_config_4
+ row_on_detect_bot[62] dac_config_0 dac_config_1 row_off_detect_bot[63] x3_net13
+ dac_config_2 vdda1 vssa1 vssc1 col_event_rst_bot_left[50] x3_net14 row_on_detect_bot[63]
+ row_off_detect_bot[62] openDVS_pixel2x2_bot
x3_x2055 dac_config_3 dac_config_5 col_event_rst_bot_left[49] dac_config_4
+ row_on_detect_bot[62] dac_config_0 dac_config_1 row_off_detect_bot[63] x3_net15
+ dac_config_2 vdda1 vssa1 vssc1 col_event_rst_bot_left[48] x3_net16 row_on_detect_bot[63]
+ row_off_detect_bot[62] openDVS_pixel2x2_bot
x3_x2056 dac_config_3 dac_config_5 col_event_rst_bot_left[47] dac_config_4
+ row_on_detect_bot[62] dac_config_0 dac_config_1 row_off_detect_bot[63] x3_net17
+ dac_config_2 vdda1 vssa1 vssc1 col_event_rst_bot_left[46] x3_net18 row_on_detect_bot[63]
+ row_off_detect_bot[62] openDVS_pixel2x2_bot
x3_x2057 dac_config_3 dac_config_5 col_event_rst_bot_left[45] dac_config_4
+ row_on_detect_bot[62] dac_config_0 dac_config_1 row_off_detect_bot[63] x3_net19
+ dac_config_2 vdda1 vssa1 vssc1 col_event_rst_bot_left[44] x3_net20 row_on_detect_bot[63]
+ row_off_detect_bot[62] openDVS_pixel2x2_bot
x3_x2058 dac_config_3 dac_config_5 col_event_rst_bot_left[43] dac_config_4
+ row_on_detect_bot[62] dac_config_0 dac_config_1 row_off_detect_bot[63] x3_net21
+ dac_config_2 vdda1 vssa1 vssc1 col_event_rst_bot_left[42] x3_net22 row_on_detect_bot[63]
+ row_off_detect_bot[62] openDVS_pixel2x2_bot
x3_x2059 dac_config_3 dac_config_5 col_event_rst_bot_left[41] dac_config_4
+ row_on_detect_bot[62] dac_config_0 dac_config_1 row_off_detect_bot[63] x3_net23
+ dac_config_2 vdda1 vssa1 vssc1 col_event_rst_bot_left[40] x3_net24 row_on_detect_bot[63]
+ row_off_detect_bot[62] openDVS_pixel2x2_bot
x3_x2060 dac_config_3 dac_config_5 col_event_rst_bot_left[39] dac_config_4
+ row_on_detect_bot[62] dac_config_0 dac_config_1 row_off_detect_bot[63] x3_net25
+ dac_config_2 vdda1 vssa1 vssc1 col_event_rst_bot_left[38] x3_net26 row_on_detect_bot[63]
+ row_off_detect_bot[62] openDVS_pixel2x2_bot
x3_x2061 dac_config_3 dac_config_5 col_event_rst_bot_left[37] dac_config_4
+ row_on_detect_bot[62] dac_config_0 dac_config_1 row_off_detect_bot[63] x3_net27
+ dac_config_2 vdda1 vssa1 vssc1 col_event_rst_bot_left[36] x3_net28 row_on_detect_bot[63]
+ row_off_detect_bot[62] openDVS_pixel2x2_bot
x3_x2062 dac_config_3 dac_config_5 col_event_rst_bot_left[35] dac_config_4
+ row_on_detect_bot[62] dac_config_0 dac_config_1 row_off_detect_bot[63] x3_net29
+ dac_config_2 vdda1 vssa1 vssc1 col_event_rst_bot_left[34] x3_net30 row_on_detect_bot[63]
+ row_off_detect_bot[62] openDVS_pixel2x2_bot
x3_x2063 dac_config_3 dac_config_5 col_event_rst_bot_left[33] dac_config_4
+ row_on_detect_bot[62] dac_config_0 dac_config_1 row_off_detect_bot[63] x3_net31
+ dac_config_2 vdda1 vssa1 vssc1 col_event_rst_bot_left[32] x3_net32 row_on_detect_bot[63]
+ row_off_detect_bot[62] openDVS_pixel2x2_bot
x3_x2064 dac_config_3 dac_config_5 col_event_rst_bot_left[31] dac_config_4
+ row_on_detect_bot[62] dac_config_0 dac_config_1 row_off_detect_bot[63] x3_net33
+ dac_config_2 vdda1 vssa1 vssc1 col_event_rst_bot_left[30] x3_net34 row_on_detect_bot[63]
+ row_off_detect_bot[62] openDVS_pixel2x2_bot
x3_x2065 dac_config_3 dac_config_5 col_event_rst_bot_left[29] dac_config_4
+ row_on_detect_bot[62] dac_config_0 dac_config_1 row_off_detect_bot[63] x3_net35
+ dac_config_2 vdda1 vssa1 vssc1 col_event_rst_bot_left[28] x3_net36 row_on_detect_bot[63]
+ row_off_detect_bot[62] openDVS_pixel2x2_bot
x3_x2066 dac_config_3 dac_config_5 col_event_rst_bot_left[27] dac_config_4
+ row_on_detect_bot[62] dac_config_0 dac_config_1 row_off_detect_bot[63] x3_net37
+ dac_config_2 vdda1 vssa1 vssc1 col_event_rst_bot_left[26] x3_net38 row_on_detect_bot[63]
+ row_off_detect_bot[62] openDVS_pixel2x2_bot
x3_x2067 dac_config_3 dac_config_5 col_event_rst_bot_left[25] dac_config_4
+ row_on_detect_bot[62] dac_config_0 dac_config_1 row_off_detect_bot[63] x3_net39
+ dac_config_2 vdda1 vssa1 vssc1 col_event_rst_bot_left[24] x3_net40 row_on_detect_bot[63]
+ row_off_detect_bot[62] openDVS_pixel2x2_bot
x3_x2068 dac_config_3 dac_config_5 col_event_rst_bot_left[23] dac_config_4
+ row_on_detect_bot[62] dac_config_0 dac_config_1 row_off_detect_bot[63] x3_net41
+ dac_config_2 vdda1 vssa1 vssc1 col_event_rst_bot_left[22] x3_net42 row_on_detect_bot[63]
+ row_off_detect_bot[62] openDVS_pixel2x2_bot
x3_x2069 dac_config_3 dac_config_5 col_event_rst_bot_left[21] dac_config_4
+ row_on_detect_bot[62] dac_config_0 dac_config_1 row_off_detect_bot[63] x3_net43
+ dac_config_2 vdda1 vssa1 vssc1 col_event_rst_bot_left[20] x3_net44 row_on_detect_bot[63]
+ row_off_detect_bot[62] openDVS_pixel2x2_bot
x3_x2070 dac_config_3 dac_config_5 col_event_rst_bot_left[19] dac_config_4
+ row_on_detect_bot[62] dac_config_0 dac_config_1 row_off_detect_bot[63] x3_net45
+ dac_config_2 vdda1 vssa1 vssc1 col_event_rst_bot_left[18] x3_net46 row_on_detect_bot[63]
+ row_off_detect_bot[62] openDVS_pixel2x2_bot
x3_x2071 dac_config_3 dac_config_5 col_event_rst_bot_left[17] dac_config_4
+ row_on_detect_bot[62] dac_config_0 dac_config_1 row_off_detect_bot[63] x3_net47
+ dac_config_2 vdda1 vssa1 vssc1 col_event_rst_bot_left[16] x3_net48 row_on_detect_bot[63]
+ row_off_detect_bot[62] openDVS_pixel2x2_bot
x3_x2072 dac_config_3 dac_config_5 col_event_rst_bot_left[15] dac_config_4
+ row_on_detect_bot[62] dac_config_0 dac_config_1 row_off_detect_bot[63] x3_net49
+ dac_config_2 vdda1 vssa1 vssc1 col_event_rst_bot_left[14] x3_net50 row_on_detect_bot[63]
+ row_off_detect_bot[62] openDVS_pixel2x2_bot
x3_x2073 dac_config_3 dac_config_5 col_event_rst_bot_left[13] dac_config_4
+ row_on_detect_bot[62] dac_config_0 dac_config_1 row_off_detect_bot[63] x3_net51
+ dac_config_2 vdda1 vssa1 vssc1 col_event_rst_bot_left[12] x3_net52 row_on_detect_bot[63]
+ row_off_detect_bot[62] openDVS_pixel2x2_bot
x3_x2074 dac_config_3 dac_config_5 col_event_rst_bot_left[11] dac_config_4
+ row_on_detect_bot[62] dac_config_0 dac_config_1 row_off_detect_bot[63] x3_net53
+ dac_config_2 vdda1 vssa1 vssc1 col_event_rst_bot_left[10] x3_net54 row_on_detect_bot[63]
+ row_off_detect_bot[62] openDVS_pixel2x2_bot
x3_x2075 dac_config_3 dac_config_5 col_event_rst_bot_left[9] dac_config_4
+ row_on_detect_bot[62] dac_config_0 dac_config_1 row_off_detect_bot[63] x3_net55
+ dac_config_2 vdda1 vssa1 vssc1 col_event_rst_bot_left[8] x3_net56 row_on_detect_bot[63]
+ row_off_detect_bot[62] openDVS_pixel2x2_bot
x3_x2076 dac_config_3 dac_config_5 col_event_rst_bot_left[7] dac_config_4
+ row_on_detect_bot[62] dac_config_0 dac_config_1 row_off_detect_bot[63] x3_net57
+ dac_config_2 vdda1 vssa1 vssc1 col_event_rst_bot_left[6] x3_net58 row_on_detect_bot[63]
+ row_off_detect_bot[62] openDVS_pixel2x2_bot
x3_x2077 dac_config_3 dac_config_5 col_event_rst_bot_left[5] dac_config_4
+ row_on_detect_bot[62] dac_config_0 dac_config_1 row_off_detect_bot[63] x3_net59
+ dac_config_2 vdda1 vssa1 vssc1 col_event_rst_bot_left[4] x3_net60 row_on_detect_bot[63]
+ row_off_detect_bot[62] openDVS_pixel2x2_bot
x3_x2078 dac_config_3 dac_config_5 col_event_rst_bot_left[3] dac_config_4
+ row_on_detect_bot[62] dac_config_0 dac_config_1 row_off_detect_bot[63] x3_net61
+ dac_config_2 vdda1 vssa1 vssc1 col_event_rst_bot_left[2] x3_net62 row_on_detect_bot[63]
+ row_off_detect_bot[62] openDVS_pixel2x2_bot
x3_x2079 dac_config_3 dac_config_5 col_event_rst_bot_left[1] dac_config_4
+ row_on_detect_bot[62] dac_config_0 dac_config_1 row_off_detect_bot[63] x3_net63
+ dac_config_2 vdda1 vssa1 vssc1 col_event_rst_bot_left[0] x3_net64 row_on_detect_bot[63]
+ row_off_detect_bot[62] openDVS_pixel2x2_bot
x4_x1024 detect_pulse_global_bot_left ndetect_pulse_global_bot_left dac_config_6
+ pre_charge_global_bot_left vdda1 vssa1 x4_net1 x4_net2 array_col_bot_right[63]
+ array_col_bot_right[62] col_event_rst_bot_right[62] col_event_rst_bot_right[63]
+ col_amp_2x1
x4_x1025 detect_pulse_global_bot_left ndetect_pulse_global_bot_left dac_config_6
+ pre_charge_global_bot_left vdda1 vssa1 x4_net3 x4_net4 array_col_bot_right[61]
+ array_col_bot_right[60] col_event_rst_bot_right[60] col_event_rst_bot_right[61]
+ col_amp_2x1
x4_x1026 detect_pulse_global_bot_left ndetect_pulse_global_bot_left dac_config_6
+ pre_charge_global_bot_left vdda1 vssa1 x4_net5 x4_net6 array_col_bot_right[59]
+ array_col_bot_right[58] col_event_rst_bot_right[58] col_event_rst_bot_right[59]
+ col_amp_2x1
x4_x1027 detect_pulse_global_bot_left ndetect_pulse_global_bot_left dac_config_6
+ pre_charge_global_bot_left vdda1 vssa1 x4_net7 x4_net8 array_col_bot_right[57]
+ array_col_bot_right[56] col_event_rst_bot_right[56] col_event_rst_bot_right[57]
+ col_amp_2x1
x4_x1028 detect_pulse_global_bot_left ndetect_pulse_global_bot_left dac_config_6
+ pre_charge_global_bot_left vdda1 vssa1 x4_net9 x4_net10 array_col_bot_right[55]
+ array_col_bot_right[54] col_event_rst_bot_right[54] col_event_rst_bot_right[55]
+ col_amp_2x1
x4_x1029 detect_pulse_global_bot_left ndetect_pulse_global_bot_left dac_config_6
+ pre_charge_global_bot_left vdda1 vssa1 x4_net11 x4_net12 array_col_bot_right[53]
+ array_col_bot_right[52] col_event_rst_bot_right[52] col_event_rst_bot_right[53]
+ col_amp_2x1
x4_x1030 detect_pulse_global_bot_left ndetect_pulse_global_bot_left dac_config_6
+ pre_charge_global_bot_left vdda1 vssa1 x4_net13 x4_net14 array_col_bot_right[51]
+ array_col_bot_right[50] col_event_rst_bot_right[50] col_event_rst_bot_right[51]
+ col_amp_2x1
x4_x1031 detect_pulse_global_bot_left ndetect_pulse_global_bot_left dac_config_6
+ pre_charge_global_bot_left vdda1 vssa1 x4_net15 x4_net16 array_col_bot_right[49]
+ array_col_bot_right[48] col_event_rst_bot_right[48] col_event_rst_bot_right[49]
+ col_amp_2x1
x4_x1032 detect_pulse_global_bot_left ndetect_pulse_global_bot_left dac_config_6
+ pre_charge_global_bot_left vdda1 vssa1 x4_net17 x4_net18 array_col_bot_right[47]
+ array_col_bot_right[46] col_event_rst_bot_right[46] col_event_rst_bot_right[47]
+ col_amp_2x1
x4_x1033 detect_pulse_global_bot_left ndetect_pulse_global_bot_left dac_config_6
+ pre_charge_global_bot_left vdda1 vssa1 x4_net19 x4_net20 array_col_bot_right[45]
+ array_col_bot_right[44] col_event_rst_bot_right[44] col_event_rst_bot_right[45]
+ col_amp_2x1
x4_x1034 detect_pulse_global_bot_left ndetect_pulse_global_bot_left dac_config_6
+ pre_charge_global_bot_left vdda1 vssa1 x4_net21 x4_net22 array_col_bot_right[43]
+ array_col_bot_right[42] col_event_rst_bot_right[42] col_event_rst_bot_right[43]
+ col_amp_2x1
x4_x1035 detect_pulse_global_bot_left ndetect_pulse_global_bot_left dac_config_6
+ pre_charge_global_bot_left vdda1 vssa1 x4_net23 x4_net24 array_col_bot_right[41]
+ array_col_bot_right[40] col_event_rst_bot_right[40] col_event_rst_bot_right[41]
+ col_amp_2x1
x4_x1036 detect_pulse_global_bot_left ndetect_pulse_global_bot_left dac_config_6
+ pre_charge_global_bot_left vdda1 vssa1 x4_net25 x4_net26 array_col_bot_right[39]
+ array_col_bot_right[38] col_event_rst_bot_right[38] col_event_rst_bot_right[39]
+ col_amp_2x1
x4_x1037 detect_pulse_global_bot_left ndetect_pulse_global_bot_left dac_config_6
+ pre_charge_global_bot_left vdda1 vssa1 x4_net27 x4_net28 array_col_bot_right[37]
+ array_col_bot_right[36] col_event_rst_bot_right[36] col_event_rst_bot_right[37]
+ col_amp_2x1
x4_x1038 detect_pulse_global_bot_left ndetect_pulse_global_bot_left dac_config_6
+ pre_charge_global_bot_left vdda1 vssa1 x4_net29 x4_net30 array_col_bot_right[35]
+ array_col_bot_right[34] col_event_rst_bot_right[34] col_event_rst_bot_right[35]
+ col_amp_2x1
x4_x1039 detect_pulse_global_bot_left ndetect_pulse_global_bot_left dac_config_6
+ pre_charge_global_bot_left vdda1 vssa1 x4_net31 x4_net32 array_col_bot_right[33]
+ array_col_bot_right[32] col_event_rst_bot_right[32] col_event_rst_bot_right[33]
+ col_amp_2x1
x4_x1040 detect_pulse_global_bot_left ndetect_pulse_global_bot_left dac_config_6
+ pre_charge_global_bot_left vdda1 vssa1 x4_net33 x4_net34 array_col_bot_right[31]
+ array_col_bot_right[30] col_event_rst_bot_right[30] col_event_rst_bot_right[31]
+ col_amp_2x1
x4_x1041 detect_pulse_global_bot_left ndetect_pulse_global_bot_left dac_config_6
+ pre_charge_global_bot_left vdda1 vssa1 x4_net35 x4_net36 array_col_bot_right[29]
+ array_col_bot_right[28] col_event_rst_bot_right[28] col_event_rst_bot_right[29]
+ col_amp_2x1
x4_x1042 detect_pulse_global_bot_left ndetect_pulse_global_bot_left dac_config_6
+ pre_charge_global_bot_left vdda1 vssa1 x4_net37 x4_net38 array_col_bot_right[27]
+ array_col_bot_right[26] col_event_rst_bot_right[26] col_event_rst_bot_right[27]
+ col_amp_2x1
x4_x1043 detect_pulse_global_bot_left ndetect_pulse_global_bot_left dac_config_6
+ pre_charge_global_bot_left vdda1 vssa1 x4_net39 x4_net40 array_col_bot_right[25]
+ array_col_bot_right[24] col_event_rst_bot_right[24] col_event_rst_bot_right[25]
+ col_amp_2x1
x4_x1044 detect_pulse_global_bot_left ndetect_pulse_global_bot_left dac_config_6
+ pre_charge_global_bot_left vdda1 vssa1 x4_net41 x4_net42 array_col_bot_right[23]
+ array_col_bot_right[22] col_event_rst_bot_right[22] col_event_rst_bot_right[23]
+ col_amp_2x1
x4_x1045 detect_pulse_global_bot_left ndetect_pulse_global_bot_left dac_config_6
+ pre_charge_global_bot_left vdda1 vssa1 x4_net43 x4_net44 array_col_bot_right[21]
+ array_col_bot_right[20] col_event_rst_bot_right[20] col_event_rst_bot_right[21]
+ col_amp_2x1
x4_x1046 detect_pulse_global_bot_left ndetect_pulse_global_bot_left dac_config_6
+ pre_charge_global_bot_left vdda1 vssa1 x4_net45 x4_net46 array_col_bot_right[19]
+ array_col_bot_right[18] col_event_rst_bot_right[18] col_event_rst_bot_right[19]
+ col_amp_2x1
x4_x1047 detect_pulse_global_bot_left ndetect_pulse_global_bot_left dac_config_6
+ pre_charge_global_bot_left vdda1 vssa1 x4_net47 x4_net48 array_col_bot_right[17]
+ array_col_bot_right[16] col_event_rst_bot_right[16] col_event_rst_bot_right[17]
+ col_amp_2x1
x4_x1048 detect_pulse_global_bot_left ndetect_pulse_global_bot_left dac_config_6
+ pre_charge_global_bot_left vdda1 vssa1 x4_net49 x4_net50 array_col_bot_right[15]
+ array_col_bot_right[14] col_event_rst_bot_right[14] col_event_rst_bot_right[15]
+ col_amp_2x1
x4_x1049 detect_pulse_global_bot_left ndetect_pulse_global_bot_left dac_config_6
+ pre_charge_global_bot_left vdda1 vssa1 x4_net51 x4_net52 array_col_bot_right[13]
+ array_col_bot_right[12] col_event_rst_bot_right[12] col_event_rst_bot_right[13]
+ col_amp_2x1
x4_x1050 detect_pulse_global_bot_left ndetect_pulse_global_bot_left dac_config_6
+ pre_charge_global_bot_left vdda1 vssa1 x4_net53 x4_net54 array_col_bot_right[11]
+ array_col_bot_right[10] col_event_rst_bot_right[10] col_event_rst_bot_right[11]
+ col_amp_2x1
x4_x1051 detect_pulse_global_bot_left ndetect_pulse_global_bot_left dac_config_6
+ pre_charge_global_bot_left vdda1 vssa1 x4_net55 x4_net56 array_col_bot_right[9]
+ array_col_bot_right[8] col_event_rst_bot_right[8] col_event_rst_bot_right[9] col_amp_2x1
x4_x1052 detect_pulse_global_bot_left ndetect_pulse_global_bot_left dac_config_6
+ pre_charge_global_bot_left vdda1 vssa1 x4_net57 x4_net58 array_col_bot_right[7]
+ array_col_bot_right[6] col_event_rst_bot_right[6] col_event_rst_bot_right[7] col_amp_2x1
x4_x1053 detect_pulse_global_bot_left ndetect_pulse_global_bot_left dac_config_6
+ pre_charge_global_bot_left vdda1 vssa1 x4_net59 x4_net60 array_col_bot_right[5]
+ array_col_bot_right[4] col_event_rst_bot_right[4] col_event_rst_bot_right[5] col_amp_2x1
x4_x1054 detect_pulse_global_bot_left ndetect_pulse_global_bot_left dac_config_6
+ pre_charge_global_bot_left vdda1 vssa1 x4_net61 x4_net62 array_col_bot_right[3]
+ array_col_bot_right[2] col_event_rst_bot_right[2] col_event_rst_bot_right[3] col_amp_2x1
x4_x1055 detect_pulse_global_bot_left ndetect_pulse_global_bot_left dac_config_6
+ pre_charge_global_bot_left vdda1 vssa1 x4_net63 x4_net64 array_col_bot_right[1]
+ array_col_bot_right[0] col_event_rst_bot_right[0] col_event_rst_bot_right[1] col_amp_2x1
x4_x1 dac_config_3 dac_config_5 col_event_rst_bot_right[63] dac_config_4
+ row_on_detect_bot[0] dac_config_0 dac_config_1 row_off_detect_bot[1] x4_net1
+ dac_config_2 vdda1 vssa1 vssc1 col_event_rst_bot_right[62] x4_net2 row_on_detect_bot[1]
+ row_off_detect_bot[0] openDVS_pixel2x2_bot
x4_x2 dac_config_3 dac_config_5 col_event_rst_bot_right[61] dac_config_4
+ row_on_detect_bot[0] dac_config_0 dac_config_1 row_off_detect_bot[1] x4_net3
+ dac_config_2 vdda1 vssa1 vssc1 col_event_rst_bot_right[60] x4_net4 row_on_detect_bot[1]
+ row_off_detect_bot[0] openDVS_pixel2x2_bot
x4_x3 dac_config_3 dac_config_5 col_event_rst_bot_right[59] dac_config_4
+ row_on_detect_bot[0] dac_config_0 dac_config_1 row_off_detect_bot[1] x4_net5
+ dac_config_2 vdda1 vssa1 vssc1 col_event_rst_bot_right[58] x4_net6 row_on_detect_bot[1]
+ row_off_detect_bot[0] openDVS_pixel2x2_bot
x4_x4 dac_config_3 dac_config_5 col_event_rst_bot_right[57] dac_config_4
+ row_on_detect_bot[0] dac_config_0 dac_config_1 row_off_detect_bot[1] x4_net7
+ dac_config_2 vdda1 vssa1 vssc1 col_event_rst_bot_right[56] x4_net8 row_on_detect_bot[1]
+ row_off_detect_bot[0] openDVS_pixel2x2_bot
x4_x5 dac_config_3 dac_config_5 col_event_rst_bot_right[55] dac_config_4
+ row_on_detect_bot[0] dac_config_0 dac_config_1 row_off_detect_bot[1] x4_net9
+ dac_config_2 vdda1 vssa1 vssc1 col_event_rst_bot_right[54] x4_net10 row_on_detect_bot[1]
+ row_off_detect_bot[0] openDVS_pixel2x2_bot
x4_x6 dac_config_3 dac_config_5 col_event_rst_bot_right[53] dac_config_4
+ row_on_detect_bot[0] dac_config_0 dac_config_1 row_off_detect_bot[1] x4_net11
+ dac_config_2 vdda1 vssa1 vssc1 col_event_rst_bot_right[52] x4_net12 row_on_detect_bot[1]
+ row_off_detect_bot[0] openDVS_pixel2x2_bot
x4_x7 dac_config_3 dac_config_5 col_event_rst_bot_right[51] dac_config_4
+ row_on_detect_bot[0] dac_config_0 dac_config_1 row_off_detect_bot[1] x4_net13
+ dac_config_2 vdda1 vssa1 vssc1 col_event_rst_bot_right[50] x4_net14 row_on_detect_bot[1]
+ row_off_detect_bot[0] openDVS_pixel2x2_bot
x4_x8 dac_config_3 dac_config_5 col_event_rst_bot_right[49] dac_config_4
+ row_on_detect_bot[0] dac_config_0 dac_config_1 row_off_detect_bot[1] x4_net15
+ dac_config_2 vdda1 vssa1 vssc1 col_event_rst_bot_right[48] x4_net16 row_on_detect_bot[1]
+ row_off_detect_bot[0] openDVS_pixel2x2_bot
x4_x9 dac_config_3 dac_config_5 col_event_rst_bot_right[47] dac_config_4
+ row_on_detect_bot[0] dac_config_0 dac_config_1 row_off_detect_bot[1] x4_net17
+ dac_config_2 vdda1 vssa1 vssc1 col_event_rst_bot_right[46] x4_net18 row_on_detect_bot[1]
+ row_off_detect_bot[0] openDVS_pixel2x2_bot
x4_x10 dac_config_3 dac_config_5 col_event_rst_bot_right[45] dac_config_4
+ row_on_detect_bot[0] dac_config_0 dac_config_1 row_off_detect_bot[1] x4_net19
+ dac_config_2 vdda1 vssa1 vssc1 col_event_rst_bot_right[44] x4_net20 row_on_detect_bot[1]
+ row_off_detect_bot[0] openDVS_pixel2x2_bot
x4_x11 dac_config_3 dac_config_5 col_event_rst_bot_right[43] dac_config_4
+ row_on_detect_bot[0] dac_config_0 dac_config_1 row_off_detect_bot[1] x4_net21
+ dac_config_2 vdda1 vssa1 vssc1 col_event_rst_bot_right[42] x4_net22 row_on_detect_bot[1]
+ row_off_detect_bot[0] openDVS_pixel2x2_bot
x4_x12 dac_config_3 dac_config_5 col_event_rst_bot_right[41] dac_config_4
+ row_on_detect_bot[0] dac_config_0 dac_config_1 row_off_detect_bot[1] x4_net23
+ dac_config_2 vdda1 vssa1 vssc1 col_event_rst_bot_right[40] x4_net24 row_on_detect_bot[1]
+ row_off_detect_bot[0] openDVS_pixel2x2_bot
x4_x13 dac_config_3 dac_config_5 col_event_rst_bot_right[39] dac_config_4
+ row_on_detect_bot[0] dac_config_0 dac_config_1 row_off_detect_bot[1] x4_net25
+ dac_config_2 vdda1 vssa1 vssc1 col_event_rst_bot_right[38] x4_net26 row_on_detect_bot[1]
+ row_off_detect_bot[0] openDVS_pixel2x2_bot
x4_x14 dac_config_3 dac_config_5 col_event_rst_bot_right[37] dac_config_4
+ row_on_detect_bot[0] dac_config_0 dac_config_1 row_off_detect_bot[1] x4_net27
+ dac_config_2 vdda1 vssa1 vssc1 col_event_rst_bot_right[36] x4_net28 row_on_detect_bot[1]
+ row_off_detect_bot[0] openDVS_pixel2x2_bot
x4_x15 dac_config_3 dac_config_5 col_event_rst_bot_right[35] dac_config_4
+ row_on_detect_bot[0] dac_config_0 dac_config_1 row_off_detect_bot[1] x4_net29
+ dac_config_2 vdda1 vssa1 vssc1 col_event_rst_bot_right[34] x4_net30 row_on_detect_bot[1]
+ row_off_detect_bot[0] openDVS_pixel2x2_bot
x4_x16 dac_config_3 dac_config_5 col_event_rst_bot_right[33] dac_config_4
+ row_on_detect_bot[0] dac_config_0 dac_config_1 row_off_detect_bot[1] x4_net31
+ dac_config_2 vdda1 vssa1 vssc1 col_event_rst_bot_right[32] x4_net32 row_on_detect_bot[1]
+ row_off_detect_bot[0] openDVS_pixel2x2_bot
x4_x17 dac_config_3 dac_config_5 col_event_rst_bot_right[31] dac_config_4
+ row_on_detect_bot[0] dac_config_0 dac_config_1 row_off_detect_bot[1] x4_net33
+ dac_config_2 vdda1 vssa1 vssc1 col_event_rst_bot_right[30] x4_net34 row_on_detect_bot[1]
+ row_off_detect_bot[0] openDVS_pixel2x2_bot
x4_x18 dac_config_3 dac_config_5 col_event_rst_bot_right[29] dac_config_4
+ row_on_detect_bot[0] dac_config_0 dac_config_1 row_off_detect_bot[1] x4_net35
+ dac_config_2 vdda1 vssa1 vssc1 col_event_rst_bot_right[28] x4_net36 row_on_detect_bot[1]
+ row_off_detect_bot[0] openDVS_pixel2x2_bot
x4_x19 dac_config_3 dac_config_5 col_event_rst_bot_right[27] dac_config_4
+ row_on_detect_bot[0] dac_config_0 dac_config_1 row_off_detect_bot[1] x4_net37
+ dac_config_2 vdda1 vssa1 vssc1 col_event_rst_bot_right[26] x4_net38 row_on_detect_bot[1]
+ row_off_detect_bot[0] openDVS_pixel2x2_bot
x4_x20 dac_config_3 dac_config_5 col_event_rst_bot_right[25] dac_config_4
+ row_on_detect_bot[0] dac_config_0 dac_config_1 row_off_detect_bot[1] x4_net39
+ dac_config_2 vdda1 vssa1 vssc1 col_event_rst_bot_right[24] x4_net40 row_on_detect_bot[1]
+ row_off_detect_bot[0] openDVS_pixel2x2_bot
x4_x21 dac_config_3 dac_config_5 col_event_rst_bot_right[23] dac_config_4
+ row_on_detect_bot[0] dac_config_0 dac_config_1 row_off_detect_bot[1] x4_net41
+ dac_config_2 vdda1 vssa1 vssc1 col_event_rst_bot_right[22] x4_net42 row_on_detect_bot[1]
+ row_off_detect_bot[0] openDVS_pixel2x2_bot
x4_x22 dac_config_3 dac_config_5 col_event_rst_bot_right[21] dac_config_4
+ row_on_detect_bot[0] dac_config_0 dac_config_1 row_off_detect_bot[1] x4_net43
+ dac_config_2 vdda1 vssa1 vssc1 col_event_rst_bot_right[20] x4_net44 row_on_detect_bot[1]
+ row_off_detect_bot[0] openDVS_pixel2x2_bot
x4_x23 dac_config_3 dac_config_5 col_event_rst_bot_right[19] dac_config_4
+ row_on_detect_bot[0] dac_config_0 dac_config_1 row_off_detect_bot[1] x4_net45
+ dac_config_2 vdda1 vssa1 vssc1 col_event_rst_bot_right[18] x4_net46 row_on_detect_bot[1]
+ row_off_detect_bot[0] openDVS_pixel2x2_bot
x4_x24 dac_config_3 dac_config_5 col_event_rst_bot_right[17] dac_config_4
+ row_on_detect_bot[0] dac_config_0 dac_config_1 row_off_detect_bot[1] x4_net47
+ dac_config_2 vdda1 vssa1 vssc1 col_event_rst_bot_right[16] x4_net48 row_on_detect_bot[1]
+ row_off_detect_bot[0] openDVS_pixel2x2_bot
x4_x25 dac_config_3 dac_config_5 col_event_rst_bot_right[15] dac_config_4
+ row_on_detect_bot[0] dac_config_0 dac_config_1 row_off_detect_bot[1] x4_net49
+ dac_config_2 vdda1 vssa1 vssc1 col_event_rst_bot_right[14] x4_net50 row_on_detect_bot[1]
+ row_off_detect_bot[0] openDVS_pixel2x2_bot
x4_x26 dac_config_3 dac_config_5 col_event_rst_bot_right[13] dac_config_4
+ row_on_detect_bot[0] dac_config_0 dac_config_1 row_off_detect_bot[1] x4_net51
+ dac_config_2 vdda1 vssa1 vssc1 col_event_rst_bot_right[12] x4_net52 row_on_detect_bot[1]
+ row_off_detect_bot[0] openDVS_pixel2x2_bot
x4_x27 dac_config_3 dac_config_5 col_event_rst_bot_right[11] dac_config_4
+ row_on_detect_bot[0] dac_config_0 dac_config_1 row_off_detect_bot[1] x4_net53
+ dac_config_2 vdda1 vssa1 vssc1 col_event_rst_bot_right[10] x4_net54 row_on_detect_bot[1]
+ row_off_detect_bot[0] openDVS_pixel2x2_bot
x4_x28 dac_config_3 dac_config_5 col_event_rst_bot_right[9] dac_config_4
+ row_on_detect_bot[0] dac_config_0 dac_config_1 row_off_detect_bot[1] x4_net55
+ dac_config_2 vdda1 vssa1 vssc1 col_event_rst_bot_right[8] x4_net56 row_on_detect_bot[1]
+ row_off_detect_bot[0] openDVS_pixel2x2_bot
x4_x29 dac_config_3 dac_config_5 col_event_rst_bot_right[7] dac_config_4
+ row_on_detect_bot[0] dac_config_0 dac_config_1 row_off_detect_bot[1] x4_net57
+ dac_config_2 vdda1 vssa1 vssc1 col_event_rst_bot_right[6] x4_net58 row_on_detect_bot[1]
+ row_off_detect_bot[0] openDVS_pixel2x2_bot
x4_x30 dac_config_3 dac_config_5 col_event_rst_bot_right[5] dac_config_4
+ row_on_detect_bot[0] dac_config_0 dac_config_1 row_off_detect_bot[1] x4_net59
+ dac_config_2 vdda1 vssa1 vssc1 col_event_rst_bot_right[4] x4_net60 row_on_detect_bot[1]
+ row_off_detect_bot[0] openDVS_pixel2x2_bot
x4_x31 dac_config_3 dac_config_5 col_event_rst_bot_right[3] dac_config_4
+ row_on_detect_bot[0] dac_config_0 dac_config_1 row_off_detect_bot[1] x4_net61
+ dac_config_2 vdda1 vssa1 vssc1 col_event_rst_bot_right[2] x4_net62 row_on_detect_bot[1]
+ row_off_detect_bot[0] openDVS_pixel2x2_bot
x4_x32 dac_config_3 dac_config_5 col_event_rst_bot_right[1] dac_config_4
+ row_on_detect_bot[0] dac_config_0 dac_config_1 row_off_detect_bot[1] x4_net63
+ dac_config_2 vdda1 vssa1 vssc1 col_event_rst_bot_right[0] x4_net64 row_on_detect_bot[1]
+ row_off_detect_bot[0] openDVS_pixel2x2_bot
x4_x1056 dac_config_3 dac_config_5 col_event_rst_bot_right[63] dac_config_4
+ row_on_detect_bot[2] dac_config_0 dac_config_1 row_off_detect_bot[3] x4_net1
+ dac_config_2 vdda1 vssa1 vssc1 col_event_rst_bot_right[62] x4_net2 row_on_detect_bot[3]
+ row_off_detect_bot[2] openDVS_pixel2x2_bot
x4_x1057 dac_config_3 dac_config_5 col_event_rst_bot_right[61] dac_config_4
+ row_on_detect_bot[2] dac_config_0 dac_config_1 row_off_detect_bot[3] x4_net3
+ dac_config_2 vdda1 vssa1 vssc1 col_event_rst_bot_right[60] x4_net4 row_on_detect_bot[3]
+ row_off_detect_bot[2] openDVS_pixel2x2_bot
x4_x1058 dac_config_3 dac_config_5 col_event_rst_bot_right[59] dac_config_4
+ row_on_detect_bot[2] dac_config_0 dac_config_1 row_off_detect_bot[3] x4_net5
+ dac_config_2 vdda1 vssa1 vssc1 col_event_rst_bot_right[58] x4_net6 row_on_detect_bot[3]
+ row_off_detect_bot[2] openDVS_pixel2x2_bot
x4_x1059 dac_config_3 dac_config_5 col_event_rst_bot_right[57] dac_config_4
+ row_on_detect_bot[2] dac_config_0 dac_config_1 row_off_detect_bot[3] x4_net7
+ dac_config_2 vdda1 vssa1 vssc1 col_event_rst_bot_right[56] x4_net8 row_on_detect_bot[3]
+ row_off_detect_bot[2] openDVS_pixel2x2_bot
x4_x1060 dac_config_3 dac_config_5 col_event_rst_bot_right[55] dac_config_4
+ row_on_detect_bot[2] dac_config_0 dac_config_1 row_off_detect_bot[3] x4_net9
+ dac_config_2 vdda1 vssa1 vssc1 col_event_rst_bot_right[54] x4_net10 row_on_detect_bot[3]
+ row_off_detect_bot[2] openDVS_pixel2x2_bot
x4_x1061 dac_config_3 dac_config_5 col_event_rst_bot_right[53] dac_config_4
+ row_on_detect_bot[2] dac_config_0 dac_config_1 row_off_detect_bot[3] x4_net11
+ dac_config_2 vdda1 vssa1 vssc1 col_event_rst_bot_right[52] x4_net12 row_on_detect_bot[3]
+ row_off_detect_bot[2] openDVS_pixel2x2_bot
x4_x1062 dac_config_3 dac_config_5 col_event_rst_bot_right[51] dac_config_4
+ row_on_detect_bot[2] dac_config_0 dac_config_1 row_off_detect_bot[3] x4_net13
+ dac_config_2 vdda1 vssa1 vssc1 col_event_rst_bot_right[50] x4_net14 row_on_detect_bot[3]
+ row_off_detect_bot[2] openDVS_pixel2x2_bot
x4_x1063 dac_config_3 dac_config_5 col_event_rst_bot_right[49] dac_config_4
+ row_on_detect_bot[2] dac_config_0 dac_config_1 row_off_detect_bot[3] x4_net15
+ dac_config_2 vdda1 vssa1 vssc1 col_event_rst_bot_right[48] x4_net16 row_on_detect_bot[3]
+ row_off_detect_bot[2] openDVS_pixel2x2_bot
x4_x1064 dac_config_3 dac_config_5 col_event_rst_bot_right[47] dac_config_4
+ row_on_detect_bot[2] dac_config_0 dac_config_1 row_off_detect_bot[3] x4_net17
+ dac_config_2 vdda1 vssa1 vssc1 col_event_rst_bot_right[46] x4_net18 row_on_detect_bot[3]
+ row_off_detect_bot[2] openDVS_pixel2x2_bot
x4_x1065 dac_config_3 dac_config_5 col_event_rst_bot_right[45] dac_config_4
+ row_on_detect_bot[2] dac_config_0 dac_config_1 row_off_detect_bot[3] x4_net19
+ dac_config_2 vdda1 vssa1 vssc1 col_event_rst_bot_right[44] x4_net20 row_on_detect_bot[3]
+ row_off_detect_bot[2] openDVS_pixel2x2_bot
x4_x1066 dac_config_3 dac_config_5 col_event_rst_bot_right[43] dac_config_4
+ row_on_detect_bot[2] dac_config_0 dac_config_1 row_off_detect_bot[3] x4_net21
+ dac_config_2 vdda1 vssa1 vssc1 col_event_rst_bot_right[42] x4_net22 row_on_detect_bot[3]
+ row_off_detect_bot[2] openDVS_pixel2x2_bot
x4_x1067 dac_config_3 dac_config_5 col_event_rst_bot_right[41] dac_config_4
+ row_on_detect_bot[2] dac_config_0 dac_config_1 row_off_detect_bot[3] x4_net23
+ dac_config_2 vdda1 vssa1 vssc1 col_event_rst_bot_right[40] x4_net24 row_on_detect_bot[3]
+ row_off_detect_bot[2] openDVS_pixel2x2_bot
x4_x1068 dac_config_3 dac_config_5 col_event_rst_bot_right[39] dac_config_4
+ row_on_detect_bot[2] dac_config_0 dac_config_1 row_off_detect_bot[3] x4_net25
+ dac_config_2 vdda1 vssa1 vssc1 col_event_rst_bot_right[38] x4_net26 row_on_detect_bot[3]
+ row_off_detect_bot[2] openDVS_pixel2x2_bot
x4_x1069 dac_config_3 dac_config_5 col_event_rst_bot_right[37] dac_config_4
+ row_on_detect_bot[2] dac_config_0 dac_config_1 row_off_detect_bot[3] x4_net27
+ dac_config_2 vdda1 vssa1 vssc1 col_event_rst_bot_right[36] x4_net28 row_on_detect_bot[3]
+ row_off_detect_bot[2] openDVS_pixel2x2_bot
x4_x1070 dac_config_3 dac_config_5 col_event_rst_bot_right[35] dac_config_4
+ row_on_detect_bot[2] dac_config_0 dac_config_1 row_off_detect_bot[3] x4_net29
+ dac_config_2 vdda1 vssa1 vssc1 col_event_rst_bot_right[34] x4_net30 row_on_detect_bot[3]
+ row_off_detect_bot[2] openDVS_pixel2x2_bot
x4_x1071 dac_config_3 dac_config_5 col_event_rst_bot_right[33] dac_config_4
+ row_on_detect_bot[2] dac_config_0 dac_config_1 row_off_detect_bot[3] x4_net31
+ dac_config_2 vdda1 vssa1 vssc1 col_event_rst_bot_right[32] x4_net32 row_on_detect_bot[3]
+ row_off_detect_bot[2] openDVS_pixel2x2_bot
x4_x1072 dac_config_3 dac_config_5 col_event_rst_bot_right[31] dac_config_4
+ row_on_detect_bot[2] dac_config_0 dac_config_1 row_off_detect_bot[3] x4_net33
+ dac_config_2 vdda1 vssa1 vssc1 col_event_rst_bot_right[30] x4_net34 row_on_detect_bot[3]
+ row_off_detect_bot[2] openDVS_pixel2x2_bot
x4_x1073 dac_config_3 dac_config_5 col_event_rst_bot_right[29] dac_config_4
+ row_on_detect_bot[2] dac_config_0 dac_config_1 row_off_detect_bot[3] x4_net35
+ dac_config_2 vdda1 vssa1 vssc1 col_event_rst_bot_right[28] x4_net36 row_on_detect_bot[3]
+ row_off_detect_bot[2] openDVS_pixel2x2_bot
x4_x1074 dac_config_3 dac_config_5 col_event_rst_bot_right[27] dac_config_4
+ row_on_detect_bot[2] dac_config_0 dac_config_1 row_off_detect_bot[3] x4_net37
+ dac_config_2 vdda1 vssa1 vssc1 col_event_rst_bot_right[26] x4_net38 row_on_detect_bot[3]
+ row_off_detect_bot[2] openDVS_pixel2x2_bot
x4_x1075 dac_config_3 dac_config_5 col_event_rst_bot_right[25] dac_config_4
+ row_on_detect_bot[2] dac_config_0 dac_config_1 row_off_detect_bot[3] x4_net39
+ dac_config_2 vdda1 vssa1 vssc1 col_event_rst_bot_right[24] x4_net40 row_on_detect_bot[3]
+ row_off_detect_bot[2] openDVS_pixel2x2_bot
x4_x1076 dac_config_3 dac_config_5 col_event_rst_bot_right[23] dac_config_4
+ row_on_detect_bot[2] dac_config_0 dac_config_1 row_off_detect_bot[3] x4_net41
+ dac_config_2 vdda1 vssa1 vssc1 col_event_rst_bot_right[22] x4_net42 row_on_detect_bot[3]
+ row_off_detect_bot[2] openDVS_pixel2x2_bot
x4_x1077 dac_config_3 dac_config_5 col_event_rst_bot_right[21] dac_config_4
+ row_on_detect_bot[2] dac_config_0 dac_config_1 row_off_detect_bot[3] x4_net43
+ dac_config_2 vdda1 vssa1 vssc1 col_event_rst_bot_right[20] x4_net44 row_on_detect_bot[3]
+ row_off_detect_bot[2] openDVS_pixel2x2_bot
x4_x1078 dac_config_3 dac_config_5 col_event_rst_bot_right[19] dac_config_4
+ row_on_detect_bot[2] dac_config_0 dac_config_1 row_off_detect_bot[3] x4_net45
+ dac_config_2 vdda1 vssa1 vssc1 col_event_rst_bot_right[18] x4_net46 row_on_detect_bot[3]
+ row_off_detect_bot[2] openDVS_pixel2x2_bot
x4_x1079 dac_config_3 dac_config_5 col_event_rst_bot_right[17] dac_config_4
+ row_on_detect_bot[2] dac_config_0 dac_config_1 row_off_detect_bot[3] x4_net47
+ dac_config_2 vdda1 vssa1 vssc1 col_event_rst_bot_right[16] x4_net48 row_on_detect_bot[3]
+ row_off_detect_bot[2] openDVS_pixel2x2_bot
x4_x1080 dac_config_3 dac_config_5 col_event_rst_bot_right[15] dac_config_4
+ row_on_detect_bot[2] dac_config_0 dac_config_1 row_off_detect_bot[3] x4_net49
+ dac_config_2 vdda1 vssa1 vssc1 col_event_rst_bot_right[14] x4_net50 row_on_detect_bot[3]
+ row_off_detect_bot[2] openDVS_pixel2x2_bot
x4_x1081 dac_config_3 dac_config_5 col_event_rst_bot_right[13] dac_config_4
+ row_on_detect_bot[2] dac_config_0 dac_config_1 row_off_detect_bot[3] x4_net51
+ dac_config_2 vdda1 vssa1 vssc1 col_event_rst_bot_right[12] x4_net52 row_on_detect_bot[3]
+ row_off_detect_bot[2] openDVS_pixel2x2_bot
x4_x1082 dac_config_3 dac_config_5 col_event_rst_bot_right[11] dac_config_4
+ row_on_detect_bot[2] dac_config_0 dac_config_1 row_off_detect_bot[3] x4_net53
+ dac_config_2 vdda1 vssa1 vssc1 col_event_rst_bot_right[10] x4_net54 row_on_detect_bot[3]
+ row_off_detect_bot[2] openDVS_pixel2x2_bot
x4_x1083 dac_config_3 dac_config_5 col_event_rst_bot_right[9] dac_config_4
+ row_on_detect_bot[2] dac_config_0 dac_config_1 row_off_detect_bot[3] x4_net55
+ dac_config_2 vdda1 vssa1 vssc1 col_event_rst_bot_right[8] x4_net56 row_on_detect_bot[3]
+ row_off_detect_bot[2] openDVS_pixel2x2_bot
x4_x1084 dac_config_3 dac_config_5 col_event_rst_bot_right[7] dac_config_4
+ row_on_detect_bot[2] dac_config_0 dac_config_1 row_off_detect_bot[3] x4_net57
+ dac_config_2 vdda1 vssa1 vssc1 col_event_rst_bot_right[6] x4_net58 row_on_detect_bot[3]
+ row_off_detect_bot[2] openDVS_pixel2x2_bot
x4_x1085 dac_config_3 dac_config_5 col_event_rst_bot_right[5] dac_config_4
+ row_on_detect_bot[2] dac_config_0 dac_config_1 row_off_detect_bot[3] x4_net59
+ dac_config_2 vdda1 vssa1 vssc1 col_event_rst_bot_right[4] x4_net60 row_on_detect_bot[3]
+ row_off_detect_bot[2] openDVS_pixel2x2_bot
x4_x1086 dac_config_3 dac_config_5 col_event_rst_bot_right[3] dac_config_4
+ row_on_detect_bot[2] dac_config_0 dac_config_1 row_off_detect_bot[3] x4_net61
+ dac_config_2 vdda1 vssa1 vssc1 col_event_rst_bot_right[2] x4_net62 row_on_detect_bot[3]
+ row_off_detect_bot[2] openDVS_pixel2x2_bot
x4_x1087 dac_config_3 dac_config_5 col_event_rst_bot_right[1] dac_config_4
+ row_on_detect_bot[2] dac_config_0 dac_config_1 row_off_detect_bot[3] x4_net63
+ dac_config_2 vdda1 vssa1 vssc1 col_event_rst_bot_right[0] x4_net64 row_on_detect_bot[3]
+ row_off_detect_bot[2] openDVS_pixel2x2_bot
x4_x1120 dac_config_3 dac_config_5 col_event_rst_bot_right[63] dac_config_4
+ row_on_detect_bot[4] dac_config_0 dac_config_1 row_off_detect_bot[5] x4_net1
+ dac_config_2 vdda1 vssa1 vssc1 col_event_rst_bot_right[62] x4_net2 row_on_detect_bot[5]
+ row_off_detect_bot[4] openDVS_pixel2x2_bot
x4_x1121 dac_config_3 dac_config_5 col_event_rst_bot_right[61] dac_config_4
+ row_on_detect_bot[4] dac_config_0 dac_config_1 row_off_detect_bot[5] x4_net3
+ dac_config_2 vdda1 vssa1 vssc1 col_event_rst_bot_right[60] x4_net4 row_on_detect_bot[5]
+ row_off_detect_bot[4] openDVS_pixel2x2_bot
x4_x1122 dac_config_3 dac_config_5 col_event_rst_bot_right[59] dac_config_4
+ row_on_detect_bot[4] dac_config_0 dac_config_1 row_off_detect_bot[5] x4_net5
+ dac_config_2 vdda1 vssa1 vssc1 col_event_rst_bot_right[58] x4_net6 row_on_detect_bot[5]
+ row_off_detect_bot[4] openDVS_pixel2x2_bot
x4_x1123 dac_config_3 dac_config_5 col_event_rst_bot_right[57] dac_config_4
+ row_on_detect_bot[4] dac_config_0 dac_config_1 row_off_detect_bot[5] x4_net7
+ dac_config_2 vdda1 vssa1 vssc1 col_event_rst_bot_right[56] x4_net8 row_on_detect_bot[5]
+ row_off_detect_bot[4] openDVS_pixel2x2_bot
x4_x1124 dac_config_3 dac_config_5 col_event_rst_bot_right[55] dac_config_4
+ row_on_detect_bot[4] dac_config_0 dac_config_1 row_off_detect_bot[5] x4_net9
+ dac_config_2 vdda1 vssa1 vssc1 col_event_rst_bot_right[54] x4_net10 row_on_detect_bot[5]
+ row_off_detect_bot[4] openDVS_pixel2x2_bot
x4_x1125 dac_config_3 dac_config_5 col_event_rst_bot_right[53] dac_config_4
+ row_on_detect_bot[4] dac_config_0 dac_config_1 row_off_detect_bot[5] x4_net11
+ dac_config_2 vdda1 vssa1 vssc1 col_event_rst_bot_right[52] x4_net12 row_on_detect_bot[5]
+ row_off_detect_bot[4] openDVS_pixel2x2_bot
x4_x1126 dac_config_3 dac_config_5 col_event_rst_bot_right[51] dac_config_4
+ row_on_detect_bot[4] dac_config_0 dac_config_1 row_off_detect_bot[5] x4_net13
+ dac_config_2 vdda1 vssa1 vssc1 col_event_rst_bot_right[50] x4_net14 row_on_detect_bot[5]
+ row_off_detect_bot[4] openDVS_pixel2x2_bot
x4_x1127 dac_config_3 dac_config_5 col_event_rst_bot_right[49] dac_config_4
+ row_on_detect_bot[4] dac_config_0 dac_config_1 row_off_detect_bot[5] x4_net15
+ dac_config_2 vdda1 vssa1 vssc1 col_event_rst_bot_right[48] x4_net16 row_on_detect_bot[5]
+ row_off_detect_bot[4] openDVS_pixel2x2_bot
x4_x1128 dac_config_3 dac_config_5 col_event_rst_bot_right[47] dac_config_4
+ row_on_detect_bot[4] dac_config_0 dac_config_1 row_off_detect_bot[5] x4_net17
+ dac_config_2 vdda1 vssa1 vssc1 col_event_rst_bot_right[46] x4_net18 row_on_detect_bot[5]
+ row_off_detect_bot[4] openDVS_pixel2x2_bot
x4_x1129 dac_config_3 dac_config_5 col_event_rst_bot_right[45] dac_config_4
+ row_on_detect_bot[4] dac_config_0 dac_config_1 row_off_detect_bot[5] x4_net19
+ dac_config_2 vdda1 vssa1 vssc1 col_event_rst_bot_right[44] x4_net20 row_on_detect_bot[5]
+ row_off_detect_bot[4] openDVS_pixel2x2_bot
x4_x1130 dac_config_3 dac_config_5 col_event_rst_bot_right[43] dac_config_4
+ row_on_detect_bot[4] dac_config_0 dac_config_1 row_off_detect_bot[5] x4_net21
+ dac_config_2 vdda1 vssa1 vssc1 col_event_rst_bot_right[42] x4_net22 row_on_detect_bot[5]
+ row_off_detect_bot[4] openDVS_pixel2x2_bot
x4_x1131 dac_config_3 dac_config_5 col_event_rst_bot_right[41] dac_config_4
+ row_on_detect_bot[4] dac_config_0 dac_config_1 row_off_detect_bot[5] x4_net23
+ dac_config_2 vdda1 vssa1 vssc1 col_event_rst_bot_right[40] x4_net24 row_on_detect_bot[5]
+ row_off_detect_bot[4] openDVS_pixel2x2_bot
x4_x1132 dac_config_3 dac_config_5 col_event_rst_bot_right[39] dac_config_4
+ row_on_detect_bot[4] dac_config_0 dac_config_1 row_off_detect_bot[5] x4_net25
+ dac_config_2 vdda1 vssa1 vssc1 col_event_rst_bot_right[38] x4_net26 row_on_detect_bot[5]
+ row_off_detect_bot[4] openDVS_pixel2x2_bot
x4_x1133 dac_config_3 dac_config_5 col_event_rst_bot_right[37] dac_config_4
+ row_on_detect_bot[4] dac_config_0 dac_config_1 row_off_detect_bot[5] x4_net27
+ dac_config_2 vdda1 vssa1 vssc1 col_event_rst_bot_right[36] x4_net28 row_on_detect_bot[5]
+ row_off_detect_bot[4] openDVS_pixel2x2_bot
x4_x1134 dac_config_3 dac_config_5 col_event_rst_bot_right[35] dac_config_4
+ row_on_detect_bot[4] dac_config_0 dac_config_1 row_off_detect_bot[5] x4_net29
+ dac_config_2 vdda1 vssa1 vssc1 col_event_rst_bot_right[34] x4_net30 row_on_detect_bot[5]
+ row_off_detect_bot[4] openDVS_pixel2x2_bot
x4_x1135 dac_config_3 dac_config_5 col_event_rst_bot_right[33] dac_config_4
+ row_on_detect_bot[4] dac_config_0 dac_config_1 row_off_detect_bot[5] x4_net31
+ dac_config_2 vdda1 vssa1 vssc1 col_event_rst_bot_right[32] x4_net32 row_on_detect_bot[5]
+ row_off_detect_bot[4] openDVS_pixel2x2_bot
x4_x1136 dac_config_3 dac_config_5 col_event_rst_bot_right[31] dac_config_4
+ row_on_detect_bot[4] dac_config_0 dac_config_1 row_off_detect_bot[5] x4_net33
+ dac_config_2 vdda1 vssa1 vssc1 col_event_rst_bot_right[30] x4_net34 row_on_detect_bot[5]
+ row_off_detect_bot[4] openDVS_pixel2x2_bot
x4_x1137 dac_config_3 dac_config_5 col_event_rst_bot_right[29] dac_config_4
+ row_on_detect_bot[4] dac_config_0 dac_config_1 row_off_detect_bot[5] x4_net35
+ dac_config_2 vdda1 vssa1 vssc1 col_event_rst_bot_right[28] x4_net36 row_on_detect_bot[5]
+ row_off_detect_bot[4] openDVS_pixel2x2_bot
x4_x1138 dac_config_3 dac_config_5 col_event_rst_bot_right[27] dac_config_4
+ row_on_detect_bot[4] dac_config_0 dac_config_1 row_off_detect_bot[5] x4_net37
+ dac_config_2 vdda1 vssa1 vssc1 col_event_rst_bot_right[26] x4_net38 row_on_detect_bot[5]
+ row_off_detect_bot[4] openDVS_pixel2x2_bot
x4_x1139 dac_config_3 dac_config_5 col_event_rst_bot_right[25] dac_config_4
+ row_on_detect_bot[4] dac_config_0 dac_config_1 row_off_detect_bot[5] x4_net39
+ dac_config_2 vdda1 vssa1 vssc1 col_event_rst_bot_right[24] x4_net40 row_on_detect_bot[5]
+ row_off_detect_bot[4] openDVS_pixel2x2_bot
x4_x1140 dac_config_3 dac_config_5 col_event_rst_bot_right[23] dac_config_4
+ row_on_detect_bot[4] dac_config_0 dac_config_1 row_off_detect_bot[5] x4_net41
+ dac_config_2 vdda1 vssa1 vssc1 col_event_rst_bot_right[22] x4_net42 row_on_detect_bot[5]
+ row_off_detect_bot[4] openDVS_pixel2x2_bot
x4_x1141 dac_config_3 dac_config_5 col_event_rst_bot_right[21] dac_config_4
+ row_on_detect_bot[4] dac_config_0 dac_config_1 row_off_detect_bot[5] x4_net43
+ dac_config_2 vdda1 vssa1 vssc1 col_event_rst_bot_right[20] x4_net44 row_on_detect_bot[5]
+ row_off_detect_bot[4] openDVS_pixel2x2_bot
x4_x1142 dac_config_3 dac_config_5 col_event_rst_bot_right[19] dac_config_4
+ row_on_detect_bot[4] dac_config_0 dac_config_1 row_off_detect_bot[5] x4_net45
+ dac_config_2 vdda1 vssa1 vssc1 col_event_rst_bot_right[18] x4_net46 row_on_detect_bot[5]
+ row_off_detect_bot[4] openDVS_pixel2x2_bot
x4_x1143 dac_config_3 dac_config_5 col_event_rst_bot_right[17] dac_config_4
+ row_on_detect_bot[4] dac_config_0 dac_config_1 row_off_detect_bot[5] x4_net47
+ dac_config_2 vdda1 vssa1 vssc1 col_event_rst_bot_right[16] x4_net48 row_on_detect_bot[5]
+ row_off_detect_bot[4] openDVS_pixel2x2_bot
x4_x1144 dac_config_3 dac_config_5 col_event_rst_bot_right[15] dac_config_4
+ row_on_detect_bot[4] dac_config_0 dac_config_1 row_off_detect_bot[5] x4_net49
+ dac_config_2 vdda1 vssa1 vssc1 col_event_rst_bot_right[14] x4_net50 row_on_detect_bot[5]
+ row_off_detect_bot[4] openDVS_pixel2x2_bot
x4_x1145 dac_config_3 dac_config_5 col_event_rst_bot_right[13] dac_config_4
+ row_on_detect_bot[4] dac_config_0 dac_config_1 row_off_detect_bot[5] x4_net51
+ dac_config_2 vdda1 vssa1 vssc1 col_event_rst_bot_right[12] x4_net52 row_on_detect_bot[5]
+ row_off_detect_bot[4] openDVS_pixel2x2_bot
x4_x1146 dac_config_3 dac_config_5 col_event_rst_bot_right[11] dac_config_4
+ row_on_detect_bot[4] dac_config_0 dac_config_1 row_off_detect_bot[5] x4_net53
+ dac_config_2 vdda1 vssa1 vssc1 col_event_rst_bot_right[10] x4_net54 row_on_detect_bot[5]
+ row_off_detect_bot[4] openDVS_pixel2x2_bot
x4_x1147 dac_config_3 dac_config_5 col_event_rst_bot_right[9] dac_config_4
+ row_on_detect_bot[4] dac_config_0 dac_config_1 row_off_detect_bot[5] x4_net55
+ dac_config_2 vdda1 vssa1 vssc1 col_event_rst_bot_right[8] x4_net56 row_on_detect_bot[5]
+ row_off_detect_bot[4] openDVS_pixel2x2_bot
x4_x1148 dac_config_3 dac_config_5 col_event_rst_bot_right[7] dac_config_4
+ row_on_detect_bot[4] dac_config_0 dac_config_1 row_off_detect_bot[5] x4_net57
+ dac_config_2 vdda1 vssa1 vssc1 col_event_rst_bot_right[6] x4_net58 row_on_detect_bot[5]
+ row_off_detect_bot[4] openDVS_pixel2x2_bot
x4_x1149 dac_config_3 dac_config_5 col_event_rst_bot_right[5] dac_config_4
+ row_on_detect_bot[4] dac_config_0 dac_config_1 row_off_detect_bot[5] x4_net59
+ dac_config_2 vdda1 vssa1 vssc1 col_event_rst_bot_right[4] x4_net60 row_on_detect_bot[5]
+ row_off_detect_bot[4] openDVS_pixel2x2_bot
x4_x1150 dac_config_3 dac_config_5 col_event_rst_bot_right[3] dac_config_4
+ row_on_detect_bot[4] dac_config_0 dac_config_1 row_off_detect_bot[5] x4_net61
+ dac_config_2 vdda1 vssa1 vssc1 col_event_rst_bot_right[2] x4_net62 row_on_detect_bot[5]
+ row_off_detect_bot[4] openDVS_pixel2x2_bot
x4_x1151 dac_config_3 dac_config_5 col_event_rst_bot_right[1] dac_config_4
+ row_on_detect_bot[4] dac_config_0 dac_config_1 row_off_detect_bot[5] x4_net63
+ dac_config_2 vdda1 vssa1 vssc1 col_event_rst_bot_right[0] x4_net64 row_on_detect_bot[5]
+ row_off_detect_bot[4] openDVS_pixel2x2_bot
x4_x1152 dac_config_3 dac_config_5 col_event_rst_bot_right[63] dac_config_4
+ row_on_detect_bot[6] dac_config_0 dac_config_1 row_off_detect_bot[7] x4_net1
+ dac_config_2 vdda1 vssa1 vssc1 col_event_rst_bot_right[62] x4_net2 row_on_detect_bot[7]
+ row_off_detect_bot[6] openDVS_pixel2x2_bot
x4_x1153 dac_config_3 dac_config_5 col_event_rst_bot_right[61] dac_config_4
+ row_on_detect_bot[6] dac_config_0 dac_config_1 row_off_detect_bot[7] x4_net3
+ dac_config_2 vdda1 vssa1 vssc1 col_event_rst_bot_right[60] x4_net4 row_on_detect_bot[7]
+ row_off_detect_bot[6] openDVS_pixel2x2_bot
x4_x1154 dac_config_3 dac_config_5 col_event_rst_bot_right[59] dac_config_4
+ row_on_detect_bot[6] dac_config_0 dac_config_1 row_off_detect_bot[7] x4_net5
+ dac_config_2 vdda1 vssa1 vssc1 col_event_rst_bot_right[58] x4_net6 row_on_detect_bot[7]
+ row_off_detect_bot[6] openDVS_pixel2x2_bot
x4_x1155 dac_config_3 dac_config_5 col_event_rst_bot_right[57] dac_config_4
+ row_on_detect_bot[6] dac_config_0 dac_config_1 row_off_detect_bot[7] x4_net7
+ dac_config_2 vdda1 vssa1 vssc1 col_event_rst_bot_right[56] x4_net8 row_on_detect_bot[7]
+ row_off_detect_bot[6] openDVS_pixel2x2_bot
x4_x1156 dac_config_3 dac_config_5 col_event_rst_bot_right[55] dac_config_4
+ row_on_detect_bot[6] dac_config_0 dac_config_1 row_off_detect_bot[7] x4_net9
+ dac_config_2 vdda1 vssa1 vssc1 col_event_rst_bot_right[54] x4_net10 row_on_detect_bot[7]
+ row_off_detect_bot[6] openDVS_pixel2x2_bot
x4_x1157 dac_config_3 dac_config_5 col_event_rst_bot_right[53] dac_config_4
+ row_on_detect_bot[6] dac_config_0 dac_config_1 row_off_detect_bot[7] x4_net11
+ dac_config_2 vdda1 vssa1 vssc1 col_event_rst_bot_right[52] x4_net12 row_on_detect_bot[7]
+ row_off_detect_bot[6] openDVS_pixel2x2_bot
x4_x1158 dac_config_3 dac_config_5 col_event_rst_bot_right[51] dac_config_4
+ row_on_detect_bot[6] dac_config_0 dac_config_1 row_off_detect_bot[7] x4_net13
+ dac_config_2 vdda1 vssa1 vssc1 col_event_rst_bot_right[50] x4_net14 row_on_detect_bot[7]
+ row_off_detect_bot[6] openDVS_pixel2x2_bot
x4_x1159 dac_config_3 dac_config_5 col_event_rst_bot_right[49] dac_config_4
+ row_on_detect_bot[6] dac_config_0 dac_config_1 row_off_detect_bot[7] x4_net15
+ dac_config_2 vdda1 vssa1 vssc1 col_event_rst_bot_right[48] x4_net16 row_on_detect_bot[7]
+ row_off_detect_bot[6] openDVS_pixel2x2_bot
x4_x1160 dac_config_3 dac_config_5 col_event_rst_bot_right[47] dac_config_4
+ row_on_detect_bot[6] dac_config_0 dac_config_1 row_off_detect_bot[7] x4_net17
+ dac_config_2 vdda1 vssa1 vssc1 col_event_rst_bot_right[46] x4_net18 row_on_detect_bot[7]
+ row_off_detect_bot[6] openDVS_pixel2x2_bot
x4_x1161 dac_config_3 dac_config_5 col_event_rst_bot_right[45] dac_config_4
+ row_on_detect_bot[6] dac_config_0 dac_config_1 row_off_detect_bot[7] x4_net19
+ dac_config_2 vdda1 vssa1 vssc1 col_event_rst_bot_right[44] x4_net20 row_on_detect_bot[7]
+ row_off_detect_bot[6] openDVS_pixel2x2_bot
x4_x1162 dac_config_3 dac_config_5 col_event_rst_bot_right[43] dac_config_4
+ row_on_detect_bot[6] dac_config_0 dac_config_1 row_off_detect_bot[7] x4_net21
+ dac_config_2 vdda1 vssa1 vssc1 col_event_rst_bot_right[42] x4_net22 row_on_detect_bot[7]
+ row_off_detect_bot[6] openDVS_pixel2x2_bot
x4_x1163 dac_config_3 dac_config_5 col_event_rst_bot_right[41] dac_config_4
+ row_on_detect_bot[6] dac_config_0 dac_config_1 row_off_detect_bot[7] x4_net23
+ dac_config_2 vdda1 vssa1 vssc1 col_event_rst_bot_right[40] x4_net24 row_on_detect_bot[7]
+ row_off_detect_bot[6] openDVS_pixel2x2_bot
x4_x1164 dac_config_3 dac_config_5 col_event_rst_bot_right[39] dac_config_4
+ row_on_detect_bot[6] dac_config_0 dac_config_1 row_off_detect_bot[7] x4_net25
+ dac_config_2 vdda1 vssa1 vssc1 col_event_rst_bot_right[38] x4_net26 row_on_detect_bot[7]
+ row_off_detect_bot[6] openDVS_pixel2x2_bot
x4_x1165 dac_config_3 dac_config_5 col_event_rst_bot_right[37] dac_config_4
+ row_on_detect_bot[6] dac_config_0 dac_config_1 row_off_detect_bot[7] x4_net27
+ dac_config_2 vdda1 vssa1 vssc1 col_event_rst_bot_right[36] x4_net28 row_on_detect_bot[7]
+ row_off_detect_bot[6] openDVS_pixel2x2_bot
x4_x1166 dac_config_3 dac_config_5 col_event_rst_bot_right[35] dac_config_4
+ row_on_detect_bot[6] dac_config_0 dac_config_1 row_off_detect_bot[7] x4_net29
+ dac_config_2 vdda1 vssa1 vssc1 col_event_rst_bot_right[34] x4_net30 row_on_detect_bot[7]
+ row_off_detect_bot[6] openDVS_pixel2x2_bot
x4_x1167 dac_config_3 dac_config_5 col_event_rst_bot_right[33] dac_config_4
+ row_on_detect_bot[6] dac_config_0 dac_config_1 row_off_detect_bot[7] x4_net31
+ dac_config_2 vdda1 vssa1 vssc1 col_event_rst_bot_right[32] x4_net32 row_on_detect_bot[7]
+ row_off_detect_bot[6] openDVS_pixel2x2_bot
x4_x1168 dac_config_3 dac_config_5 col_event_rst_bot_right[31] dac_config_4
+ row_on_detect_bot[6] dac_config_0 dac_config_1 row_off_detect_bot[7] x4_net33
+ dac_config_2 vdda1 vssa1 vssc1 col_event_rst_bot_right[30] x4_net34 row_on_detect_bot[7]
+ row_off_detect_bot[6] openDVS_pixel2x2_bot
x4_x1169 dac_config_3 dac_config_5 col_event_rst_bot_right[29] dac_config_4
+ row_on_detect_bot[6] dac_config_0 dac_config_1 row_off_detect_bot[7] x4_net35
+ dac_config_2 vdda1 vssa1 vssc1 col_event_rst_bot_right[28] x4_net36 row_on_detect_bot[7]
+ row_off_detect_bot[6] openDVS_pixel2x2_bot
x4_x1170 dac_config_3 dac_config_5 col_event_rst_bot_right[27] dac_config_4
+ row_on_detect_bot[6] dac_config_0 dac_config_1 row_off_detect_bot[7] x4_net37
+ dac_config_2 vdda1 vssa1 vssc1 col_event_rst_bot_right[26] x4_net38 row_on_detect_bot[7]
+ row_off_detect_bot[6] openDVS_pixel2x2_bot
x4_x1171 dac_config_3 dac_config_5 col_event_rst_bot_right[25] dac_config_4
+ row_on_detect_bot[6] dac_config_0 dac_config_1 row_off_detect_bot[7] x4_net39
+ dac_config_2 vdda1 vssa1 vssc1 col_event_rst_bot_right[24] x4_net40 row_on_detect_bot[7]
+ row_off_detect_bot[6] openDVS_pixel2x2_bot
x4_x1172 dac_config_3 dac_config_5 col_event_rst_bot_right[23] dac_config_4
+ row_on_detect_bot[6] dac_config_0 dac_config_1 row_off_detect_bot[7] x4_net41
+ dac_config_2 vdda1 vssa1 vssc1 col_event_rst_bot_right[22] x4_net42 row_on_detect_bot[7]
+ row_off_detect_bot[6] openDVS_pixel2x2_bot
x4_x1173 dac_config_3 dac_config_5 col_event_rst_bot_right[21] dac_config_4
+ row_on_detect_bot[6] dac_config_0 dac_config_1 row_off_detect_bot[7] x4_net43
+ dac_config_2 vdda1 vssa1 vssc1 col_event_rst_bot_right[20] x4_net44 row_on_detect_bot[7]
+ row_off_detect_bot[6] openDVS_pixel2x2_bot
x4_x1174 dac_config_3 dac_config_5 col_event_rst_bot_right[19] dac_config_4
+ row_on_detect_bot[6] dac_config_0 dac_config_1 row_off_detect_bot[7] x4_net45
+ dac_config_2 vdda1 vssa1 vssc1 col_event_rst_bot_right[18] x4_net46 row_on_detect_bot[7]
+ row_off_detect_bot[6] openDVS_pixel2x2_bot
x4_x1175 dac_config_3 dac_config_5 col_event_rst_bot_right[17] dac_config_4
+ row_on_detect_bot[6] dac_config_0 dac_config_1 row_off_detect_bot[7] x4_net47
+ dac_config_2 vdda1 vssa1 vssc1 col_event_rst_bot_right[16] x4_net48 row_on_detect_bot[7]
+ row_off_detect_bot[6] openDVS_pixel2x2_bot
x4_x1176 dac_config_3 dac_config_5 col_event_rst_bot_right[15] dac_config_4
+ row_on_detect_bot[6] dac_config_0 dac_config_1 row_off_detect_bot[7] x4_net49
+ dac_config_2 vdda1 vssa1 vssc1 col_event_rst_bot_right[14] x4_net50 row_on_detect_bot[7]
+ row_off_detect_bot[6] openDVS_pixel2x2_bot
x4_x1177 dac_config_3 dac_config_5 col_event_rst_bot_right[13] dac_config_4
+ row_on_detect_bot[6] dac_config_0 dac_config_1 row_off_detect_bot[7] x4_net51
+ dac_config_2 vdda1 vssa1 vssc1 col_event_rst_bot_right[12] x4_net52 row_on_detect_bot[7]
+ row_off_detect_bot[6] openDVS_pixel2x2_bot
x4_x1178 dac_config_3 dac_config_5 col_event_rst_bot_right[11] dac_config_4
+ row_on_detect_bot[6] dac_config_0 dac_config_1 row_off_detect_bot[7] x4_net53
+ dac_config_2 vdda1 vssa1 vssc1 col_event_rst_bot_right[10] x4_net54 row_on_detect_bot[7]
+ row_off_detect_bot[6] openDVS_pixel2x2_bot
x4_x1179 dac_config_3 dac_config_5 col_event_rst_bot_right[9] dac_config_4
+ row_on_detect_bot[6] dac_config_0 dac_config_1 row_off_detect_bot[7] x4_net55
+ dac_config_2 vdda1 vssa1 vssc1 col_event_rst_bot_right[8] x4_net56 row_on_detect_bot[7]
+ row_off_detect_bot[6] openDVS_pixel2x2_bot
x4_x1180 dac_config_3 dac_config_5 col_event_rst_bot_right[7] dac_config_4
+ row_on_detect_bot[6] dac_config_0 dac_config_1 row_off_detect_bot[7] x4_net57
+ dac_config_2 vdda1 vssa1 vssc1 col_event_rst_bot_right[6] x4_net58 row_on_detect_bot[7]
+ row_off_detect_bot[6] openDVS_pixel2x2_bot
x4_x1181 dac_config_3 dac_config_5 col_event_rst_bot_right[5] dac_config_4
+ row_on_detect_bot[6] dac_config_0 dac_config_1 row_off_detect_bot[7] x4_net59
+ dac_config_2 vdda1 vssa1 vssc1 col_event_rst_bot_right[4] x4_net60 row_on_detect_bot[7]
+ row_off_detect_bot[6] openDVS_pixel2x2_bot
x4_x1182 dac_config_3 dac_config_5 col_event_rst_bot_right[3] dac_config_4
+ row_on_detect_bot[6] dac_config_0 dac_config_1 row_off_detect_bot[7] x4_net61
+ dac_config_2 vdda1 vssa1 vssc1 col_event_rst_bot_right[2] x4_net62 row_on_detect_bot[7]
+ row_off_detect_bot[6] openDVS_pixel2x2_bot
x4_x1183 dac_config_3 dac_config_5 col_event_rst_bot_right[1] dac_config_4
+ row_on_detect_bot[6] dac_config_0 dac_config_1 row_off_detect_bot[7] x4_net63
+ dac_config_2 vdda1 vssa1 vssc1 col_event_rst_bot_right[0] x4_net64 row_on_detect_bot[7]
+ row_off_detect_bot[6] openDVS_pixel2x2_bot
x4_x1184 dac_config_3 dac_config_5 col_event_rst_bot_right[63] dac_config_4
+ row_on_detect_bot[8] dac_config_0 dac_config_1 row_off_detect_bot[9] x4_net1
+ dac_config_2 vdda1 vssa1 vssc1 col_event_rst_bot_right[62] x4_net2 row_on_detect_bot[9]
+ row_off_detect_bot[8] openDVS_pixel2x2_bot
x4_x1185 dac_config_3 dac_config_5 col_event_rst_bot_right[61] dac_config_4
+ row_on_detect_bot[8] dac_config_0 dac_config_1 row_off_detect_bot[9] x4_net3
+ dac_config_2 vdda1 vssa1 vssc1 col_event_rst_bot_right[60] x4_net4 row_on_detect_bot[9]
+ row_off_detect_bot[8] openDVS_pixel2x2_bot
x4_x1186 dac_config_3 dac_config_5 col_event_rst_bot_right[59] dac_config_4
+ row_on_detect_bot[8] dac_config_0 dac_config_1 row_off_detect_bot[9] x4_net5
+ dac_config_2 vdda1 vssa1 vssc1 col_event_rst_bot_right[58] x4_net6 row_on_detect_bot[9]
+ row_off_detect_bot[8] openDVS_pixel2x2_bot
x4_x1187 dac_config_3 dac_config_5 col_event_rst_bot_right[57] dac_config_4
+ row_on_detect_bot[8] dac_config_0 dac_config_1 row_off_detect_bot[9] x4_net7
+ dac_config_2 vdda1 vssa1 vssc1 col_event_rst_bot_right[56] x4_net8 row_on_detect_bot[9]
+ row_off_detect_bot[8] openDVS_pixel2x2_bot
x4_x1188 dac_config_3 dac_config_5 col_event_rst_bot_right[55] dac_config_4
+ row_on_detect_bot[8] dac_config_0 dac_config_1 row_off_detect_bot[9] x4_net9
+ dac_config_2 vdda1 vssa1 vssc1 col_event_rst_bot_right[54] x4_net10 row_on_detect_bot[9]
+ row_off_detect_bot[8] openDVS_pixel2x2_bot
x4_x1189 dac_config_3 dac_config_5 col_event_rst_bot_right[53] dac_config_4
+ row_on_detect_bot[8] dac_config_0 dac_config_1 row_off_detect_bot[9] x4_net11
+ dac_config_2 vdda1 vssa1 vssc1 col_event_rst_bot_right[52] x4_net12 row_on_detect_bot[9]
+ row_off_detect_bot[8] openDVS_pixel2x2_bot
x4_x1190 dac_config_3 dac_config_5 col_event_rst_bot_right[51] dac_config_4
+ row_on_detect_bot[8] dac_config_0 dac_config_1 row_off_detect_bot[9] x4_net13
+ dac_config_2 vdda1 vssa1 vssc1 col_event_rst_bot_right[50] x4_net14 row_on_detect_bot[9]
+ row_off_detect_bot[8] openDVS_pixel2x2_bot
x4_x1191 dac_config_3 dac_config_5 col_event_rst_bot_right[49] dac_config_4
+ row_on_detect_bot[8] dac_config_0 dac_config_1 row_off_detect_bot[9] x4_net15
+ dac_config_2 vdda1 vssa1 vssc1 col_event_rst_bot_right[48] x4_net16 row_on_detect_bot[9]
+ row_off_detect_bot[8] openDVS_pixel2x2_bot
x4_x1192 dac_config_3 dac_config_5 col_event_rst_bot_right[47] dac_config_4
+ row_on_detect_bot[8] dac_config_0 dac_config_1 row_off_detect_bot[9] x4_net17
+ dac_config_2 vdda1 vssa1 vssc1 col_event_rst_bot_right[46] x4_net18 row_on_detect_bot[9]
+ row_off_detect_bot[8] openDVS_pixel2x2_bot
x4_x1193 dac_config_3 dac_config_5 col_event_rst_bot_right[45] dac_config_4
+ row_on_detect_bot[8] dac_config_0 dac_config_1 row_off_detect_bot[9] x4_net19
+ dac_config_2 vdda1 vssa1 vssc1 col_event_rst_bot_right[44] x4_net20 row_on_detect_bot[9]
+ row_off_detect_bot[8] openDVS_pixel2x2_bot
x4_x1194 dac_config_3 dac_config_5 col_event_rst_bot_right[43] dac_config_4
+ row_on_detect_bot[8] dac_config_0 dac_config_1 row_off_detect_bot[9] x4_net21
+ dac_config_2 vdda1 vssa1 vssc1 col_event_rst_bot_right[42] x4_net22 row_on_detect_bot[9]
+ row_off_detect_bot[8] openDVS_pixel2x2_bot
x4_x1195 dac_config_3 dac_config_5 col_event_rst_bot_right[41] dac_config_4
+ row_on_detect_bot[8] dac_config_0 dac_config_1 row_off_detect_bot[9] x4_net23
+ dac_config_2 vdda1 vssa1 vssc1 col_event_rst_bot_right[40] x4_net24 row_on_detect_bot[9]
+ row_off_detect_bot[8] openDVS_pixel2x2_bot
x4_x1196 dac_config_3 dac_config_5 col_event_rst_bot_right[39] dac_config_4
+ row_on_detect_bot[8] dac_config_0 dac_config_1 row_off_detect_bot[9] x4_net25
+ dac_config_2 vdda1 vssa1 vssc1 col_event_rst_bot_right[38] x4_net26 row_on_detect_bot[9]
+ row_off_detect_bot[8] openDVS_pixel2x2_bot
x4_x1197 dac_config_3 dac_config_5 col_event_rst_bot_right[37] dac_config_4
+ row_on_detect_bot[8] dac_config_0 dac_config_1 row_off_detect_bot[9] x4_net27
+ dac_config_2 vdda1 vssa1 vssc1 col_event_rst_bot_right[36] x4_net28 row_on_detect_bot[9]
+ row_off_detect_bot[8] openDVS_pixel2x2_bot
x4_x1198 dac_config_3 dac_config_5 col_event_rst_bot_right[35] dac_config_4
+ row_on_detect_bot[8] dac_config_0 dac_config_1 row_off_detect_bot[9] x4_net29
+ dac_config_2 vdda1 vssa1 vssc1 col_event_rst_bot_right[34] x4_net30 row_on_detect_bot[9]
+ row_off_detect_bot[8] openDVS_pixel2x2_bot
x4_x1199 dac_config_3 dac_config_5 col_event_rst_bot_right[33] dac_config_4
+ row_on_detect_bot[8] dac_config_0 dac_config_1 row_off_detect_bot[9] x4_net31
+ dac_config_2 vdda1 vssa1 vssc1 col_event_rst_bot_right[32] x4_net32 row_on_detect_bot[9]
+ row_off_detect_bot[8] openDVS_pixel2x2_bot
x4_x1200 dac_config_3 dac_config_5 col_event_rst_bot_right[31] dac_config_4
+ row_on_detect_bot[8] dac_config_0 dac_config_1 row_off_detect_bot[9] x4_net33
+ dac_config_2 vdda1 vssa1 vssc1 col_event_rst_bot_right[30] x4_net34 row_on_detect_bot[9]
+ row_off_detect_bot[8] openDVS_pixel2x2_bot
x4_x1201 dac_config_3 dac_config_5 col_event_rst_bot_right[29] dac_config_4
+ row_on_detect_bot[8] dac_config_0 dac_config_1 row_off_detect_bot[9] x4_net35
+ dac_config_2 vdda1 vssa1 vssc1 col_event_rst_bot_right[28] x4_net36 row_on_detect_bot[9]
+ row_off_detect_bot[8] openDVS_pixel2x2_bot
x4_x1202 dac_config_3 dac_config_5 col_event_rst_bot_right[27] dac_config_4
+ row_on_detect_bot[8] dac_config_0 dac_config_1 row_off_detect_bot[9] x4_net37
+ dac_config_2 vdda1 vssa1 vssc1 col_event_rst_bot_right[26] x4_net38 row_on_detect_bot[9]
+ row_off_detect_bot[8] openDVS_pixel2x2_bot
x4_x1203 dac_config_3 dac_config_5 col_event_rst_bot_right[25] dac_config_4
+ row_on_detect_bot[8] dac_config_0 dac_config_1 row_off_detect_bot[9] x4_net39
+ dac_config_2 vdda1 vssa1 vssc1 col_event_rst_bot_right[24] x4_net40 row_on_detect_bot[9]
+ row_off_detect_bot[8] openDVS_pixel2x2_bot
x4_x1204 dac_config_3 dac_config_5 col_event_rst_bot_right[23] dac_config_4
+ row_on_detect_bot[8] dac_config_0 dac_config_1 row_off_detect_bot[9] x4_net41
+ dac_config_2 vdda1 vssa1 vssc1 col_event_rst_bot_right[22] x4_net42 row_on_detect_bot[9]
+ row_off_detect_bot[8] openDVS_pixel2x2_bot
x4_x1205 dac_config_3 dac_config_5 col_event_rst_bot_right[21] dac_config_4
+ row_on_detect_bot[8] dac_config_0 dac_config_1 row_off_detect_bot[9] x4_net43
+ dac_config_2 vdda1 vssa1 vssc1 col_event_rst_bot_right[20] x4_net44 row_on_detect_bot[9]
+ row_off_detect_bot[8] openDVS_pixel2x2_bot
x4_x1206 dac_config_3 dac_config_5 col_event_rst_bot_right[19] dac_config_4
+ row_on_detect_bot[8] dac_config_0 dac_config_1 row_off_detect_bot[9] x4_net45
+ dac_config_2 vdda1 vssa1 vssc1 col_event_rst_bot_right[18] x4_net46 row_on_detect_bot[9]
+ row_off_detect_bot[8] openDVS_pixel2x2_bot
x4_x1207 dac_config_3 dac_config_5 col_event_rst_bot_right[17] dac_config_4
+ row_on_detect_bot[8] dac_config_0 dac_config_1 row_off_detect_bot[9] x4_net47
+ dac_config_2 vdda1 vssa1 vssc1 col_event_rst_bot_right[16] x4_net48 row_on_detect_bot[9]
+ row_off_detect_bot[8] openDVS_pixel2x2_bot
x4_x1208 dac_config_3 dac_config_5 col_event_rst_bot_right[15] dac_config_4
+ row_on_detect_bot[8] dac_config_0 dac_config_1 row_off_detect_bot[9] x4_net49
+ dac_config_2 vdda1 vssa1 vssc1 col_event_rst_bot_right[14] x4_net50 row_on_detect_bot[9]
+ row_off_detect_bot[8] openDVS_pixel2x2_bot
x4_x1209 dac_config_3 dac_config_5 col_event_rst_bot_right[13] dac_config_4
+ row_on_detect_bot[8] dac_config_0 dac_config_1 row_off_detect_bot[9] x4_net51
+ dac_config_2 vdda1 vssa1 vssc1 col_event_rst_bot_right[12] x4_net52 row_on_detect_bot[9]
+ row_off_detect_bot[8] openDVS_pixel2x2_bot
x4_x1210 dac_config_3 dac_config_5 col_event_rst_bot_right[11] dac_config_4
+ row_on_detect_bot[8] dac_config_0 dac_config_1 row_off_detect_bot[9] x4_net53
+ dac_config_2 vdda1 vssa1 vssc1 col_event_rst_bot_right[10] x4_net54 row_on_detect_bot[9]
+ row_off_detect_bot[8] openDVS_pixel2x2_bot
x4_x1211 dac_config_3 dac_config_5 col_event_rst_bot_right[9] dac_config_4
+ row_on_detect_bot[8] dac_config_0 dac_config_1 row_off_detect_bot[9] x4_net55
+ dac_config_2 vdda1 vssa1 vssc1 col_event_rst_bot_right[8] x4_net56 row_on_detect_bot[9]
+ row_off_detect_bot[8] openDVS_pixel2x2_bot
x4_x1212 dac_config_3 dac_config_5 col_event_rst_bot_right[7] dac_config_4
+ row_on_detect_bot[8] dac_config_0 dac_config_1 row_off_detect_bot[9] x4_net57
+ dac_config_2 vdda1 vssa1 vssc1 col_event_rst_bot_right[6] x4_net58 row_on_detect_bot[9]
+ row_off_detect_bot[8] openDVS_pixel2x2_bot
x4_x1213 dac_config_3 dac_config_5 col_event_rst_bot_right[5] dac_config_4
+ row_on_detect_bot[8] dac_config_0 dac_config_1 row_off_detect_bot[9] x4_net59
+ dac_config_2 vdda1 vssa1 vssc1 col_event_rst_bot_right[4] x4_net60 row_on_detect_bot[9]
+ row_off_detect_bot[8] openDVS_pixel2x2_bot
x4_x1214 dac_config_3 dac_config_5 col_event_rst_bot_right[3] dac_config_4
+ row_on_detect_bot[8] dac_config_0 dac_config_1 row_off_detect_bot[9] x4_net61
+ dac_config_2 vdda1 vssa1 vssc1 col_event_rst_bot_right[2] x4_net62 row_on_detect_bot[9]
+ row_off_detect_bot[8] openDVS_pixel2x2_bot
x4_x1215 dac_config_3 dac_config_5 col_event_rst_bot_right[1] dac_config_4
+ row_on_detect_bot[8] dac_config_0 dac_config_1 row_off_detect_bot[9] x4_net63
+ dac_config_2 vdda1 vssa1 vssc1 col_event_rst_bot_right[0] x4_net64 row_on_detect_bot[9]
+ row_off_detect_bot[8] openDVS_pixel2x2_bot
x4_x1216 dac_config_3 dac_config_5 col_event_rst_bot_right[63] dac_config_4
+ row_on_detect_bot[10] dac_config_0 dac_config_1 row_off_detect_bot[11] x4_net1
+ dac_config_2 vdda1 vssa1 vssc1 col_event_rst_bot_right[62] x4_net2 row_on_detect_bot[11]
+ row_off_detect_bot[10] openDVS_pixel2x2_bot
x4_x1217 dac_config_3 dac_config_5 col_event_rst_bot_right[61] dac_config_4
+ row_on_detect_bot[10] dac_config_0 dac_config_1 row_off_detect_bot[11] x4_net3
+ dac_config_2 vdda1 vssa1 vssc1 col_event_rst_bot_right[60] x4_net4 row_on_detect_bot[11]
+ row_off_detect_bot[10] openDVS_pixel2x2_bot
x4_x1218 dac_config_3 dac_config_5 col_event_rst_bot_right[59] dac_config_4
+ row_on_detect_bot[10] dac_config_0 dac_config_1 row_off_detect_bot[11] x4_net5
+ dac_config_2 vdda1 vssa1 vssc1 col_event_rst_bot_right[58] x4_net6 row_on_detect_bot[11]
+ row_off_detect_bot[10] openDVS_pixel2x2_bot
x4_x1219 dac_config_3 dac_config_5 col_event_rst_bot_right[57] dac_config_4
+ row_on_detect_bot[10] dac_config_0 dac_config_1 row_off_detect_bot[11] x4_net7
+ dac_config_2 vdda1 vssa1 vssc1 col_event_rst_bot_right[56] x4_net8 row_on_detect_bot[11]
+ row_off_detect_bot[10] openDVS_pixel2x2_bot
x4_x1220 dac_config_3 dac_config_5 col_event_rst_bot_right[55] dac_config_4
+ row_on_detect_bot[10] dac_config_0 dac_config_1 row_off_detect_bot[11] x4_net9
+ dac_config_2 vdda1 vssa1 vssc1 col_event_rst_bot_right[54] x4_net10
+ row_on_detect_bot[11] row_off_detect_bot[10] openDVS_pixel2x2_bot
x4_x1221 dac_config_3 dac_config_5 col_event_rst_bot_right[53] dac_config_4
+ row_on_detect_bot[10] dac_config_0 dac_config_1 row_off_detect_bot[11] x4_net11
+ dac_config_2 vdda1 vssa1 vssc1 col_event_rst_bot_right[52] x4_net12
+ row_on_detect_bot[11] row_off_detect_bot[10] openDVS_pixel2x2_bot
x4_x1222 dac_config_3 dac_config_5 col_event_rst_bot_right[51] dac_config_4
+ row_on_detect_bot[10] dac_config_0 dac_config_1 row_off_detect_bot[11] x4_net13
+ dac_config_2 vdda1 vssa1 vssc1 col_event_rst_bot_right[50] x4_net14
+ row_on_detect_bot[11] row_off_detect_bot[10] openDVS_pixel2x2_bot
x4_x1223 dac_config_3 dac_config_5 col_event_rst_bot_right[49] dac_config_4
+ row_on_detect_bot[10] dac_config_0 dac_config_1 row_off_detect_bot[11] x4_net15
+ dac_config_2 vdda1 vssa1 vssc1 col_event_rst_bot_right[48] x4_net16
+ row_on_detect_bot[11] row_off_detect_bot[10] openDVS_pixel2x2_bot
x4_x1224 dac_config_3 dac_config_5 col_event_rst_bot_right[47] dac_config_4
+ row_on_detect_bot[10] dac_config_0 dac_config_1 row_off_detect_bot[11] x4_net17
+ dac_config_2 vdda1 vssa1 vssc1 col_event_rst_bot_right[46] x4_net18
+ row_on_detect_bot[11] row_off_detect_bot[10] openDVS_pixel2x2_bot
x4_x1225 dac_config_3 dac_config_5 col_event_rst_bot_right[45] dac_config_4
+ row_on_detect_bot[10] dac_config_0 dac_config_1 row_off_detect_bot[11] x4_net19
+ dac_config_2 vdda1 vssa1 vssc1 col_event_rst_bot_right[44] x4_net20
+ row_on_detect_bot[11] row_off_detect_bot[10] openDVS_pixel2x2_bot
x4_x1226 dac_config_3 dac_config_5 col_event_rst_bot_right[43] dac_config_4
+ row_on_detect_bot[10] dac_config_0 dac_config_1 row_off_detect_bot[11] x4_net21
+ dac_config_2 vdda1 vssa1 vssc1 col_event_rst_bot_right[42] x4_net22
+ row_on_detect_bot[11] row_off_detect_bot[10] openDVS_pixel2x2_bot
x4_x1227 dac_config_3 dac_config_5 col_event_rst_bot_right[41] dac_config_4
+ row_on_detect_bot[10] dac_config_0 dac_config_1 row_off_detect_bot[11] x4_net23
+ dac_config_2 vdda1 vssa1 vssc1 col_event_rst_bot_right[40] x4_net24
+ row_on_detect_bot[11] row_off_detect_bot[10] openDVS_pixel2x2_bot
x4_x1228 dac_config_3 dac_config_5 col_event_rst_bot_right[39] dac_config_4
+ row_on_detect_bot[10] dac_config_0 dac_config_1 row_off_detect_bot[11] x4_net25
+ dac_config_2 vdda1 vssa1 vssc1 col_event_rst_bot_right[38] x4_net26
+ row_on_detect_bot[11] row_off_detect_bot[10] openDVS_pixel2x2_bot
x4_x1229 dac_config_3 dac_config_5 col_event_rst_bot_right[37] dac_config_4
+ row_on_detect_bot[10] dac_config_0 dac_config_1 row_off_detect_bot[11] x4_net27
+ dac_config_2 vdda1 vssa1 vssc1 col_event_rst_bot_right[36] x4_net28
+ row_on_detect_bot[11] row_off_detect_bot[10] openDVS_pixel2x2_bot
x4_x1230 dac_config_3 dac_config_5 col_event_rst_bot_right[35] dac_config_4
+ row_on_detect_bot[10] dac_config_0 dac_config_1 row_off_detect_bot[11] x4_net29
+ dac_config_2 vdda1 vssa1 vssc1 col_event_rst_bot_right[34] x4_net30
+ row_on_detect_bot[11] row_off_detect_bot[10] openDVS_pixel2x2_bot
x4_x1231 dac_config_3 dac_config_5 col_event_rst_bot_right[33] dac_config_4
+ row_on_detect_bot[10] dac_config_0 dac_config_1 row_off_detect_bot[11] x4_net31
+ dac_config_2 vdda1 vssa1 vssc1 col_event_rst_bot_right[32] x4_net32
+ row_on_detect_bot[11] row_off_detect_bot[10] openDVS_pixel2x2_bot
x4_x1232 dac_config_3 dac_config_5 col_event_rst_bot_right[31] dac_config_4
+ row_on_detect_bot[10] dac_config_0 dac_config_1 row_off_detect_bot[11] x4_net33
+ dac_config_2 vdda1 vssa1 vssc1 col_event_rst_bot_right[30] x4_net34
+ row_on_detect_bot[11] row_off_detect_bot[10] openDVS_pixel2x2_bot
x4_x1233 dac_config_3 dac_config_5 col_event_rst_bot_right[29] dac_config_4
+ row_on_detect_bot[10] dac_config_0 dac_config_1 row_off_detect_bot[11] x4_net35
+ dac_config_2 vdda1 vssa1 vssc1 col_event_rst_bot_right[28] x4_net36
+ row_on_detect_bot[11] row_off_detect_bot[10] openDVS_pixel2x2_bot
x4_x1234 dac_config_3 dac_config_5 col_event_rst_bot_right[27] dac_config_4
+ row_on_detect_bot[10] dac_config_0 dac_config_1 row_off_detect_bot[11] x4_net37
+ dac_config_2 vdda1 vssa1 vssc1 col_event_rst_bot_right[26] x4_net38
+ row_on_detect_bot[11] row_off_detect_bot[10] openDVS_pixel2x2_bot
x4_x1235 dac_config_3 dac_config_5 col_event_rst_bot_right[25] dac_config_4
+ row_on_detect_bot[10] dac_config_0 dac_config_1 row_off_detect_bot[11] x4_net39
+ dac_config_2 vdda1 vssa1 vssc1 col_event_rst_bot_right[24] x4_net40
+ row_on_detect_bot[11] row_off_detect_bot[10] openDVS_pixel2x2_bot
x4_x1236 dac_config_3 dac_config_5 col_event_rst_bot_right[23] dac_config_4
+ row_on_detect_bot[10] dac_config_0 dac_config_1 row_off_detect_bot[11] x4_net41
+ dac_config_2 vdda1 vssa1 vssc1 col_event_rst_bot_right[22] x4_net42
+ row_on_detect_bot[11] row_off_detect_bot[10] openDVS_pixel2x2_bot
x4_x1237 dac_config_3 dac_config_5 col_event_rst_bot_right[21] dac_config_4
+ row_on_detect_bot[10] dac_config_0 dac_config_1 row_off_detect_bot[11] x4_net43
+ dac_config_2 vdda1 vssa1 vssc1 col_event_rst_bot_right[20] x4_net44
+ row_on_detect_bot[11] row_off_detect_bot[10] openDVS_pixel2x2_bot
x4_x1238 dac_config_3 dac_config_5 col_event_rst_bot_right[19] dac_config_4
+ row_on_detect_bot[10] dac_config_0 dac_config_1 row_off_detect_bot[11] x4_net45
+ dac_config_2 vdda1 vssa1 vssc1 col_event_rst_bot_right[18] x4_net46
+ row_on_detect_bot[11] row_off_detect_bot[10] openDVS_pixel2x2_bot
x4_x1239 dac_config_3 dac_config_5 col_event_rst_bot_right[17] dac_config_4
+ row_on_detect_bot[10] dac_config_0 dac_config_1 row_off_detect_bot[11] x4_net47
+ dac_config_2 vdda1 vssa1 vssc1 col_event_rst_bot_right[16] x4_net48
+ row_on_detect_bot[11] row_off_detect_bot[10] openDVS_pixel2x2_bot
x4_x1240 dac_config_3 dac_config_5 col_event_rst_bot_right[15] dac_config_4
+ row_on_detect_bot[10] dac_config_0 dac_config_1 row_off_detect_bot[11] x4_net49
+ dac_config_2 vdda1 vssa1 vssc1 col_event_rst_bot_right[14] x4_net50
+ row_on_detect_bot[11] row_off_detect_bot[10] openDVS_pixel2x2_bot
x4_x1241 dac_config_3 dac_config_5 col_event_rst_bot_right[13] dac_config_4
+ row_on_detect_bot[10] dac_config_0 dac_config_1 row_off_detect_bot[11] x4_net51
+ dac_config_2 vdda1 vssa1 vssc1 col_event_rst_bot_right[12] x4_net52
+ row_on_detect_bot[11] row_off_detect_bot[10] openDVS_pixel2x2_bot
x4_x1242 dac_config_3 dac_config_5 col_event_rst_bot_right[11] dac_config_4
+ row_on_detect_bot[10] dac_config_0 dac_config_1 row_off_detect_bot[11] x4_net53
+ dac_config_2 vdda1 vssa1 vssc1 col_event_rst_bot_right[10] x4_net54
+ row_on_detect_bot[11] row_off_detect_bot[10] openDVS_pixel2x2_bot
x4_x1243 dac_config_3 dac_config_5 col_event_rst_bot_right[9] dac_config_4
+ row_on_detect_bot[10] dac_config_0 dac_config_1 row_off_detect_bot[11] x4_net55
+ dac_config_2 vdda1 vssa1 vssc1 col_event_rst_bot_right[8] x4_net56 row_on_detect_bot[11]
+ row_off_detect_bot[10] openDVS_pixel2x2_bot
x4_x1244 dac_config_3 dac_config_5 col_event_rst_bot_right[7] dac_config_4
+ row_on_detect_bot[10] dac_config_0 dac_config_1 row_off_detect_bot[11] x4_net57
+ dac_config_2 vdda1 vssa1 vssc1 col_event_rst_bot_right[6] x4_net58 row_on_detect_bot[11]
+ row_off_detect_bot[10] openDVS_pixel2x2_bot
x4_x1245 dac_config_3 dac_config_5 col_event_rst_bot_right[5] dac_config_4
+ row_on_detect_bot[10] dac_config_0 dac_config_1 row_off_detect_bot[11] x4_net59
+ dac_config_2 vdda1 vssa1 vssc1 col_event_rst_bot_right[4] x4_net60 row_on_detect_bot[11]
+ row_off_detect_bot[10] openDVS_pixel2x2_bot
x4_x1246 dac_config_3 dac_config_5 col_event_rst_bot_right[3] dac_config_4
+ row_on_detect_bot[10] dac_config_0 dac_config_1 row_off_detect_bot[11] x4_net61
+ dac_config_2 vdda1 vssa1 vssc1 col_event_rst_bot_right[2] x4_net62 row_on_detect_bot[11]
+ row_off_detect_bot[10] openDVS_pixel2x2_bot
x4_x1247 dac_config_3 dac_config_5 col_event_rst_bot_right[1] dac_config_4
+ row_on_detect_bot[10] dac_config_0 dac_config_1 row_off_detect_bot[11] x4_net63
+ dac_config_2 vdda1 vssa1 vssc1 col_event_rst_bot_right[0] x4_net64 row_on_detect_bot[11]
+ row_off_detect_bot[10] openDVS_pixel2x2_bot
x4_x1248 dac_config_3 dac_config_5 col_event_rst_bot_right[63] dac_config_4
+ row_on_detect_bot[12] dac_config_0 dac_config_1 row_off_detect_bot[13] x4_net1
+ dac_config_2 vdda1 vssa1 vssc1 col_event_rst_bot_right[62] x4_net2 row_on_detect_bot[13]
+ row_off_detect_bot[12] openDVS_pixel2x2_bot
x4_x1249 dac_config_3 dac_config_5 col_event_rst_bot_right[61] dac_config_4
+ row_on_detect_bot[12] dac_config_0 dac_config_1 row_off_detect_bot[13] x4_net3
+ dac_config_2 vdda1 vssa1 vssc1 col_event_rst_bot_right[60] x4_net4 row_on_detect_bot[13]
+ row_off_detect_bot[12] openDVS_pixel2x2_bot
x4_x1250 dac_config_3 dac_config_5 col_event_rst_bot_right[59] dac_config_4
+ row_on_detect_bot[12] dac_config_0 dac_config_1 row_off_detect_bot[13] x4_net5
+ dac_config_2 vdda1 vssa1 vssc1 col_event_rst_bot_right[58] x4_net6 row_on_detect_bot[13]
+ row_off_detect_bot[12] openDVS_pixel2x2_bot
x4_x1251 dac_config_3 dac_config_5 col_event_rst_bot_right[57] dac_config_4
+ row_on_detect_bot[12] dac_config_0 dac_config_1 row_off_detect_bot[13] x4_net7
+ dac_config_2 vdda1 vssa1 vssc1 col_event_rst_bot_right[56] x4_net8 row_on_detect_bot[13]
+ row_off_detect_bot[12] openDVS_pixel2x2_bot
x4_x1252 dac_config_3 dac_config_5 col_event_rst_bot_right[55] dac_config_4
+ row_on_detect_bot[12] dac_config_0 dac_config_1 row_off_detect_bot[13] x4_net9
+ dac_config_2 vdda1 vssa1 vssc1 col_event_rst_bot_right[54] x4_net10
+ row_on_detect_bot[13] row_off_detect_bot[12] openDVS_pixel2x2_bot
x4_x1253 dac_config_3 dac_config_5 col_event_rst_bot_right[53] dac_config_4
+ row_on_detect_bot[12] dac_config_0 dac_config_1 row_off_detect_bot[13] x4_net11
+ dac_config_2 vdda1 vssa1 vssc1 col_event_rst_bot_right[52] x4_net12
+ row_on_detect_bot[13] row_off_detect_bot[12] openDVS_pixel2x2_bot
x4_x1254 dac_config_3 dac_config_5 col_event_rst_bot_right[51] dac_config_4
+ row_on_detect_bot[12] dac_config_0 dac_config_1 row_off_detect_bot[13] x4_net13
+ dac_config_2 vdda1 vssa1 vssc1 col_event_rst_bot_right[50] x4_net14
+ row_on_detect_bot[13] row_off_detect_bot[12] openDVS_pixel2x2_bot
x4_x1255 dac_config_3 dac_config_5 col_event_rst_bot_right[49] dac_config_4
+ row_on_detect_bot[12] dac_config_0 dac_config_1 row_off_detect_bot[13] x4_net15
+ dac_config_2 vdda1 vssa1 vssc1 col_event_rst_bot_right[48] x4_net16
+ row_on_detect_bot[13] row_off_detect_bot[12] openDVS_pixel2x2_bot
x4_x1256 dac_config_3 dac_config_5 col_event_rst_bot_right[47] dac_config_4
+ row_on_detect_bot[12] dac_config_0 dac_config_1 row_off_detect_bot[13] x4_net17
+ dac_config_2 vdda1 vssa1 vssc1 col_event_rst_bot_right[46] x4_net18
+ row_on_detect_bot[13] row_off_detect_bot[12] openDVS_pixel2x2_bot
x4_x1257 dac_config_3 dac_config_5 col_event_rst_bot_right[45] dac_config_4
+ row_on_detect_bot[12] dac_config_0 dac_config_1 row_off_detect_bot[13] x4_net19
+ dac_config_2 vdda1 vssa1 vssc1 col_event_rst_bot_right[44] x4_net20
+ row_on_detect_bot[13] row_off_detect_bot[12] openDVS_pixel2x2_bot
x4_x1258 dac_config_3 dac_config_5 col_event_rst_bot_right[43] dac_config_4
+ row_on_detect_bot[12] dac_config_0 dac_config_1 row_off_detect_bot[13] x4_net21
+ dac_config_2 vdda1 vssa1 vssc1 col_event_rst_bot_right[42] x4_net22
+ row_on_detect_bot[13] row_off_detect_bot[12] openDVS_pixel2x2_bot
x4_x1259 dac_config_3 dac_config_5 col_event_rst_bot_right[41] dac_config_4
+ row_on_detect_bot[12] dac_config_0 dac_config_1 row_off_detect_bot[13] x4_net23
+ dac_config_2 vdda1 vssa1 vssc1 col_event_rst_bot_right[40] x4_net24
+ row_on_detect_bot[13] row_off_detect_bot[12] openDVS_pixel2x2_bot
x4_x1260 dac_config_3 dac_config_5 col_event_rst_bot_right[39] dac_config_4
+ row_on_detect_bot[12] dac_config_0 dac_config_1 row_off_detect_bot[13] x4_net25
+ dac_config_2 vdda1 vssa1 vssc1 col_event_rst_bot_right[38] x4_net26
+ row_on_detect_bot[13] row_off_detect_bot[12] openDVS_pixel2x2_bot
x4_x1261 dac_config_3 dac_config_5 col_event_rst_bot_right[37] dac_config_4
+ row_on_detect_bot[12] dac_config_0 dac_config_1 row_off_detect_bot[13] x4_net27
+ dac_config_2 vdda1 vssa1 vssc1 col_event_rst_bot_right[36] x4_net28
+ row_on_detect_bot[13] row_off_detect_bot[12] openDVS_pixel2x2_bot
x4_x1262 dac_config_3 dac_config_5 col_event_rst_bot_right[35] dac_config_4
+ row_on_detect_bot[12] dac_config_0 dac_config_1 row_off_detect_bot[13] x4_net29
+ dac_config_2 vdda1 vssa1 vssc1 col_event_rst_bot_right[34] x4_net30
+ row_on_detect_bot[13] row_off_detect_bot[12] openDVS_pixel2x2_bot
x4_x1263 dac_config_3 dac_config_5 col_event_rst_bot_right[33] dac_config_4
+ row_on_detect_bot[12] dac_config_0 dac_config_1 row_off_detect_bot[13] x4_net31
+ dac_config_2 vdda1 vssa1 vssc1 col_event_rst_bot_right[32] x4_net32
+ row_on_detect_bot[13] row_off_detect_bot[12] openDVS_pixel2x2_bot
x4_x1264 dac_config_3 dac_config_5 col_event_rst_bot_right[31] dac_config_4
+ row_on_detect_bot[12] dac_config_0 dac_config_1 row_off_detect_bot[13] x4_net33
+ dac_config_2 vdda1 vssa1 vssc1 col_event_rst_bot_right[30] x4_net34
+ row_on_detect_bot[13] row_off_detect_bot[12] openDVS_pixel2x2_bot
x4_x1265 dac_config_3 dac_config_5 col_event_rst_bot_right[29] dac_config_4
+ row_on_detect_bot[12] dac_config_0 dac_config_1 row_off_detect_bot[13] x4_net35
+ dac_config_2 vdda1 vssa1 vssc1 col_event_rst_bot_right[28] x4_net36
+ row_on_detect_bot[13] row_off_detect_bot[12] openDVS_pixel2x2_bot
x4_x1266 dac_config_3 dac_config_5 col_event_rst_bot_right[27] dac_config_4
+ row_on_detect_bot[12] dac_config_0 dac_config_1 row_off_detect_bot[13] x4_net37
+ dac_config_2 vdda1 vssa1 vssc1 col_event_rst_bot_right[26] x4_net38
+ row_on_detect_bot[13] row_off_detect_bot[12] openDVS_pixel2x2_bot
x4_x1267 dac_config_3 dac_config_5 col_event_rst_bot_right[25] dac_config_4
+ row_on_detect_bot[12] dac_config_0 dac_config_1 row_off_detect_bot[13] x4_net39
+ dac_config_2 vdda1 vssa1 vssc1 col_event_rst_bot_right[24] x4_net40
+ row_on_detect_bot[13] row_off_detect_bot[12] openDVS_pixel2x2_bot
x4_x1268 dac_config_3 dac_config_5 col_event_rst_bot_right[23] dac_config_4
+ row_on_detect_bot[12] dac_config_0 dac_config_1 row_off_detect_bot[13] x4_net41
+ dac_config_2 vdda1 vssa1 vssc1 col_event_rst_bot_right[22] x4_net42
+ row_on_detect_bot[13] row_off_detect_bot[12] openDVS_pixel2x2_bot
x4_x1269 dac_config_3 dac_config_5 col_event_rst_bot_right[21] dac_config_4
+ row_on_detect_bot[12] dac_config_0 dac_config_1 row_off_detect_bot[13] x4_net43
+ dac_config_2 vdda1 vssa1 vssc1 col_event_rst_bot_right[20] x4_net44
+ row_on_detect_bot[13] row_off_detect_bot[12] openDVS_pixel2x2_bot
x4_x1270 dac_config_3 dac_config_5 col_event_rst_bot_right[19] dac_config_4
+ row_on_detect_bot[12] dac_config_0 dac_config_1 row_off_detect_bot[13] x4_net45
+ dac_config_2 vdda1 vssa1 vssc1 col_event_rst_bot_right[18] x4_net46
+ row_on_detect_bot[13] row_off_detect_bot[12] openDVS_pixel2x2_bot
x4_x1271 dac_config_3 dac_config_5 col_event_rst_bot_right[17] dac_config_4
+ row_on_detect_bot[12] dac_config_0 dac_config_1 row_off_detect_bot[13] x4_net47
+ dac_config_2 vdda1 vssa1 vssc1 col_event_rst_bot_right[16] x4_net48
+ row_on_detect_bot[13] row_off_detect_bot[12] openDVS_pixel2x2_bot
x4_x1272 dac_config_3 dac_config_5 col_event_rst_bot_right[15] dac_config_4
+ row_on_detect_bot[12] dac_config_0 dac_config_1 row_off_detect_bot[13] x4_net49
+ dac_config_2 vdda1 vssa1 vssc1 col_event_rst_bot_right[14] x4_net50
+ row_on_detect_bot[13] row_off_detect_bot[12] openDVS_pixel2x2_bot
x4_x1273 dac_config_3 dac_config_5 col_event_rst_bot_right[13] dac_config_4
+ row_on_detect_bot[12] dac_config_0 dac_config_1 row_off_detect_bot[13] x4_net51
+ dac_config_2 vdda1 vssa1 vssc1 col_event_rst_bot_right[12] x4_net52
+ row_on_detect_bot[13] row_off_detect_bot[12] openDVS_pixel2x2_bot
x4_x1274 dac_config_3 dac_config_5 col_event_rst_bot_right[11] dac_config_4
+ row_on_detect_bot[12] dac_config_0 dac_config_1 row_off_detect_bot[13] x4_net53
+ dac_config_2 vdda1 vssa1 vssc1 col_event_rst_bot_right[10] x4_net54
+ row_on_detect_bot[13] row_off_detect_bot[12] openDVS_pixel2x2_bot
x4_x1275 dac_config_3 dac_config_5 col_event_rst_bot_right[9] dac_config_4
+ row_on_detect_bot[12] dac_config_0 dac_config_1 row_off_detect_bot[13] x4_net55
+ dac_config_2 vdda1 vssa1 vssc1 col_event_rst_bot_right[8] x4_net56 row_on_detect_bot[13]
+ row_off_detect_bot[12] openDVS_pixel2x2_bot
x4_x1276 dac_config_3 dac_config_5 col_event_rst_bot_right[7] dac_config_4
+ row_on_detect_bot[12] dac_config_0 dac_config_1 row_off_detect_bot[13] x4_net57
+ dac_config_2 vdda1 vssa1 vssc1 col_event_rst_bot_right[6] x4_net58 row_on_detect_bot[13]
+ row_off_detect_bot[12] openDVS_pixel2x2_bot
x4_x1277 dac_config_3 dac_config_5 col_event_rst_bot_right[5] dac_config_4
+ row_on_detect_bot[12] dac_config_0 dac_config_1 row_off_detect_bot[13] x4_net59
+ dac_config_2 vdda1 vssa1 vssc1 col_event_rst_bot_right[4] x4_net60 row_on_detect_bot[13]
+ row_off_detect_bot[12] openDVS_pixel2x2_bot
x4_x1278 dac_config_3 dac_config_5 col_event_rst_bot_right[3] dac_config_4
+ row_on_detect_bot[12] dac_config_0 dac_config_1 row_off_detect_bot[13] x4_net61
+ dac_config_2 vdda1 vssa1 vssc1 col_event_rst_bot_right[2] x4_net62 row_on_detect_bot[13]
+ row_off_detect_bot[12] openDVS_pixel2x2_bot
x4_x1279 dac_config_3 dac_config_5 col_event_rst_bot_right[1] dac_config_4
+ row_on_detect_bot[12] dac_config_0 dac_config_1 row_off_detect_bot[13] x4_net63
+ dac_config_2 vdda1 vssa1 vssc1 col_event_rst_bot_right[0] x4_net64 row_on_detect_bot[13]
+ row_off_detect_bot[12] openDVS_pixel2x2_bot
x4_x1280 dac_config_3 dac_config_5 col_event_rst_bot_right[63] dac_config_4
+ row_on_detect_bot[14] dac_config_0 dac_config_1 row_off_detect_bot[15] x4_net1
+ dac_config_2 vdda1 vssa1 vssc1 col_event_rst_bot_right[62] x4_net2 row_on_detect_bot[15]
+ row_off_detect_bot[14] openDVS_pixel2x2_bot
x4_x1281 dac_config_3 dac_config_5 col_event_rst_bot_right[61] dac_config_4
+ row_on_detect_bot[14] dac_config_0 dac_config_1 row_off_detect_bot[15] x4_net3
+ dac_config_2 vdda1 vssa1 vssc1 col_event_rst_bot_right[60] x4_net4 row_on_detect_bot[15]
+ row_off_detect_bot[14] openDVS_pixel2x2_bot
x4_x1282 dac_config_3 dac_config_5 col_event_rst_bot_right[59] dac_config_4
+ row_on_detect_bot[14] dac_config_0 dac_config_1 row_off_detect_bot[15] x4_net5
+ dac_config_2 vdda1 vssa1 vssc1 col_event_rst_bot_right[58] x4_net6 row_on_detect_bot[15]
+ row_off_detect_bot[14] openDVS_pixel2x2_bot
x4_x1283 dac_config_3 dac_config_5 col_event_rst_bot_right[57] dac_config_4
+ row_on_detect_bot[14] dac_config_0 dac_config_1 row_off_detect_bot[15] x4_net7
+ dac_config_2 vdda1 vssa1 vssc1 col_event_rst_bot_right[56] x4_net8 row_on_detect_bot[15]
+ row_off_detect_bot[14] openDVS_pixel2x2_bot
x4_x1284 dac_config_3 dac_config_5 col_event_rst_bot_right[55] dac_config_4
+ row_on_detect_bot[14] dac_config_0 dac_config_1 row_off_detect_bot[15] x4_net9
+ dac_config_2 vdda1 vssa1 vssc1 col_event_rst_bot_right[54] x4_net10
+ row_on_detect_bot[15] row_off_detect_bot[14] openDVS_pixel2x2_bot
x4_x1285 dac_config_3 dac_config_5 col_event_rst_bot_right[53] dac_config_4
+ row_on_detect_bot[14] dac_config_0 dac_config_1 row_off_detect_bot[15] x4_net11
+ dac_config_2 vdda1 vssa1 vssc1 col_event_rst_bot_right[52] x4_net12
+ row_on_detect_bot[15] row_off_detect_bot[14] openDVS_pixel2x2_bot
x4_x1286 dac_config_3 dac_config_5 col_event_rst_bot_right[51] dac_config_4
+ row_on_detect_bot[14] dac_config_0 dac_config_1 row_off_detect_bot[15] x4_net13
+ dac_config_2 vdda1 vssa1 vssc1 col_event_rst_bot_right[50] x4_net14
+ row_on_detect_bot[15] row_off_detect_bot[14] openDVS_pixel2x2_bot
x4_x1287 dac_config_3 dac_config_5 col_event_rst_bot_right[49] dac_config_4
+ row_on_detect_bot[14] dac_config_0 dac_config_1 row_off_detect_bot[15] x4_net15
+ dac_config_2 vdda1 vssa1 vssc1 col_event_rst_bot_right[48] x4_net16
+ row_on_detect_bot[15] row_off_detect_bot[14] openDVS_pixel2x2_bot
x4_x1288 dac_config_3 dac_config_5 col_event_rst_bot_right[47] dac_config_4
+ row_on_detect_bot[14] dac_config_0 dac_config_1 row_off_detect_bot[15] x4_net17
+ dac_config_2 vdda1 vssa1 vssc1 col_event_rst_bot_right[46] x4_net18
+ row_on_detect_bot[15] row_off_detect_bot[14] openDVS_pixel2x2_bot
x4_x1289 dac_config_3 dac_config_5 col_event_rst_bot_right[45] dac_config_4
+ row_on_detect_bot[14] dac_config_0 dac_config_1 row_off_detect_bot[15] x4_net19
+ dac_config_2 vdda1 vssa1 vssc1 col_event_rst_bot_right[44] x4_net20
+ row_on_detect_bot[15] row_off_detect_bot[14] openDVS_pixel2x2_bot
x4_x1290 dac_config_3 dac_config_5 col_event_rst_bot_right[43] dac_config_4
+ row_on_detect_bot[14] dac_config_0 dac_config_1 row_off_detect_bot[15] x4_net21
+ dac_config_2 vdda1 vssa1 vssc1 col_event_rst_bot_right[42] x4_net22
+ row_on_detect_bot[15] row_off_detect_bot[14] openDVS_pixel2x2_bot
x4_x1291 dac_config_3 dac_config_5 col_event_rst_bot_right[41] dac_config_4
+ row_on_detect_bot[14] dac_config_0 dac_config_1 row_off_detect_bot[15] x4_net23
+ dac_config_2 vdda1 vssa1 vssc1 col_event_rst_bot_right[40] x4_net24
+ row_on_detect_bot[15] row_off_detect_bot[14] openDVS_pixel2x2_bot
x4_x1292 dac_config_3 dac_config_5 col_event_rst_bot_right[39] dac_config_4
+ row_on_detect_bot[14] dac_config_0 dac_config_1 row_off_detect_bot[15] x4_net25
+ dac_config_2 vdda1 vssa1 vssc1 col_event_rst_bot_right[38] x4_net26
+ row_on_detect_bot[15] row_off_detect_bot[14] openDVS_pixel2x2_bot
x4_x1293 dac_config_3 dac_config_5 col_event_rst_bot_right[37] dac_config_4
+ row_on_detect_bot[14] dac_config_0 dac_config_1 row_off_detect_bot[15] x4_net27
+ dac_config_2 vdda1 vssa1 vssc1 col_event_rst_bot_right[36] x4_net28
+ row_on_detect_bot[15] row_off_detect_bot[14] openDVS_pixel2x2_bot
x4_x1294 dac_config_3 dac_config_5 col_event_rst_bot_right[35] dac_config_4
+ row_on_detect_bot[14] dac_config_0 dac_config_1 row_off_detect_bot[15] x4_net29
+ dac_config_2 vdda1 vssa1 vssc1 col_event_rst_bot_right[34] x4_net30
+ row_on_detect_bot[15] row_off_detect_bot[14] openDVS_pixel2x2_bot
x4_x1295 dac_config_3 dac_config_5 col_event_rst_bot_right[33] dac_config_4
+ row_on_detect_bot[14] dac_config_0 dac_config_1 row_off_detect_bot[15] x4_net31
+ dac_config_2 vdda1 vssa1 vssc1 col_event_rst_bot_right[32] x4_net32
+ row_on_detect_bot[15] row_off_detect_bot[14] openDVS_pixel2x2_bot
x4_x1296 dac_config_3 dac_config_5 col_event_rst_bot_right[31] dac_config_4
+ row_on_detect_bot[14] dac_config_0 dac_config_1 row_off_detect_bot[15] x4_net33
+ dac_config_2 vdda1 vssa1 vssc1 col_event_rst_bot_right[30] x4_net34
+ row_on_detect_bot[15] row_off_detect_bot[14] openDVS_pixel2x2_bot
x4_x1297 dac_config_3 dac_config_5 col_event_rst_bot_right[29] dac_config_4
+ row_on_detect_bot[14] dac_config_0 dac_config_1 row_off_detect_bot[15] x4_net35
+ dac_config_2 vdda1 vssa1 vssc1 col_event_rst_bot_right[28] x4_net36
+ row_on_detect_bot[15] row_off_detect_bot[14] openDVS_pixel2x2_bot
x4_x1298 dac_config_3 dac_config_5 col_event_rst_bot_right[27] dac_config_4
+ row_on_detect_bot[14] dac_config_0 dac_config_1 row_off_detect_bot[15] x4_net37
+ dac_config_2 vdda1 vssa1 vssc1 col_event_rst_bot_right[26] x4_net38
+ row_on_detect_bot[15] row_off_detect_bot[14] openDVS_pixel2x2_bot
x4_x1299 dac_config_3 dac_config_5 col_event_rst_bot_right[25] dac_config_4
+ row_on_detect_bot[14] dac_config_0 dac_config_1 row_off_detect_bot[15] x4_net39
+ dac_config_2 vdda1 vssa1 vssc1 col_event_rst_bot_right[24] x4_net40
+ row_on_detect_bot[15] row_off_detect_bot[14] openDVS_pixel2x2_bot
x4_x1300 dac_config_3 dac_config_5 col_event_rst_bot_right[23] dac_config_4
+ row_on_detect_bot[14] dac_config_0 dac_config_1 row_off_detect_bot[15] x4_net41
+ dac_config_2 vdda1 vssa1 vssc1 col_event_rst_bot_right[22] x4_net42
+ row_on_detect_bot[15] row_off_detect_bot[14] openDVS_pixel2x2_bot
x4_x1301 dac_config_3 dac_config_5 col_event_rst_bot_right[21] dac_config_4
+ row_on_detect_bot[14] dac_config_0 dac_config_1 row_off_detect_bot[15] x4_net43
+ dac_config_2 vdda1 vssa1 vssc1 col_event_rst_bot_right[20] x4_net44
+ row_on_detect_bot[15] row_off_detect_bot[14] openDVS_pixel2x2_bot
x4_x1302 dac_config_3 dac_config_5 col_event_rst_bot_right[19] dac_config_4
+ row_on_detect_bot[14] dac_config_0 dac_config_1 row_off_detect_bot[15] x4_net45
+ dac_config_2 vdda1 vssa1 vssc1 col_event_rst_bot_right[18] x4_net46
+ row_on_detect_bot[15] row_off_detect_bot[14] openDVS_pixel2x2_bot
x4_x1303 dac_config_3 dac_config_5 col_event_rst_bot_right[17] dac_config_4
+ row_on_detect_bot[14] dac_config_0 dac_config_1 row_off_detect_bot[15] x4_net47
+ dac_config_2 vdda1 vssa1 vssc1 col_event_rst_bot_right[16] x4_net48
+ row_on_detect_bot[15] row_off_detect_bot[14] openDVS_pixel2x2_bot
x4_x1304 dac_config_3 dac_config_5 col_event_rst_bot_right[15] dac_config_4
+ row_on_detect_bot[14] dac_config_0 dac_config_1 row_off_detect_bot[15] x4_net49
+ dac_config_2 vdda1 vssa1 vssc1 col_event_rst_bot_right[14] x4_net50
+ row_on_detect_bot[15] row_off_detect_bot[14] openDVS_pixel2x2_bot
x4_x1305 dac_config_3 dac_config_5 col_event_rst_bot_right[13] dac_config_4
+ row_on_detect_bot[14] dac_config_0 dac_config_1 row_off_detect_bot[15] x4_net51
+ dac_config_2 vdda1 vssa1 vssc1 col_event_rst_bot_right[12] x4_net52
+ row_on_detect_bot[15] row_off_detect_bot[14] openDVS_pixel2x2_bot
x4_x1306 dac_config_3 dac_config_5 col_event_rst_bot_right[11] dac_config_4
+ row_on_detect_bot[14] dac_config_0 dac_config_1 row_off_detect_bot[15] x4_net53
+ dac_config_2 vdda1 vssa1 vssc1 col_event_rst_bot_right[10] x4_net54
+ row_on_detect_bot[15] row_off_detect_bot[14] openDVS_pixel2x2_bot
x4_x1307 dac_config_3 dac_config_5 col_event_rst_bot_right[9] dac_config_4
+ row_on_detect_bot[14] dac_config_0 dac_config_1 row_off_detect_bot[15] x4_net55
+ dac_config_2 vdda1 vssa1 vssc1 col_event_rst_bot_right[8] x4_net56 row_on_detect_bot[15]
+ row_off_detect_bot[14] openDVS_pixel2x2_bot
x4_x1308 dac_config_3 dac_config_5 col_event_rst_bot_right[7] dac_config_4
+ row_on_detect_bot[14] dac_config_0 dac_config_1 row_off_detect_bot[15] x4_net57
+ dac_config_2 vdda1 vssa1 vssc1 col_event_rst_bot_right[6] x4_net58 row_on_detect_bot[15]
+ row_off_detect_bot[14] openDVS_pixel2x2_bot
x4_x1309 dac_config_3 dac_config_5 col_event_rst_bot_right[5] dac_config_4
+ row_on_detect_bot[14] dac_config_0 dac_config_1 row_off_detect_bot[15] x4_net59
+ dac_config_2 vdda1 vssa1 vssc1 col_event_rst_bot_right[4] x4_net60 row_on_detect_bot[15]
+ row_off_detect_bot[14] openDVS_pixel2x2_bot
x4_x1310 dac_config_3 dac_config_5 col_event_rst_bot_right[3] dac_config_4
+ row_on_detect_bot[14] dac_config_0 dac_config_1 row_off_detect_bot[15] x4_net61
+ dac_config_2 vdda1 vssa1 vssc1 col_event_rst_bot_right[2] x4_net62 row_on_detect_bot[15]
+ row_off_detect_bot[14] openDVS_pixel2x2_bot
x4_x1311 dac_config_3 dac_config_5 col_event_rst_bot_right[1] dac_config_4
+ row_on_detect_bot[14] dac_config_0 dac_config_1 row_off_detect_bot[15] x4_net63
+ dac_config_2 vdda1 vssa1 vssc1 col_event_rst_bot_right[0] x4_net64 row_on_detect_bot[15]
+ row_off_detect_bot[14] openDVS_pixel2x2_bot
x4_x1312 dac_config_3 dac_config_5 col_event_rst_bot_right[63] dac_config_4
+ row_on_detect_bot[16] dac_config_0 dac_config_1 row_off_detect_bot[17] x4_net1
+ dac_config_2 vdda1 vssa1 vssc1 col_event_rst_bot_right[62] x4_net2 row_on_detect_bot[17]
+ row_off_detect_bot[16] openDVS_pixel2x2_bot
x4_x1313 dac_config_3 dac_config_5 col_event_rst_bot_right[61] dac_config_4
+ row_on_detect_bot[16] dac_config_0 dac_config_1 row_off_detect_bot[17] x4_net3
+ dac_config_2 vdda1 vssa1 vssc1 col_event_rst_bot_right[60] x4_net4 row_on_detect_bot[17]
+ row_off_detect_bot[16] openDVS_pixel2x2_bot
x4_x1314 dac_config_3 dac_config_5 col_event_rst_bot_right[59] dac_config_4
+ row_on_detect_bot[16] dac_config_0 dac_config_1 row_off_detect_bot[17] x4_net5
+ dac_config_2 vdda1 vssa1 vssc1 col_event_rst_bot_right[58] x4_net6 row_on_detect_bot[17]
+ row_off_detect_bot[16] openDVS_pixel2x2_bot
x4_x1315 dac_config_3 dac_config_5 col_event_rst_bot_right[57] dac_config_4
+ row_on_detect_bot[16] dac_config_0 dac_config_1 row_off_detect_bot[17] x4_net7
+ dac_config_2 vdda1 vssa1 vssc1 col_event_rst_bot_right[56] x4_net8 row_on_detect_bot[17]
+ row_off_detect_bot[16] openDVS_pixel2x2_bot
x4_x1316 dac_config_3 dac_config_5 col_event_rst_bot_right[55] dac_config_4
+ row_on_detect_bot[16] dac_config_0 dac_config_1 row_off_detect_bot[17] x4_net9
+ dac_config_2 vdda1 vssa1 vssc1 col_event_rst_bot_right[54] x4_net10
+ row_on_detect_bot[17] row_off_detect_bot[16] openDVS_pixel2x2_bot
x4_x1317 dac_config_3 dac_config_5 col_event_rst_bot_right[53] dac_config_4
+ row_on_detect_bot[16] dac_config_0 dac_config_1 row_off_detect_bot[17] x4_net11
+ dac_config_2 vdda1 vssa1 vssc1 col_event_rst_bot_right[52] x4_net12
+ row_on_detect_bot[17] row_off_detect_bot[16] openDVS_pixel2x2_bot
x4_x1318 dac_config_3 dac_config_5 col_event_rst_bot_right[51] dac_config_4
+ row_on_detect_bot[16] dac_config_0 dac_config_1 row_off_detect_bot[17] x4_net13
+ dac_config_2 vdda1 vssa1 vssc1 col_event_rst_bot_right[50] x4_net14
+ row_on_detect_bot[17] row_off_detect_bot[16] openDVS_pixel2x2_bot
x4_x1319 dac_config_3 dac_config_5 col_event_rst_bot_right[49] dac_config_4
+ row_on_detect_bot[16] dac_config_0 dac_config_1 row_off_detect_bot[17] x4_net15
+ dac_config_2 vdda1 vssa1 vssc1 col_event_rst_bot_right[48] x4_net16
+ row_on_detect_bot[17] row_off_detect_bot[16] openDVS_pixel2x2_bot
x4_x1320 dac_config_3 dac_config_5 col_event_rst_bot_right[47] dac_config_4
+ row_on_detect_bot[16] dac_config_0 dac_config_1 row_off_detect_bot[17] x4_net17
+ dac_config_2 vdda1 vssa1 vssc1 col_event_rst_bot_right[46] x4_net18
+ row_on_detect_bot[17] row_off_detect_bot[16] openDVS_pixel2x2_bot
x4_x1321 dac_config_3 dac_config_5 col_event_rst_bot_right[45] dac_config_4
+ row_on_detect_bot[16] dac_config_0 dac_config_1 row_off_detect_bot[17] x4_net19
+ dac_config_2 vdda1 vssa1 vssc1 col_event_rst_bot_right[44] x4_net20
+ row_on_detect_bot[17] row_off_detect_bot[16] openDVS_pixel2x2_bot
x4_x1322 dac_config_3 dac_config_5 col_event_rst_bot_right[43] dac_config_4
+ row_on_detect_bot[16] dac_config_0 dac_config_1 row_off_detect_bot[17] x4_net21
+ dac_config_2 vdda1 vssa1 vssc1 col_event_rst_bot_right[42] x4_net22
+ row_on_detect_bot[17] row_off_detect_bot[16] openDVS_pixel2x2_bot
x4_x1323 dac_config_3 dac_config_5 col_event_rst_bot_right[41] dac_config_4
+ row_on_detect_bot[16] dac_config_0 dac_config_1 row_off_detect_bot[17] x4_net23
+ dac_config_2 vdda1 vssa1 vssc1 col_event_rst_bot_right[40] x4_net24
+ row_on_detect_bot[17] row_off_detect_bot[16] openDVS_pixel2x2_bot
x4_x1324 dac_config_3 dac_config_5 col_event_rst_bot_right[39] dac_config_4
+ row_on_detect_bot[16] dac_config_0 dac_config_1 row_off_detect_bot[17] x4_net25
+ dac_config_2 vdda1 vssa1 vssc1 col_event_rst_bot_right[38] x4_net26
+ row_on_detect_bot[17] row_off_detect_bot[16] openDVS_pixel2x2_bot
x4_x1325 dac_config_3 dac_config_5 col_event_rst_bot_right[37] dac_config_4
+ row_on_detect_bot[16] dac_config_0 dac_config_1 row_off_detect_bot[17] x4_net27
+ dac_config_2 vdda1 vssa1 vssc1 col_event_rst_bot_right[36] x4_net28
+ row_on_detect_bot[17] row_off_detect_bot[16] openDVS_pixel2x2_bot
x4_x1326 dac_config_3 dac_config_5 col_event_rst_bot_right[35] dac_config_4
+ row_on_detect_bot[16] dac_config_0 dac_config_1 row_off_detect_bot[17] x4_net29
+ dac_config_2 vdda1 vssa1 vssc1 col_event_rst_bot_right[34] x4_net30
+ row_on_detect_bot[17] row_off_detect_bot[16] openDVS_pixel2x2_bot
x4_x1327 dac_config_3 dac_config_5 col_event_rst_bot_right[33] dac_config_4
+ row_on_detect_bot[16] dac_config_0 dac_config_1 row_off_detect_bot[17] x4_net31
+ dac_config_2 vdda1 vssa1 vssc1 col_event_rst_bot_right[32] x4_net32
+ row_on_detect_bot[17] row_off_detect_bot[16] openDVS_pixel2x2_bot
x4_x1328 dac_config_3 dac_config_5 col_event_rst_bot_right[31] dac_config_4
+ row_on_detect_bot[16] dac_config_0 dac_config_1 row_off_detect_bot[17] x4_net33
+ dac_config_2 vdda1 vssa1 vssc1 col_event_rst_bot_right[30] x4_net34
+ row_on_detect_bot[17] row_off_detect_bot[16] openDVS_pixel2x2_bot
x4_x1329 dac_config_3 dac_config_5 col_event_rst_bot_right[29] dac_config_4
+ row_on_detect_bot[16] dac_config_0 dac_config_1 row_off_detect_bot[17] x4_net35
+ dac_config_2 vdda1 vssa1 vssc1 col_event_rst_bot_right[28] x4_net36
+ row_on_detect_bot[17] row_off_detect_bot[16] openDVS_pixel2x2_bot
x4_x1330 dac_config_3 dac_config_5 col_event_rst_bot_right[27] dac_config_4
+ row_on_detect_bot[16] dac_config_0 dac_config_1 row_off_detect_bot[17] x4_net37
+ dac_config_2 vdda1 vssa1 vssc1 col_event_rst_bot_right[26] x4_net38
+ row_on_detect_bot[17] row_off_detect_bot[16] openDVS_pixel2x2_bot
x4_x1331 dac_config_3 dac_config_5 col_event_rst_bot_right[25] dac_config_4
+ row_on_detect_bot[16] dac_config_0 dac_config_1 row_off_detect_bot[17] x4_net39
+ dac_config_2 vdda1 vssa1 vssc1 col_event_rst_bot_right[24] x4_net40
+ row_on_detect_bot[17] row_off_detect_bot[16] openDVS_pixel2x2_bot
x4_x1332 dac_config_3 dac_config_5 col_event_rst_bot_right[23] dac_config_4
+ row_on_detect_bot[16] dac_config_0 dac_config_1 row_off_detect_bot[17] x4_net41
+ dac_config_2 vdda1 vssa1 vssc1 col_event_rst_bot_right[22] x4_net42
+ row_on_detect_bot[17] row_off_detect_bot[16] openDVS_pixel2x2_bot
x4_x1333 dac_config_3 dac_config_5 col_event_rst_bot_right[21] dac_config_4
+ row_on_detect_bot[16] dac_config_0 dac_config_1 row_off_detect_bot[17] x4_net43
+ dac_config_2 vdda1 vssa1 vssc1 col_event_rst_bot_right[20] x4_net44
+ row_on_detect_bot[17] row_off_detect_bot[16] openDVS_pixel2x2_bot
x4_x1334 dac_config_3 dac_config_5 col_event_rst_bot_right[19] dac_config_4
+ row_on_detect_bot[16] dac_config_0 dac_config_1 row_off_detect_bot[17] x4_net45
+ dac_config_2 vdda1 vssa1 vssc1 col_event_rst_bot_right[18] x4_net46
+ row_on_detect_bot[17] row_off_detect_bot[16] openDVS_pixel2x2_bot
x4_x1335 dac_config_3 dac_config_5 col_event_rst_bot_right[17] dac_config_4
+ row_on_detect_bot[16] dac_config_0 dac_config_1 row_off_detect_bot[17] x4_net47
+ dac_config_2 vdda1 vssa1 vssc1 col_event_rst_bot_right[16] x4_net48
+ row_on_detect_bot[17] row_off_detect_bot[16] openDVS_pixel2x2_bot
x4_x1336 dac_config_3 dac_config_5 col_event_rst_bot_right[15] dac_config_4
+ row_on_detect_bot[16] dac_config_0 dac_config_1 row_off_detect_bot[17] x4_net49
+ dac_config_2 vdda1 vssa1 vssc1 col_event_rst_bot_right[14] x4_net50
+ row_on_detect_bot[17] row_off_detect_bot[16] openDVS_pixel2x2_bot
x4_x1337 dac_config_3 dac_config_5 col_event_rst_bot_right[13] dac_config_4
+ row_on_detect_bot[16] dac_config_0 dac_config_1 row_off_detect_bot[17] x4_net51
+ dac_config_2 vdda1 vssa1 vssc1 col_event_rst_bot_right[12] x4_net52
+ row_on_detect_bot[17] row_off_detect_bot[16] openDVS_pixel2x2_bot
x4_x1338 dac_config_3 dac_config_5 col_event_rst_bot_right[11] dac_config_4
+ row_on_detect_bot[16] dac_config_0 dac_config_1 row_off_detect_bot[17] x4_net53
+ dac_config_2 vdda1 vssa1 vssc1 col_event_rst_bot_right[10] x4_net54
+ row_on_detect_bot[17] row_off_detect_bot[16] openDVS_pixel2x2_bot
x4_x1339 dac_config_3 dac_config_5 col_event_rst_bot_right[9] dac_config_4
+ row_on_detect_bot[16] dac_config_0 dac_config_1 row_off_detect_bot[17] x4_net55
+ dac_config_2 vdda1 vssa1 vssc1 col_event_rst_bot_right[8] x4_net56 row_on_detect_bot[17]
+ row_off_detect_bot[16] openDVS_pixel2x2_bot
x4_x1340 dac_config_3 dac_config_5 col_event_rst_bot_right[7] dac_config_4
+ row_on_detect_bot[16] dac_config_0 dac_config_1 row_off_detect_bot[17] x4_net57
+ dac_config_2 vdda1 vssa1 vssc1 col_event_rst_bot_right[6] x4_net58 row_on_detect_bot[17]
+ row_off_detect_bot[16] openDVS_pixel2x2_bot
x4_x1341 dac_config_3 dac_config_5 col_event_rst_bot_right[5] dac_config_4
+ row_on_detect_bot[16] dac_config_0 dac_config_1 row_off_detect_bot[17] x4_net59
+ dac_config_2 vdda1 vssa1 vssc1 col_event_rst_bot_right[4] x4_net60 row_on_detect_bot[17]
+ row_off_detect_bot[16] openDVS_pixel2x2_bot
x4_x1342 dac_config_3 dac_config_5 col_event_rst_bot_right[3] dac_config_4
+ row_on_detect_bot[16] dac_config_0 dac_config_1 row_off_detect_bot[17] x4_net61
+ dac_config_2 vdda1 vssa1 vssc1 col_event_rst_bot_right[2] x4_net62 row_on_detect_bot[17]
+ row_off_detect_bot[16] openDVS_pixel2x2_bot
x4_x1343 dac_config_3 dac_config_5 col_event_rst_bot_right[1] dac_config_4
+ row_on_detect_bot[16] dac_config_0 dac_config_1 row_off_detect_bot[17] x4_net63
+ dac_config_2 vdda1 vssa1 vssc1 col_event_rst_bot_right[0] x4_net64 row_on_detect_bot[17]
+ row_off_detect_bot[16] openDVS_pixel2x2_bot
x4_x1344 dac_config_3 dac_config_5 col_event_rst_bot_right[63] dac_config_4
+ row_on_detect_bot[18] dac_config_0 dac_config_1 row_off_detect_bot[19] x4_net1
+ dac_config_2 vdda1 vssa1 vssc1 col_event_rst_bot_right[62] x4_net2 row_on_detect_bot[19]
+ row_off_detect_bot[18] openDVS_pixel2x2_bot
x4_x1345 dac_config_3 dac_config_5 col_event_rst_bot_right[61] dac_config_4
+ row_on_detect_bot[18] dac_config_0 dac_config_1 row_off_detect_bot[19] x4_net3
+ dac_config_2 vdda1 vssa1 vssc1 col_event_rst_bot_right[60] x4_net4 row_on_detect_bot[19]
+ row_off_detect_bot[18] openDVS_pixel2x2_bot
x4_x1346 dac_config_3 dac_config_5 col_event_rst_bot_right[59] dac_config_4
+ row_on_detect_bot[18] dac_config_0 dac_config_1 row_off_detect_bot[19] x4_net5
+ dac_config_2 vdda1 vssa1 vssc1 col_event_rst_bot_right[58] x4_net6 row_on_detect_bot[19]
+ row_off_detect_bot[18] openDVS_pixel2x2_bot
x4_x1347 dac_config_3 dac_config_5 col_event_rst_bot_right[57] dac_config_4
+ row_on_detect_bot[18] dac_config_0 dac_config_1 row_off_detect_bot[19] x4_net7
+ dac_config_2 vdda1 vssa1 vssc1 col_event_rst_bot_right[56] x4_net8 row_on_detect_bot[19]
+ row_off_detect_bot[18] openDVS_pixel2x2_bot
x4_x1348 dac_config_3 dac_config_5 col_event_rst_bot_right[55] dac_config_4
+ row_on_detect_bot[18] dac_config_0 dac_config_1 row_off_detect_bot[19] x4_net9
+ dac_config_2 vdda1 vssa1 vssc1 col_event_rst_bot_right[54] x4_net10
+ row_on_detect_bot[19] row_off_detect_bot[18] openDVS_pixel2x2_bot
x4_x1349 dac_config_3 dac_config_5 col_event_rst_bot_right[53] dac_config_4
+ row_on_detect_bot[18] dac_config_0 dac_config_1 row_off_detect_bot[19] x4_net11
+ dac_config_2 vdda1 vssa1 vssc1 col_event_rst_bot_right[52] x4_net12
+ row_on_detect_bot[19] row_off_detect_bot[18] openDVS_pixel2x2_bot
x4_x1350 dac_config_3 dac_config_5 col_event_rst_bot_right[51] dac_config_4
+ row_on_detect_bot[18] dac_config_0 dac_config_1 row_off_detect_bot[19] x4_net13
+ dac_config_2 vdda1 vssa1 vssc1 col_event_rst_bot_right[50] x4_net14
+ row_on_detect_bot[19] row_off_detect_bot[18] openDVS_pixel2x2_bot
x4_x1351 dac_config_3 dac_config_5 col_event_rst_bot_right[49] dac_config_4
+ row_on_detect_bot[18] dac_config_0 dac_config_1 row_off_detect_bot[19] x4_net15
+ dac_config_2 vdda1 vssa1 vssc1 col_event_rst_bot_right[48] x4_net16
+ row_on_detect_bot[19] row_off_detect_bot[18] openDVS_pixel2x2_bot
x4_x1352 dac_config_3 dac_config_5 col_event_rst_bot_right[47] dac_config_4
+ row_on_detect_bot[18] dac_config_0 dac_config_1 row_off_detect_bot[19] x4_net17
+ dac_config_2 vdda1 vssa1 vssc1 col_event_rst_bot_right[46] x4_net18
+ row_on_detect_bot[19] row_off_detect_bot[18] openDVS_pixel2x2_bot
x4_x1353 dac_config_3 dac_config_5 col_event_rst_bot_right[45] dac_config_4
+ row_on_detect_bot[18] dac_config_0 dac_config_1 row_off_detect_bot[19] x4_net19
+ dac_config_2 vdda1 vssa1 vssc1 col_event_rst_bot_right[44] x4_net20
+ row_on_detect_bot[19] row_off_detect_bot[18] openDVS_pixel2x2_bot
x4_x1354 dac_config_3 dac_config_5 col_event_rst_bot_right[43] dac_config_4
+ row_on_detect_bot[18] dac_config_0 dac_config_1 row_off_detect_bot[19] x4_net21
+ dac_config_2 vdda1 vssa1 vssc1 col_event_rst_bot_right[42] x4_net22
+ row_on_detect_bot[19] row_off_detect_bot[18] openDVS_pixel2x2_bot
x4_x1355 dac_config_3 dac_config_5 col_event_rst_bot_right[41] dac_config_4
+ row_on_detect_bot[18] dac_config_0 dac_config_1 row_off_detect_bot[19] x4_net23
+ dac_config_2 vdda1 vssa1 vssc1 col_event_rst_bot_right[40] x4_net24
+ row_on_detect_bot[19] row_off_detect_bot[18] openDVS_pixel2x2_bot
x4_x1356 dac_config_3 dac_config_5 col_event_rst_bot_right[39] dac_config_4
+ row_on_detect_bot[18] dac_config_0 dac_config_1 row_off_detect_bot[19] x4_net25
+ dac_config_2 vdda1 vssa1 vssc1 col_event_rst_bot_right[38] x4_net26
+ row_on_detect_bot[19] row_off_detect_bot[18] openDVS_pixel2x2_bot
x4_x1357 dac_config_3 dac_config_5 col_event_rst_bot_right[37] dac_config_4
+ row_on_detect_bot[18] dac_config_0 dac_config_1 row_off_detect_bot[19] x4_net27
+ dac_config_2 vdda1 vssa1 vssc1 col_event_rst_bot_right[36] x4_net28
+ row_on_detect_bot[19] row_off_detect_bot[18] openDVS_pixel2x2_bot
x4_x1358 dac_config_3 dac_config_5 col_event_rst_bot_right[35] dac_config_4
+ row_on_detect_bot[18] dac_config_0 dac_config_1 row_off_detect_bot[19] x4_net29
+ dac_config_2 vdda1 vssa1 vssc1 col_event_rst_bot_right[34] x4_net30
+ row_on_detect_bot[19] row_off_detect_bot[18] openDVS_pixel2x2_bot
x4_x1359 dac_config_3 dac_config_5 col_event_rst_bot_right[33] dac_config_4
+ row_on_detect_bot[18] dac_config_0 dac_config_1 row_off_detect_bot[19] x4_net31
+ dac_config_2 vdda1 vssa1 vssc1 col_event_rst_bot_right[32] x4_net32
+ row_on_detect_bot[19] row_off_detect_bot[18] openDVS_pixel2x2_bot
x4_x1360 dac_config_3 dac_config_5 col_event_rst_bot_right[31] dac_config_4
+ row_on_detect_bot[18] dac_config_0 dac_config_1 row_off_detect_bot[19] x4_net33
+ dac_config_2 vdda1 vssa1 vssc1 col_event_rst_bot_right[30] x4_net34
+ row_on_detect_bot[19] row_off_detect_bot[18] openDVS_pixel2x2_bot
x4_x1361 dac_config_3 dac_config_5 col_event_rst_bot_right[29] dac_config_4
+ row_on_detect_bot[18] dac_config_0 dac_config_1 row_off_detect_bot[19] x4_net35
+ dac_config_2 vdda1 vssa1 vssc1 col_event_rst_bot_right[28] x4_net36
+ row_on_detect_bot[19] row_off_detect_bot[18] openDVS_pixel2x2_bot
x4_x1362 dac_config_3 dac_config_5 col_event_rst_bot_right[27] dac_config_4
+ row_on_detect_bot[18] dac_config_0 dac_config_1 row_off_detect_bot[19] x4_net37
+ dac_config_2 vdda1 vssa1 vssc1 col_event_rst_bot_right[26] x4_net38
+ row_on_detect_bot[19] row_off_detect_bot[18] openDVS_pixel2x2_bot
x4_x1363 dac_config_3 dac_config_5 col_event_rst_bot_right[25] dac_config_4
+ row_on_detect_bot[18] dac_config_0 dac_config_1 row_off_detect_bot[19] x4_net39
+ dac_config_2 vdda1 vssa1 vssc1 col_event_rst_bot_right[24] x4_net40
+ row_on_detect_bot[19] row_off_detect_bot[18] openDVS_pixel2x2_bot
x4_x1364 dac_config_3 dac_config_5 col_event_rst_bot_right[23] dac_config_4
+ row_on_detect_bot[18] dac_config_0 dac_config_1 row_off_detect_bot[19] x4_net41
+ dac_config_2 vdda1 vssa1 vssc1 col_event_rst_bot_right[22] x4_net42
+ row_on_detect_bot[19] row_off_detect_bot[18] openDVS_pixel2x2_bot
x4_x1365 dac_config_3 dac_config_5 col_event_rst_bot_right[21] dac_config_4
+ row_on_detect_bot[18] dac_config_0 dac_config_1 row_off_detect_bot[19] x4_net43
+ dac_config_2 vdda1 vssa1 vssc1 col_event_rst_bot_right[20] x4_net44
+ row_on_detect_bot[19] row_off_detect_bot[18] openDVS_pixel2x2_bot
x4_x1366 dac_config_3 dac_config_5 col_event_rst_bot_right[19] dac_config_4
+ row_on_detect_bot[18] dac_config_0 dac_config_1 row_off_detect_bot[19] x4_net45
+ dac_config_2 vdda1 vssa1 vssc1 col_event_rst_bot_right[18] x4_net46
+ row_on_detect_bot[19] row_off_detect_bot[18] openDVS_pixel2x2_bot
x4_x1367 dac_config_3 dac_config_5 col_event_rst_bot_right[17] dac_config_4
+ row_on_detect_bot[18] dac_config_0 dac_config_1 row_off_detect_bot[19] x4_net47
+ dac_config_2 vdda1 vssa1 vssc1 col_event_rst_bot_right[16] x4_net48
+ row_on_detect_bot[19] row_off_detect_bot[18] openDVS_pixel2x2_bot
x4_x1368 dac_config_3 dac_config_5 col_event_rst_bot_right[15] dac_config_4
+ row_on_detect_bot[18] dac_config_0 dac_config_1 row_off_detect_bot[19] x4_net49
+ dac_config_2 vdda1 vssa1 vssc1 col_event_rst_bot_right[14] x4_net50
+ row_on_detect_bot[19] row_off_detect_bot[18] openDVS_pixel2x2_bot
x4_x1369 dac_config_3 dac_config_5 col_event_rst_bot_right[13] dac_config_4
+ row_on_detect_bot[18] dac_config_0 dac_config_1 row_off_detect_bot[19] x4_net51
+ dac_config_2 vdda1 vssa1 vssc1 col_event_rst_bot_right[12] x4_net52
+ row_on_detect_bot[19] row_off_detect_bot[18] openDVS_pixel2x2_bot
x4_x1370 dac_config_3 dac_config_5 col_event_rst_bot_right[11] dac_config_4
+ row_on_detect_bot[18] dac_config_0 dac_config_1 row_off_detect_bot[19] x4_net53
+ dac_config_2 vdda1 vssa1 vssc1 col_event_rst_bot_right[10] x4_net54
+ row_on_detect_bot[19] row_off_detect_bot[18] openDVS_pixel2x2_bot
x4_x1371 dac_config_3 dac_config_5 col_event_rst_bot_right[9] dac_config_4
+ row_on_detect_bot[18] dac_config_0 dac_config_1 row_off_detect_bot[19] x4_net55
+ dac_config_2 vdda1 vssa1 vssc1 col_event_rst_bot_right[8] x4_net56 row_on_detect_bot[19]
+ row_off_detect_bot[18] openDVS_pixel2x2_bot
x4_x1372 dac_config_3 dac_config_5 col_event_rst_bot_right[7] dac_config_4
+ row_on_detect_bot[18] dac_config_0 dac_config_1 row_off_detect_bot[19] x4_net57
+ dac_config_2 vdda1 vssa1 vssc1 col_event_rst_bot_right[6] x4_net58 row_on_detect_bot[19]
+ row_off_detect_bot[18] openDVS_pixel2x2_bot
x4_x1373 dac_config_3 dac_config_5 col_event_rst_bot_right[5] dac_config_4
+ row_on_detect_bot[18] dac_config_0 dac_config_1 row_off_detect_bot[19] x4_net59
+ dac_config_2 vdda1 vssa1 vssc1 col_event_rst_bot_right[4] x4_net60 row_on_detect_bot[19]
+ row_off_detect_bot[18] openDVS_pixel2x2_bot
x4_x1374 dac_config_3 dac_config_5 col_event_rst_bot_right[3] dac_config_4
+ row_on_detect_bot[18] dac_config_0 dac_config_1 row_off_detect_bot[19] x4_net61
+ dac_config_2 vdda1 vssa1 vssc1 col_event_rst_bot_right[2] x4_net62 row_on_detect_bot[19]
+ row_off_detect_bot[18] openDVS_pixel2x2_bot
x4_x1375 dac_config_3 dac_config_5 col_event_rst_bot_right[1] dac_config_4
+ row_on_detect_bot[18] dac_config_0 dac_config_1 row_off_detect_bot[19] x4_net63
+ dac_config_2 vdda1 vssa1 vssc1 col_event_rst_bot_right[0] x4_net64 row_on_detect_bot[19]
+ row_off_detect_bot[18] openDVS_pixel2x2_bot
x4_x1376 dac_config_3 dac_config_5 col_event_rst_bot_right[63] dac_config_4
+ row_on_detect_bot[20] dac_config_0 dac_config_1 row_off_detect_bot[21] x4_net1
+ dac_config_2 vdda1 vssa1 vssc1 col_event_rst_bot_right[62] x4_net2 row_on_detect_bot[21]
+ row_off_detect_bot[20] openDVS_pixel2x2_bot
x4_x1377 dac_config_3 dac_config_5 col_event_rst_bot_right[61] dac_config_4
+ row_on_detect_bot[20] dac_config_0 dac_config_1 row_off_detect_bot[21] x4_net3
+ dac_config_2 vdda1 vssa1 vssc1 col_event_rst_bot_right[60] x4_net4 row_on_detect_bot[21]
+ row_off_detect_bot[20] openDVS_pixel2x2_bot
x4_x1378 dac_config_3 dac_config_5 col_event_rst_bot_right[59] dac_config_4
+ row_on_detect_bot[20] dac_config_0 dac_config_1 row_off_detect_bot[21] x4_net5
+ dac_config_2 vdda1 vssa1 vssc1 col_event_rst_bot_right[58] x4_net6 row_on_detect_bot[21]
+ row_off_detect_bot[20] openDVS_pixel2x2_bot
x4_x1379 dac_config_3 dac_config_5 col_event_rst_bot_right[57] dac_config_4
+ row_on_detect_bot[20] dac_config_0 dac_config_1 row_off_detect_bot[21] x4_net7
+ dac_config_2 vdda1 vssa1 vssc1 col_event_rst_bot_right[56] x4_net8 row_on_detect_bot[21]
+ row_off_detect_bot[20] openDVS_pixel2x2_bot
x4_x1380 dac_config_3 dac_config_5 col_event_rst_bot_right[55] dac_config_4
+ row_on_detect_bot[20] dac_config_0 dac_config_1 row_off_detect_bot[21] x4_net9
+ dac_config_2 vdda1 vssa1 vssc1 col_event_rst_bot_right[54] x4_net10
+ row_on_detect_bot[21] row_off_detect_bot[20] openDVS_pixel2x2_bot
x4_x1381 dac_config_3 dac_config_5 col_event_rst_bot_right[53] dac_config_4
+ row_on_detect_bot[20] dac_config_0 dac_config_1 row_off_detect_bot[21] x4_net11
+ dac_config_2 vdda1 vssa1 vssc1 col_event_rst_bot_right[52] x4_net12
+ row_on_detect_bot[21] row_off_detect_bot[20] openDVS_pixel2x2_bot
x4_x1382 dac_config_3 dac_config_5 col_event_rst_bot_right[51] dac_config_4
+ row_on_detect_bot[20] dac_config_0 dac_config_1 row_off_detect_bot[21] x4_net13
+ dac_config_2 vdda1 vssa1 vssc1 col_event_rst_bot_right[50] x4_net14
+ row_on_detect_bot[21] row_off_detect_bot[20] openDVS_pixel2x2_bot
x4_x1383 dac_config_3 dac_config_5 col_event_rst_bot_right[49] dac_config_4
+ row_on_detect_bot[20] dac_config_0 dac_config_1 row_off_detect_bot[21] x4_net15
+ dac_config_2 vdda1 vssa1 vssc1 col_event_rst_bot_right[48] x4_net16
+ row_on_detect_bot[21] row_off_detect_bot[20] openDVS_pixel2x2_bot
x4_x1384 dac_config_3 dac_config_5 col_event_rst_bot_right[47] dac_config_4
+ row_on_detect_bot[20] dac_config_0 dac_config_1 row_off_detect_bot[21] x4_net17
+ dac_config_2 vdda1 vssa1 vssc1 col_event_rst_bot_right[46] x4_net18
+ row_on_detect_bot[21] row_off_detect_bot[20] openDVS_pixel2x2_bot
x4_x1385 dac_config_3 dac_config_5 col_event_rst_bot_right[45] dac_config_4
+ row_on_detect_bot[20] dac_config_0 dac_config_1 row_off_detect_bot[21] x4_net19
+ dac_config_2 vdda1 vssa1 vssc1 col_event_rst_bot_right[44] x4_net20
+ row_on_detect_bot[21] row_off_detect_bot[20] openDVS_pixel2x2_bot
x4_x1386 dac_config_3 dac_config_5 col_event_rst_bot_right[43] dac_config_4
+ row_on_detect_bot[20] dac_config_0 dac_config_1 row_off_detect_bot[21] x4_net21
+ dac_config_2 vdda1 vssa1 vssc1 col_event_rst_bot_right[42] x4_net22
+ row_on_detect_bot[21] row_off_detect_bot[20] openDVS_pixel2x2_bot
x4_x1387 dac_config_3 dac_config_5 col_event_rst_bot_right[41] dac_config_4
+ row_on_detect_bot[20] dac_config_0 dac_config_1 row_off_detect_bot[21] x4_net23
+ dac_config_2 vdda1 vssa1 vssc1 col_event_rst_bot_right[40] x4_net24
+ row_on_detect_bot[21] row_off_detect_bot[20] openDVS_pixel2x2_bot
x4_x1388 dac_config_3 dac_config_5 col_event_rst_bot_right[39] dac_config_4
+ row_on_detect_bot[20] dac_config_0 dac_config_1 row_off_detect_bot[21] x4_net25
+ dac_config_2 vdda1 vssa1 vssc1 col_event_rst_bot_right[38] x4_net26
+ row_on_detect_bot[21] row_off_detect_bot[20] openDVS_pixel2x2_bot
x4_x1389 dac_config_3 dac_config_5 col_event_rst_bot_right[37] dac_config_4
+ row_on_detect_bot[20] dac_config_0 dac_config_1 row_off_detect_bot[21] x4_net27
+ dac_config_2 vdda1 vssa1 vssc1 col_event_rst_bot_right[36] x4_net28
+ row_on_detect_bot[21] row_off_detect_bot[20] openDVS_pixel2x2_bot
x4_x1390 dac_config_3 dac_config_5 col_event_rst_bot_right[35] dac_config_4
+ row_on_detect_bot[20] dac_config_0 dac_config_1 row_off_detect_bot[21] x4_net29
+ dac_config_2 vdda1 vssa1 vssc1 col_event_rst_bot_right[34] x4_net30
+ row_on_detect_bot[21] row_off_detect_bot[20] openDVS_pixel2x2_bot
x4_x1391 dac_config_3 dac_config_5 col_event_rst_bot_right[33] dac_config_4
+ row_on_detect_bot[20] dac_config_0 dac_config_1 row_off_detect_bot[21] x4_net31
+ dac_config_2 vdda1 vssa1 vssc1 col_event_rst_bot_right[32] x4_net32
+ row_on_detect_bot[21] row_off_detect_bot[20] openDVS_pixel2x2_bot
x4_x1392 dac_config_3 dac_config_5 col_event_rst_bot_right[31] dac_config_4
+ row_on_detect_bot[20] dac_config_0 dac_config_1 row_off_detect_bot[21] x4_net33
+ dac_config_2 vdda1 vssa1 vssc1 col_event_rst_bot_right[30] x4_net34
+ row_on_detect_bot[21] row_off_detect_bot[20] openDVS_pixel2x2_bot
x4_x1393 dac_config_3 dac_config_5 col_event_rst_bot_right[29] dac_config_4
+ row_on_detect_bot[20] dac_config_0 dac_config_1 row_off_detect_bot[21] x4_net35
+ dac_config_2 vdda1 vssa1 vssc1 col_event_rst_bot_right[28] x4_net36
+ row_on_detect_bot[21] row_off_detect_bot[20] openDVS_pixel2x2_bot
x4_x1394 dac_config_3 dac_config_5 col_event_rst_bot_right[27] dac_config_4
+ row_on_detect_bot[20] dac_config_0 dac_config_1 row_off_detect_bot[21] x4_net37
+ dac_config_2 vdda1 vssa1 vssc1 col_event_rst_bot_right[26] x4_net38
+ row_on_detect_bot[21] row_off_detect_bot[20] openDVS_pixel2x2_bot
x4_x1395 dac_config_3 dac_config_5 col_event_rst_bot_right[25] dac_config_4
+ row_on_detect_bot[20] dac_config_0 dac_config_1 row_off_detect_bot[21] x4_net39
+ dac_config_2 vdda1 vssa1 vssc1 col_event_rst_bot_right[24] x4_net40
+ row_on_detect_bot[21] row_off_detect_bot[20] openDVS_pixel2x2_bot
x4_x1396 dac_config_3 dac_config_5 col_event_rst_bot_right[23] dac_config_4
+ row_on_detect_bot[20] dac_config_0 dac_config_1 row_off_detect_bot[21] x4_net41
+ dac_config_2 vdda1 vssa1 vssc1 col_event_rst_bot_right[22] x4_net42
+ row_on_detect_bot[21] row_off_detect_bot[20] openDVS_pixel2x2_bot
x4_x1397 dac_config_3 dac_config_5 col_event_rst_bot_right[21] dac_config_4
+ row_on_detect_bot[20] dac_config_0 dac_config_1 row_off_detect_bot[21] x4_net43
+ dac_config_2 vdda1 vssa1 vssc1 col_event_rst_bot_right[20] x4_net44
+ row_on_detect_bot[21] row_off_detect_bot[20] openDVS_pixel2x2_bot
x4_x1398 dac_config_3 dac_config_5 col_event_rst_bot_right[19] dac_config_4
+ row_on_detect_bot[20] dac_config_0 dac_config_1 row_off_detect_bot[21] x4_net45
+ dac_config_2 vdda1 vssa1 vssc1 col_event_rst_bot_right[18] x4_net46
+ row_on_detect_bot[21] row_off_detect_bot[20] openDVS_pixel2x2_bot
x4_x1399 dac_config_3 dac_config_5 col_event_rst_bot_right[17] dac_config_4
+ row_on_detect_bot[20] dac_config_0 dac_config_1 row_off_detect_bot[21] x4_net47
+ dac_config_2 vdda1 vssa1 vssc1 col_event_rst_bot_right[16] x4_net48
+ row_on_detect_bot[21] row_off_detect_bot[20] openDVS_pixel2x2_bot
x4_x1400 dac_config_3 dac_config_5 col_event_rst_bot_right[15] dac_config_4
+ row_on_detect_bot[20] dac_config_0 dac_config_1 row_off_detect_bot[21] x4_net49
+ dac_config_2 vdda1 vssa1 vssc1 col_event_rst_bot_right[14] x4_net50
+ row_on_detect_bot[21] row_off_detect_bot[20] openDVS_pixel2x2_bot
x4_x1401 dac_config_3 dac_config_5 col_event_rst_bot_right[13] dac_config_4
+ row_on_detect_bot[20] dac_config_0 dac_config_1 row_off_detect_bot[21] x4_net51
+ dac_config_2 vdda1 vssa1 vssc1 col_event_rst_bot_right[12] x4_net52
+ row_on_detect_bot[21] row_off_detect_bot[20] openDVS_pixel2x2_bot
x4_x1402 dac_config_3 dac_config_5 col_event_rst_bot_right[11] dac_config_4
+ row_on_detect_bot[20] dac_config_0 dac_config_1 row_off_detect_bot[21] x4_net53
+ dac_config_2 vdda1 vssa1 vssc1 col_event_rst_bot_right[10] x4_net54
+ row_on_detect_bot[21] row_off_detect_bot[20] openDVS_pixel2x2_bot
x4_x1403 dac_config_3 dac_config_5 col_event_rst_bot_right[9] dac_config_4
+ row_on_detect_bot[20] dac_config_0 dac_config_1 row_off_detect_bot[21] x4_net55
+ dac_config_2 vdda1 vssa1 vssc1 col_event_rst_bot_right[8] x4_net56 row_on_detect_bot[21]
+ row_off_detect_bot[20] openDVS_pixel2x2_bot
x4_x1404 dac_config_3 dac_config_5 col_event_rst_bot_right[7] dac_config_4
+ row_on_detect_bot[20] dac_config_0 dac_config_1 row_off_detect_bot[21] x4_net57
+ dac_config_2 vdda1 vssa1 vssc1 col_event_rst_bot_right[6] x4_net58 row_on_detect_bot[21]
+ row_off_detect_bot[20] openDVS_pixel2x2_bot
x4_x1405 dac_config_3 dac_config_5 col_event_rst_bot_right[5] dac_config_4
+ row_on_detect_bot[20] dac_config_0 dac_config_1 row_off_detect_bot[21] x4_net59
+ dac_config_2 vdda1 vssa1 vssc1 col_event_rst_bot_right[4] x4_net60 row_on_detect_bot[21]
+ row_off_detect_bot[20] openDVS_pixel2x2_bot
x4_x1406 dac_config_3 dac_config_5 col_event_rst_bot_right[3] dac_config_4
+ row_on_detect_bot[20] dac_config_0 dac_config_1 row_off_detect_bot[21] x4_net61
+ dac_config_2 vdda1 vssa1 vssc1 col_event_rst_bot_right[2] x4_net62 row_on_detect_bot[21]
+ row_off_detect_bot[20] openDVS_pixel2x2_bot
x4_x1407 dac_config_3 dac_config_5 col_event_rst_bot_right[1] dac_config_4
+ row_on_detect_bot[20] dac_config_0 dac_config_1 row_off_detect_bot[21] x4_net63
+ dac_config_2 vdda1 vssa1 vssc1 col_event_rst_bot_right[0] x4_net64 row_on_detect_bot[21]
+ row_off_detect_bot[20] openDVS_pixel2x2_bot
x4_x1408 dac_config_3 dac_config_5 col_event_rst_bot_right[63] dac_config_4
+ row_on_detect_bot[22] dac_config_0 dac_config_1 row_off_detect_bot[23] x4_net1
+ dac_config_2 vdda1 vssa1 vssc1 col_event_rst_bot_right[62] x4_net2 row_on_detect_bot[23]
+ row_off_detect_bot[22] openDVS_pixel2x2_bot
x4_x1409 dac_config_3 dac_config_5 col_event_rst_bot_right[61] dac_config_4
+ row_on_detect_bot[22] dac_config_0 dac_config_1 row_off_detect_bot[23] x4_net3
+ dac_config_2 vdda1 vssa1 vssc1 col_event_rst_bot_right[60] x4_net4 row_on_detect_bot[23]
+ row_off_detect_bot[22] openDVS_pixel2x2_bot
x4_x1410 dac_config_3 dac_config_5 col_event_rst_bot_right[59] dac_config_4
+ row_on_detect_bot[22] dac_config_0 dac_config_1 row_off_detect_bot[23] x4_net5
+ dac_config_2 vdda1 vssa1 vssc1 col_event_rst_bot_right[58] x4_net6 row_on_detect_bot[23]
+ row_off_detect_bot[22] openDVS_pixel2x2_bot
x4_x1411 dac_config_3 dac_config_5 col_event_rst_bot_right[57] dac_config_4
+ row_on_detect_bot[22] dac_config_0 dac_config_1 row_off_detect_bot[23] x4_net7
+ dac_config_2 vdda1 vssa1 vssc1 col_event_rst_bot_right[56] x4_net8 row_on_detect_bot[23]
+ row_off_detect_bot[22] openDVS_pixel2x2_bot
x4_x1412 dac_config_3 dac_config_5 col_event_rst_bot_right[55] dac_config_4
+ row_on_detect_bot[22] dac_config_0 dac_config_1 row_off_detect_bot[23] x4_net9
+ dac_config_2 vdda1 vssa1 vssc1 col_event_rst_bot_right[54] x4_net10
+ row_on_detect_bot[23] row_off_detect_bot[22] openDVS_pixel2x2_bot
x4_x1413 dac_config_3 dac_config_5 col_event_rst_bot_right[53] dac_config_4
+ row_on_detect_bot[22] dac_config_0 dac_config_1 row_off_detect_bot[23] x4_net11
+ dac_config_2 vdda1 vssa1 vssc1 col_event_rst_bot_right[52] x4_net12
+ row_on_detect_bot[23] row_off_detect_bot[22] openDVS_pixel2x2_bot
x4_x1414 dac_config_3 dac_config_5 col_event_rst_bot_right[51] dac_config_4
+ row_on_detect_bot[22] dac_config_0 dac_config_1 row_off_detect_bot[23] x4_net13
+ dac_config_2 vdda1 vssa1 vssc1 col_event_rst_bot_right[50] x4_net14
+ row_on_detect_bot[23] row_off_detect_bot[22] openDVS_pixel2x2_bot
x4_x1415 dac_config_3 dac_config_5 col_event_rst_bot_right[49] dac_config_4
+ row_on_detect_bot[22] dac_config_0 dac_config_1 row_off_detect_bot[23] x4_net15
+ dac_config_2 vdda1 vssa1 vssc1 col_event_rst_bot_right[48] x4_net16
+ row_on_detect_bot[23] row_off_detect_bot[22] openDVS_pixel2x2_bot
x4_x1416 dac_config_3 dac_config_5 col_event_rst_bot_right[47] dac_config_4
+ row_on_detect_bot[22] dac_config_0 dac_config_1 row_off_detect_bot[23] x4_net17
+ dac_config_2 vdda1 vssa1 vssc1 col_event_rst_bot_right[46] x4_net18
+ row_on_detect_bot[23] row_off_detect_bot[22] openDVS_pixel2x2_bot
x4_x1417 dac_config_3 dac_config_5 col_event_rst_bot_right[45] dac_config_4
+ row_on_detect_bot[22] dac_config_0 dac_config_1 row_off_detect_bot[23] x4_net19
+ dac_config_2 vdda1 vssa1 vssc1 col_event_rst_bot_right[44] x4_net20
+ row_on_detect_bot[23] row_off_detect_bot[22] openDVS_pixel2x2_bot
x4_x1418 dac_config_3 dac_config_5 col_event_rst_bot_right[43] dac_config_4
+ row_on_detect_bot[22] dac_config_0 dac_config_1 row_off_detect_bot[23] x4_net21
+ dac_config_2 vdda1 vssa1 vssc1 col_event_rst_bot_right[42] x4_net22
+ row_on_detect_bot[23] row_off_detect_bot[22] openDVS_pixel2x2_bot
x4_x1419 dac_config_3 dac_config_5 col_event_rst_bot_right[41] dac_config_4
+ row_on_detect_bot[22] dac_config_0 dac_config_1 row_off_detect_bot[23] x4_net23
+ dac_config_2 vdda1 vssa1 vssc1 col_event_rst_bot_right[40] x4_net24
+ row_on_detect_bot[23] row_off_detect_bot[22] openDVS_pixel2x2_bot
x4_x1420 dac_config_3 dac_config_5 col_event_rst_bot_right[39] dac_config_4
+ row_on_detect_bot[22] dac_config_0 dac_config_1 row_off_detect_bot[23] x4_net25
+ dac_config_2 vdda1 vssa1 vssc1 col_event_rst_bot_right[38] x4_net26
+ row_on_detect_bot[23] row_off_detect_bot[22] openDVS_pixel2x2_bot
x4_x1421 dac_config_3 dac_config_5 col_event_rst_bot_right[37] dac_config_4
+ row_on_detect_bot[22] dac_config_0 dac_config_1 row_off_detect_bot[23] x4_net27
+ dac_config_2 vdda1 vssa1 vssc1 col_event_rst_bot_right[36] x4_net28
+ row_on_detect_bot[23] row_off_detect_bot[22] openDVS_pixel2x2_bot
x4_x1422 dac_config_3 dac_config_5 col_event_rst_bot_right[35] dac_config_4
+ row_on_detect_bot[22] dac_config_0 dac_config_1 row_off_detect_bot[23] x4_net29
+ dac_config_2 vdda1 vssa1 vssc1 col_event_rst_bot_right[34] x4_net30
+ row_on_detect_bot[23] row_off_detect_bot[22] openDVS_pixel2x2_bot
x4_x1423 dac_config_3 dac_config_5 col_event_rst_bot_right[33] dac_config_4
+ row_on_detect_bot[22] dac_config_0 dac_config_1 row_off_detect_bot[23] x4_net31
+ dac_config_2 vdda1 vssa1 vssc1 col_event_rst_bot_right[32] x4_net32
+ row_on_detect_bot[23] row_off_detect_bot[22] openDVS_pixel2x2_bot
x4_x1424 dac_config_3 dac_config_5 col_event_rst_bot_right[31] dac_config_4
+ row_on_detect_bot[22] dac_config_0 dac_config_1 row_off_detect_bot[23] x4_net33
+ dac_config_2 vdda1 vssa1 vssc1 col_event_rst_bot_right[30] x4_net34
+ row_on_detect_bot[23] row_off_detect_bot[22] openDVS_pixel2x2_bot
x4_x1425 dac_config_3 dac_config_5 col_event_rst_bot_right[29] dac_config_4
+ row_on_detect_bot[22] dac_config_0 dac_config_1 row_off_detect_bot[23] x4_net35
+ dac_config_2 vdda1 vssa1 vssc1 col_event_rst_bot_right[28] x4_net36
+ row_on_detect_bot[23] row_off_detect_bot[22] openDVS_pixel2x2_bot
x4_x1426 dac_config_3 dac_config_5 col_event_rst_bot_right[27] dac_config_4
+ row_on_detect_bot[22] dac_config_0 dac_config_1 row_off_detect_bot[23] x4_net37
+ dac_config_2 vdda1 vssa1 vssc1 col_event_rst_bot_right[26] x4_net38
+ row_on_detect_bot[23] row_off_detect_bot[22] openDVS_pixel2x2_bot
x4_x1427 dac_config_3 dac_config_5 col_event_rst_bot_right[25] dac_config_4
+ row_on_detect_bot[22] dac_config_0 dac_config_1 row_off_detect_bot[23] x4_net39
+ dac_config_2 vdda1 vssa1 vssc1 col_event_rst_bot_right[24] x4_net40
+ row_on_detect_bot[23] row_off_detect_bot[22] openDVS_pixel2x2_bot
x4_x1428 dac_config_3 dac_config_5 col_event_rst_bot_right[23] dac_config_4
+ row_on_detect_bot[22] dac_config_0 dac_config_1 row_off_detect_bot[23] x4_net41
+ dac_config_2 vdda1 vssa1 vssc1 col_event_rst_bot_right[22] x4_net42
+ row_on_detect_bot[23] row_off_detect_bot[22] openDVS_pixel2x2_bot
x4_x1429 dac_config_3 dac_config_5 col_event_rst_bot_right[21] dac_config_4
+ row_on_detect_bot[22] dac_config_0 dac_config_1 row_off_detect_bot[23] x4_net43
+ dac_config_2 vdda1 vssa1 vssc1 col_event_rst_bot_right[20] x4_net44
+ row_on_detect_bot[23] row_off_detect_bot[22] openDVS_pixel2x2_bot
x4_x1430 dac_config_3 dac_config_5 col_event_rst_bot_right[19] dac_config_4
+ row_on_detect_bot[22] dac_config_0 dac_config_1 row_off_detect_bot[23] x4_net45
+ dac_config_2 vdda1 vssa1 vssc1 col_event_rst_bot_right[18] x4_net46
+ row_on_detect_bot[23] row_off_detect_bot[22] openDVS_pixel2x2_bot
x4_x1431 dac_config_3 dac_config_5 col_event_rst_bot_right[17] dac_config_4
+ row_on_detect_bot[22] dac_config_0 dac_config_1 row_off_detect_bot[23] x4_net47
+ dac_config_2 vdda1 vssa1 vssc1 col_event_rst_bot_right[16] x4_net48
+ row_on_detect_bot[23] row_off_detect_bot[22] openDVS_pixel2x2_bot
x4_x1432 dac_config_3 dac_config_5 col_event_rst_bot_right[15] dac_config_4
+ row_on_detect_bot[22] dac_config_0 dac_config_1 row_off_detect_bot[23] x4_net49
+ dac_config_2 vdda1 vssa1 vssc1 col_event_rst_bot_right[14] x4_net50
+ row_on_detect_bot[23] row_off_detect_bot[22] openDVS_pixel2x2_bot
x4_x1433 dac_config_3 dac_config_5 col_event_rst_bot_right[13] dac_config_4
+ row_on_detect_bot[22] dac_config_0 dac_config_1 row_off_detect_bot[23] x4_net51
+ dac_config_2 vdda1 vssa1 vssc1 col_event_rst_bot_right[12] x4_net52
+ row_on_detect_bot[23] row_off_detect_bot[22] openDVS_pixel2x2_bot
x4_x1434 dac_config_3 dac_config_5 col_event_rst_bot_right[11] dac_config_4
+ row_on_detect_bot[22] dac_config_0 dac_config_1 row_off_detect_bot[23] x4_net53
+ dac_config_2 vdda1 vssa1 vssc1 col_event_rst_bot_right[10] x4_net54
+ row_on_detect_bot[23] row_off_detect_bot[22] openDVS_pixel2x2_bot
x4_x1435 dac_config_3 dac_config_5 col_event_rst_bot_right[9] dac_config_4
+ row_on_detect_bot[22] dac_config_0 dac_config_1 row_off_detect_bot[23] x4_net55
+ dac_config_2 vdda1 vssa1 vssc1 col_event_rst_bot_right[8] x4_net56 row_on_detect_bot[23]
+ row_off_detect_bot[22] openDVS_pixel2x2_bot
x4_x1436 dac_config_3 dac_config_5 col_event_rst_bot_right[7] dac_config_4
+ row_on_detect_bot[22] dac_config_0 dac_config_1 row_off_detect_bot[23] x4_net57
+ dac_config_2 vdda1 vssa1 vssc1 col_event_rst_bot_right[6] x4_net58 row_on_detect_bot[23]
+ row_off_detect_bot[22] openDVS_pixel2x2_bot
x4_x1437 dac_config_3 dac_config_5 col_event_rst_bot_right[5] dac_config_4
+ row_on_detect_bot[22] dac_config_0 dac_config_1 row_off_detect_bot[23] x4_net59
+ dac_config_2 vdda1 vssa1 vssc1 col_event_rst_bot_right[4] x4_net60 row_on_detect_bot[23]
+ row_off_detect_bot[22] openDVS_pixel2x2_bot
x4_x1438 dac_config_3 dac_config_5 col_event_rst_bot_right[3] dac_config_4
+ row_on_detect_bot[22] dac_config_0 dac_config_1 row_off_detect_bot[23] x4_net61
+ dac_config_2 vdda1 vssa1 vssc1 col_event_rst_bot_right[2] x4_net62 row_on_detect_bot[23]
+ row_off_detect_bot[22] openDVS_pixel2x2_bot
x4_x1439 dac_config_3 dac_config_5 col_event_rst_bot_right[1] dac_config_4
+ row_on_detect_bot[22] dac_config_0 dac_config_1 row_off_detect_bot[23] x4_net63
+ dac_config_2 vdda1 vssa1 vssc1 col_event_rst_bot_right[0] x4_net64 row_on_detect_bot[23]
+ row_off_detect_bot[22] openDVS_pixel2x2_bot
x4_x1440 dac_config_3 dac_config_5 col_event_rst_bot_right[63] dac_config_4
+ row_on_detect_bot[24] dac_config_0 dac_config_1 row_off_detect_bot[25] x4_net1
+ dac_config_2 vdda1 vssa1 vssc1 col_event_rst_bot_right[62] x4_net2 row_on_detect_bot[25]
+ row_off_detect_bot[24] openDVS_pixel2x2_bot
x4_x1441 dac_config_3 dac_config_5 col_event_rst_bot_right[61] dac_config_4
+ row_on_detect_bot[24] dac_config_0 dac_config_1 row_off_detect_bot[25] x4_net3
+ dac_config_2 vdda1 vssa1 vssc1 col_event_rst_bot_right[60] x4_net4 row_on_detect_bot[25]
+ row_off_detect_bot[24] openDVS_pixel2x2_bot
x4_x1442 dac_config_3 dac_config_5 col_event_rst_bot_right[59] dac_config_4
+ row_on_detect_bot[24] dac_config_0 dac_config_1 row_off_detect_bot[25] x4_net5
+ dac_config_2 vdda1 vssa1 vssc1 col_event_rst_bot_right[58] x4_net6 row_on_detect_bot[25]
+ row_off_detect_bot[24] openDVS_pixel2x2_bot
x4_x1443 dac_config_3 dac_config_5 col_event_rst_bot_right[57] dac_config_4
+ row_on_detect_bot[24] dac_config_0 dac_config_1 row_off_detect_bot[25] x4_net7
+ dac_config_2 vdda1 vssa1 vssc1 col_event_rst_bot_right[56] x4_net8 row_on_detect_bot[25]
+ row_off_detect_bot[24] openDVS_pixel2x2_bot
x4_x1444 dac_config_3 dac_config_5 col_event_rst_bot_right[55] dac_config_4
+ row_on_detect_bot[24] dac_config_0 dac_config_1 row_off_detect_bot[25] x4_net9
+ dac_config_2 vdda1 vssa1 vssc1 col_event_rst_bot_right[54] x4_net10
+ row_on_detect_bot[25] row_off_detect_bot[24] openDVS_pixel2x2_bot
x4_x1445 dac_config_3 dac_config_5 col_event_rst_bot_right[53] dac_config_4
+ row_on_detect_bot[24] dac_config_0 dac_config_1 row_off_detect_bot[25] x4_net11
+ dac_config_2 vdda1 vssa1 vssc1 col_event_rst_bot_right[52] x4_net12
+ row_on_detect_bot[25] row_off_detect_bot[24] openDVS_pixel2x2_bot
x4_x1446 dac_config_3 dac_config_5 col_event_rst_bot_right[51] dac_config_4
+ row_on_detect_bot[24] dac_config_0 dac_config_1 row_off_detect_bot[25] x4_net13
+ dac_config_2 vdda1 vssa1 vssc1 col_event_rst_bot_right[50] x4_net14
+ row_on_detect_bot[25] row_off_detect_bot[24] openDVS_pixel2x2_bot
x4_x1447 dac_config_3 dac_config_5 col_event_rst_bot_right[49] dac_config_4
+ row_on_detect_bot[24] dac_config_0 dac_config_1 row_off_detect_bot[25] x4_net15
+ dac_config_2 vdda1 vssa1 vssc1 col_event_rst_bot_right[48] x4_net16
+ row_on_detect_bot[25] row_off_detect_bot[24] openDVS_pixel2x2_bot
x4_x1448 dac_config_3 dac_config_5 col_event_rst_bot_right[47] dac_config_4
+ row_on_detect_bot[24] dac_config_0 dac_config_1 row_off_detect_bot[25] x4_net17
+ dac_config_2 vdda1 vssa1 vssc1 col_event_rst_bot_right[46] x4_net18
+ row_on_detect_bot[25] row_off_detect_bot[24] openDVS_pixel2x2_bot
x4_x1449 dac_config_3 dac_config_5 col_event_rst_bot_right[45] dac_config_4
+ row_on_detect_bot[24] dac_config_0 dac_config_1 row_off_detect_bot[25] x4_net19
+ dac_config_2 vdda1 vssa1 vssc1 col_event_rst_bot_right[44] x4_net20
+ row_on_detect_bot[25] row_off_detect_bot[24] openDVS_pixel2x2_bot
x4_x1450 dac_config_3 dac_config_5 col_event_rst_bot_right[43] dac_config_4
+ row_on_detect_bot[24] dac_config_0 dac_config_1 row_off_detect_bot[25] x4_net21
+ dac_config_2 vdda1 vssa1 vssc1 col_event_rst_bot_right[42] x4_net22
+ row_on_detect_bot[25] row_off_detect_bot[24] openDVS_pixel2x2_bot
x4_x1451 dac_config_3 dac_config_5 col_event_rst_bot_right[41] dac_config_4
+ row_on_detect_bot[24] dac_config_0 dac_config_1 row_off_detect_bot[25] x4_net23
+ dac_config_2 vdda1 vssa1 vssc1 col_event_rst_bot_right[40] x4_net24
+ row_on_detect_bot[25] row_off_detect_bot[24] openDVS_pixel2x2_bot
x4_x1452 dac_config_3 dac_config_5 col_event_rst_bot_right[39] dac_config_4
+ row_on_detect_bot[24] dac_config_0 dac_config_1 row_off_detect_bot[25] x4_net25
+ dac_config_2 vdda1 vssa1 vssc1 col_event_rst_bot_right[38] x4_net26
+ row_on_detect_bot[25] row_off_detect_bot[24] openDVS_pixel2x2_bot
x4_x1453 dac_config_3 dac_config_5 col_event_rst_bot_right[37] dac_config_4
+ row_on_detect_bot[24] dac_config_0 dac_config_1 row_off_detect_bot[25] x4_net27
+ dac_config_2 vdda1 vssa1 vssc1 col_event_rst_bot_right[36] x4_net28
+ row_on_detect_bot[25] row_off_detect_bot[24] openDVS_pixel2x2_bot
x4_x1454 dac_config_3 dac_config_5 col_event_rst_bot_right[35] dac_config_4
+ row_on_detect_bot[24] dac_config_0 dac_config_1 row_off_detect_bot[25] x4_net29
+ dac_config_2 vdda1 vssa1 vssc1 col_event_rst_bot_right[34] x4_net30
+ row_on_detect_bot[25] row_off_detect_bot[24] openDVS_pixel2x2_bot
x4_x1455 dac_config_3 dac_config_5 col_event_rst_bot_right[33] dac_config_4
+ row_on_detect_bot[24] dac_config_0 dac_config_1 row_off_detect_bot[25] x4_net31
+ dac_config_2 vdda1 vssa1 vssc1 col_event_rst_bot_right[32] x4_net32
+ row_on_detect_bot[25] row_off_detect_bot[24] openDVS_pixel2x2_bot
x4_x1456 dac_config_3 dac_config_5 col_event_rst_bot_right[31] dac_config_4
+ row_on_detect_bot[24] dac_config_0 dac_config_1 row_off_detect_bot[25] x4_net33
+ dac_config_2 vdda1 vssa1 vssc1 col_event_rst_bot_right[30] x4_net34
+ row_on_detect_bot[25] row_off_detect_bot[24] openDVS_pixel2x2_bot
x4_x1457 dac_config_3 dac_config_5 col_event_rst_bot_right[29] dac_config_4
+ row_on_detect_bot[24] dac_config_0 dac_config_1 row_off_detect_bot[25] x4_net35
+ dac_config_2 vdda1 vssa1 vssc1 col_event_rst_bot_right[28] x4_net36
+ row_on_detect_bot[25] row_off_detect_bot[24] openDVS_pixel2x2_bot
x4_x1458 dac_config_3 dac_config_5 col_event_rst_bot_right[27] dac_config_4
+ row_on_detect_bot[24] dac_config_0 dac_config_1 row_off_detect_bot[25] x4_net37
+ dac_config_2 vdda1 vssa1 vssc1 col_event_rst_bot_right[26] x4_net38
+ row_on_detect_bot[25] row_off_detect_bot[24] openDVS_pixel2x2_bot
x4_x1459 dac_config_3 dac_config_5 col_event_rst_bot_right[25] dac_config_4
+ row_on_detect_bot[24] dac_config_0 dac_config_1 row_off_detect_bot[25] x4_net39
+ dac_config_2 vdda1 vssa1 vssc1 col_event_rst_bot_right[24] x4_net40
+ row_on_detect_bot[25] row_off_detect_bot[24] openDVS_pixel2x2_bot
x4_x1460 dac_config_3 dac_config_5 col_event_rst_bot_right[23] dac_config_4
+ row_on_detect_bot[24] dac_config_0 dac_config_1 row_off_detect_bot[25] x4_net41
+ dac_config_2 vdda1 vssa1 vssc1 col_event_rst_bot_right[22] x4_net42
+ row_on_detect_bot[25] row_off_detect_bot[24] openDVS_pixel2x2_bot
x4_x1461 dac_config_3 dac_config_5 col_event_rst_bot_right[21] dac_config_4
+ row_on_detect_bot[24] dac_config_0 dac_config_1 row_off_detect_bot[25] x4_net43
+ dac_config_2 vdda1 vssa1 vssc1 col_event_rst_bot_right[20] x4_net44
+ row_on_detect_bot[25] row_off_detect_bot[24] openDVS_pixel2x2_bot
x4_x1462 dac_config_3 dac_config_5 col_event_rst_bot_right[19] dac_config_4
+ row_on_detect_bot[24] dac_config_0 dac_config_1 row_off_detect_bot[25] x4_net45
+ dac_config_2 vdda1 vssa1 vssc1 col_event_rst_bot_right[18] x4_net46
+ row_on_detect_bot[25] row_off_detect_bot[24] openDVS_pixel2x2_bot
x4_x1463 dac_config_3 dac_config_5 col_event_rst_bot_right[17] dac_config_4
+ row_on_detect_bot[24] dac_config_0 dac_config_1 row_off_detect_bot[25] x4_net47
+ dac_config_2 vdda1 vssa1 vssc1 col_event_rst_bot_right[16] x4_net48
+ row_on_detect_bot[25] row_off_detect_bot[24] openDVS_pixel2x2_bot
x4_x1464 dac_config_3 dac_config_5 col_event_rst_bot_right[15] dac_config_4
+ row_on_detect_bot[24] dac_config_0 dac_config_1 row_off_detect_bot[25] x4_net49
+ dac_config_2 vdda1 vssa1 vssc1 col_event_rst_bot_right[14] x4_net50
+ row_on_detect_bot[25] row_off_detect_bot[24] openDVS_pixel2x2_bot
x4_x1465 dac_config_3 dac_config_5 col_event_rst_bot_right[13] dac_config_4
+ row_on_detect_bot[24] dac_config_0 dac_config_1 row_off_detect_bot[25] x4_net51
+ dac_config_2 vdda1 vssa1 vssc1 col_event_rst_bot_right[12] x4_net52
+ row_on_detect_bot[25] row_off_detect_bot[24] openDVS_pixel2x2_bot
x4_x1466 dac_config_3 dac_config_5 col_event_rst_bot_right[11] dac_config_4
+ row_on_detect_bot[24] dac_config_0 dac_config_1 row_off_detect_bot[25] x4_net53
+ dac_config_2 vdda1 vssa1 vssc1 col_event_rst_bot_right[10] x4_net54
+ row_on_detect_bot[25] row_off_detect_bot[24] openDVS_pixel2x2_bot
x4_x1467 dac_config_3 dac_config_5 col_event_rst_bot_right[9] dac_config_4
+ row_on_detect_bot[24] dac_config_0 dac_config_1 row_off_detect_bot[25] x4_net55
+ dac_config_2 vdda1 vssa1 vssc1 col_event_rst_bot_right[8] x4_net56 row_on_detect_bot[25]
+ row_off_detect_bot[24] openDVS_pixel2x2_bot
x4_x1468 dac_config_3 dac_config_5 col_event_rst_bot_right[7] dac_config_4
+ row_on_detect_bot[24] dac_config_0 dac_config_1 row_off_detect_bot[25] x4_net57
+ dac_config_2 vdda1 vssa1 vssc1 col_event_rst_bot_right[6] x4_net58 row_on_detect_bot[25]
+ row_off_detect_bot[24] openDVS_pixel2x2_bot
x4_x1469 dac_config_3 dac_config_5 col_event_rst_bot_right[5] dac_config_4
+ row_on_detect_bot[24] dac_config_0 dac_config_1 row_off_detect_bot[25] x4_net59
+ dac_config_2 vdda1 vssa1 vssc1 col_event_rst_bot_right[4] x4_net60 row_on_detect_bot[25]
+ row_off_detect_bot[24] openDVS_pixel2x2_bot
x4_x1470 dac_config_3 dac_config_5 col_event_rst_bot_right[3] dac_config_4
+ row_on_detect_bot[24] dac_config_0 dac_config_1 row_off_detect_bot[25] x4_net61
+ dac_config_2 vdda1 vssa1 vssc1 col_event_rst_bot_right[2] x4_net62 row_on_detect_bot[25]
+ row_off_detect_bot[24] openDVS_pixel2x2_bot
x4_x1471 dac_config_3 dac_config_5 col_event_rst_bot_right[1] dac_config_4
+ row_on_detect_bot[24] dac_config_0 dac_config_1 row_off_detect_bot[25] x4_net63
+ dac_config_2 vdda1 vssa1 vssc1 col_event_rst_bot_right[0] x4_net64 row_on_detect_bot[25]
+ row_off_detect_bot[24] openDVS_pixel2x2_bot
x4_x1472 dac_config_3 dac_config_5 col_event_rst_bot_right[63] dac_config_4
+ row_on_detect_bot[26] dac_config_0 dac_config_1 row_off_detect_bot[27] x4_net1
+ dac_config_2 vdda1 vssa1 vssc1 col_event_rst_bot_right[62] x4_net2 row_on_detect_bot[27]
+ row_off_detect_bot[26] openDVS_pixel2x2_bot
x4_x1473 dac_config_3 dac_config_5 col_event_rst_bot_right[61] dac_config_4
+ row_on_detect_bot[26] dac_config_0 dac_config_1 row_off_detect_bot[27] x4_net3
+ dac_config_2 vdda1 vssa1 vssc1 col_event_rst_bot_right[60] x4_net4 row_on_detect_bot[27]
+ row_off_detect_bot[26] openDVS_pixel2x2_bot
x4_x1474 dac_config_3 dac_config_5 col_event_rst_bot_right[59] dac_config_4
+ row_on_detect_bot[26] dac_config_0 dac_config_1 row_off_detect_bot[27] x4_net5
+ dac_config_2 vdda1 vssa1 vssc1 col_event_rst_bot_right[58] x4_net6 row_on_detect_bot[27]
+ row_off_detect_bot[26] openDVS_pixel2x2_bot
x4_x1475 dac_config_3 dac_config_5 col_event_rst_bot_right[57] dac_config_4
+ row_on_detect_bot[26] dac_config_0 dac_config_1 row_off_detect_bot[27] x4_net7
+ dac_config_2 vdda1 vssa1 vssc1 col_event_rst_bot_right[56] x4_net8 row_on_detect_bot[27]
+ row_off_detect_bot[26] openDVS_pixel2x2_bot
x4_x1476 dac_config_3 dac_config_5 col_event_rst_bot_right[55] dac_config_4
+ row_on_detect_bot[26] dac_config_0 dac_config_1 row_off_detect_bot[27] x4_net9
+ dac_config_2 vdda1 vssa1 vssc1 col_event_rst_bot_right[54] x4_net10
+ row_on_detect_bot[27] row_off_detect_bot[26] openDVS_pixel2x2_bot
x4_x1477 dac_config_3 dac_config_5 col_event_rst_bot_right[53] dac_config_4
+ row_on_detect_bot[26] dac_config_0 dac_config_1 row_off_detect_bot[27] x4_net11
+ dac_config_2 vdda1 vssa1 vssc1 col_event_rst_bot_right[52] x4_net12
+ row_on_detect_bot[27] row_off_detect_bot[26] openDVS_pixel2x2_bot
x4_x1478 dac_config_3 dac_config_5 col_event_rst_bot_right[51] dac_config_4
+ row_on_detect_bot[26] dac_config_0 dac_config_1 row_off_detect_bot[27] x4_net13
+ dac_config_2 vdda1 vssa1 vssc1 col_event_rst_bot_right[50] x4_net14
+ row_on_detect_bot[27] row_off_detect_bot[26] openDVS_pixel2x2_bot
x4_x1479 dac_config_3 dac_config_5 col_event_rst_bot_right[49] dac_config_4
+ row_on_detect_bot[26] dac_config_0 dac_config_1 row_off_detect_bot[27] x4_net15
+ dac_config_2 vdda1 vssa1 vssc1 col_event_rst_bot_right[48] x4_net16
+ row_on_detect_bot[27] row_off_detect_bot[26] openDVS_pixel2x2_bot
x4_x1480 dac_config_3 dac_config_5 col_event_rst_bot_right[47] dac_config_4
+ row_on_detect_bot[26] dac_config_0 dac_config_1 row_off_detect_bot[27] x4_net17
+ dac_config_2 vdda1 vssa1 vssc1 col_event_rst_bot_right[46] x4_net18
+ row_on_detect_bot[27] row_off_detect_bot[26] openDVS_pixel2x2_bot
x4_x1481 dac_config_3 dac_config_5 col_event_rst_bot_right[45] dac_config_4
+ row_on_detect_bot[26] dac_config_0 dac_config_1 row_off_detect_bot[27] x4_net19
+ dac_config_2 vdda1 vssa1 vssc1 col_event_rst_bot_right[44] x4_net20
+ row_on_detect_bot[27] row_off_detect_bot[26] openDVS_pixel2x2_bot
x4_x1482 dac_config_3 dac_config_5 col_event_rst_bot_right[43] dac_config_4
+ row_on_detect_bot[26] dac_config_0 dac_config_1 row_off_detect_bot[27] x4_net21
+ dac_config_2 vdda1 vssa1 vssc1 col_event_rst_bot_right[42] x4_net22
+ row_on_detect_bot[27] row_off_detect_bot[26] openDVS_pixel2x2_bot
x4_x1483 dac_config_3 dac_config_5 col_event_rst_bot_right[41] dac_config_4
+ row_on_detect_bot[26] dac_config_0 dac_config_1 row_off_detect_bot[27] x4_net23
+ dac_config_2 vdda1 vssa1 vssc1 col_event_rst_bot_right[40] x4_net24
+ row_on_detect_bot[27] row_off_detect_bot[26] openDVS_pixel2x2_bot
x4_x1484 dac_config_3 dac_config_5 col_event_rst_bot_right[39] dac_config_4
+ row_on_detect_bot[26] dac_config_0 dac_config_1 row_off_detect_bot[27] x4_net25
+ dac_config_2 vdda1 vssa1 vssc1 col_event_rst_bot_right[38] x4_net26
+ row_on_detect_bot[27] row_off_detect_bot[26] openDVS_pixel2x2_bot
x4_x1485 dac_config_3 dac_config_5 col_event_rst_bot_right[37] dac_config_4
+ row_on_detect_bot[26] dac_config_0 dac_config_1 row_off_detect_bot[27] x4_net27
+ dac_config_2 vdda1 vssa1 vssc1 col_event_rst_bot_right[36] x4_net28
+ row_on_detect_bot[27] row_off_detect_bot[26] openDVS_pixel2x2_bot
x4_x1486 dac_config_3 dac_config_5 col_event_rst_bot_right[35] dac_config_4
+ row_on_detect_bot[26] dac_config_0 dac_config_1 row_off_detect_bot[27] x4_net29
+ dac_config_2 vdda1 vssa1 vssc1 col_event_rst_bot_right[34] x4_net30
+ row_on_detect_bot[27] row_off_detect_bot[26] openDVS_pixel2x2_bot
x4_x1487 dac_config_3 dac_config_5 col_event_rst_bot_right[33] dac_config_4
+ row_on_detect_bot[26] dac_config_0 dac_config_1 row_off_detect_bot[27] x4_net31
+ dac_config_2 vdda1 vssa1 vssc1 col_event_rst_bot_right[32] x4_net32
+ row_on_detect_bot[27] row_off_detect_bot[26] openDVS_pixel2x2_bot
x4_x1488 dac_config_3 dac_config_5 col_event_rst_bot_right[31] dac_config_4
+ row_on_detect_bot[26] dac_config_0 dac_config_1 row_off_detect_bot[27] x4_net33
+ dac_config_2 vdda1 vssa1 vssc1 col_event_rst_bot_right[30] x4_net34
+ row_on_detect_bot[27] row_off_detect_bot[26] openDVS_pixel2x2_bot
x4_x1489 dac_config_3 dac_config_5 col_event_rst_bot_right[29] dac_config_4
+ row_on_detect_bot[26] dac_config_0 dac_config_1 row_off_detect_bot[27] x4_net35
+ dac_config_2 vdda1 vssa1 vssc1 col_event_rst_bot_right[28] x4_net36
+ row_on_detect_bot[27] row_off_detect_bot[26] openDVS_pixel2x2_bot
x4_x1490 dac_config_3 dac_config_5 col_event_rst_bot_right[27] dac_config_4
+ row_on_detect_bot[26] dac_config_0 dac_config_1 row_off_detect_bot[27] x4_net37
+ dac_config_2 vdda1 vssa1 vssc1 col_event_rst_bot_right[26] x4_net38
+ row_on_detect_bot[27] row_off_detect_bot[26] openDVS_pixel2x2_bot
x4_x1491 dac_config_3 dac_config_5 col_event_rst_bot_right[25] dac_config_4
+ row_on_detect_bot[26] dac_config_0 dac_config_1 row_off_detect_bot[27] x4_net39
+ dac_config_2 vdda1 vssa1 vssc1 col_event_rst_bot_right[24] x4_net40
+ row_on_detect_bot[27] row_off_detect_bot[26] openDVS_pixel2x2_bot
x4_x1492 dac_config_3 dac_config_5 col_event_rst_bot_right[23] dac_config_4
+ row_on_detect_bot[26] dac_config_0 dac_config_1 row_off_detect_bot[27] x4_net41
+ dac_config_2 vdda1 vssa1 vssc1 col_event_rst_bot_right[22] x4_net42
+ row_on_detect_bot[27] row_off_detect_bot[26] openDVS_pixel2x2_bot
x4_x1493 dac_config_3 dac_config_5 col_event_rst_bot_right[21] dac_config_4
+ row_on_detect_bot[26] dac_config_0 dac_config_1 row_off_detect_bot[27] x4_net43
+ dac_config_2 vdda1 vssa1 vssc1 col_event_rst_bot_right[20] x4_net44
+ row_on_detect_bot[27] row_off_detect_bot[26] openDVS_pixel2x2_bot
x4_x1494 dac_config_3 dac_config_5 col_event_rst_bot_right[19] dac_config_4
+ row_on_detect_bot[26] dac_config_0 dac_config_1 row_off_detect_bot[27] x4_net45
+ dac_config_2 vdda1 vssa1 vssc1 col_event_rst_bot_right[18] x4_net46
+ row_on_detect_bot[27] row_off_detect_bot[26] openDVS_pixel2x2_bot
x4_x1495 dac_config_3 dac_config_5 col_event_rst_bot_right[17] dac_config_4
+ row_on_detect_bot[26] dac_config_0 dac_config_1 row_off_detect_bot[27] x4_net47
+ dac_config_2 vdda1 vssa1 vssc1 col_event_rst_bot_right[16] x4_net48
+ row_on_detect_bot[27] row_off_detect_bot[26] openDVS_pixel2x2_bot
x4_x1496 dac_config_3 dac_config_5 col_event_rst_bot_right[15] dac_config_4
+ row_on_detect_bot[26] dac_config_0 dac_config_1 row_off_detect_bot[27] x4_net49
+ dac_config_2 vdda1 vssa1 vssc1 col_event_rst_bot_right[14] x4_net50
+ row_on_detect_bot[27] row_off_detect_bot[26] openDVS_pixel2x2_bot
x4_x1497 dac_config_3 dac_config_5 col_event_rst_bot_right[13] dac_config_4
+ row_on_detect_bot[26] dac_config_0 dac_config_1 row_off_detect_bot[27] x4_net51
+ dac_config_2 vdda1 vssa1 vssc1 col_event_rst_bot_right[12] x4_net52
+ row_on_detect_bot[27] row_off_detect_bot[26] openDVS_pixel2x2_bot
x4_x1498 dac_config_3 dac_config_5 col_event_rst_bot_right[11] dac_config_4
+ row_on_detect_bot[26] dac_config_0 dac_config_1 row_off_detect_bot[27] x4_net53
+ dac_config_2 vdda1 vssa1 vssc1 col_event_rst_bot_right[10] x4_net54
+ row_on_detect_bot[27] row_off_detect_bot[26] openDVS_pixel2x2_bot
x4_x1499 dac_config_3 dac_config_5 col_event_rst_bot_right[9] dac_config_4
+ row_on_detect_bot[26] dac_config_0 dac_config_1 row_off_detect_bot[27] x4_net55
+ dac_config_2 vdda1 vssa1 vssc1 col_event_rst_bot_right[8] x4_net56 row_on_detect_bot[27]
+ row_off_detect_bot[26] openDVS_pixel2x2_bot
x4_x1500 dac_config_3 dac_config_5 col_event_rst_bot_right[7] dac_config_4
+ row_on_detect_bot[26] dac_config_0 dac_config_1 row_off_detect_bot[27] x4_net57
+ dac_config_2 vdda1 vssa1 vssc1 col_event_rst_bot_right[6] x4_net58 row_on_detect_bot[27]
+ row_off_detect_bot[26] openDVS_pixel2x2_bot
x4_x1501 dac_config_3 dac_config_5 col_event_rst_bot_right[5] dac_config_4
+ row_on_detect_bot[26] dac_config_0 dac_config_1 row_off_detect_bot[27] x4_net59
+ dac_config_2 vdda1 vssa1 vssc1 col_event_rst_bot_right[4] x4_net60 row_on_detect_bot[27]
+ row_off_detect_bot[26] openDVS_pixel2x2_bot
x4_x1502 dac_config_3 dac_config_5 col_event_rst_bot_right[3] dac_config_4
+ row_on_detect_bot[26] dac_config_0 dac_config_1 row_off_detect_bot[27] x4_net61
+ dac_config_2 vdda1 vssa1 vssc1 col_event_rst_bot_right[2] x4_net62 row_on_detect_bot[27]
+ row_off_detect_bot[26] openDVS_pixel2x2_bot
x4_x1503 dac_config_3 dac_config_5 col_event_rst_bot_right[1] dac_config_4
+ row_on_detect_bot[26] dac_config_0 dac_config_1 row_off_detect_bot[27] x4_net63
+ dac_config_2 vdda1 vssa1 vssc1 col_event_rst_bot_right[0] x4_net64 row_on_detect_bot[27]
+ row_off_detect_bot[26] openDVS_pixel2x2_bot
x4_x1504 dac_config_3 dac_config_5 col_event_rst_bot_right[63] dac_config_4
+ row_on_detect_bot[28] dac_config_0 dac_config_1 row_off_detect_bot[29] x4_net1
+ dac_config_2 vdda1 vssa1 vssc1 col_event_rst_bot_right[62] x4_net2 row_on_detect_bot[29]
+ row_off_detect_bot[28] openDVS_pixel2x2_bot
x4_x1505 dac_config_3 dac_config_5 col_event_rst_bot_right[61] dac_config_4
+ row_on_detect_bot[28] dac_config_0 dac_config_1 row_off_detect_bot[29] x4_net3
+ dac_config_2 vdda1 vssa1 vssc1 col_event_rst_bot_right[60] x4_net4 row_on_detect_bot[29]
+ row_off_detect_bot[28] openDVS_pixel2x2_bot
x4_x1506 dac_config_3 dac_config_5 col_event_rst_bot_right[59] dac_config_4
+ row_on_detect_bot[28] dac_config_0 dac_config_1 row_off_detect_bot[29] x4_net5
+ dac_config_2 vdda1 vssa1 vssc1 col_event_rst_bot_right[58] x4_net6 row_on_detect_bot[29]
+ row_off_detect_bot[28] openDVS_pixel2x2_bot
x4_x1507 dac_config_3 dac_config_5 col_event_rst_bot_right[57] dac_config_4
+ row_on_detect_bot[28] dac_config_0 dac_config_1 row_off_detect_bot[29] x4_net7
+ dac_config_2 vdda1 vssa1 vssc1 col_event_rst_bot_right[56] x4_net8 row_on_detect_bot[29]
+ row_off_detect_bot[28] openDVS_pixel2x2_bot
x4_x1508 dac_config_3 dac_config_5 col_event_rst_bot_right[55] dac_config_4
+ row_on_detect_bot[28] dac_config_0 dac_config_1 row_off_detect_bot[29] x4_net9
+ dac_config_2 vdda1 vssa1 vssc1 col_event_rst_bot_right[54] x4_net10
+ row_on_detect_bot[29] row_off_detect_bot[28] openDVS_pixel2x2_bot
x4_x1509 dac_config_3 dac_config_5 col_event_rst_bot_right[53] dac_config_4
+ row_on_detect_bot[28] dac_config_0 dac_config_1 row_off_detect_bot[29] x4_net11
+ dac_config_2 vdda1 vssa1 vssc1 col_event_rst_bot_right[52] x4_net12
+ row_on_detect_bot[29] row_off_detect_bot[28] openDVS_pixel2x2_bot
x4_x1510 dac_config_3 dac_config_5 col_event_rst_bot_right[51] dac_config_4
+ row_on_detect_bot[28] dac_config_0 dac_config_1 row_off_detect_bot[29] x4_net13
+ dac_config_2 vdda1 vssa1 vssc1 col_event_rst_bot_right[50] x4_net14
+ row_on_detect_bot[29] row_off_detect_bot[28] openDVS_pixel2x2_bot
x4_x1511 dac_config_3 dac_config_5 col_event_rst_bot_right[49] dac_config_4
+ row_on_detect_bot[28] dac_config_0 dac_config_1 row_off_detect_bot[29] x4_net15
+ dac_config_2 vdda1 vssa1 vssc1 col_event_rst_bot_right[48] x4_net16
+ row_on_detect_bot[29] row_off_detect_bot[28] openDVS_pixel2x2_bot
x4_x1512 dac_config_3 dac_config_5 col_event_rst_bot_right[47] dac_config_4
+ row_on_detect_bot[28] dac_config_0 dac_config_1 row_off_detect_bot[29] x4_net17
+ dac_config_2 vdda1 vssa1 vssc1 col_event_rst_bot_right[46] x4_net18
+ row_on_detect_bot[29] row_off_detect_bot[28] openDVS_pixel2x2_bot
x4_x1513 dac_config_3 dac_config_5 col_event_rst_bot_right[45] dac_config_4
+ row_on_detect_bot[28] dac_config_0 dac_config_1 row_off_detect_bot[29] x4_net19
+ dac_config_2 vdda1 vssa1 vssc1 col_event_rst_bot_right[44] x4_net20
+ row_on_detect_bot[29] row_off_detect_bot[28] openDVS_pixel2x2_bot
x4_x1514 dac_config_3 dac_config_5 col_event_rst_bot_right[43] dac_config_4
+ row_on_detect_bot[28] dac_config_0 dac_config_1 row_off_detect_bot[29] x4_net21
+ dac_config_2 vdda1 vssa1 vssc1 col_event_rst_bot_right[42] x4_net22
+ row_on_detect_bot[29] row_off_detect_bot[28] openDVS_pixel2x2_bot
x4_x1515 dac_config_3 dac_config_5 col_event_rst_bot_right[41] dac_config_4
+ row_on_detect_bot[28] dac_config_0 dac_config_1 row_off_detect_bot[29] x4_net23
+ dac_config_2 vdda1 vssa1 vssc1 col_event_rst_bot_right[40] x4_net24
+ row_on_detect_bot[29] row_off_detect_bot[28] openDVS_pixel2x2_bot
x4_x1516 dac_config_3 dac_config_5 col_event_rst_bot_right[39] dac_config_4
+ row_on_detect_bot[28] dac_config_0 dac_config_1 row_off_detect_bot[29] x4_net25
+ dac_config_2 vdda1 vssa1 vssc1 col_event_rst_bot_right[38] x4_net26
+ row_on_detect_bot[29] row_off_detect_bot[28] openDVS_pixel2x2_bot
x4_x1517 dac_config_3 dac_config_5 col_event_rst_bot_right[37] dac_config_4
+ row_on_detect_bot[28] dac_config_0 dac_config_1 row_off_detect_bot[29] x4_net27
+ dac_config_2 vdda1 vssa1 vssc1 col_event_rst_bot_right[36] x4_net28
+ row_on_detect_bot[29] row_off_detect_bot[28] openDVS_pixel2x2_bot
x4_x1518 dac_config_3 dac_config_5 col_event_rst_bot_right[35] dac_config_4
+ row_on_detect_bot[28] dac_config_0 dac_config_1 row_off_detect_bot[29] x4_net29
+ dac_config_2 vdda1 vssa1 vssc1 col_event_rst_bot_right[34] x4_net30
+ row_on_detect_bot[29] row_off_detect_bot[28] openDVS_pixel2x2_bot
x4_x1519 dac_config_3 dac_config_5 col_event_rst_bot_right[33] dac_config_4
+ row_on_detect_bot[28] dac_config_0 dac_config_1 row_off_detect_bot[29] x4_net31
+ dac_config_2 vdda1 vssa1 vssc1 col_event_rst_bot_right[32] x4_net32
+ row_on_detect_bot[29] row_off_detect_bot[28] openDVS_pixel2x2_bot
x4_x1520 dac_config_3 dac_config_5 col_event_rst_bot_right[31] dac_config_4
+ row_on_detect_bot[28] dac_config_0 dac_config_1 row_off_detect_bot[29] x4_net33
+ dac_config_2 vdda1 vssa1 vssc1 col_event_rst_bot_right[30] x4_net34
+ row_on_detect_bot[29] row_off_detect_bot[28] openDVS_pixel2x2_bot
x4_x1521 dac_config_3 dac_config_5 col_event_rst_bot_right[29] dac_config_4
+ row_on_detect_bot[28] dac_config_0 dac_config_1 row_off_detect_bot[29] x4_net35
+ dac_config_2 vdda1 vssa1 vssc1 col_event_rst_bot_right[28] x4_net36
+ row_on_detect_bot[29] row_off_detect_bot[28] openDVS_pixel2x2_bot
x4_x1522 dac_config_3 dac_config_5 col_event_rst_bot_right[27] dac_config_4
+ row_on_detect_bot[28] dac_config_0 dac_config_1 row_off_detect_bot[29] x4_net37
+ dac_config_2 vdda1 vssa1 vssc1 col_event_rst_bot_right[26] x4_net38
+ row_on_detect_bot[29] row_off_detect_bot[28] openDVS_pixel2x2_bot
x4_x1523 dac_config_3 dac_config_5 col_event_rst_bot_right[25] dac_config_4
+ row_on_detect_bot[28] dac_config_0 dac_config_1 row_off_detect_bot[29] x4_net39
+ dac_config_2 vdda1 vssa1 vssc1 col_event_rst_bot_right[24] x4_net40
+ row_on_detect_bot[29] row_off_detect_bot[28] openDVS_pixel2x2_bot
x4_x1524 dac_config_3 dac_config_5 col_event_rst_bot_right[23] dac_config_4
+ row_on_detect_bot[28] dac_config_0 dac_config_1 row_off_detect_bot[29] x4_net41
+ dac_config_2 vdda1 vssa1 vssc1 col_event_rst_bot_right[22] x4_net42
+ row_on_detect_bot[29] row_off_detect_bot[28] openDVS_pixel2x2_bot
x4_x1525 dac_config_3 dac_config_5 col_event_rst_bot_right[21] dac_config_4
+ row_on_detect_bot[28] dac_config_0 dac_config_1 row_off_detect_bot[29] x4_net43
+ dac_config_2 vdda1 vssa1 vssc1 col_event_rst_bot_right[20] x4_net44
+ row_on_detect_bot[29] row_off_detect_bot[28] openDVS_pixel2x2_bot
x4_x1526 dac_config_3 dac_config_5 col_event_rst_bot_right[19] dac_config_4
+ row_on_detect_bot[28] dac_config_0 dac_config_1 row_off_detect_bot[29] x4_net45
+ dac_config_2 vdda1 vssa1 vssc1 col_event_rst_bot_right[18] x4_net46
+ row_on_detect_bot[29] row_off_detect_bot[28] openDVS_pixel2x2_bot
x4_x1527 dac_config_3 dac_config_5 col_event_rst_bot_right[17] dac_config_4
+ row_on_detect_bot[28] dac_config_0 dac_config_1 row_off_detect_bot[29] x4_net47
+ dac_config_2 vdda1 vssa1 vssc1 col_event_rst_bot_right[16] x4_net48
+ row_on_detect_bot[29] row_off_detect_bot[28] openDVS_pixel2x2_bot
x4_x1528 dac_config_3 dac_config_5 col_event_rst_bot_right[15] dac_config_4
+ row_on_detect_bot[28] dac_config_0 dac_config_1 row_off_detect_bot[29] x4_net49
+ dac_config_2 vdda1 vssa1 vssc1 col_event_rst_bot_right[14] x4_net50
+ row_on_detect_bot[29] row_off_detect_bot[28] openDVS_pixel2x2_bot
x4_x1529 dac_config_3 dac_config_5 col_event_rst_bot_right[13] dac_config_4
+ row_on_detect_bot[28] dac_config_0 dac_config_1 row_off_detect_bot[29] x4_net51
+ dac_config_2 vdda1 vssa1 vssc1 col_event_rst_bot_right[12] x4_net52
+ row_on_detect_bot[29] row_off_detect_bot[28] openDVS_pixel2x2_bot
x4_x1530 dac_config_3 dac_config_5 col_event_rst_bot_right[11] dac_config_4
+ row_on_detect_bot[28] dac_config_0 dac_config_1 row_off_detect_bot[29] x4_net53
+ dac_config_2 vdda1 vssa1 vssc1 col_event_rst_bot_right[10] x4_net54
+ row_on_detect_bot[29] row_off_detect_bot[28] openDVS_pixel2x2_bot
x4_x1531 dac_config_3 dac_config_5 col_event_rst_bot_right[9] dac_config_4
+ row_on_detect_bot[28] dac_config_0 dac_config_1 row_off_detect_bot[29] x4_net55
+ dac_config_2 vdda1 vssa1 vssc1 col_event_rst_bot_right[8] x4_net56 row_on_detect_bot[29]
+ row_off_detect_bot[28] openDVS_pixel2x2_bot
x4_x1532 dac_config_3 dac_config_5 col_event_rst_bot_right[7] dac_config_4
+ row_on_detect_bot[28] dac_config_0 dac_config_1 row_off_detect_bot[29] x4_net57
+ dac_config_2 vdda1 vssa1 vssc1 col_event_rst_bot_right[6] x4_net58 row_on_detect_bot[29]
+ row_off_detect_bot[28] openDVS_pixel2x2_bot
x4_x1533 dac_config_3 dac_config_5 col_event_rst_bot_right[5] dac_config_4
+ row_on_detect_bot[28] dac_config_0 dac_config_1 row_off_detect_bot[29] x4_net59
+ dac_config_2 vdda1 vssa1 vssc1 col_event_rst_bot_right[4] x4_net60 row_on_detect_bot[29]
+ row_off_detect_bot[28] openDVS_pixel2x2_bot
x4_x1534 dac_config_3 dac_config_5 col_event_rst_bot_right[3] dac_config_4
+ row_on_detect_bot[28] dac_config_0 dac_config_1 row_off_detect_bot[29] x4_net61
+ dac_config_2 vdda1 vssa1 vssc1 col_event_rst_bot_right[2] x4_net62 row_on_detect_bot[29]
+ row_off_detect_bot[28] openDVS_pixel2x2_bot
x4_x1535 dac_config_3 dac_config_5 col_event_rst_bot_right[1] dac_config_4
+ row_on_detect_bot[28] dac_config_0 dac_config_1 row_off_detect_bot[29] x4_net63
+ dac_config_2 vdda1 vssa1 vssc1 col_event_rst_bot_right[0] x4_net64 row_on_detect_bot[29]
+ row_off_detect_bot[28] openDVS_pixel2x2_bot
x4_x1536 dac_config_3 dac_config_5 col_event_rst_bot_right[63] dac_config_4
+ row_on_detect_bot[30] dac_config_0 dac_config_1 row_off_detect_bot[31] x4_net1
+ dac_config_2 vdda1 vssa1 vssc1 col_event_rst_bot_right[62] x4_net2 row_on_detect_bot[31]
+ row_off_detect_bot[30] openDVS_pixel2x2_bot
x4_x1537 dac_config_3 dac_config_5 col_event_rst_bot_right[61] dac_config_4
+ row_on_detect_bot[30] dac_config_0 dac_config_1 row_off_detect_bot[31] x4_net3
+ dac_config_2 vdda1 vssa1 vssc1 col_event_rst_bot_right[60] x4_net4 row_on_detect_bot[31]
+ row_off_detect_bot[30] openDVS_pixel2x2_bot
x4_x1538 dac_config_3 dac_config_5 col_event_rst_bot_right[59] dac_config_4
+ row_on_detect_bot[30] dac_config_0 dac_config_1 row_off_detect_bot[31] x4_net5
+ dac_config_2 vdda1 vssa1 vssc1 col_event_rst_bot_right[58] x4_net6 row_on_detect_bot[31]
+ row_off_detect_bot[30] openDVS_pixel2x2_bot
x4_x1539 dac_config_3 dac_config_5 col_event_rst_bot_right[57] dac_config_4
+ row_on_detect_bot[30] dac_config_0 dac_config_1 row_off_detect_bot[31] x4_net7
+ dac_config_2 vdda1 vssa1 vssc1 col_event_rst_bot_right[56] x4_net8 row_on_detect_bot[31]
+ row_off_detect_bot[30] openDVS_pixel2x2_bot
x4_x1540 dac_config_3 dac_config_5 col_event_rst_bot_right[55] dac_config_4
+ row_on_detect_bot[30] dac_config_0 dac_config_1 row_off_detect_bot[31] x4_net9
+ dac_config_2 vdda1 vssa1 vssc1 col_event_rst_bot_right[54] x4_net10
+ row_on_detect_bot[31] row_off_detect_bot[30] openDVS_pixel2x2_bot
x4_x1541 dac_config_3 dac_config_5 col_event_rst_bot_right[53] dac_config_4
+ row_on_detect_bot[30] dac_config_0 dac_config_1 row_off_detect_bot[31] x4_net11
+ dac_config_2 vdda1 vssa1 vssc1 col_event_rst_bot_right[52] x4_net12
+ row_on_detect_bot[31] row_off_detect_bot[30] openDVS_pixel2x2_bot
x4_x1542 dac_config_3 dac_config_5 col_event_rst_bot_right[51] dac_config_4
+ row_on_detect_bot[30] dac_config_0 dac_config_1 row_off_detect_bot[31] x4_net13
+ dac_config_2 vdda1 vssa1 vssc1 col_event_rst_bot_right[50] x4_net14
+ row_on_detect_bot[31] row_off_detect_bot[30] openDVS_pixel2x2_bot
x4_x1543 dac_config_3 dac_config_5 col_event_rst_bot_right[49] dac_config_4
+ row_on_detect_bot[30] dac_config_0 dac_config_1 row_off_detect_bot[31] x4_net15
+ dac_config_2 vdda1 vssa1 vssc1 col_event_rst_bot_right[48] x4_net16
+ row_on_detect_bot[31] row_off_detect_bot[30] openDVS_pixel2x2_bot
x4_x1544 dac_config_3 dac_config_5 col_event_rst_bot_right[47] dac_config_4
+ row_on_detect_bot[30] dac_config_0 dac_config_1 row_off_detect_bot[31] x4_net17
+ dac_config_2 vdda1 vssa1 vssc1 col_event_rst_bot_right[46] x4_net18
+ row_on_detect_bot[31] row_off_detect_bot[30] openDVS_pixel2x2_bot
x4_x1545 dac_config_3 dac_config_5 col_event_rst_bot_right[45] dac_config_4
+ row_on_detect_bot[30] dac_config_0 dac_config_1 row_off_detect_bot[31] x4_net19
+ dac_config_2 vdda1 vssa1 vssc1 col_event_rst_bot_right[44] x4_net20
+ row_on_detect_bot[31] row_off_detect_bot[30] openDVS_pixel2x2_bot
x4_x1546 dac_config_3 dac_config_5 col_event_rst_bot_right[43] dac_config_4
+ row_on_detect_bot[30] dac_config_0 dac_config_1 row_off_detect_bot[31] x4_net21
+ dac_config_2 vdda1 vssa1 vssc1 col_event_rst_bot_right[42] x4_net22
+ row_on_detect_bot[31] row_off_detect_bot[30] openDVS_pixel2x2_bot
x4_x1547 dac_config_3 dac_config_5 col_event_rst_bot_right[41] dac_config_4
+ row_on_detect_bot[30] dac_config_0 dac_config_1 row_off_detect_bot[31] x4_net23
+ dac_config_2 vdda1 vssa1 vssc1 col_event_rst_bot_right[40] x4_net24
+ row_on_detect_bot[31] row_off_detect_bot[30] openDVS_pixel2x2_bot
x4_x1548 dac_config_3 dac_config_5 col_event_rst_bot_right[39] dac_config_4
+ row_on_detect_bot[30] dac_config_0 dac_config_1 row_off_detect_bot[31] x4_net25
+ dac_config_2 vdda1 vssa1 vssc1 col_event_rst_bot_right[38] x4_net26
+ row_on_detect_bot[31] row_off_detect_bot[30] openDVS_pixel2x2_bot
x4_x1549 dac_config_3 dac_config_5 col_event_rst_bot_right[37] dac_config_4
+ row_on_detect_bot[30] dac_config_0 dac_config_1 row_off_detect_bot[31] x4_net27
+ dac_config_2 vdda1 vssa1 vssc1 col_event_rst_bot_right[36] x4_net28
+ row_on_detect_bot[31] row_off_detect_bot[30] openDVS_pixel2x2_bot
x4_x1550 dac_config_3 dac_config_5 col_event_rst_bot_right[35] dac_config_4
+ row_on_detect_bot[30] dac_config_0 dac_config_1 row_off_detect_bot[31] x4_net29
+ dac_config_2 vdda1 vssa1 vssc1 col_event_rst_bot_right[34] x4_net30
+ row_on_detect_bot[31] row_off_detect_bot[30] openDVS_pixel2x2_bot
x4_x1551 dac_config_3 dac_config_5 col_event_rst_bot_right[33] dac_config_4
+ row_on_detect_bot[30] dac_config_0 dac_config_1 row_off_detect_bot[31] x4_net31
+ dac_config_2 vdda1 vssa1 vssc1 col_event_rst_bot_right[32] x4_net32
+ row_on_detect_bot[31] row_off_detect_bot[30] openDVS_pixel2x2_bot
x4_x1552 dac_config_3 dac_config_5 col_event_rst_bot_right[31] dac_config_4
+ row_on_detect_bot[30] dac_config_0 dac_config_1 row_off_detect_bot[31] x4_net33
+ dac_config_2 vdda1 vssa1 vssc1 col_event_rst_bot_right[30] x4_net34
+ row_on_detect_bot[31] row_off_detect_bot[30] openDVS_pixel2x2_bot
x4_x1553 dac_config_3 dac_config_5 col_event_rst_bot_right[29] dac_config_4
+ row_on_detect_bot[30] dac_config_0 dac_config_1 row_off_detect_bot[31] x4_net35
+ dac_config_2 vdda1 vssa1 vssc1 col_event_rst_bot_right[28] x4_net36
+ row_on_detect_bot[31] row_off_detect_bot[30] openDVS_pixel2x2_bot
x4_x1554 dac_config_3 dac_config_5 col_event_rst_bot_right[27] dac_config_4
+ row_on_detect_bot[30] dac_config_0 dac_config_1 row_off_detect_bot[31] x4_net37
+ dac_config_2 vdda1 vssa1 vssc1 col_event_rst_bot_right[26] x4_net38
+ row_on_detect_bot[31] row_off_detect_bot[30] openDVS_pixel2x2_bot
x4_x1555 dac_config_3 dac_config_5 col_event_rst_bot_right[25] dac_config_4
+ row_on_detect_bot[30] dac_config_0 dac_config_1 row_off_detect_bot[31] x4_net39
+ dac_config_2 vdda1 vssa1 vssc1 col_event_rst_bot_right[24] x4_net40
+ row_on_detect_bot[31] row_off_detect_bot[30] openDVS_pixel2x2_bot
x4_x1556 dac_config_3 dac_config_5 col_event_rst_bot_right[23] dac_config_4
+ row_on_detect_bot[30] dac_config_0 dac_config_1 row_off_detect_bot[31] x4_net41
+ dac_config_2 vdda1 vssa1 vssc1 col_event_rst_bot_right[22] x4_net42
+ row_on_detect_bot[31] row_off_detect_bot[30] openDVS_pixel2x2_bot
x4_x1557 dac_config_3 dac_config_5 col_event_rst_bot_right[21] dac_config_4
+ row_on_detect_bot[30] dac_config_0 dac_config_1 row_off_detect_bot[31] x4_net43
+ dac_config_2 vdda1 vssa1 vssc1 col_event_rst_bot_right[20] x4_net44
+ row_on_detect_bot[31] row_off_detect_bot[30] openDVS_pixel2x2_bot
x4_x1558 dac_config_3 dac_config_5 col_event_rst_bot_right[19] dac_config_4
+ row_on_detect_bot[30] dac_config_0 dac_config_1 row_off_detect_bot[31] x4_net45
+ dac_config_2 vdda1 vssa1 vssc1 col_event_rst_bot_right[18] x4_net46
+ row_on_detect_bot[31] row_off_detect_bot[30] openDVS_pixel2x2_bot
x4_x1559 dac_config_3 dac_config_5 col_event_rst_bot_right[17] dac_config_4
+ row_on_detect_bot[30] dac_config_0 dac_config_1 row_off_detect_bot[31] x4_net47
+ dac_config_2 vdda1 vssa1 vssc1 col_event_rst_bot_right[16] x4_net48
+ row_on_detect_bot[31] row_off_detect_bot[30] openDVS_pixel2x2_bot
x4_x1560 dac_config_3 dac_config_5 col_event_rst_bot_right[15] dac_config_4
+ row_on_detect_bot[30] dac_config_0 dac_config_1 row_off_detect_bot[31] x4_net49
+ dac_config_2 vdda1 vssa1 vssc1 col_event_rst_bot_right[14] x4_net50
+ row_on_detect_bot[31] row_off_detect_bot[30] openDVS_pixel2x2_bot
x4_x1561 dac_config_3 dac_config_5 col_event_rst_bot_right[13] dac_config_4
+ row_on_detect_bot[30] dac_config_0 dac_config_1 row_off_detect_bot[31] x4_net51
+ dac_config_2 vdda1 vssa1 vssc1 col_event_rst_bot_right[12] x4_net52
+ row_on_detect_bot[31] row_off_detect_bot[30] openDVS_pixel2x2_bot
x4_x1562 dac_config_3 dac_config_5 col_event_rst_bot_right[11] dac_config_4
+ row_on_detect_bot[30] dac_config_0 dac_config_1 row_off_detect_bot[31] x4_net53
+ dac_config_2 vdda1 vssa1 vssc1 col_event_rst_bot_right[10] x4_net54
+ row_on_detect_bot[31] row_off_detect_bot[30] openDVS_pixel2x2_bot
x4_x1563 dac_config_3 dac_config_5 col_event_rst_bot_right[9] dac_config_4
+ row_on_detect_bot[30] dac_config_0 dac_config_1 row_off_detect_bot[31] x4_net55
+ dac_config_2 vdda1 vssa1 vssc1 col_event_rst_bot_right[8] x4_net56 row_on_detect_bot[31]
+ row_off_detect_bot[30] openDVS_pixel2x2_bot
x4_x1564 dac_config_3 dac_config_5 col_event_rst_bot_right[7] dac_config_4
+ row_on_detect_bot[30] dac_config_0 dac_config_1 row_off_detect_bot[31] x4_net57
+ dac_config_2 vdda1 vssa1 vssc1 col_event_rst_bot_right[6] x4_net58 row_on_detect_bot[31]
+ row_off_detect_bot[30] openDVS_pixel2x2_bot
x4_x1565 dac_config_3 dac_config_5 col_event_rst_bot_right[5] dac_config_4
+ row_on_detect_bot[30] dac_config_0 dac_config_1 row_off_detect_bot[31] x4_net59
+ dac_config_2 vdda1 vssa1 vssc1 col_event_rst_bot_right[4] x4_net60 row_on_detect_bot[31]
+ row_off_detect_bot[30] openDVS_pixel2x2_bot
x4_x1566 dac_config_3 dac_config_5 col_event_rst_bot_right[3] dac_config_4
+ row_on_detect_bot[30] dac_config_0 dac_config_1 row_off_detect_bot[31] x4_net61
+ dac_config_2 vdda1 vssa1 vssc1 col_event_rst_bot_right[2] x4_net62 row_on_detect_bot[31]
+ row_off_detect_bot[30] openDVS_pixel2x2_bot
x4_x1567 dac_config_3 dac_config_5 col_event_rst_bot_right[1] dac_config_4
+ row_on_detect_bot[30] dac_config_0 dac_config_1 row_off_detect_bot[31] x4_net63
+ dac_config_2 vdda1 vssa1 vssc1 col_event_rst_bot_right[0] x4_net64 row_on_detect_bot[31]
+ row_off_detect_bot[30] openDVS_pixel2x2_bot
x4_x1568 dac_config_3 dac_config_5 col_event_rst_bot_right[63] dac_config_4
+ row_on_detect_bot[32] dac_config_0 dac_config_1 row_off_detect_bot[33] x4_net1
+ dac_config_2 vdda1 vssa1 vssc1 col_event_rst_bot_right[62] x4_net2 row_on_detect_bot[33]
+ row_off_detect_bot[32] openDVS_pixel2x2_bot
x4_x1569 dac_config_3 dac_config_5 col_event_rst_bot_right[61] dac_config_4
+ row_on_detect_bot[32] dac_config_0 dac_config_1 row_off_detect_bot[33] x4_net3
+ dac_config_2 vdda1 vssa1 vssc1 col_event_rst_bot_right[60] x4_net4 row_on_detect_bot[33]
+ row_off_detect_bot[32] openDVS_pixel2x2_bot
x4_x1570 dac_config_3 dac_config_5 col_event_rst_bot_right[59] dac_config_4
+ row_on_detect_bot[32] dac_config_0 dac_config_1 row_off_detect_bot[33] x4_net5
+ dac_config_2 vdda1 vssa1 vssc1 col_event_rst_bot_right[58] x4_net6 row_on_detect_bot[33]
+ row_off_detect_bot[32] openDVS_pixel2x2_bot
x4_x1571 dac_config_3 dac_config_5 col_event_rst_bot_right[57] dac_config_4
+ row_on_detect_bot[32] dac_config_0 dac_config_1 row_off_detect_bot[33] x4_net7
+ dac_config_2 vdda1 vssa1 vssc1 col_event_rst_bot_right[56] x4_net8 row_on_detect_bot[33]
+ row_off_detect_bot[32] openDVS_pixel2x2_bot
x4_x1572 dac_config_3 dac_config_5 col_event_rst_bot_right[55] dac_config_4
+ row_on_detect_bot[32] dac_config_0 dac_config_1 row_off_detect_bot[33] x4_net9
+ dac_config_2 vdda1 vssa1 vssc1 col_event_rst_bot_right[54] x4_net10
+ row_on_detect_bot[33] row_off_detect_bot[32] openDVS_pixel2x2_bot
x4_x1573 dac_config_3 dac_config_5 col_event_rst_bot_right[53] dac_config_4
+ row_on_detect_bot[32] dac_config_0 dac_config_1 row_off_detect_bot[33] x4_net11
+ dac_config_2 vdda1 vssa1 vssc1 col_event_rst_bot_right[52] x4_net12
+ row_on_detect_bot[33] row_off_detect_bot[32] openDVS_pixel2x2_bot
x4_x1574 dac_config_3 dac_config_5 col_event_rst_bot_right[51] dac_config_4
+ row_on_detect_bot[32] dac_config_0 dac_config_1 row_off_detect_bot[33] x4_net13
+ dac_config_2 vdda1 vssa1 vssc1 col_event_rst_bot_right[50] x4_net14
+ row_on_detect_bot[33] row_off_detect_bot[32] openDVS_pixel2x2_bot
x4_x1575 dac_config_3 dac_config_5 col_event_rst_bot_right[49] dac_config_4
+ row_on_detect_bot[32] dac_config_0 dac_config_1 row_off_detect_bot[33] x4_net15
+ dac_config_2 vdda1 vssa1 vssc1 col_event_rst_bot_right[48] x4_net16
+ row_on_detect_bot[33] row_off_detect_bot[32] openDVS_pixel2x2_bot
x4_x1576 dac_config_3 dac_config_5 col_event_rst_bot_right[47] dac_config_4
+ row_on_detect_bot[32] dac_config_0 dac_config_1 row_off_detect_bot[33] x4_net17
+ dac_config_2 vdda1 vssa1 vssc1 col_event_rst_bot_right[46] x4_net18
+ row_on_detect_bot[33] row_off_detect_bot[32] openDVS_pixel2x2_bot
x4_x1577 dac_config_3 dac_config_5 col_event_rst_bot_right[45] dac_config_4
+ row_on_detect_bot[32] dac_config_0 dac_config_1 row_off_detect_bot[33] x4_net19
+ dac_config_2 vdda1 vssa1 vssc1 col_event_rst_bot_right[44] x4_net20
+ row_on_detect_bot[33] row_off_detect_bot[32] openDVS_pixel2x2_bot
x4_x1578 dac_config_3 dac_config_5 col_event_rst_bot_right[43] dac_config_4
+ row_on_detect_bot[32] dac_config_0 dac_config_1 row_off_detect_bot[33] x4_net21
+ dac_config_2 vdda1 vssa1 vssc1 col_event_rst_bot_right[42] x4_net22
+ row_on_detect_bot[33] row_off_detect_bot[32] openDVS_pixel2x2_bot
x4_x1579 dac_config_3 dac_config_5 col_event_rst_bot_right[41] dac_config_4
+ row_on_detect_bot[32] dac_config_0 dac_config_1 row_off_detect_bot[33] x4_net23
+ dac_config_2 vdda1 vssa1 vssc1 col_event_rst_bot_right[40] x4_net24
+ row_on_detect_bot[33] row_off_detect_bot[32] openDVS_pixel2x2_bot
x4_x1580 dac_config_3 dac_config_5 col_event_rst_bot_right[39] dac_config_4
+ row_on_detect_bot[32] dac_config_0 dac_config_1 row_off_detect_bot[33] x4_net25
+ dac_config_2 vdda1 vssa1 vssc1 col_event_rst_bot_right[38] x4_net26
+ row_on_detect_bot[33] row_off_detect_bot[32] openDVS_pixel2x2_bot
x4_x1581 dac_config_3 dac_config_5 col_event_rst_bot_right[37] dac_config_4
+ row_on_detect_bot[32] dac_config_0 dac_config_1 row_off_detect_bot[33] x4_net27
+ dac_config_2 vdda1 vssa1 vssc1 col_event_rst_bot_right[36] x4_net28
+ row_on_detect_bot[33] row_off_detect_bot[32] openDVS_pixel2x2_bot
x4_x1582 dac_config_3 dac_config_5 col_event_rst_bot_right[35] dac_config_4
+ row_on_detect_bot[32] dac_config_0 dac_config_1 row_off_detect_bot[33] x4_net29
+ dac_config_2 vdda1 vssa1 vssc1 col_event_rst_bot_right[34] x4_net30
+ row_on_detect_bot[33] row_off_detect_bot[32] openDVS_pixel2x2_bot
x4_x1583 dac_config_3 dac_config_5 col_event_rst_bot_right[33] dac_config_4
+ row_on_detect_bot[32] dac_config_0 dac_config_1 row_off_detect_bot[33] x4_net31
+ dac_config_2 vdda1 vssa1 vssc1 col_event_rst_bot_right[32] x4_net32
+ row_on_detect_bot[33] row_off_detect_bot[32] openDVS_pixel2x2_bot
x4_x1584 dac_config_3 dac_config_5 col_event_rst_bot_right[31] dac_config_4
+ row_on_detect_bot[32] dac_config_0 dac_config_1 row_off_detect_bot[33] x4_net33
+ dac_config_2 vdda1 vssa1 vssc1 col_event_rst_bot_right[30] x4_net34
+ row_on_detect_bot[33] row_off_detect_bot[32] openDVS_pixel2x2_bot
x4_x1585 dac_config_3 dac_config_5 col_event_rst_bot_right[29] dac_config_4
+ row_on_detect_bot[32] dac_config_0 dac_config_1 row_off_detect_bot[33] x4_net35
+ dac_config_2 vdda1 vssa1 vssc1 col_event_rst_bot_right[28] x4_net36
+ row_on_detect_bot[33] row_off_detect_bot[32] openDVS_pixel2x2_bot
x4_x1586 dac_config_3 dac_config_5 col_event_rst_bot_right[27] dac_config_4
+ row_on_detect_bot[32] dac_config_0 dac_config_1 row_off_detect_bot[33] x4_net37
+ dac_config_2 vdda1 vssa1 vssc1 col_event_rst_bot_right[26] x4_net38
+ row_on_detect_bot[33] row_off_detect_bot[32] openDVS_pixel2x2_bot
x4_x1587 dac_config_3 dac_config_5 col_event_rst_bot_right[25] dac_config_4
+ row_on_detect_bot[32] dac_config_0 dac_config_1 row_off_detect_bot[33] x4_net39
+ dac_config_2 vdda1 vssa1 vssc1 col_event_rst_bot_right[24] x4_net40
+ row_on_detect_bot[33] row_off_detect_bot[32] openDVS_pixel2x2_bot
x4_x1588 dac_config_3 dac_config_5 col_event_rst_bot_right[23] dac_config_4
+ row_on_detect_bot[32] dac_config_0 dac_config_1 row_off_detect_bot[33] x4_net41
+ dac_config_2 vdda1 vssa1 vssc1 col_event_rst_bot_right[22] x4_net42
+ row_on_detect_bot[33] row_off_detect_bot[32] openDVS_pixel2x2_bot
x4_x1589 dac_config_3 dac_config_5 col_event_rst_bot_right[21] dac_config_4
+ row_on_detect_bot[32] dac_config_0 dac_config_1 row_off_detect_bot[33] x4_net43
+ dac_config_2 vdda1 vssa1 vssc1 col_event_rst_bot_right[20] x4_net44
+ row_on_detect_bot[33] row_off_detect_bot[32] openDVS_pixel2x2_bot
x4_x1590 dac_config_3 dac_config_5 col_event_rst_bot_right[19] dac_config_4
+ row_on_detect_bot[32] dac_config_0 dac_config_1 row_off_detect_bot[33] x4_net45
+ dac_config_2 vdda1 vssa1 vssc1 col_event_rst_bot_right[18] x4_net46
+ row_on_detect_bot[33] row_off_detect_bot[32] openDVS_pixel2x2_bot
x4_x1591 dac_config_3 dac_config_5 col_event_rst_bot_right[17] dac_config_4
+ row_on_detect_bot[32] dac_config_0 dac_config_1 row_off_detect_bot[33] x4_net47
+ dac_config_2 vdda1 vssa1 vssc1 col_event_rst_bot_right[16] x4_net48
+ row_on_detect_bot[33] row_off_detect_bot[32] openDVS_pixel2x2_bot
x4_x1592 dac_config_3 dac_config_5 col_event_rst_bot_right[15] dac_config_4
+ row_on_detect_bot[32] dac_config_0 dac_config_1 row_off_detect_bot[33] x4_net49
+ dac_config_2 vdda1 vssa1 vssc1 col_event_rst_bot_right[14] x4_net50
+ row_on_detect_bot[33] row_off_detect_bot[32] openDVS_pixel2x2_bot
x4_x1593 dac_config_3 dac_config_5 col_event_rst_bot_right[13] dac_config_4
+ row_on_detect_bot[32] dac_config_0 dac_config_1 row_off_detect_bot[33] x4_net51
+ dac_config_2 vdda1 vssa1 vssc1 col_event_rst_bot_right[12] x4_net52
+ row_on_detect_bot[33] row_off_detect_bot[32] openDVS_pixel2x2_bot
x4_x1594 dac_config_3 dac_config_5 col_event_rst_bot_right[11] dac_config_4
+ row_on_detect_bot[32] dac_config_0 dac_config_1 row_off_detect_bot[33] x4_net53
+ dac_config_2 vdda1 vssa1 vssc1 col_event_rst_bot_right[10] x4_net54
+ row_on_detect_bot[33] row_off_detect_bot[32] openDVS_pixel2x2_bot
x4_x1595 dac_config_3 dac_config_5 col_event_rst_bot_right[9] dac_config_4
+ row_on_detect_bot[32] dac_config_0 dac_config_1 row_off_detect_bot[33] x4_net55
+ dac_config_2 vdda1 vssa1 vssc1 col_event_rst_bot_right[8] x4_net56 row_on_detect_bot[33]
+ row_off_detect_bot[32] openDVS_pixel2x2_bot
x4_x1596 dac_config_3 dac_config_5 col_event_rst_bot_right[7] dac_config_4
+ row_on_detect_bot[32] dac_config_0 dac_config_1 row_off_detect_bot[33] x4_net57
+ dac_config_2 vdda1 vssa1 vssc1 col_event_rst_bot_right[6] x4_net58 row_on_detect_bot[33]
+ row_off_detect_bot[32] openDVS_pixel2x2_bot
x4_x1597 dac_config_3 dac_config_5 col_event_rst_bot_right[5] dac_config_4
+ row_on_detect_bot[32] dac_config_0 dac_config_1 row_off_detect_bot[33] x4_net59
+ dac_config_2 vdda1 vssa1 vssc1 col_event_rst_bot_right[4] x4_net60 row_on_detect_bot[33]
+ row_off_detect_bot[32] openDVS_pixel2x2_bot
x4_x1598 dac_config_3 dac_config_5 col_event_rst_bot_right[3] dac_config_4
+ row_on_detect_bot[32] dac_config_0 dac_config_1 row_off_detect_bot[33] x4_net61
+ dac_config_2 vdda1 vssa1 vssc1 col_event_rst_bot_right[2] x4_net62 row_on_detect_bot[33]
+ row_off_detect_bot[32] openDVS_pixel2x2_bot
x4_x1599 dac_config_3 dac_config_5 col_event_rst_bot_right[1] dac_config_4
+ row_on_detect_bot[32] dac_config_0 dac_config_1 row_off_detect_bot[33] x4_net63
+ dac_config_2 vdda1 vssa1 vssc1 col_event_rst_bot_right[0] x4_net64 row_on_detect_bot[33]
+ row_off_detect_bot[32] openDVS_pixel2x2_bot
x4_x1600 dac_config_3 dac_config_5 col_event_rst_bot_right[63] dac_config_4
+ row_on_detect_bot[34] dac_config_0 dac_config_1 row_off_detect_bot[35] x4_net1
+ dac_config_2 vdda1 vssa1 vssc1 col_event_rst_bot_right[62] x4_net2 row_on_detect_bot[35]
+ row_off_detect_bot[34] openDVS_pixel2x2_bot
x4_x1601 dac_config_3 dac_config_5 col_event_rst_bot_right[61] dac_config_4
+ row_on_detect_bot[34] dac_config_0 dac_config_1 row_off_detect_bot[35] x4_net3
+ dac_config_2 vdda1 vssa1 vssc1 col_event_rst_bot_right[60] x4_net4 row_on_detect_bot[35]
+ row_off_detect_bot[34] openDVS_pixel2x2_bot
x4_x1602 dac_config_3 dac_config_5 col_event_rst_bot_right[59] dac_config_4
+ row_on_detect_bot[34] dac_config_0 dac_config_1 row_off_detect_bot[35] x4_net5
+ dac_config_2 vdda1 vssa1 vssc1 col_event_rst_bot_right[58] x4_net6 row_on_detect_bot[35]
+ row_off_detect_bot[34] openDVS_pixel2x2_bot
x4_x1603 dac_config_3 dac_config_5 col_event_rst_bot_right[57] dac_config_4
+ row_on_detect_bot[34] dac_config_0 dac_config_1 row_off_detect_bot[35] x4_net7
+ dac_config_2 vdda1 vssa1 vssc1 col_event_rst_bot_right[56] x4_net8 row_on_detect_bot[35]
+ row_off_detect_bot[34] openDVS_pixel2x2_bot
x4_x1604 dac_config_3 dac_config_5 col_event_rst_bot_right[55] dac_config_4
+ row_on_detect_bot[34] dac_config_0 dac_config_1 row_off_detect_bot[35] x4_net9
+ dac_config_2 vdda1 vssa1 vssc1 col_event_rst_bot_right[54] x4_net10
+ row_on_detect_bot[35] row_off_detect_bot[34] openDVS_pixel2x2_bot
x4_x1605 dac_config_3 dac_config_5 col_event_rst_bot_right[53] dac_config_4
+ row_on_detect_bot[34] dac_config_0 dac_config_1 row_off_detect_bot[35] x4_net11
+ dac_config_2 vdda1 vssa1 vssc1 col_event_rst_bot_right[52] x4_net12
+ row_on_detect_bot[35] row_off_detect_bot[34] openDVS_pixel2x2_bot
x4_x1606 dac_config_3 dac_config_5 col_event_rst_bot_right[51] dac_config_4
+ row_on_detect_bot[34] dac_config_0 dac_config_1 row_off_detect_bot[35] x4_net13
+ dac_config_2 vdda1 vssa1 vssc1 col_event_rst_bot_right[50] x4_net14
+ row_on_detect_bot[35] row_off_detect_bot[34] openDVS_pixel2x2_bot
x4_x1607 dac_config_3 dac_config_5 col_event_rst_bot_right[49] dac_config_4
+ row_on_detect_bot[34] dac_config_0 dac_config_1 row_off_detect_bot[35] x4_net15
+ dac_config_2 vdda1 vssa1 vssc1 col_event_rst_bot_right[48] x4_net16
+ row_on_detect_bot[35] row_off_detect_bot[34] openDVS_pixel2x2_bot
x4_x1608 dac_config_3 dac_config_5 col_event_rst_bot_right[47] dac_config_4
+ row_on_detect_bot[34] dac_config_0 dac_config_1 row_off_detect_bot[35] x4_net17
+ dac_config_2 vdda1 vssa1 vssc1 col_event_rst_bot_right[46] x4_net18
+ row_on_detect_bot[35] row_off_detect_bot[34] openDVS_pixel2x2_bot
x4_x1609 dac_config_3 dac_config_5 col_event_rst_bot_right[45] dac_config_4
+ row_on_detect_bot[34] dac_config_0 dac_config_1 row_off_detect_bot[35] x4_net19
+ dac_config_2 vdda1 vssa1 vssc1 col_event_rst_bot_right[44] x4_net20
+ row_on_detect_bot[35] row_off_detect_bot[34] openDVS_pixel2x2_bot
x4_x1610 dac_config_3 dac_config_5 col_event_rst_bot_right[43] dac_config_4
+ row_on_detect_bot[34] dac_config_0 dac_config_1 row_off_detect_bot[35] x4_net21
+ dac_config_2 vdda1 vssa1 vssc1 col_event_rst_bot_right[42] x4_net22
+ row_on_detect_bot[35] row_off_detect_bot[34] openDVS_pixel2x2_bot
x4_x1611 dac_config_3 dac_config_5 col_event_rst_bot_right[41] dac_config_4
+ row_on_detect_bot[34] dac_config_0 dac_config_1 row_off_detect_bot[35] x4_net23
+ dac_config_2 vdda1 vssa1 vssc1 col_event_rst_bot_right[40] x4_net24
+ row_on_detect_bot[35] row_off_detect_bot[34] openDVS_pixel2x2_bot
x4_x1612 dac_config_3 dac_config_5 col_event_rst_bot_right[39] dac_config_4
+ row_on_detect_bot[34] dac_config_0 dac_config_1 row_off_detect_bot[35] x4_net25
+ dac_config_2 vdda1 vssa1 vssc1 col_event_rst_bot_right[38] x4_net26
+ row_on_detect_bot[35] row_off_detect_bot[34] openDVS_pixel2x2_bot
x4_x1613 dac_config_3 dac_config_5 col_event_rst_bot_right[37] dac_config_4
+ row_on_detect_bot[34] dac_config_0 dac_config_1 row_off_detect_bot[35] x4_net27
+ dac_config_2 vdda1 vssa1 vssc1 col_event_rst_bot_right[36] x4_net28
+ row_on_detect_bot[35] row_off_detect_bot[34] openDVS_pixel2x2_bot
x4_x1614 dac_config_3 dac_config_5 col_event_rst_bot_right[35] dac_config_4
+ row_on_detect_bot[34] dac_config_0 dac_config_1 row_off_detect_bot[35] x4_net29
+ dac_config_2 vdda1 vssa1 vssc1 col_event_rst_bot_right[34] x4_net30
+ row_on_detect_bot[35] row_off_detect_bot[34] openDVS_pixel2x2_bot
x4_x1615 dac_config_3 dac_config_5 col_event_rst_bot_right[33] dac_config_4
+ row_on_detect_bot[34] dac_config_0 dac_config_1 row_off_detect_bot[35] x4_net31
+ dac_config_2 vdda1 vssa1 vssc1 col_event_rst_bot_right[32] x4_net32
+ row_on_detect_bot[35] row_off_detect_bot[34] openDVS_pixel2x2_bot
x4_x1616 dac_config_3 dac_config_5 col_event_rst_bot_right[31] dac_config_4
+ row_on_detect_bot[34] dac_config_0 dac_config_1 row_off_detect_bot[35] x4_net33
+ dac_config_2 vdda1 vssa1 vssc1 col_event_rst_bot_right[30] x4_net34
+ row_on_detect_bot[35] row_off_detect_bot[34] openDVS_pixel2x2_bot
x4_x1617 dac_config_3 dac_config_5 col_event_rst_bot_right[29] dac_config_4
+ row_on_detect_bot[34] dac_config_0 dac_config_1 row_off_detect_bot[35] x4_net35
+ dac_config_2 vdda1 vssa1 vssc1 col_event_rst_bot_right[28] x4_net36
+ row_on_detect_bot[35] row_off_detect_bot[34] openDVS_pixel2x2_bot
x4_x1618 dac_config_3 dac_config_5 col_event_rst_bot_right[27] dac_config_4
+ row_on_detect_bot[34] dac_config_0 dac_config_1 row_off_detect_bot[35] x4_net37
+ dac_config_2 vdda1 vssa1 vssc1 col_event_rst_bot_right[26] x4_net38
+ row_on_detect_bot[35] row_off_detect_bot[34] openDVS_pixel2x2_bot
x4_x1619 dac_config_3 dac_config_5 col_event_rst_bot_right[25] dac_config_4
+ row_on_detect_bot[34] dac_config_0 dac_config_1 row_off_detect_bot[35] x4_net39
+ dac_config_2 vdda1 vssa1 vssc1 col_event_rst_bot_right[24] x4_net40
+ row_on_detect_bot[35] row_off_detect_bot[34] openDVS_pixel2x2_bot
x4_x1620 dac_config_3 dac_config_5 col_event_rst_bot_right[23] dac_config_4
+ row_on_detect_bot[34] dac_config_0 dac_config_1 row_off_detect_bot[35] x4_net41
+ dac_config_2 vdda1 vssa1 vssc1 col_event_rst_bot_right[22] x4_net42
+ row_on_detect_bot[35] row_off_detect_bot[34] openDVS_pixel2x2_bot
x4_x1621 dac_config_3 dac_config_5 col_event_rst_bot_right[21] dac_config_4
+ row_on_detect_bot[34] dac_config_0 dac_config_1 row_off_detect_bot[35] x4_net43
+ dac_config_2 vdda1 vssa1 vssc1 col_event_rst_bot_right[20] x4_net44
+ row_on_detect_bot[35] row_off_detect_bot[34] openDVS_pixel2x2_bot
x4_x1622 dac_config_3 dac_config_5 col_event_rst_bot_right[19] dac_config_4
+ row_on_detect_bot[34] dac_config_0 dac_config_1 row_off_detect_bot[35] x4_net45
+ dac_config_2 vdda1 vssa1 vssc1 col_event_rst_bot_right[18] x4_net46
+ row_on_detect_bot[35] row_off_detect_bot[34] openDVS_pixel2x2_bot
x4_x1623 dac_config_3 dac_config_5 col_event_rst_bot_right[17] dac_config_4
+ row_on_detect_bot[34] dac_config_0 dac_config_1 row_off_detect_bot[35] x4_net47
+ dac_config_2 vdda1 vssa1 vssc1 col_event_rst_bot_right[16] x4_net48
+ row_on_detect_bot[35] row_off_detect_bot[34] openDVS_pixel2x2_bot
x4_x1624 dac_config_3 dac_config_5 col_event_rst_bot_right[15] dac_config_4
+ row_on_detect_bot[34] dac_config_0 dac_config_1 row_off_detect_bot[35] x4_net49
+ dac_config_2 vdda1 vssa1 vssc1 col_event_rst_bot_right[14] x4_net50
+ row_on_detect_bot[35] row_off_detect_bot[34] openDVS_pixel2x2_bot
x4_x1625 dac_config_3 dac_config_5 col_event_rst_bot_right[13] dac_config_4
+ row_on_detect_bot[34] dac_config_0 dac_config_1 row_off_detect_bot[35] x4_net51
+ dac_config_2 vdda1 vssa1 vssc1 col_event_rst_bot_right[12] x4_net52
+ row_on_detect_bot[35] row_off_detect_bot[34] openDVS_pixel2x2_bot
x4_x1626 dac_config_3 dac_config_5 col_event_rst_bot_right[11] dac_config_4
+ row_on_detect_bot[34] dac_config_0 dac_config_1 row_off_detect_bot[35] x4_net53
+ dac_config_2 vdda1 vssa1 vssc1 col_event_rst_bot_right[10] x4_net54
+ row_on_detect_bot[35] row_off_detect_bot[34] openDVS_pixel2x2_bot
x4_x1627 dac_config_3 dac_config_5 col_event_rst_bot_right[9] dac_config_4
+ row_on_detect_bot[34] dac_config_0 dac_config_1 row_off_detect_bot[35] x4_net55
+ dac_config_2 vdda1 vssa1 vssc1 col_event_rst_bot_right[8] x4_net56 row_on_detect_bot[35]
+ row_off_detect_bot[34] openDVS_pixel2x2_bot
x4_x1628 dac_config_3 dac_config_5 col_event_rst_bot_right[7] dac_config_4
+ row_on_detect_bot[34] dac_config_0 dac_config_1 row_off_detect_bot[35] x4_net57
+ dac_config_2 vdda1 vssa1 vssc1 col_event_rst_bot_right[6] x4_net58 row_on_detect_bot[35]
+ row_off_detect_bot[34] openDVS_pixel2x2_bot
x4_x1629 dac_config_3 dac_config_5 col_event_rst_bot_right[5] dac_config_4
+ row_on_detect_bot[34] dac_config_0 dac_config_1 row_off_detect_bot[35] x4_net59
+ dac_config_2 vdda1 vssa1 vssc1 col_event_rst_bot_right[4] x4_net60 row_on_detect_bot[35]
+ row_off_detect_bot[34] openDVS_pixel2x2_bot
x4_x1630 dac_config_3 dac_config_5 col_event_rst_bot_right[3] dac_config_4
+ row_on_detect_bot[34] dac_config_0 dac_config_1 row_off_detect_bot[35] x4_net61
+ dac_config_2 vdda1 vssa1 vssc1 col_event_rst_bot_right[2] x4_net62 row_on_detect_bot[35]
+ row_off_detect_bot[34] openDVS_pixel2x2_bot
x4_x1631 dac_config_3 dac_config_5 col_event_rst_bot_right[1] dac_config_4
+ row_on_detect_bot[34] dac_config_0 dac_config_1 row_off_detect_bot[35] x4_net63
+ dac_config_2 vdda1 vssa1 vssc1 col_event_rst_bot_right[0] x4_net64 row_on_detect_bot[35]
+ row_off_detect_bot[34] openDVS_pixel2x2_bot
x4_x1632 dac_config_3 dac_config_5 col_event_rst_bot_right[63] dac_config_4
+ row_on_detect_bot[36] dac_config_0 dac_config_1 row_off_detect_bot[37] x4_net1
+ dac_config_2 vdda1 vssa1 vssc1 col_event_rst_bot_right[62] x4_net2 row_on_detect_bot[37]
+ row_off_detect_bot[36] openDVS_pixel2x2_bot
x4_x1633 dac_config_3 dac_config_5 col_event_rst_bot_right[61] dac_config_4
+ row_on_detect_bot[36] dac_config_0 dac_config_1 row_off_detect_bot[37] x4_net3
+ dac_config_2 vdda1 vssa1 vssc1 col_event_rst_bot_right[60] x4_net4 row_on_detect_bot[37]
+ row_off_detect_bot[36] openDVS_pixel2x2_bot
x4_x1634 dac_config_3 dac_config_5 col_event_rst_bot_right[59] dac_config_4
+ row_on_detect_bot[36] dac_config_0 dac_config_1 row_off_detect_bot[37] x4_net5
+ dac_config_2 vdda1 vssa1 vssc1 col_event_rst_bot_right[58] x4_net6 row_on_detect_bot[37]
+ row_off_detect_bot[36] openDVS_pixel2x2_bot
x4_x1635 dac_config_3 dac_config_5 col_event_rst_bot_right[57] dac_config_4
+ row_on_detect_bot[36] dac_config_0 dac_config_1 row_off_detect_bot[37] x4_net7
+ dac_config_2 vdda1 vssa1 vssc1 col_event_rst_bot_right[56] x4_net8 row_on_detect_bot[37]
+ row_off_detect_bot[36] openDVS_pixel2x2_bot
x4_x1636 dac_config_3 dac_config_5 col_event_rst_bot_right[55] dac_config_4
+ row_on_detect_bot[36] dac_config_0 dac_config_1 row_off_detect_bot[37] x4_net9
+ dac_config_2 vdda1 vssa1 vssc1 col_event_rst_bot_right[54] x4_net10
+ row_on_detect_bot[37] row_off_detect_bot[36] openDVS_pixel2x2_bot
x4_x1637 dac_config_3 dac_config_5 col_event_rst_bot_right[53] dac_config_4
+ row_on_detect_bot[36] dac_config_0 dac_config_1 row_off_detect_bot[37] x4_net11
+ dac_config_2 vdda1 vssa1 vssc1 col_event_rst_bot_right[52] x4_net12
+ row_on_detect_bot[37] row_off_detect_bot[36] openDVS_pixel2x2_bot
x4_x1638 dac_config_3 dac_config_5 col_event_rst_bot_right[51] dac_config_4
+ row_on_detect_bot[36] dac_config_0 dac_config_1 row_off_detect_bot[37] x4_net13
+ dac_config_2 vdda1 vssa1 vssc1 col_event_rst_bot_right[50] x4_net14
+ row_on_detect_bot[37] row_off_detect_bot[36] openDVS_pixel2x2_bot
x4_x1639 dac_config_3 dac_config_5 col_event_rst_bot_right[49] dac_config_4
+ row_on_detect_bot[36] dac_config_0 dac_config_1 row_off_detect_bot[37] x4_net15
+ dac_config_2 vdda1 vssa1 vssc1 col_event_rst_bot_right[48] x4_net16
+ row_on_detect_bot[37] row_off_detect_bot[36] openDVS_pixel2x2_bot
x4_x1640 dac_config_3 dac_config_5 col_event_rst_bot_right[47] dac_config_4
+ row_on_detect_bot[36] dac_config_0 dac_config_1 row_off_detect_bot[37] x4_net17
+ dac_config_2 vdda1 vssa1 vssc1 col_event_rst_bot_right[46] x4_net18
+ row_on_detect_bot[37] row_off_detect_bot[36] openDVS_pixel2x2_bot
x4_x1641 dac_config_3 dac_config_5 col_event_rst_bot_right[45] dac_config_4
+ row_on_detect_bot[36] dac_config_0 dac_config_1 row_off_detect_bot[37] x4_net19
+ dac_config_2 vdda1 vssa1 vssc1 col_event_rst_bot_right[44] x4_net20
+ row_on_detect_bot[37] row_off_detect_bot[36] openDVS_pixel2x2_bot
x4_x1642 dac_config_3 dac_config_5 col_event_rst_bot_right[43] dac_config_4
+ row_on_detect_bot[36] dac_config_0 dac_config_1 row_off_detect_bot[37] x4_net21
+ dac_config_2 vdda1 vssa1 vssc1 col_event_rst_bot_right[42] x4_net22
+ row_on_detect_bot[37] row_off_detect_bot[36] openDVS_pixel2x2_bot
x4_x1643 dac_config_3 dac_config_5 col_event_rst_bot_right[41] dac_config_4
+ row_on_detect_bot[36] dac_config_0 dac_config_1 row_off_detect_bot[37] x4_net23
+ dac_config_2 vdda1 vssa1 vssc1 col_event_rst_bot_right[40] x4_net24
+ row_on_detect_bot[37] row_off_detect_bot[36] openDVS_pixel2x2_bot
x4_x1644 dac_config_3 dac_config_5 col_event_rst_bot_right[39] dac_config_4
+ row_on_detect_bot[36] dac_config_0 dac_config_1 row_off_detect_bot[37] x4_net25
+ dac_config_2 vdda1 vssa1 vssc1 col_event_rst_bot_right[38] x4_net26
+ row_on_detect_bot[37] row_off_detect_bot[36] openDVS_pixel2x2_bot
x4_x1645 dac_config_3 dac_config_5 col_event_rst_bot_right[37] dac_config_4
+ row_on_detect_bot[36] dac_config_0 dac_config_1 row_off_detect_bot[37] x4_net27
+ dac_config_2 vdda1 vssa1 vssc1 col_event_rst_bot_right[36] x4_net28
+ row_on_detect_bot[37] row_off_detect_bot[36] openDVS_pixel2x2_bot
x4_x1646 dac_config_3 dac_config_5 col_event_rst_bot_right[35] dac_config_4
+ row_on_detect_bot[36] dac_config_0 dac_config_1 row_off_detect_bot[37] x4_net29
+ dac_config_2 vdda1 vssa1 vssc1 col_event_rst_bot_right[34] x4_net30
+ row_on_detect_bot[37] row_off_detect_bot[36] openDVS_pixel2x2_bot
x4_x1647 dac_config_3 dac_config_5 col_event_rst_bot_right[33] dac_config_4
+ row_on_detect_bot[36] dac_config_0 dac_config_1 row_off_detect_bot[37] x4_net31
+ dac_config_2 vdda1 vssa1 vssc1 col_event_rst_bot_right[32] x4_net32
+ row_on_detect_bot[37] row_off_detect_bot[36] openDVS_pixel2x2_bot
x4_x1648 dac_config_3 dac_config_5 col_event_rst_bot_right[31] dac_config_4
+ row_on_detect_bot[36] dac_config_0 dac_config_1 row_off_detect_bot[37] x4_net33
+ dac_config_2 vdda1 vssa1 vssc1 col_event_rst_bot_right[30] x4_net34
+ row_on_detect_bot[37] row_off_detect_bot[36] openDVS_pixel2x2_bot
x4_x1649 dac_config_3 dac_config_5 col_event_rst_bot_right[29] dac_config_4
+ row_on_detect_bot[36] dac_config_0 dac_config_1 row_off_detect_bot[37] x4_net35
+ dac_config_2 vdda1 vssa1 vssc1 col_event_rst_bot_right[28] x4_net36
+ row_on_detect_bot[37] row_off_detect_bot[36] openDVS_pixel2x2_bot
x4_x1650 dac_config_3 dac_config_5 col_event_rst_bot_right[27] dac_config_4
+ row_on_detect_bot[36] dac_config_0 dac_config_1 row_off_detect_bot[37] x4_net37
+ dac_config_2 vdda1 vssa1 vssc1 col_event_rst_bot_right[26] x4_net38
+ row_on_detect_bot[37] row_off_detect_bot[36] openDVS_pixel2x2_bot
x4_x1651 dac_config_3 dac_config_5 col_event_rst_bot_right[25] dac_config_4
+ row_on_detect_bot[36] dac_config_0 dac_config_1 row_off_detect_bot[37] x4_net39
+ dac_config_2 vdda1 vssa1 vssc1 col_event_rst_bot_right[24] x4_net40
+ row_on_detect_bot[37] row_off_detect_bot[36] openDVS_pixel2x2_bot
x4_x1652 dac_config_3 dac_config_5 col_event_rst_bot_right[23] dac_config_4
+ row_on_detect_bot[36] dac_config_0 dac_config_1 row_off_detect_bot[37] x4_net41
+ dac_config_2 vdda1 vssa1 vssc1 col_event_rst_bot_right[22] x4_net42
+ row_on_detect_bot[37] row_off_detect_bot[36] openDVS_pixel2x2_bot
x4_x1653 dac_config_3 dac_config_5 col_event_rst_bot_right[21] dac_config_4
+ row_on_detect_bot[36] dac_config_0 dac_config_1 row_off_detect_bot[37] x4_net43
+ dac_config_2 vdda1 vssa1 vssc1 col_event_rst_bot_right[20] x4_net44
+ row_on_detect_bot[37] row_off_detect_bot[36] openDVS_pixel2x2_bot
x4_x1654 dac_config_3 dac_config_5 col_event_rst_bot_right[19] dac_config_4
+ row_on_detect_bot[36] dac_config_0 dac_config_1 row_off_detect_bot[37] x4_net45
+ dac_config_2 vdda1 vssa1 vssc1 col_event_rst_bot_right[18] x4_net46
+ row_on_detect_bot[37] row_off_detect_bot[36] openDVS_pixel2x2_bot
x4_x1655 dac_config_3 dac_config_5 col_event_rst_bot_right[17] dac_config_4
+ row_on_detect_bot[36] dac_config_0 dac_config_1 row_off_detect_bot[37] x4_net47
+ dac_config_2 vdda1 vssa1 vssc1 col_event_rst_bot_right[16] x4_net48
+ row_on_detect_bot[37] row_off_detect_bot[36] openDVS_pixel2x2_bot
x4_x1656 dac_config_3 dac_config_5 col_event_rst_bot_right[15] dac_config_4
+ row_on_detect_bot[36] dac_config_0 dac_config_1 row_off_detect_bot[37] x4_net49
+ dac_config_2 vdda1 vssa1 vssc1 col_event_rst_bot_right[14] x4_net50
+ row_on_detect_bot[37] row_off_detect_bot[36] openDVS_pixel2x2_bot
x4_x1657 dac_config_3 dac_config_5 col_event_rst_bot_right[13] dac_config_4
+ row_on_detect_bot[36] dac_config_0 dac_config_1 row_off_detect_bot[37] x4_net51
+ dac_config_2 vdda1 vssa1 vssc1 col_event_rst_bot_right[12] x4_net52
+ row_on_detect_bot[37] row_off_detect_bot[36] openDVS_pixel2x2_bot
x4_x1658 dac_config_3 dac_config_5 col_event_rst_bot_right[11] dac_config_4
+ row_on_detect_bot[36] dac_config_0 dac_config_1 row_off_detect_bot[37] x4_net53
+ dac_config_2 vdda1 vssa1 vssc1 col_event_rst_bot_right[10] x4_net54
+ row_on_detect_bot[37] row_off_detect_bot[36] openDVS_pixel2x2_bot
x4_x1659 dac_config_3 dac_config_5 col_event_rst_bot_right[9] dac_config_4
+ row_on_detect_bot[36] dac_config_0 dac_config_1 row_off_detect_bot[37] x4_net55
+ dac_config_2 vdda1 vssa1 vssc1 col_event_rst_bot_right[8] x4_net56 row_on_detect_bot[37]
+ row_off_detect_bot[36] openDVS_pixel2x2_bot
x4_x1660 dac_config_3 dac_config_5 col_event_rst_bot_right[7] dac_config_4
+ row_on_detect_bot[36] dac_config_0 dac_config_1 row_off_detect_bot[37] x4_net57
+ dac_config_2 vdda1 vssa1 vssc1 col_event_rst_bot_right[6] x4_net58 row_on_detect_bot[37]
+ row_off_detect_bot[36] openDVS_pixel2x2_bot
x4_x1661 dac_config_3 dac_config_5 col_event_rst_bot_right[5] dac_config_4
+ row_on_detect_bot[36] dac_config_0 dac_config_1 row_off_detect_bot[37] x4_net59
+ dac_config_2 vdda1 vssa1 vssc1 col_event_rst_bot_right[4] x4_net60 row_on_detect_bot[37]
+ row_off_detect_bot[36] openDVS_pixel2x2_bot
x4_x1662 dac_config_3 dac_config_5 col_event_rst_bot_right[3] dac_config_4
+ row_on_detect_bot[36] dac_config_0 dac_config_1 row_off_detect_bot[37] x4_net61
+ dac_config_2 vdda1 vssa1 vssc1 col_event_rst_bot_right[2] x4_net62 row_on_detect_bot[37]
+ row_off_detect_bot[36] openDVS_pixel2x2_bot
x4_x1663 dac_config_3 dac_config_5 col_event_rst_bot_right[1] dac_config_4
+ row_on_detect_bot[36] dac_config_0 dac_config_1 row_off_detect_bot[37] x4_net63
+ dac_config_2 vdda1 vssa1 vssc1 col_event_rst_bot_right[0] x4_net64 row_on_detect_bot[37]
+ row_off_detect_bot[36] openDVS_pixel2x2_bot
x4_x1664 dac_config_3 dac_config_5 col_event_rst_bot_right[63] dac_config_4
+ row_on_detect_bot[38] dac_config_0 dac_config_1 row_off_detect_bot[39] x4_net1
+ dac_config_2 vdda1 vssa1 vssc1 col_event_rst_bot_right[62] x4_net2 row_on_detect_bot[39]
+ row_off_detect_bot[38] openDVS_pixel2x2_bot
x4_x1665 dac_config_3 dac_config_5 col_event_rst_bot_right[61] dac_config_4
+ row_on_detect_bot[38] dac_config_0 dac_config_1 row_off_detect_bot[39] x4_net3
+ dac_config_2 vdda1 vssa1 vssc1 col_event_rst_bot_right[60] x4_net4 row_on_detect_bot[39]
+ row_off_detect_bot[38] openDVS_pixel2x2_bot
x4_x1666 dac_config_3 dac_config_5 col_event_rst_bot_right[59] dac_config_4
+ row_on_detect_bot[38] dac_config_0 dac_config_1 row_off_detect_bot[39] x4_net5
+ dac_config_2 vdda1 vssa1 vssc1 col_event_rst_bot_right[58] x4_net6 row_on_detect_bot[39]
+ row_off_detect_bot[38] openDVS_pixel2x2_bot
x4_x1667 dac_config_3 dac_config_5 col_event_rst_bot_right[57] dac_config_4
+ row_on_detect_bot[38] dac_config_0 dac_config_1 row_off_detect_bot[39] x4_net7
+ dac_config_2 vdda1 vssa1 vssc1 col_event_rst_bot_right[56] x4_net8 row_on_detect_bot[39]
+ row_off_detect_bot[38] openDVS_pixel2x2_bot
x4_x1668 dac_config_3 dac_config_5 col_event_rst_bot_right[55] dac_config_4
+ row_on_detect_bot[38] dac_config_0 dac_config_1 row_off_detect_bot[39] x4_net9
+ dac_config_2 vdda1 vssa1 vssc1 col_event_rst_bot_right[54] x4_net10
+ row_on_detect_bot[39] row_off_detect_bot[38] openDVS_pixel2x2_bot
x4_x1669 dac_config_3 dac_config_5 col_event_rst_bot_right[53] dac_config_4
+ row_on_detect_bot[38] dac_config_0 dac_config_1 row_off_detect_bot[39] x4_net11
+ dac_config_2 vdda1 vssa1 vssc1 col_event_rst_bot_right[52] x4_net12
+ row_on_detect_bot[39] row_off_detect_bot[38] openDVS_pixel2x2_bot
x4_x1670 dac_config_3 dac_config_5 col_event_rst_bot_right[51] dac_config_4
+ row_on_detect_bot[38] dac_config_0 dac_config_1 row_off_detect_bot[39] x4_net13
+ dac_config_2 vdda1 vssa1 vssc1 col_event_rst_bot_right[50] x4_net14
+ row_on_detect_bot[39] row_off_detect_bot[38] openDVS_pixel2x2_bot
x4_x1671 dac_config_3 dac_config_5 col_event_rst_bot_right[49] dac_config_4
+ row_on_detect_bot[38] dac_config_0 dac_config_1 row_off_detect_bot[39] x4_net15
+ dac_config_2 vdda1 vssa1 vssc1 col_event_rst_bot_right[48] x4_net16
+ row_on_detect_bot[39] row_off_detect_bot[38] openDVS_pixel2x2_bot
x4_x1672 dac_config_3 dac_config_5 col_event_rst_bot_right[47] dac_config_4
+ row_on_detect_bot[38] dac_config_0 dac_config_1 row_off_detect_bot[39] x4_net17
+ dac_config_2 vdda1 vssa1 vssc1 col_event_rst_bot_right[46] x4_net18
+ row_on_detect_bot[39] row_off_detect_bot[38] openDVS_pixel2x2_bot
x4_x1673 dac_config_3 dac_config_5 col_event_rst_bot_right[45] dac_config_4
+ row_on_detect_bot[38] dac_config_0 dac_config_1 row_off_detect_bot[39] x4_net19
+ dac_config_2 vdda1 vssa1 vssc1 col_event_rst_bot_right[44] x4_net20
+ row_on_detect_bot[39] row_off_detect_bot[38] openDVS_pixel2x2_bot
x4_x1674 dac_config_3 dac_config_5 col_event_rst_bot_right[43] dac_config_4
+ row_on_detect_bot[38] dac_config_0 dac_config_1 row_off_detect_bot[39] x4_net21
+ dac_config_2 vdda1 vssa1 vssc1 col_event_rst_bot_right[42] x4_net22
+ row_on_detect_bot[39] row_off_detect_bot[38] openDVS_pixel2x2_bot
x4_x1675 dac_config_3 dac_config_5 col_event_rst_bot_right[41] dac_config_4
+ row_on_detect_bot[38] dac_config_0 dac_config_1 row_off_detect_bot[39] x4_net23
+ dac_config_2 vdda1 vssa1 vssc1 col_event_rst_bot_right[40] x4_net24
+ row_on_detect_bot[39] row_off_detect_bot[38] openDVS_pixel2x2_bot
x4_x1676 dac_config_3 dac_config_5 col_event_rst_bot_right[39] dac_config_4
+ row_on_detect_bot[38] dac_config_0 dac_config_1 row_off_detect_bot[39] x4_net25
+ dac_config_2 vdda1 vssa1 vssc1 col_event_rst_bot_right[38] x4_net26
+ row_on_detect_bot[39] row_off_detect_bot[38] openDVS_pixel2x2_bot
x4_x1677 dac_config_3 dac_config_5 col_event_rst_bot_right[37] dac_config_4
+ row_on_detect_bot[38] dac_config_0 dac_config_1 row_off_detect_bot[39] x4_net27
+ dac_config_2 vdda1 vssa1 vssc1 col_event_rst_bot_right[36] x4_net28
+ row_on_detect_bot[39] row_off_detect_bot[38] openDVS_pixel2x2_bot
x4_x1678 dac_config_3 dac_config_5 col_event_rst_bot_right[35] dac_config_4
+ row_on_detect_bot[38] dac_config_0 dac_config_1 row_off_detect_bot[39] x4_net29
+ dac_config_2 vdda1 vssa1 vssc1 col_event_rst_bot_right[34] x4_net30
+ row_on_detect_bot[39] row_off_detect_bot[38] openDVS_pixel2x2_bot
x4_x1679 dac_config_3 dac_config_5 col_event_rst_bot_right[33] dac_config_4
+ row_on_detect_bot[38] dac_config_0 dac_config_1 row_off_detect_bot[39] x4_net31
+ dac_config_2 vdda1 vssa1 vssc1 col_event_rst_bot_right[32] x4_net32
+ row_on_detect_bot[39] row_off_detect_bot[38] openDVS_pixel2x2_bot
x4_x1680 dac_config_3 dac_config_5 col_event_rst_bot_right[31] dac_config_4
+ row_on_detect_bot[38] dac_config_0 dac_config_1 row_off_detect_bot[39] x4_net33
+ dac_config_2 vdda1 vssa1 vssc1 col_event_rst_bot_right[30] x4_net34
+ row_on_detect_bot[39] row_off_detect_bot[38] openDVS_pixel2x2_bot
x4_x1681 dac_config_3 dac_config_5 col_event_rst_bot_right[29] dac_config_4
+ row_on_detect_bot[38] dac_config_0 dac_config_1 row_off_detect_bot[39] x4_net35
+ dac_config_2 vdda1 vssa1 vssc1 col_event_rst_bot_right[28] x4_net36
+ row_on_detect_bot[39] row_off_detect_bot[38] openDVS_pixel2x2_bot
x4_x1682 dac_config_3 dac_config_5 col_event_rst_bot_right[27] dac_config_4
+ row_on_detect_bot[38] dac_config_0 dac_config_1 row_off_detect_bot[39] x4_net37
+ dac_config_2 vdda1 vssa1 vssc1 col_event_rst_bot_right[26] x4_net38
+ row_on_detect_bot[39] row_off_detect_bot[38] openDVS_pixel2x2_bot
x4_x1683 dac_config_3 dac_config_5 col_event_rst_bot_right[25] dac_config_4
+ row_on_detect_bot[38] dac_config_0 dac_config_1 row_off_detect_bot[39] x4_net39
+ dac_config_2 vdda1 vssa1 vssc1 col_event_rst_bot_right[24] x4_net40
+ row_on_detect_bot[39] row_off_detect_bot[38] openDVS_pixel2x2_bot
x4_x1684 dac_config_3 dac_config_5 col_event_rst_bot_right[23] dac_config_4
+ row_on_detect_bot[38] dac_config_0 dac_config_1 row_off_detect_bot[39] x4_net41
+ dac_config_2 vdda1 vssa1 vssc1 col_event_rst_bot_right[22] x4_net42
+ row_on_detect_bot[39] row_off_detect_bot[38] openDVS_pixel2x2_bot
x4_x1685 dac_config_3 dac_config_5 col_event_rst_bot_right[21] dac_config_4
+ row_on_detect_bot[38] dac_config_0 dac_config_1 row_off_detect_bot[39] x4_net43
+ dac_config_2 vdda1 vssa1 vssc1 col_event_rst_bot_right[20] x4_net44
+ row_on_detect_bot[39] row_off_detect_bot[38] openDVS_pixel2x2_bot
x4_x1686 dac_config_3 dac_config_5 col_event_rst_bot_right[19] dac_config_4
+ row_on_detect_bot[38] dac_config_0 dac_config_1 row_off_detect_bot[39] x4_net45
+ dac_config_2 vdda1 vssa1 vssc1 col_event_rst_bot_right[18] x4_net46
+ row_on_detect_bot[39] row_off_detect_bot[38] openDVS_pixel2x2_bot
x4_x1687 dac_config_3 dac_config_5 col_event_rst_bot_right[17] dac_config_4
+ row_on_detect_bot[38] dac_config_0 dac_config_1 row_off_detect_bot[39] x4_net47
+ dac_config_2 vdda1 vssa1 vssc1 col_event_rst_bot_right[16] x4_net48
+ row_on_detect_bot[39] row_off_detect_bot[38] openDVS_pixel2x2_bot
x4_x1688 dac_config_3 dac_config_5 col_event_rst_bot_right[15] dac_config_4
+ row_on_detect_bot[38] dac_config_0 dac_config_1 row_off_detect_bot[39] x4_net49
+ dac_config_2 vdda1 vssa1 vssc1 col_event_rst_bot_right[14] x4_net50
+ row_on_detect_bot[39] row_off_detect_bot[38] openDVS_pixel2x2_bot
x4_x1689 dac_config_3 dac_config_5 col_event_rst_bot_right[13] dac_config_4
+ row_on_detect_bot[38] dac_config_0 dac_config_1 row_off_detect_bot[39] x4_net51
+ dac_config_2 vdda1 vssa1 vssc1 col_event_rst_bot_right[12] x4_net52
+ row_on_detect_bot[39] row_off_detect_bot[38] openDVS_pixel2x2_bot
x4_x1690 dac_config_3 dac_config_5 col_event_rst_bot_right[11] dac_config_4
+ row_on_detect_bot[38] dac_config_0 dac_config_1 row_off_detect_bot[39] x4_net53
+ dac_config_2 vdda1 vssa1 vssc1 col_event_rst_bot_right[10] x4_net54
+ row_on_detect_bot[39] row_off_detect_bot[38] openDVS_pixel2x2_bot
x4_x1691 dac_config_3 dac_config_5 col_event_rst_bot_right[9] dac_config_4
+ row_on_detect_bot[38] dac_config_0 dac_config_1 row_off_detect_bot[39] x4_net55
+ dac_config_2 vdda1 vssa1 vssc1 col_event_rst_bot_right[8] x4_net56 row_on_detect_bot[39]
+ row_off_detect_bot[38] openDVS_pixel2x2_bot
x4_x1692 dac_config_3 dac_config_5 col_event_rst_bot_right[7] dac_config_4
+ row_on_detect_bot[38] dac_config_0 dac_config_1 row_off_detect_bot[39] x4_net57
+ dac_config_2 vdda1 vssa1 vssc1 col_event_rst_bot_right[6] x4_net58 row_on_detect_bot[39]
+ row_off_detect_bot[38] openDVS_pixel2x2_bot
x4_x1693 dac_config_3 dac_config_5 col_event_rst_bot_right[5] dac_config_4
+ row_on_detect_bot[38] dac_config_0 dac_config_1 row_off_detect_bot[39] x4_net59
+ dac_config_2 vdda1 vssa1 vssc1 col_event_rst_bot_right[4] x4_net60 row_on_detect_bot[39]
+ row_off_detect_bot[38] openDVS_pixel2x2_bot
x4_x1694 dac_config_3 dac_config_5 col_event_rst_bot_right[3] dac_config_4
+ row_on_detect_bot[38] dac_config_0 dac_config_1 row_off_detect_bot[39] x4_net61
+ dac_config_2 vdda1 vssa1 vssc1 col_event_rst_bot_right[2] x4_net62 row_on_detect_bot[39]
+ row_off_detect_bot[38] openDVS_pixel2x2_bot
x4_x1695 dac_config_3 dac_config_5 col_event_rst_bot_right[1] dac_config_4
+ row_on_detect_bot[38] dac_config_0 dac_config_1 row_off_detect_bot[39] x4_net63
+ dac_config_2 vdda1 vssa1 vssc1 col_event_rst_bot_right[0] x4_net64 row_on_detect_bot[39]
+ row_off_detect_bot[38] openDVS_pixel2x2_bot
x4_x1696 dac_config_3 dac_config_5 col_event_rst_bot_right[63] dac_config_4
+ row_on_detect_bot[40] dac_config_0 dac_config_1 row_off_detect_bot[41] x4_net1
+ dac_config_2 vdda1 vssa1 vssc1 col_event_rst_bot_right[62] x4_net2 row_on_detect_bot[41]
+ row_off_detect_bot[40] openDVS_pixel2x2_bot
x4_x1697 dac_config_3 dac_config_5 col_event_rst_bot_right[61] dac_config_4
+ row_on_detect_bot[40] dac_config_0 dac_config_1 row_off_detect_bot[41] x4_net3
+ dac_config_2 vdda1 vssa1 vssc1 col_event_rst_bot_right[60] x4_net4 row_on_detect_bot[41]
+ row_off_detect_bot[40] openDVS_pixel2x2_bot
x4_x1698 dac_config_3 dac_config_5 col_event_rst_bot_right[59] dac_config_4
+ row_on_detect_bot[40] dac_config_0 dac_config_1 row_off_detect_bot[41] x4_net5
+ dac_config_2 vdda1 vssa1 vssc1 col_event_rst_bot_right[58] x4_net6 row_on_detect_bot[41]
+ row_off_detect_bot[40] openDVS_pixel2x2_bot
x4_x1699 dac_config_3 dac_config_5 col_event_rst_bot_right[57] dac_config_4
+ row_on_detect_bot[40] dac_config_0 dac_config_1 row_off_detect_bot[41] x4_net7
+ dac_config_2 vdda1 vssa1 vssc1 col_event_rst_bot_right[56] x4_net8 row_on_detect_bot[41]
+ row_off_detect_bot[40] openDVS_pixel2x2_bot
x4_x1700 dac_config_3 dac_config_5 col_event_rst_bot_right[55] dac_config_4
+ row_on_detect_bot[40] dac_config_0 dac_config_1 row_off_detect_bot[41] x4_net9
+ dac_config_2 vdda1 vssa1 vssc1 col_event_rst_bot_right[54] x4_net10
+ row_on_detect_bot[41] row_off_detect_bot[40] openDVS_pixel2x2_bot
x4_x1701 dac_config_3 dac_config_5 col_event_rst_bot_right[53] dac_config_4
+ row_on_detect_bot[40] dac_config_0 dac_config_1 row_off_detect_bot[41] x4_net11
+ dac_config_2 vdda1 vssa1 vssc1 col_event_rst_bot_right[52] x4_net12
+ row_on_detect_bot[41] row_off_detect_bot[40] openDVS_pixel2x2_bot
x4_x1702 dac_config_3 dac_config_5 col_event_rst_bot_right[51] dac_config_4
+ row_on_detect_bot[40] dac_config_0 dac_config_1 row_off_detect_bot[41] x4_net13
+ dac_config_2 vdda1 vssa1 vssc1 col_event_rst_bot_right[50] x4_net14
+ row_on_detect_bot[41] row_off_detect_bot[40] openDVS_pixel2x2_bot
x4_x1703 dac_config_3 dac_config_5 col_event_rst_bot_right[49] dac_config_4
+ row_on_detect_bot[40] dac_config_0 dac_config_1 row_off_detect_bot[41] x4_net15
+ dac_config_2 vdda1 vssa1 vssc1 col_event_rst_bot_right[48] x4_net16
+ row_on_detect_bot[41] row_off_detect_bot[40] openDVS_pixel2x2_bot
x4_x1704 dac_config_3 dac_config_5 col_event_rst_bot_right[47] dac_config_4
+ row_on_detect_bot[40] dac_config_0 dac_config_1 row_off_detect_bot[41] x4_net17
+ dac_config_2 vdda1 vssa1 vssc1 col_event_rst_bot_right[46] x4_net18
+ row_on_detect_bot[41] row_off_detect_bot[40] openDVS_pixel2x2_bot
x4_x1705 dac_config_3 dac_config_5 col_event_rst_bot_right[45] dac_config_4
+ row_on_detect_bot[40] dac_config_0 dac_config_1 row_off_detect_bot[41] x4_net19
+ dac_config_2 vdda1 vssa1 vssc1 col_event_rst_bot_right[44] x4_net20
+ row_on_detect_bot[41] row_off_detect_bot[40] openDVS_pixel2x2_bot
x4_x1706 dac_config_3 dac_config_5 col_event_rst_bot_right[43] dac_config_4
+ row_on_detect_bot[40] dac_config_0 dac_config_1 row_off_detect_bot[41] x4_net21
+ dac_config_2 vdda1 vssa1 vssc1 col_event_rst_bot_right[42] x4_net22
+ row_on_detect_bot[41] row_off_detect_bot[40] openDVS_pixel2x2_bot
x4_x1707 dac_config_3 dac_config_5 col_event_rst_bot_right[41] dac_config_4
+ row_on_detect_bot[40] dac_config_0 dac_config_1 row_off_detect_bot[41] x4_net23
+ dac_config_2 vdda1 vssa1 vssc1 col_event_rst_bot_right[40] x4_net24
+ row_on_detect_bot[41] row_off_detect_bot[40] openDVS_pixel2x2_bot
x4_x1708 dac_config_3 dac_config_5 col_event_rst_bot_right[39] dac_config_4
+ row_on_detect_bot[40] dac_config_0 dac_config_1 row_off_detect_bot[41] x4_net25
+ dac_config_2 vdda1 vssa1 vssc1 col_event_rst_bot_right[38] x4_net26
+ row_on_detect_bot[41] row_off_detect_bot[40] openDVS_pixel2x2_bot
x4_x1709 dac_config_3 dac_config_5 col_event_rst_bot_right[37] dac_config_4
+ row_on_detect_bot[40] dac_config_0 dac_config_1 row_off_detect_bot[41] x4_net27
+ dac_config_2 vdda1 vssa1 vssc1 col_event_rst_bot_right[36] x4_net28
+ row_on_detect_bot[41] row_off_detect_bot[40] openDVS_pixel2x2_bot
x4_x1710 dac_config_3 dac_config_5 col_event_rst_bot_right[35] dac_config_4
+ row_on_detect_bot[40] dac_config_0 dac_config_1 row_off_detect_bot[41] x4_net29
+ dac_config_2 vdda1 vssa1 vssc1 col_event_rst_bot_right[34] x4_net30
+ row_on_detect_bot[41] row_off_detect_bot[40] openDVS_pixel2x2_bot
x4_x1711 dac_config_3 dac_config_5 col_event_rst_bot_right[33] dac_config_4
+ row_on_detect_bot[40] dac_config_0 dac_config_1 row_off_detect_bot[41] x4_net31
+ dac_config_2 vdda1 vssa1 vssc1 col_event_rst_bot_right[32] x4_net32
+ row_on_detect_bot[41] row_off_detect_bot[40] openDVS_pixel2x2_bot
x4_x1712 dac_config_3 dac_config_5 col_event_rst_bot_right[31] dac_config_4
+ row_on_detect_bot[40] dac_config_0 dac_config_1 row_off_detect_bot[41] x4_net33
+ dac_config_2 vdda1 vssa1 vssc1 col_event_rst_bot_right[30] x4_net34
+ row_on_detect_bot[41] row_off_detect_bot[40] openDVS_pixel2x2_bot
x4_x1713 dac_config_3 dac_config_5 col_event_rst_bot_right[29] dac_config_4
+ row_on_detect_bot[40] dac_config_0 dac_config_1 row_off_detect_bot[41] x4_net35
+ dac_config_2 vdda1 vssa1 vssc1 col_event_rst_bot_right[28] x4_net36
+ row_on_detect_bot[41] row_off_detect_bot[40] openDVS_pixel2x2_bot
x4_x1714 dac_config_3 dac_config_5 col_event_rst_bot_right[27] dac_config_4
+ row_on_detect_bot[40] dac_config_0 dac_config_1 row_off_detect_bot[41] x4_net37
+ dac_config_2 vdda1 vssa1 vssc1 col_event_rst_bot_right[26] x4_net38
+ row_on_detect_bot[41] row_off_detect_bot[40] openDVS_pixel2x2_bot
x4_x1715 dac_config_3 dac_config_5 col_event_rst_bot_right[25] dac_config_4
+ row_on_detect_bot[40] dac_config_0 dac_config_1 row_off_detect_bot[41] x4_net39
+ dac_config_2 vdda1 vssa1 vssc1 col_event_rst_bot_right[24] x4_net40
+ row_on_detect_bot[41] row_off_detect_bot[40] openDVS_pixel2x2_bot
x4_x1716 dac_config_3 dac_config_5 col_event_rst_bot_right[23] dac_config_4
+ row_on_detect_bot[40] dac_config_0 dac_config_1 row_off_detect_bot[41] x4_net41
+ dac_config_2 vdda1 vssa1 vssc1 col_event_rst_bot_right[22] x4_net42
+ row_on_detect_bot[41] row_off_detect_bot[40] openDVS_pixel2x2_bot
x4_x1717 dac_config_3 dac_config_5 col_event_rst_bot_right[21] dac_config_4
+ row_on_detect_bot[40] dac_config_0 dac_config_1 row_off_detect_bot[41] x4_net43
+ dac_config_2 vdda1 vssa1 vssc1 col_event_rst_bot_right[20] x4_net44
+ row_on_detect_bot[41] row_off_detect_bot[40] openDVS_pixel2x2_bot
x4_x1718 dac_config_3 dac_config_5 col_event_rst_bot_right[19] dac_config_4
+ row_on_detect_bot[40] dac_config_0 dac_config_1 row_off_detect_bot[41] x4_net45
+ dac_config_2 vdda1 vssa1 vssc1 col_event_rst_bot_right[18] x4_net46
+ row_on_detect_bot[41] row_off_detect_bot[40] openDVS_pixel2x2_bot
x4_x1719 dac_config_3 dac_config_5 col_event_rst_bot_right[17] dac_config_4
+ row_on_detect_bot[40] dac_config_0 dac_config_1 row_off_detect_bot[41] x4_net47
+ dac_config_2 vdda1 vssa1 vssc1 col_event_rst_bot_right[16] x4_net48
+ row_on_detect_bot[41] row_off_detect_bot[40] openDVS_pixel2x2_bot
x4_x1720 dac_config_3 dac_config_5 col_event_rst_bot_right[15] dac_config_4
+ row_on_detect_bot[40] dac_config_0 dac_config_1 row_off_detect_bot[41] x4_net49
+ dac_config_2 vdda1 vssa1 vssc1 col_event_rst_bot_right[14] x4_net50
+ row_on_detect_bot[41] row_off_detect_bot[40] openDVS_pixel2x2_bot
x4_x1721 dac_config_3 dac_config_5 col_event_rst_bot_right[13] dac_config_4
+ row_on_detect_bot[40] dac_config_0 dac_config_1 row_off_detect_bot[41] x4_net51
+ dac_config_2 vdda1 vssa1 vssc1 col_event_rst_bot_right[12] x4_net52
+ row_on_detect_bot[41] row_off_detect_bot[40] openDVS_pixel2x2_bot
x4_x1722 dac_config_3 dac_config_5 col_event_rst_bot_right[11] dac_config_4
+ row_on_detect_bot[40] dac_config_0 dac_config_1 row_off_detect_bot[41] x4_net53
+ dac_config_2 vdda1 vssa1 vssc1 col_event_rst_bot_right[10] x4_net54
+ row_on_detect_bot[41] row_off_detect_bot[40] openDVS_pixel2x2_bot
x4_x1723 dac_config_3 dac_config_5 col_event_rst_bot_right[9] dac_config_4
+ row_on_detect_bot[40] dac_config_0 dac_config_1 row_off_detect_bot[41] x4_net55
+ dac_config_2 vdda1 vssa1 vssc1 col_event_rst_bot_right[8] x4_net56 row_on_detect_bot[41]
+ row_off_detect_bot[40] openDVS_pixel2x2_bot
x4_x1724 dac_config_3 dac_config_5 col_event_rst_bot_right[7] dac_config_4
+ row_on_detect_bot[40] dac_config_0 dac_config_1 row_off_detect_bot[41] x4_net57
+ dac_config_2 vdda1 vssa1 vssc1 col_event_rst_bot_right[6] x4_net58 row_on_detect_bot[41]
+ row_off_detect_bot[40] openDVS_pixel2x2_bot
x4_x1725 dac_config_3 dac_config_5 col_event_rst_bot_right[5] dac_config_4
+ row_on_detect_bot[40] dac_config_0 dac_config_1 row_off_detect_bot[41] x4_net59
+ dac_config_2 vdda1 vssa1 vssc1 col_event_rst_bot_right[4] x4_net60 row_on_detect_bot[41]
+ row_off_detect_bot[40] openDVS_pixel2x2_bot
x4_x1726 dac_config_3 dac_config_5 col_event_rst_bot_right[3] dac_config_4
+ row_on_detect_bot[40] dac_config_0 dac_config_1 row_off_detect_bot[41] x4_net61
+ dac_config_2 vdda1 vssa1 vssc1 col_event_rst_bot_right[2] x4_net62 row_on_detect_bot[41]
+ row_off_detect_bot[40] openDVS_pixel2x2_bot
x4_x1727 dac_config_3 dac_config_5 col_event_rst_bot_right[1] dac_config_4
+ row_on_detect_bot[40] dac_config_0 dac_config_1 row_off_detect_bot[41] x4_net63
+ dac_config_2 vdda1 vssa1 vssc1 col_event_rst_bot_right[0] x4_net64 row_on_detect_bot[41]
+ row_off_detect_bot[40] openDVS_pixel2x2_bot
x4_x1728 dac_config_3 dac_config_5 col_event_rst_bot_right[63] dac_config_4
+ row_on_detect_bot[42] dac_config_0 dac_config_1 row_off_detect_bot[43] x4_net1
+ dac_config_2 vdda1 vssa1 vssc1 col_event_rst_bot_right[62] x4_net2 row_on_detect_bot[43]
+ row_off_detect_bot[42] openDVS_pixel2x2_bot
x4_x1729 dac_config_3 dac_config_5 col_event_rst_bot_right[61] dac_config_4
+ row_on_detect_bot[42] dac_config_0 dac_config_1 row_off_detect_bot[43] x4_net3
+ dac_config_2 vdda1 vssa1 vssc1 col_event_rst_bot_right[60] x4_net4 row_on_detect_bot[43]
+ row_off_detect_bot[42] openDVS_pixel2x2_bot
x4_x1730 dac_config_3 dac_config_5 col_event_rst_bot_right[59] dac_config_4
+ row_on_detect_bot[42] dac_config_0 dac_config_1 row_off_detect_bot[43] x4_net5
+ dac_config_2 vdda1 vssa1 vssc1 col_event_rst_bot_right[58] x4_net6 row_on_detect_bot[43]
+ row_off_detect_bot[42] openDVS_pixel2x2_bot
x4_x1731 dac_config_3 dac_config_5 col_event_rst_bot_right[57] dac_config_4
+ row_on_detect_bot[42] dac_config_0 dac_config_1 row_off_detect_bot[43] x4_net7
+ dac_config_2 vdda1 vssa1 vssc1 col_event_rst_bot_right[56] x4_net8 row_on_detect_bot[43]
+ row_off_detect_bot[42] openDVS_pixel2x2_bot
x4_x1732 dac_config_3 dac_config_5 col_event_rst_bot_right[55] dac_config_4
+ row_on_detect_bot[42] dac_config_0 dac_config_1 row_off_detect_bot[43] x4_net9
+ dac_config_2 vdda1 vssa1 vssc1 col_event_rst_bot_right[54] x4_net10
+ row_on_detect_bot[43] row_off_detect_bot[42] openDVS_pixel2x2_bot
x4_x1733 dac_config_3 dac_config_5 col_event_rst_bot_right[53] dac_config_4
+ row_on_detect_bot[42] dac_config_0 dac_config_1 row_off_detect_bot[43] x4_net11
+ dac_config_2 vdda1 vssa1 vssc1 col_event_rst_bot_right[52] x4_net12
+ row_on_detect_bot[43] row_off_detect_bot[42] openDVS_pixel2x2_bot
x4_x1734 dac_config_3 dac_config_5 col_event_rst_bot_right[51] dac_config_4
+ row_on_detect_bot[42] dac_config_0 dac_config_1 row_off_detect_bot[43] x4_net13
+ dac_config_2 vdda1 vssa1 vssc1 col_event_rst_bot_right[50] x4_net14
+ row_on_detect_bot[43] row_off_detect_bot[42] openDVS_pixel2x2_bot
x4_x1735 dac_config_3 dac_config_5 col_event_rst_bot_right[49] dac_config_4
+ row_on_detect_bot[42] dac_config_0 dac_config_1 row_off_detect_bot[43] x4_net15
+ dac_config_2 vdda1 vssa1 vssc1 col_event_rst_bot_right[48] x4_net16
+ row_on_detect_bot[43] row_off_detect_bot[42] openDVS_pixel2x2_bot
x4_x1736 dac_config_3 dac_config_5 col_event_rst_bot_right[47] dac_config_4
+ row_on_detect_bot[42] dac_config_0 dac_config_1 row_off_detect_bot[43] x4_net17
+ dac_config_2 vdda1 vssa1 vssc1 col_event_rst_bot_right[46] x4_net18
+ row_on_detect_bot[43] row_off_detect_bot[42] openDVS_pixel2x2_bot
x4_x1737 dac_config_3 dac_config_5 col_event_rst_bot_right[45] dac_config_4
+ row_on_detect_bot[42] dac_config_0 dac_config_1 row_off_detect_bot[43] x4_net19
+ dac_config_2 vdda1 vssa1 vssc1 col_event_rst_bot_right[44] x4_net20
+ row_on_detect_bot[43] row_off_detect_bot[42] openDVS_pixel2x2_bot
x4_x1738 dac_config_3 dac_config_5 col_event_rst_bot_right[43] dac_config_4
+ row_on_detect_bot[42] dac_config_0 dac_config_1 row_off_detect_bot[43] x4_net21
+ dac_config_2 vdda1 vssa1 vssc1 col_event_rst_bot_right[42] x4_net22
+ row_on_detect_bot[43] row_off_detect_bot[42] openDVS_pixel2x2_bot
x4_x1739 dac_config_3 dac_config_5 col_event_rst_bot_right[41] dac_config_4
+ row_on_detect_bot[42] dac_config_0 dac_config_1 row_off_detect_bot[43] x4_net23
+ dac_config_2 vdda1 vssa1 vssc1 col_event_rst_bot_right[40] x4_net24
+ row_on_detect_bot[43] row_off_detect_bot[42] openDVS_pixel2x2_bot
x4_x1740 dac_config_3 dac_config_5 col_event_rst_bot_right[39] dac_config_4
+ row_on_detect_bot[42] dac_config_0 dac_config_1 row_off_detect_bot[43] x4_net25
+ dac_config_2 vdda1 vssa1 vssc1 col_event_rst_bot_right[38] x4_net26
+ row_on_detect_bot[43] row_off_detect_bot[42] openDVS_pixel2x2_bot
x4_x1741 dac_config_3 dac_config_5 col_event_rst_bot_right[37] dac_config_4
+ row_on_detect_bot[42] dac_config_0 dac_config_1 row_off_detect_bot[43] x4_net27
+ dac_config_2 vdda1 vssa1 vssc1 col_event_rst_bot_right[36] x4_net28
+ row_on_detect_bot[43] row_off_detect_bot[42] openDVS_pixel2x2_bot
x4_x1742 dac_config_3 dac_config_5 col_event_rst_bot_right[35] dac_config_4
+ row_on_detect_bot[42] dac_config_0 dac_config_1 row_off_detect_bot[43] x4_net29
+ dac_config_2 vdda1 vssa1 vssc1 col_event_rst_bot_right[34] x4_net30
+ row_on_detect_bot[43] row_off_detect_bot[42] openDVS_pixel2x2_bot
x4_x1743 dac_config_3 dac_config_5 col_event_rst_bot_right[33] dac_config_4
+ row_on_detect_bot[42] dac_config_0 dac_config_1 row_off_detect_bot[43] x4_net31
+ dac_config_2 vdda1 vssa1 vssc1 col_event_rst_bot_right[32] x4_net32
+ row_on_detect_bot[43] row_off_detect_bot[42] openDVS_pixel2x2_bot
x4_x1744 dac_config_3 dac_config_5 col_event_rst_bot_right[31] dac_config_4
+ row_on_detect_bot[42] dac_config_0 dac_config_1 row_off_detect_bot[43] x4_net33
+ dac_config_2 vdda1 vssa1 vssc1 col_event_rst_bot_right[30] x4_net34
+ row_on_detect_bot[43] row_off_detect_bot[42] openDVS_pixel2x2_bot
x4_x1745 dac_config_3 dac_config_5 col_event_rst_bot_right[29] dac_config_4
+ row_on_detect_bot[42] dac_config_0 dac_config_1 row_off_detect_bot[43] x4_net35
+ dac_config_2 vdda1 vssa1 vssc1 col_event_rst_bot_right[28] x4_net36
+ row_on_detect_bot[43] row_off_detect_bot[42] openDVS_pixel2x2_bot
x4_x1746 dac_config_3 dac_config_5 col_event_rst_bot_right[27] dac_config_4
+ row_on_detect_bot[42] dac_config_0 dac_config_1 row_off_detect_bot[43] x4_net37
+ dac_config_2 vdda1 vssa1 vssc1 col_event_rst_bot_right[26] x4_net38
+ row_on_detect_bot[43] row_off_detect_bot[42] openDVS_pixel2x2_bot
x4_x1747 dac_config_3 dac_config_5 col_event_rst_bot_right[25] dac_config_4
+ row_on_detect_bot[42] dac_config_0 dac_config_1 row_off_detect_bot[43] x4_net39
+ dac_config_2 vdda1 vssa1 vssc1 col_event_rst_bot_right[24] x4_net40
+ row_on_detect_bot[43] row_off_detect_bot[42] openDVS_pixel2x2_bot
x4_x1748 dac_config_3 dac_config_5 col_event_rst_bot_right[23] dac_config_4
+ row_on_detect_bot[42] dac_config_0 dac_config_1 row_off_detect_bot[43] x4_net41
+ dac_config_2 vdda1 vssa1 vssc1 col_event_rst_bot_right[22] x4_net42
+ row_on_detect_bot[43] row_off_detect_bot[42] openDVS_pixel2x2_bot
x4_x1749 dac_config_3 dac_config_5 col_event_rst_bot_right[21] dac_config_4
+ row_on_detect_bot[42] dac_config_0 dac_config_1 row_off_detect_bot[43] x4_net43
+ dac_config_2 vdda1 vssa1 vssc1 col_event_rst_bot_right[20] x4_net44
+ row_on_detect_bot[43] row_off_detect_bot[42] openDVS_pixel2x2_bot
x4_x1750 dac_config_3 dac_config_5 col_event_rst_bot_right[19] dac_config_4
+ row_on_detect_bot[42] dac_config_0 dac_config_1 row_off_detect_bot[43] x4_net45
+ dac_config_2 vdda1 vssa1 vssc1 col_event_rst_bot_right[18] x4_net46
+ row_on_detect_bot[43] row_off_detect_bot[42] openDVS_pixel2x2_bot
x4_x1751 dac_config_3 dac_config_5 col_event_rst_bot_right[17] dac_config_4
+ row_on_detect_bot[42] dac_config_0 dac_config_1 row_off_detect_bot[43] x4_net47
+ dac_config_2 vdda1 vssa1 vssc1 col_event_rst_bot_right[16] x4_net48
+ row_on_detect_bot[43] row_off_detect_bot[42] openDVS_pixel2x2_bot
x4_x1752 dac_config_3 dac_config_5 col_event_rst_bot_right[15] dac_config_4
+ row_on_detect_bot[42] dac_config_0 dac_config_1 row_off_detect_bot[43] x4_net49
+ dac_config_2 vdda1 vssa1 vssc1 col_event_rst_bot_right[14] x4_net50
+ row_on_detect_bot[43] row_off_detect_bot[42] openDVS_pixel2x2_bot
x4_x1753 dac_config_3 dac_config_5 col_event_rst_bot_right[13] dac_config_4
+ row_on_detect_bot[42] dac_config_0 dac_config_1 row_off_detect_bot[43] x4_net51
+ dac_config_2 vdda1 vssa1 vssc1 col_event_rst_bot_right[12] x4_net52
+ row_on_detect_bot[43] row_off_detect_bot[42] openDVS_pixel2x2_bot
x4_x1754 dac_config_3 dac_config_5 col_event_rst_bot_right[11] dac_config_4
+ row_on_detect_bot[42] dac_config_0 dac_config_1 row_off_detect_bot[43] x4_net53
+ dac_config_2 vdda1 vssa1 vssc1 col_event_rst_bot_right[10] x4_net54
+ row_on_detect_bot[43] row_off_detect_bot[42] openDVS_pixel2x2_bot
x4_x1755 dac_config_3 dac_config_5 col_event_rst_bot_right[9] dac_config_4
+ row_on_detect_bot[42] dac_config_0 dac_config_1 row_off_detect_bot[43] x4_net55
+ dac_config_2 vdda1 vssa1 vssc1 col_event_rst_bot_right[8] x4_net56 row_on_detect_bot[43]
+ row_off_detect_bot[42] openDVS_pixel2x2_bot
x4_x1756 dac_config_3 dac_config_5 col_event_rst_bot_right[7] dac_config_4
+ row_on_detect_bot[42] dac_config_0 dac_config_1 row_off_detect_bot[43] x4_net57
+ dac_config_2 vdda1 vssa1 vssc1 col_event_rst_bot_right[6] x4_net58 row_on_detect_bot[43]
+ row_off_detect_bot[42] openDVS_pixel2x2_bot
x4_x1757 dac_config_3 dac_config_5 col_event_rst_bot_right[5] dac_config_4
+ row_on_detect_bot[42] dac_config_0 dac_config_1 row_off_detect_bot[43] x4_net59
+ dac_config_2 vdda1 vssa1 vssc1 col_event_rst_bot_right[4] x4_net60 row_on_detect_bot[43]
+ row_off_detect_bot[42] openDVS_pixel2x2_bot
x4_x1758 dac_config_3 dac_config_5 col_event_rst_bot_right[3] dac_config_4
+ row_on_detect_bot[42] dac_config_0 dac_config_1 row_off_detect_bot[43] x4_net61
+ dac_config_2 vdda1 vssa1 vssc1 col_event_rst_bot_right[2] x4_net62 row_on_detect_bot[43]
+ row_off_detect_bot[42] openDVS_pixel2x2_bot
x4_x1759 dac_config_3 dac_config_5 col_event_rst_bot_right[1] dac_config_4
+ row_on_detect_bot[42] dac_config_0 dac_config_1 row_off_detect_bot[43] x4_net63
+ dac_config_2 vdda1 vssa1 vssc1 col_event_rst_bot_right[0] x4_net64 row_on_detect_bot[43]
+ row_off_detect_bot[42] openDVS_pixel2x2_bot
x4_x1760 dac_config_3 dac_config_5 col_event_rst_bot_right[63] dac_config_4
+ row_on_detect_bot[44] dac_config_0 dac_config_1 row_off_detect_bot[45] x4_net1
+ dac_config_2 vdda1 vssa1 vssc1 col_event_rst_bot_right[62] x4_net2 row_on_detect_bot[45]
+ row_off_detect_bot[44] openDVS_pixel2x2_bot
x4_x1761 dac_config_3 dac_config_5 col_event_rst_bot_right[61] dac_config_4
+ row_on_detect_bot[44] dac_config_0 dac_config_1 row_off_detect_bot[45] x4_net3
+ dac_config_2 vdda1 vssa1 vssc1 col_event_rst_bot_right[60] x4_net4 row_on_detect_bot[45]
+ row_off_detect_bot[44] openDVS_pixel2x2_bot
x4_x1762 dac_config_3 dac_config_5 col_event_rst_bot_right[59] dac_config_4
+ row_on_detect_bot[44] dac_config_0 dac_config_1 row_off_detect_bot[45] x4_net5
+ dac_config_2 vdda1 vssa1 vssc1 col_event_rst_bot_right[58] x4_net6 row_on_detect_bot[45]
+ row_off_detect_bot[44] openDVS_pixel2x2_bot
x4_x1763 dac_config_3 dac_config_5 col_event_rst_bot_right[57] dac_config_4
+ row_on_detect_bot[44] dac_config_0 dac_config_1 row_off_detect_bot[45] x4_net7
+ dac_config_2 vdda1 vssa1 vssc1 col_event_rst_bot_right[56] x4_net8 row_on_detect_bot[45]
+ row_off_detect_bot[44] openDVS_pixel2x2_bot
x4_x1764 dac_config_3 dac_config_5 col_event_rst_bot_right[55] dac_config_4
+ row_on_detect_bot[44] dac_config_0 dac_config_1 row_off_detect_bot[45] x4_net9
+ dac_config_2 vdda1 vssa1 vssc1 col_event_rst_bot_right[54] x4_net10
+ row_on_detect_bot[45] row_off_detect_bot[44] openDVS_pixel2x2_bot
x4_x1765 dac_config_3 dac_config_5 col_event_rst_bot_right[53] dac_config_4
+ row_on_detect_bot[44] dac_config_0 dac_config_1 row_off_detect_bot[45] x4_net11
+ dac_config_2 vdda1 vssa1 vssc1 col_event_rst_bot_right[52] x4_net12
+ row_on_detect_bot[45] row_off_detect_bot[44] openDVS_pixel2x2_bot
x4_x1766 dac_config_3 dac_config_5 col_event_rst_bot_right[51] dac_config_4
+ row_on_detect_bot[44] dac_config_0 dac_config_1 row_off_detect_bot[45] x4_net13
+ dac_config_2 vdda1 vssa1 vssc1 col_event_rst_bot_right[50] x4_net14
+ row_on_detect_bot[45] row_off_detect_bot[44] openDVS_pixel2x2_bot
x4_x1767 dac_config_3 dac_config_5 col_event_rst_bot_right[49] dac_config_4
+ row_on_detect_bot[44] dac_config_0 dac_config_1 row_off_detect_bot[45] x4_net15
+ dac_config_2 vdda1 vssa1 vssc1 col_event_rst_bot_right[48] x4_net16
+ row_on_detect_bot[45] row_off_detect_bot[44] openDVS_pixel2x2_bot
x4_x1768 dac_config_3 dac_config_5 col_event_rst_bot_right[47] dac_config_4
+ row_on_detect_bot[44] dac_config_0 dac_config_1 row_off_detect_bot[45] x4_net17
+ dac_config_2 vdda1 vssa1 vssc1 col_event_rst_bot_right[46] x4_net18
+ row_on_detect_bot[45] row_off_detect_bot[44] openDVS_pixel2x2_bot
x4_x1769 dac_config_3 dac_config_5 col_event_rst_bot_right[45] dac_config_4
+ row_on_detect_bot[44] dac_config_0 dac_config_1 row_off_detect_bot[45] x4_net19
+ dac_config_2 vdda1 vssa1 vssc1 col_event_rst_bot_right[44] x4_net20
+ row_on_detect_bot[45] row_off_detect_bot[44] openDVS_pixel2x2_bot
x4_x1770 dac_config_3 dac_config_5 col_event_rst_bot_right[43] dac_config_4
+ row_on_detect_bot[44] dac_config_0 dac_config_1 row_off_detect_bot[45] x4_net21
+ dac_config_2 vdda1 vssa1 vssc1 col_event_rst_bot_right[42] x4_net22
+ row_on_detect_bot[45] row_off_detect_bot[44] openDVS_pixel2x2_bot
x4_x1771 dac_config_3 dac_config_5 col_event_rst_bot_right[41] dac_config_4
+ row_on_detect_bot[44] dac_config_0 dac_config_1 row_off_detect_bot[45] x4_net23
+ dac_config_2 vdda1 vssa1 vssc1 col_event_rst_bot_right[40] x4_net24
+ row_on_detect_bot[45] row_off_detect_bot[44] openDVS_pixel2x2_bot
x4_x1772 dac_config_3 dac_config_5 col_event_rst_bot_right[39] dac_config_4
+ row_on_detect_bot[44] dac_config_0 dac_config_1 row_off_detect_bot[45] x4_net25
+ dac_config_2 vdda1 vssa1 vssc1 col_event_rst_bot_right[38] x4_net26
+ row_on_detect_bot[45] row_off_detect_bot[44] openDVS_pixel2x2_bot
x4_x1773 dac_config_3 dac_config_5 col_event_rst_bot_right[37] dac_config_4
+ row_on_detect_bot[44] dac_config_0 dac_config_1 row_off_detect_bot[45] x4_net27
+ dac_config_2 vdda1 vssa1 vssc1 col_event_rst_bot_right[36] x4_net28
+ row_on_detect_bot[45] row_off_detect_bot[44] openDVS_pixel2x2_bot
x4_x1774 dac_config_3 dac_config_5 col_event_rst_bot_right[35] dac_config_4
+ row_on_detect_bot[44] dac_config_0 dac_config_1 row_off_detect_bot[45] x4_net29
+ dac_config_2 vdda1 vssa1 vssc1 col_event_rst_bot_right[34] x4_net30
+ row_on_detect_bot[45] row_off_detect_bot[44] openDVS_pixel2x2_bot
x4_x1775 dac_config_3 dac_config_5 col_event_rst_bot_right[33] dac_config_4
+ row_on_detect_bot[44] dac_config_0 dac_config_1 row_off_detect_bot[45] x4_net31
+ dac_config_2 vdda1 vssa1 vssc1 col_event_rst_bot_right[32] x4_net32
+ row_on_detect_bot[45] row_off_detect_bot[44] openDVS_pixel2x2_bot
x4_x1776 dac_config_3 dac_config_5 col_event_rst_bot_right[31] dac_config_4
+ row_on_detect_bot[44] dac_config_0 dac_config_1 row_off_detect_bot[45] x4_net33
+ dac_config_2 vdda1 vssa1 vssc1 col_event_rst_bot_right[30] x4_net34
+ row_on_detect_bot[45] row_off_detect_bot[44] openDVS_pixel2x2_bot
x4_x1777 dac_config_3 dac_config_5 col_event_rst_bot_right[29] dac_config_4
+ row_on_detect_bot[44] dac_config_0 dac_config_1 row_off_detect_bot[45] x4_net35
+ dac_config_2 vdda1 vssa1 vssc1 col_event_rst_bot_right[28] x4_net36
+ row_on_detect_bot[45] row_off_detect_bot[44] openDVS_pixel2x2_bot
x4_x1778 dac_config_3 dac_config_5 col_event_rst_bot_right[27] dac_config_4
+ row_on_detect_bot[44] dac_config_0 dac_config_1 row_off_detect_bot[45] x4_net37
+ dac_config_2 vdda1 vssa1 vssc1 col_event_rst_bot_right[26] x4_net38
+ row_on_detect_bot[45] row_off_detect_bot[44] openDVS_pixel2x2_bot
x4_x1779 dac_config_3 dac_config_5 col_event_rst_bot_right[25] dac_config_4
+ row_on_detect_bot[44] dac_config_0 dac_config_1 row_off_detect_bot[45] x4_net39
+ dac_config_2 vdda1 vssa1 vssc1 col_event_rst_bot_right[24] x4_net40
+ row_on_detect_bot[45] row_off_detect_bot[44] openDVS_pixel2x2_bot
x4_x1780 dac_config_3 dac_config_5 col_event_rst_bot_right[23] dac_config_4
+ row_on_detect_bot[44] dac_config_0 dac_config_1 row_off_detect_bot[45] x4_net41
+ dac_config_2 vdda1 vssa1 vssc1 col_event_rst_bot_right[22] x4_net42
+ row_on_detect_bot[45] row_off_detect_bot[44] openDVS_pixel2x2_bot
x4_x1781 dac_config_3 dac_config_5 col_event_rst_bot_right[21] dac_config_4
+ row_on_detect_bot[44] dac_config_0 dac_config_1 row_off_detect_bot[45] x4_net43
+ dac_config_2 vdda1 vssa1 vssc1 col_event_rst_bot_right[20] x4_net44
+ row_on_detect_bot[45] row_off_detect_bot[44] openDVS_pixel2x2_bot
x4_x1782 dac_config_3 dac_config_5 col_event_rst_bot_right[19] dac_config_4
+ row_on_detect_bot[44] dac_config_0 dac_config_1 row_off_detect_bot[45] x4_net45
+ dac_config_2 vdda1 vssa1 vssc1 col_event_rst_bot_right[18] x4_net46
+ row_on_detect_bot[45] row_off_detect_bot[44] openDVS_pixel2x2_bot
x4_x1783 dac_config_3 dac_config_5 col_event_rst_bot_right[17] dac_config_4
+ row_on_detect_bot[44] dac_config_0 dac_config_1 row_off_detect_bot[45] x4_net47
+ dac_config_2 vdda1 vssa1 vssc1 col_event_rst_bot_right[16] x4_net48
+ row_on_detect_bot[45] row_off_detect_bot[44] openDVS_pixel2x2_bot
x4_x1784 dac_config_3 dac_config_5 col_event_rst_bot_right[15] dac_config_4
+ row_on_detect_bot[44] dac_config_0 dac_config_1 row_off_detect_bot[45] x4_net49
+ dac_config_2 vdda1 vssa1 vssc1 col_event_rst_bot_right[14] x4_net50
+ row_on_detect_bot[45] row_off_detect_bot[44] openDVS_pixel2x2_bot
x4_x1785 dac_config_3 dac_config_5 col_event_rst_bot_right[13] dac_config_4
+ row_on_detect_bot[44] dac_config_0 dac_config_1 row_off_detect_bot[45] x4_net51
+ dac_config_2 vdda1 vssa1 vssc1 col_event_rst_bot_right[12] x4_net52
+ row_on_detect_bot[45] row_off_detect_bot[44] openDVS_pixel2x2_bot
x4_x1786 dac_config_3 dac_config_5 col_event_rst_bot_right[11] dac_config_4
+ row_on_detect_bot[44] dac_config_0 dac_config_1 row_off_detect_bot[45] x4_net53
+ dac_config_2 vdda1 vssa1 vssc1 col_event_rst_bot_right[10] x4_net54
+ row_on_detect_bot[45] row_off_detect_bot[44] openDVS_pixel2x2_bot
x4_x1787 dac_config_3 dac_config_5 col_event_rst_bot_right[9] dac_config_4
+ row_on_detect_bot[44] dac_config_0 dac_config_1 row_off_detect_bot[45] x4_net55
+ dac_config_2 vdda1 vssa1 vssc1 col_event_rst_bot_right[8] x4_net56 row_on_detect_bot[45]
+ row_off_detect_bot[44] openDVS_pixel2x2_bot
x4_x1788 dac_config_3 dac_config_5 col_event_rst_bot_right[7] dac_config_4
+ row_on_detect_bot[44] dac_config_0 dac_config_1 row_off_detect_bot[45] x4_net57
+ dac_config_2 vdda1 vssa1 vssc1 col_event_rst_bot_right[6] x4_net58 row_on_detect_bot[45]
+ row_off_detect_bot[44] openDVS_pixel2x2_bot
x4_x1789 dac_config_3 dac_config_5 col_event_rst_bot_right[5] dac_config_4
+ row_on_detect_bot[44] dac_config_0 dac_config_1 row_off_detect_bot[45] x4_net59
+ dac_config_2 vdda1 vssa1 vssc1 col_event_rst_bot_right[4] x4_net60 row_on_detect_bot[45]
+ row_off_detect_bot[44] openDVS_pixel2x2_bot
x4_x1790 dac_config_3 dac_config_5 col_event_rst_bot_right[3] dac_config_4
+ row_on_detect_bot[44] dac_config_0 dac_config_1 row_off_detect_bot[45] x4_net61
+ dac_config_2 vdda1 vssa1 vssc1 col_event_rst_bot_right[2] x4_net62 row_on_detect_bot[45]
+ row_off_detect_bot[44] openDVS_pixel2x2_bot
x4_x1791 dac_config_3 dac_config_5 col_event_rst_bot_right[1] dac_config_4
+ row_on_detect_bot[44] dac_config_0 dac_config_1 row_off_detect_bot[45] x4_net63
+ dac_config_2 vdda1 vssa1 vssc1 col_event_rst_bot_right[0] x4_net64 row_on_detect_bot[45]
+ row_off_detect_bot[44] openDVS_pixel2x2_bot
x4_x1792 dac_config_3 dac_config_5 col_event_rst_bot_right[63] dac_config_4
+ row_on_detect_bot[46] dac_config_0 dac_config_1 row_off_detect_bot[47] x4_net1
+ dac_config_2 vdda1 vssa1 vssc1 col_event_rst_bot_right[62] x4_net2 row_on_detect_bot[47]
+ row_off_detect_bot[46] openDVS_pixel2x2_bot
x4_x1793 dac_config_3 dac_config_5 col_event_rst_bot_right[61] dac_config_4
+ row_on_detect_bot[46] dac_config_0 dac_config_1 row_off_detect_bot[47] x4_net3
+ dac_config_2 vdda1 vssa1 vssc1 col_event_rst_bot_right[60] x4_net4 row_on_detect_bot[47]
+ row_off_detect_bot[46] openDVS_pixel2x2_bot
x4_x1794 dac_config_3 dac_config_5 col_event_rst_bot_right[59] dac_config_4
+ row_on_detect_bot[46] dac_config_0 dac_config_1 row_off_detect_bot[47] x4_net5
+ dac_config_2 vdda1 vssa1 vssc1 col_event_rst_bot_right[58] x4_net6 row_on_detect_bot[47]
+ row_off_detect_bot[46] openDVS_pixel2x2_bot
x4_x1795 dac_config_3 dac_config_5 col_event_rst_bot_right[57] dac_config_4
+ row_on_detect_bot[46] dac_config_0 dac_config_1 row_off_detect_bot[47] x4_net7
+ dac_config_2 vdda1 vssa1 vssc1 col_event_rst_bot_right[56] x4_net8 row_on_detect_bot[47]
+ row_off_detect_bot[46] openDVS_pixel2x2_bot
x4_x1796 dac_config_3 dac_config_5 col_event_rst_bot_right[55] dac_config_4
+ row_on_detect_bot[46] dac_config_0 dac_config_1 row_off_detect_bot[47] x4_net9
+ dac_config_2 vdda1 vssa1 vssc1 col_event_rst_bot_right[54] x4_net10
+ row_on_detect_bot[47] row_off_detect_bot[46] openDVS_pixel2x2_bot
x4_x1797 dac_config_3 dac_config_5 col_event_rst_bot_right[53] dac_config_4
+ row_on_detect_bot[46] dac_config_0 dac_config_1 row_off_detect_bot[47] x4_net11
+ dac_config_2 vdda1 vssa1 vssc1 col_event_rst_bot_right[52] x4_net12
+ row_on_detect_bot[47] row_off_detect_bot[46] openDVS_pixel2x2_bot
x4_x1798 dac_config_3 dac_config_5 col_event_rst_bot_right[51] dac_config_4
+ row_on_detect_bot[46] dac_config_0 dac_config_1 row_off_detect_bot[47] x4_net13
+ dac_config_2 vdda1 vssa1 vssc1 col_event_rst_bot_right[50] x4_net14
+ row_on_detect_bot[47] row_off_detect_bot[46] openDVS_pixel2x2_bot
x4_x1799 dac_config_3 dac_config_5 col_event_rst_bot_right[49] dac_config_4
+ row_on_detect_bot[46] dac_config_0 dac_config_1 row_off_detect_bot[47] x4_net15
+ dac_config_2 vdda1 vssa1 vssc1 col_event_rst_bot_right[48] x4_net16
+ row_on_detect_bot[47] row_off_detect_bot[46] openDVS_pixel2x2_bot
x4_x1800 dac_config_3 dac_config_5 col_event_rst_bot_right[47] dac_config_4
+ row_on_detect_bot[46] dac_config_0 dac_config_1 row_off_detect_bot[47] x4_net17
+ dac_config_2 vdda1 vssa1 vssc1 col_event_rst_bot_right[46] x4_net18
+ row_on_detect_bot[47] row_off_detect_bot[46] openDVS_pixel2x2_bot
x4_x1801 dac_config_3 dac_config_5 col_event_rst_bot_right[45] dac_config_4
+ row_on_detect_bot[46] dac_config_0 dac_config_1 row_off_detect_bot[47] x4_net19
+ dac_config_2 vdda1 vssa1 vssc1 col_event_rst_bot_right[44] x4_net20
+ row_on_detect_bot[47] row_off_detect_bot[46] openDVS_pixel2x2_bot
x4_x1802 dac_config_3 dac_config_5 col_event_rst_bot_right[43] dac_config_4
+ row_on_detect_bot[46] dac_config_0 dac_config_1 row_off_detect_bot[47] x4_net21
+ dac_config_2 vdda1 vssa1 vssc1 col_event_rst_bot_right[42] x4_net22
+ row_on_detect_bot[47] row_off_detect_bot[46] openDVS_pixel2x2_bot
x4_x1803 dac_config_3 dac_config_5 col_event_rst_bot_right[41] dac_config_4
+ row_on_detect_bot[46] dac_config_0 dac_config_1 row_off_detect_bot[47] x4_net23
+ dac_config_2 vdda1 vssa1 vssc1 col_event_rst_bot_right[40] x4_net24
+ row_on_detect_bot[47] row_off_detect_bot[46] openDVS_pixel2x2_bot
x4_x1804 dac_config_3 dac_config_5 col_event_rst_bot_right[39] dac_config_4
+ row_on_detect_bot[46] dac_config_0 dac_config_1 row_off_detect_bot[47] x4_net25
+ dac_config_2 vdda1 vssa1 vssc1 col_event_rst_bot_right[38] x4_net26
+ row_on_detect_bot[47] row_off_detect_bot[46] openDVS_pixel2x2_bot
x4_x1805 dac_config_3 dac_config_5 col_event_rst_bot_right[37] dac_config_4
+ row_on_detect_bot[46] dac_config_0 dac_config_1 row_off_detect_bot[47] x4_net27
+ dac_config_2 vdda1 vssa1 vssc1 col_event_rst_bot_right[36] x4_net28
+ row_on_detect_bot[47] row_off_detect_bot[46] openDVS_pixel2x2_bot
x4_x1806 dac_config_3 dac_config_5 col_event_rst_bot_right[35] dac_config_4
+ row_on_detect_bot[46] dac_config_0 dac_config_1 row_off_detect_bot[47] x4_net29
+ dac_config_2 vdda1 vssa1 vssc1 col_event_rst_bot_right[34] x4_net30
+ row_on_detect_bot[47] row_off_detect_bot[46] openDVS_pixel2x2_bot
x4_x1807 dac_config_3 dac_config_5 col_event_rst_bot_right[33] dac_config_4
+ row_on_detect_bot[46] dac_config_0 dac_config_1 row_off_detect_bot[47] x4_net31
+ dac_config_2 vdda1 vssa1 vssc1 col_event_rst_bot_right[32] x4_net32
+ row_on_detect_bot[47] row_off_detect_bot[46] openDVS_pixel2x2_bot
x4_x1808 dac_config_3 dac_config_5 col_event_rst_bot_right[31] dac_config_4
+ row_on_detect_bot[46] dac_config_0 dac_config_1 row_off_detect_bot[47] x4_net33
+ dac_config_2 vdda1 vssa1 vssc1 col_event_rst_bot_right[30] x4_net34
+ row_on_detect_bot[47] row_off_detect_bot[46] openDVS_pixel2x2_bot
x4_x1809 dac_config_3 dac_config_5 col_event_rst_bot_right[29] dac_config_4
+ row_on_detect_bot[46] dac_config_0 dac_config_1 row_off_detect_bot[47] x4_net35
+ dac_config_2 vdda1 vssa1 vssc1 col_event_rst_bot_right[28] x4_net36
+ row_on_detect_bot[47] row_off_detect_bot[46] openDVS_pixel2x2_bot
x4_x1810 dac_config_3 dac_config_5 col_event_rst_bot_right[27] dac_config_4
+ row_on_detect_bot[46] dac_config_0 dac_config_1 row_off_detect_bot[47] x4_net37
+ dac_config_2 vdda1 vssa1 vssc1 col_event_rst_bot_right[26] x4_net38
+ row_on_detect_bot[47] row_off_detect_bot[46] openDVS_pixel2x2_bot
x4_x1811 dac_config_3 dac_config_5 col_event_rst_bot_right[25] dac_config_4
+ row_on_detect_bot[46] dac_config_0 dac_config_1 row_off_detect_bot[47] x4_net39
+ dac_config_2 vdda1 vssa1 vssc1 col_event_rst_bot_right[24] x4_net40
+ row_on_detect_bot[47] row_off_detect_bot[46] openDVS_pixel2x2_bot
x4_x1812 dac_config_3 dac_config_5 col_event_rst_bot_right[23] dac_config_4
+ row_on_detect_bot[46] dac_config_0 dac_config_1 row_off_detect_bot[47] x4_net41
+ dac_config_2 vdda1 vssa1 vssc1 col_event_rst_bot_right[22] x4_net42
+ row_on_detect_bot[47] row_off_detect_bot[46] openDVS_pixel2x2_bot
x4_x1813 dac_config_3 dac_config_5 col_event_rst_bot_right[21] dac_config_4
+ row_on_detect_bot[46] dac_config_0 dac_config_1 row_off_detect_bot[47] x4_net43
+ dac_config_2 vdda1 vssa1 vssc1 col_event_rst_bot_right[20] x4_net44
+ row_on_detect_bot[47] row_off_detect_bot[46] openDVS_pixel2x2_bot
x4_x1814 dac_config_3 dac_config_5 col_event_rst_bot_right[19] dac_config_4
+ row_on_detect_bot[46] dac_config_0 dac_config_1 row_off_detect_bot[47] x4_net45
+ dac_config_2 vdda1 vssa1 vssc1 col_event_rst_bot_right[18] x4_net46
+ row_on_detect_bot[47] row_off_detect_bot[46] openDVS_pixel2x2_bot
x4_x1815 dac_config_3 dac_config_5 col_event_rst_bot_right[17] dac_config_4
+ row_on_detect_bot[46] dac_config_0 dac_config_1 row_off_detect_bot[47] x4_net47
+ dac_config_2 vdda1 vssa1 vssc1 col_event_rst_bot_right[16] x4_net48
+ row_on_detect_bot[47] row_off_detect_bot[46] openDVS_pixel2x2_bot
x4_x1816 dac_config_3 dac_config_5 col_event_rst_bot_right[15] dac_config_4
+ row_on_detect_bot[46] dac_config_0 dac_config_1 row_off_detect_bot[47] x4_net49
+ dac_config_2 vdda1 vssa1 vssc1 col_event_rst_bot_right[14] x4_net50
+ row_on_detect_bot[47] row_off_detect_bot[46] openDVS_pixel2x2_bot
x4_x1817 dac_config_3 dac_config_5 col_event_rst_bot_right[13] dac_config_4
+ row_on_detect_bot[46] dac_config_0 dac_config_1 row_off_detect_bot[47] x4_net51
+ dac_config_2 vdda1 vssa1 vssc1 col_event_rst_bot_right[12] x4_net52
+ row_on_detect_bot[47] row_off_detect_bot[46] openDVS_pixel2x2_bot
x4_x1818 dac_config_3 dac_config_5 col_event_rst_bot_right[11] dac_config_4
+ row_on_detect_bot[46] dac_config_0 dac_config_1 row_off_detect_bot[47] x4_net53
+ dac_config_2 vdda1 vssa1 vssc1 col_event_rst_bot_right[10] x4_net54
+ row_on_detect_bot[47] row_off_detect_bot[46] openDVS_pixel2x2_bot
x4_x1819 dac_config_3 dac_config_5 col_event_rst_bot_right[9] dac_config_4
+ row_on_detect_bot[46] dac_config_0 dac_config_1 row_off_detect_bot[47] x4_net55
+ dac_config_2 vdda1 vssa1 vssc1 col_event_rst_bot_right[8] x4_net56 row_on_detect_bot[47]
+ row_off_detect_bot[46] openDVS_pixel2x2_bot
x4_x1820 dac_config_3 dac_config_5 col_event_rst_bot_right[7] dac_config_4
+ row_on_detect_bot[46] dac_config_0 dac_config_1 row_off_detect_bot[47] x4_net57
+ dac_config_2 vdda1 vssa1 vssc1 col_event_rst_bot_right[6] x4_net58 row_on_detect_bot[47]
+ row_off_detect_bot[46] openDVS_pixel2x2_bot
x4_x1821 dac_config_3 dac_config_5 col_event_rst_bot_right[5] dac_config_4
+ row_on_detect_bot[46] dac_config_0 dac_config_1 row_off_detect_bot[47] x4_net59
+ dac_config_2 vdda1 vssa1 vssc1 col_event_rst_bot_right[4] x4_net60 row_on_detect_bot[47]
+ row_off_detect_bot[46] openDVS_pixel2x2_bot
x4_x1822 dac_config_3 dac_config_5 col_event_rst_bot_right[3] dac_config_4
+ row_on_detect_bot[46] dac_config_0 dac_config_1 row_off_detect_bot[47] x4_net61
+ dac_config_2 vdda1 vssa1 vssc1 col_event_rst_bot_right[2] x4_net62 row_on_detect_bot[47]
+ row_off_detect_bot[46] openDVS_pixel2x2_bot
x4_x1823 dac_config_3 dac_config_5 col_event_rst_bot_right[1] dac_config_4
+ row_on_detect_bot[46] dac_config_0 dac_config_1 row_off_detect_bot[47] x4_net63
+ dac_config_2 vdda1 vssa1 vssc1 col_event_rst_bot_right[0] x4_net64 row_on_detect_bot[47]
+ row_off_detect_bot[46] openDVS_pixel2x2_bot
x4_x1824 dac_config_3 dac_config_5 col_event_rst_bot_right[63] dac_config_4
+ row_on_detect_bot[48] dac_config_0 dac_config_1 row_off_detect_bot[49] x4_net1
+ dac_config_2 vdda1 vssa1 vssc1 col_event_rst_bot_right[62] x4_net2 row_on_detect_bot[49]
+ row_off_detect_bot[48] openDVS_pixel2x2_bot
x4_x1825 dac_config_3 dac_config_5 col_event_rst_bot_right[61] dac_config_4
+ row_on_detect_bot[48] dac_config_0 dac_config_1 row_off_detect_bot[49] x4_net3
+ dac_config_2 vdda1 vssa1 vssc1 col_event_rst_bot_right[60] x4_net4 row_on_detect_bot[49]
+ row_off_detect_bot[48] openDVS_pixel2x2_bot
x4_x1826 dac_config_3 dac_config_5 col_event_rst_bot_right[59] dac_config_4
+ row_on_detect_bot[48] dac_config_0 dac_config_1 row_off_detect_bot[49] x4_net5
+ dac_config_2 vdda1 vssa1 vssc1 col_event_rst_bot_right[58] x4_net6 row_on_detect_bot[49]
+ row_off_detect_bot[48] openDVS_pixel2x2_bot
x4_x1827 dac_config_3 dac_config_5 col_event_rst_bot_right[57] dac_config_4
+ row_on_detect_bot[48] dac_config_0 dac_config_1 row_off_detect_bot[49] x4_net7
+ dac_config_2 vdda1 vssa1 vssc1 col_event_rst_bot_right[56] x4_net8 row_on_detect_bot[49]
+ row_off_detect_bot[48] openDVS_pixel2x2_bot
x4_x1828 dac_config_3 dac_config_5 col_event_rst_bot_right[55] dac_config_4
+ row_on_detect_bot[48] dac_config_0 dac_config_1 row_off_detect_bot[49] x4_net9
+ dac_config_2 vdda1 vssa1 vssc1 col_event_rst_bot_right[54] x4_net10
+ row_on_detect_bot[49] row_off_detect_bot[48] openDVS_pixel2x2_bot
x4_x1829 dac_config_3 dac_config_5 col_event_rst_bot_right[53] dac_config_4
+ row_on_detect_bot[48] dac_config_0 dac_config_1 row_off_detect_bot[49] x4_net11
+ dac_config_2 vdda1 vssa1 vssc1 col_event_rst_bot_right[52] x4_net12
+ row_on_detect_bot[49] row_off_detect_bot[48] openDVS_pixel2x2_bot
x4_x1830 dac_config_3 dac_config_5 col_event_rst_bot_right[51] dac_config_4
+ row_on_detect_bot[48] dac_config_0 dac_config_1 row_off_detect_bot[49] x4_net13
+ dac_config_2 vdda1 vssa1 vssc1 col_event_rst_bot_right[50] x4_net14
+ row_on_detect_bot[49] row_off_detect_bot[48] openDVS_pixel2x2_bot
x4_x1831 dac_config_3 dac_config_5 col_event_rst_bot_right[49] dac_config_4
+ row_on_detect_bot[48] dac_config_0 dac_config_1 row_off_detect_bot[49] x4_net15
+ dac_config_2 vdda1 vssa1 vssc1 col_event_rst_bot_right[48] x4_net16
+ row_on_detect_bot[49] row_off_detect_bot[48] openDVS_pixel2x2_bot
x4_x1832 dac_config_3 dac_config_5 col_event_rst_bot_right[47] dac_config_4
+ row_on_detect_bot[48] dac_config_0 dac_config_1 row_off_detect_bot[49] x4_net17
+ dac_config_2 vdda1 vssa1 vssc1 col_event_rst_bot_right[46] x4_net18
+ row_on_detect_bot[49] row_off_detect_bot[48] openDVS_pixel2x2_bot
x4_x1833 dac_config_3 dac_config_5 col_event_rst_bot_right[45] dac_config_4
+ row_on_detect_bot[48] dac_config_0 dac_config_1 row_off_detect_bot[49] x4_net19
+ dac_config_2 vdda1 vssa1 vssc1 col_event_rst_bot_right[44] x4_net20
+ row_on_detect_bot[49] row_off_detect_bot[48] openDVS_pixel2x2_bot
x4_x1834 dac_config_3 dac_config_5 col_event_rst_bot_right[43] dac_config_4
+ row_on_detect_bot[48] dac_config_0 dac_config_1 row_off_detect_bot[49] x4_net21
+ dac_config_2 vdda1 vssa1 vssc1 col_event_rst_bot_right[42] x4_net22
+ row_on_detect_bot[49] row_off_detect_bot[48] openDVS_pixel2x2_bot
x4_x1835 dac_config_3 dac_config_5 col_event_rst_bot_right[41] dac_config_4
+ row_on_detect_bot[48] dac_config_0 dac_config_1 row_off_detect_bot[49] x4_net23
+ dac_config_2 vdda1 vssa1 vssc1 col_event_rst_bot_right[40] x4_net24
+ row_on_detect_bot[49] row_off_detect_bot[48] openDVS_pixel2x2_bot
x4_x1836 dac_config_3 dac_config_5 col_event_rst_bot_right[39] dac_config_4
+ row_on_detect_bot[48] dac_config_0 dac_config_1 row_off_detect_bot[49] x4_net25
+ dac_config_2 vdda1 vssa1 vssc1 col_event_rst_bot_right[38] x4_net26
+ row_on_detect_bot[49] row_off_detect_bot[48] openDVS_pixel2x2_bot
x4_x1837 dac_config_3 dac_config_5 col_event_rst_bot_right[37] dac_config_4
+ row_on_detect_bot[48] dac_config_0 dac_config_1 row_off_detect_bot[49] x4_net27
+ dac_config_2 vdda1 vssa1 vssc1 col_event_rst_bot_right[36] x4_net28
+ row_on_detect_bot[49] row_off_detect_bot[48] openDVS_pixel2x2_bot
x4_x1838 dac_config_3 dac_config_5 col_event_rst_bot_right[35] dac_config_4
+ row_on_detect_bot[48] dac_config_0 dac_config_1 row_off_detect_bot[49] x4_net29
+ dac_config_2 vdda1 vssa1 vssc1 col_event_rst_bot_right[34] x4_net30
+ row_on_detect_bot[49] row_off_detect_bot[48] openDVS_pixel2x2_bot
x4_x1839 dac_config_3 dac_config_5 col_event_rst_bot_right[33] dac_config_4
+ row_on_detect_bot[48] dac_config_0 dac_config_1 row_off_detect_bot[49] x4_net31
+ dac_config_2 vdda1 vssa1 vssc1 col_event_rst_bot_right[32] x4_net32
+ row_on_detect_bot[49] row_off_detect_bot[48] openDVS_pixel2x2_bot
x4_x1840 dac_config_3 dac_config_5 col_event_rst_bot_right[31] dac_config_4
+ row_on_detect_bot[48] dac_config_0 dac_config_1 row_off_detect_bot[49] x4_net33
+ dac_config_2 vdda1 vssa1 vssc1 col_event_rst_bot_right[30] x4_net34
+ row_on_detect_bot[49] row_off_detect_bot[48] openDVS_pixel2x2_bot
x4_x1841 dac_config_3 dac_config_5 col_event_rst_bot_right[29] dac_config_4
+ row_on_detect_bot[48] dac_config_0 dac_config_1 row_off_detect_bot[49] x4_net35
+ dac_config_2 vdda1 vssa1 vssc1 col_event_rst_bot_right[28] x4_net36
+ row_on_detect_bot[49] row_off_detect_bot[48] openDVS_pixel2x2_bot
x4_x1842 dac_config_3 dac_config_5 col_event_rst_bot_right[27] dac_config_4
+ row_on_detect_bot[48] dac_config_0 dac_config_1 row_off_detect_bot[49] x4_net37
+ dac_config_2 vdda1 vssa1 vssc1 col_event_rst_bot_right[26] x4_net38
+ row_on_detect_bot[49] row_off_detect_bot[48] openDVS_pixel2x2_bot
x4_x1843 dac_config_3 dac_config_5 col_event_rst_bot_right[25] dac_config_4
+ row_on_detect_bot[48] dac_config_0 dac_config_1 row_off_detect_bot[49] x4_net39
+ dac_config_2 vdda1 vssa1 vssc1 col_event_rst_bot_right[24] x4_net40
+ row_on_detect_bot[49] row_off_detect_bot[48] openDVS_pixel2x2_bot
x4_x1844 dac_config_3 dac_config_5 col_event_rst_bot_right[23] dac_config_4
+ row_on_detect_bot[48] dac_config_0 dac_config_1 row_off_detect_bot[49] x4_net41
+ dac_config_2 vdda1 vssa1 vssc1 col_event_rst_bot_right[22] x4_net42
+ row_on_detect_bot[49] row_off_detect_bot[48] openDVS_pixel2x2_bot
x4_x1845 dac_config_3 dac_config_5 col_event_rst_bot_right[21] dac_config_4
+ row_on_detect_bot[48] dac_config_0 dac_config_1 row_off_detect_bot[49] x4_net43
+ dac_config_2 vdda1 vssa1 vssc1 col_event_rst_bot_right[20] x4_net44
+ row_on_detect_bot[49] row_off_detect_bot[48] openDVS_pixel2x2_bot
x4_x1846 dac_config_3 dac_config_5 col_event_rst_bot_right[19] dac_config_4
+ row_on_detect_bot[48] dac_config_0 dac_config_1 row_off_detect_bot[49] x4_net45
+ dac_config_2 vdda1 vssa1 vssc1 col_event_rst_bot_right[18] x4_net46
+ row_on_detect_bot[49] row_off_detect_bot[48] openDVS_pixel2x2_bot
x4_x1847 dac_config_3 dac_config_5 col_event_rst_bot_right[17] dac_config_4
+ row_on_detect_bot[48] dac_config_0 dac_config_1 row_off_detect_bot[49] x4_net47
+ dac_config_2 vdda1 vssa1 vssc1 col_event_rst_bot_right[16] x4_net48
+ row_on_detect_bot[49] row_off_detect_bot[48] openDVS_pixel2x2_bot
x4_x1848 dac_config_3 dac_config_5 col_event_rst_bot_right[15] dac_config_4
+ row_on_detect_bot[48] dac_config_0 dac_config_1 row_off_detect_bot[49] x4_net49
+ dac_config_2 vdda1 vssa1 vssc1 col_event_rst_bot_right[14] x4_net50
+ row_on_detect_bot[49] row_off_detect_bot[48] openDVS_pixel2x2_bot
x4_x1849 dac_config_3 dac_config_5 col_event_rst_bot_right[13] dac_config_4
+ row_on_detect_bot[48] dac_config_0 dac_config_1 row_off_detect_bot[49] x4_net51
+ dac_config_2 vdda1 vssa1 vssc1 col_event_rst_bot_right[12] x4_net52
+ row_on_detect_bot[49] row_off_detect_bot[48] openDVS_pixel2x2_bot
x4_x1850 dac_config_3 dac_config_5 col_event_rst_bot_right[11] dac_config_4
+ row_on_detect_bot[48] dac_config_0 dac_config_1 row_off_detect_bot[49] x4_net53
+ dac_config_2 vdda1 vssa1 vssc1 col_event_rst_bot_right[10] x4_net54
+ row_on_detect_bot[49] row_off_detect_bot[48] openDVS_pixel2x2_bot
x4_x1851 dac_config_3 dac_config_5 col_event_rst_bot_right[9] dac_config_4
+ row_on_detect_bot[48] dac_config_0 dac_config_1 row_off_detect_bot[49] x4_net55
+ dac_config_2 vdda1 vssa1 vssc1 col_event_rst_bot_right[8] x4_net56 row_on_detect_bot[49]
+ row_off_detect_bot[48] openDVS_pixel2x2_bot
x4_x1852 dac_config_3 dac_config_5 col_event_rst_bot_right[7] dac_config_4
+ row_on_detect_bot[48] dac_config_0 dac_config_1 row_off_detect_bot[49] x4_net57
+ dac_config_2 vdda1 vssa1 vssc1 col_event_rst_bot_right[6] x4_net58 row_on_detect_bot[49]
+ row_off_detect_bot[48] openDVS_pixel2x2_bot
x4_x1853 dac_config_3 dac_config_5 col_event_rst_bot_right[5] dac_config_4
+ row_on_detect_bot[48] dac_config_0 dac_config_1 row_off_detect_bot[49] x4_net59
+ dac_config_2 vdda1 vssa1 vssc1 col_event_rst_bot_right[4] x4_net60 row_on_detect_bot[49]
+ row_off_detect_bot[48] openDVS_pixel2x2_bot
x4_x1854 dac_config_3 dac_config_5 col_event_rst_bot_right[3] dac_config_4
+ row_on_detect_bot[48] dac_config_0 dac_config_1 row_off_detect_bot[49] x4_net61
+ dac_config_2 vdda1 vssa1 vssc1 col_event_rst_bot_right[2] x4_net62 row_on_detect_bot[49]
+ row_off_detect_bot[48] openDVS_pixel2x2_bot
x4_x1855 dac_config_3 dac_config_5 col_event_rst_bot_right[1] dac_config_4
+ row_on_detect_bot[48] dac_config_0 dac_config_1 row_off_detect_bot[49] x4_net63
+ dac_config_2 vdda1 vssa1 vssc1 col_event_rst_bot_right[0] x4_net64 row_on_detect_bot[49]
+ row_off_detect_bot[48] openDVS_pixel2x2_bot
x4_x1856 dac_config_3 dac_config_5 col_event_rst_bot_right[63] dac_config_4
+ row_on_detect_bot[50] dac_config_0 dac_config_1 row_off_detect_bot[51] x4_net1
+ dac_config_2 vdda1 vssa1 vssc1 col_event_rst_bot_right[62] x4_net2 row_on_detect_bot[51]
+ row_off_detect_bot[50] openDVS_pixel2x2_bot
x4_x1857 dac_config_3 dac_config_5 col_event_rst_bot_right[61] dac_config_4
+ row_on_detect_bot[50] dac_config_0 dac_config_1 row_off_detect_bot[51] x4_net3
+ dac_config_2 vdda1 vssa1 vssc1 col_event_rst_bot_right[60] x4_net4 row_on_detect_bot[51]
+ row_off_detect_bot[50] openDVS_pixel2x2_bot
x4_x1858 dac_config_3 dac_config_5 col_event_rst_bot_right[59] dac_config_4
+ row_on_detect_bot[50] dac_config_0 dac_config_1 row_off_detect_bot[51] x4_net5
+ dac_config_2 vdda1 vssa1 vssc1 col_event_rst_bot_right[58] x4_net6 row_on_detect_bot[51]
+ row_off_detect_bot[50] openDVS_pixel2x2_bot
x4_x1859 dac_config_3 dac_config_5 col_event_rst_bot_right[57] dac_config_4
+ row_on_detect_bot[50] dac_config_0 dac_config_1 row_off_detect_bot[51] x4_net7
+ dac_config_2 vdda1 vssa1 vssc1 col_event_rst_bot_right[56] x4_net8 row_on_detect_bot[51]
+ row_off_detect_bot[50] openDVS_pixel2x2_bot
x4_x1860 dac_config_3 dac_config_5 col_event_rst_bot_right[55] dac_config_4
+ row_on_detect_bot[50] dac_config_0 dac_config_1 row_off_detect_bot[51] x4_net9
+ dac_config_2 vdda1 vssa1 vssc1 col_event_rst_bot_right[54] x4_net10
+ row_on_detect_bot[51] row_off_detect_bot[50] openDVS_pixel2x2_bot
x4_x1861 dac_config_3 dac_config_5 col_event_rst_bot_right[53] dac_config_4
+ row_on_detect_bot[50] dac_config_0 dac_config_1 row_off_detect_bot[51] x4_net11
+ dac_config_2 vdda1 vssa1 vssc1 col_event_rst_bot_right[52] x4_net12
+ row_on_detect_bot[51] row_off_detect_bot[50] openDVS_pixel2x2_bot
x4_x1862 dac_config_3 dac_config_5 col_event_rst_bot_right[51] dac_config_4
+ row_on_detect_bot[50] dac_config_0 dac_config_1 row_off_detect_bot[51] x4_net13
+ dac_config_2 vdda1 vssa1 vssc1 col_event_rst_bot_right[50] x4_net14
+ row_on_detect_bot[51] row_off_detect_bot[50] openDVS_pixel2x2_bot
x4_x1863 dac_config_3 dac_config_5 col_event_rst_bot_right[49] dac_config_4
+ row_on_detect_bot[50] dac_config_0 dac_config_1 row_off_detect_bot[51] x4_net15
+ dac_config_2 vdda1 vssa1 vssc1 col_event_rst_bot_right[48] x4_net16
+ row_on_detect_bot[51] row_off_detect_bot[50] openDVS_pixel2x2_bot
x4_x1864 dac_config_3 dac_config_5 col_event_rst_bot_right[47] dac_config_4
+ row_on_detect_bot[50] dac_config_0 dac_config_1 row_off_detect_bot[51] x4_net17
+ dac_config_2 vdda1 vssa1 vssc1 col_event_rst_bot_right[46] x4_net18
+ row_on_detect_bot[51] row_off_detect_bot[50] openDVS_pixel2x2_bot
x4_x1865 dac_config_3 dac_config_5 col_event_rst_bot_right[45] dac_config_4
+ row_on_detect_bot[50] dac_config_0 dac_config_1 row_off_detect_bot[51] x4_net19
+ dac_config_2 vdda1 vssa1 vssc1 col_event_rst_bot_right[44] x4_net20
+ row_on_detect_bot[51] row_off_detect_bot[50] openDVS_pixel2x2_bot
x4_x1866 dac_config_3 dac_config_5 col_event_rst_bot_right[43] dac_config_4
+ row_on_detect_bot[50] dac_config_0 dac_config_1 row_off_detect_bot[51] x4_net21
+ dac_config_2 vdda1 vssa1 vssc1 col_event_rst_bot_right[42] x4_net22
+ row_on_detect_bot[51] row_off_detect_bot[50] openDVS_pixel2x2_bot
x4_x1867 dac_config_3 dac_config_5 col_event_rst_bot_right[41] dac_config_4
+ row_on_detect_bot[50] dac_config_0 dac_config_1 row_off_detect_bot[51] x4_net23
+ dac_config_2 vdda1 vssa1 vssc1 col_event_rst_bot_right[40] x4_net24
+ row_on_detect_bot[51] row_off_detect_bot[50] openDVS_pixel2x2_bot
x4_x1868 dac_config_3 dac_config_5 col_event_rst_bot_right[39] dac_config_4
+ row_on_detect_bot[50] dac_config_0 dac_config_1 row_off_detect_bot[51] x4_net25
+ dac_config_2 vdda1 vssa1 vssc1 col_event_rst_bot_right[38] x4_net26
+ row_on_detect_bot[51] row_off_detect_bot[50] openDVS_pixel2x2_bot
x4_x1869 dac_config_3 dac_config_5 col_event_rst_bot_right[37] dac_config_4
+ row_on_detect_bot[50] dac_config_0 dac_config_1 row_off_detect_bot[51] x4_net27
+ dac_config_2 vdda1 vssa1 vssc1 col_event_rst_bot_right[36] x4_net28
+ row_on_detect_bot[51] row_off_detect_bot[50] openDVS_pixel2x2_bot
x4_x1870 dac_config_3 dac_config_5 col_event_rst_bot_right[35] dac_config_4
+ row_on_detect_bot[50] dac_config_0 dac_config_1 row_off_detect_bot[51] x4_net29
+ dac_config_2 vdda1 vssa1 vssc1 col_event_rst_bot_right[34] x4_net30
+ row_on_detect_bot[51] row_off_detect_bot[50] openDVS_pixel2x2_bot
x4_x1871 dac_config_3 dac_config_5 col_event_rst_bot_right[33] dac_config_4
+ row_on_detect_bot[50] dac_config_0 dac_config_1 row_off_detect_bot[51] x4_net31
+ dac_config_2 vdda1 vssa1 vssc1 col_event_rst_bot_right[32] x4_net32
+ row_on_detect_bot[51] row_off_detect_bot[50] openDVS_pixel2x2_bot
x4_x1872 dac_config_3 dac_config_5 col_event_rst_bot_right[31] dac_config_4
+ row_on_detect_bot[50] dac_config_0 dac_config_1 row_off_detect_bot[51] x4_net33
+ dac_config_2 vdda1 vssa1 vssc1 col_event_rst_bot_right[30] x4_net34
+ row_on_detect_bot[51] row_off_detect_bot[50] openDVS_pixel2x2_bot
x4_x1873 dac_config_3 dac_config_5 col_event_rst_bot_right[29] dac_config_4
+ row_on_detect_bot[50] dac_config_0 dac_config_1 row_off_detect_bot[51] x4_net35
+ dac_config_2 vdda1 vssa1 vssc1 col_event_rst_bot_right[28] x4_net36
+ row_on_detect_bot[51] row_off_detect_bot[50] openDVS_pixel2x2_bot
x4_x1874 dac_config_3 dac_config_5 col_event_rst_bot_right[27] dac_config_4
+ row_on_detect_bot[50] dac_config_0 dac_config_1 row_off_detect_bot[51] x4_net37
+ dac_config_2 vdda1 vssa1 vssc1 col_event_rst_bot_right[26] x4_net38
+ row_on_detect_bot[51] row_off_detect_bot[50] openDVS_pixel2x2_bot
x4_x1875 dac_config_3 dac_config_5 col_event_rst_bot_right[25] dac_config_4
+ row_on_detect_bot[50] dac_config_0 dac_config_1 row_off_detect_bot[51] x4_net39
+ dac_config_2 vdda1 vssa1 vssc1 col_event_rst_bot_right[24] x4_net40
+ row_on_detect_bot[51] row_off_detect_bot[50] openDVS_pixel2x2_bot
x4_x1876 dac_config_3 dac_config_5 col_event_rst_bot_right[23] dac_config_4
+ row_on_detect_bot[50] dac_config_0 dac_config_1 row_off_detect_bot[51] x4_net41
+ dac_config_2 vdda1 vssa1 vssc1 col_event_rst_bot_right[22] x4_net42
+ row_on_detect_bot[51] row_off_detect_bot[50] openDVS_pixel2x2_bot
x4_x1877 dac_config_3 dac_config_5 col_event_rst_bot_right[21] dac_config_4
+ row_on_detect_bot[50] dac_config_0 dac_config_1 row_off_detect_bot[51] x4_net43
+ dac_config_2 vdda1 vssa1 vssc1 col_event_rst_bot_right[20] x4_net44
+ row_on_detect_bot[51] row_off_detect_bot[50] openDVS_pixel2x2_bot
x4_x1878 dac_config_3 dac_config_5 col_event_rst_bot_right[19] dac_config_4
+ row_on_detect_bot[50] dac_config_0 dac_config_1 row_off_detect_bot[51] x4_net45
+ dac_config_2 vdda1 vssa1 vssc1 col_event_rst_bot_right[18] x4_net46
+ row_on_detect_bot[51] row_off_detect_bot[50] openDVS_pixel2x2_bot
x4_x1879 dac_config_3 dac_config_5 col_event_rst_bot_right[17] dac_config_4
+ row_on_detect_bot[50] dac_config_0 dac_config_1 row_off_detect_bot[51] x4_net47
+ dac_config_2 vdda1 vssa1 vssc1 col_event_rst_bot_right[16] x4_net48
+ row_on_detect_bot[51] row_off_detect_bot[50] openDVS_pixel2x2_bot
x4_x1880 dac_config_3 dac_config_5 col_event_rst_bot_right[15] dac_config_4
+ row_on_detect_bot[50] dac_config_0 dac_config_1 row_off_detect_bot[51] x4_net49
+ dac_config_2 vdda1 vssa1 vssc1 col_event_rst_bot_right[14] x4_net50
+ row_on_detect_bot[51] row_off_detect_bot[50] openDVS_pixel2x2_bot
x4_x1881 dac_config_3 dac_config_5 col_event_rst_bot_right[13] dac_config_4
+ row_on_detect_bot[50] dac_config_0 dac_config_1 row_off_detect_bot[51] x4_net51
+ dac_config_2 vdda1 vssa1 vssc1 col_event_rst_bot_right[12] x4_net52
+ row_on_detect_bot[51] row_off_detect_bot[50] openDVS_pixel2x2_bot
x4_x1882 dac_config_3 dac_config_5 col_event_rst_bot_right[11] dac_config_4
+ row_on_detect_bot[50] dac_config_0 dac_config_1 row_off_detect_bot[51] x4_net53
+ dac_config_2 vdda1 vssa1 vssc1 col_event_rst_bot_right[10] x4_net54
+ row_on_detect_bot[51] row_off_detect_bot[50] openDVS_pixel2x2_bot
x4_x1883 dac_config_3 dac_config_5 col_event_rst_bot_right[9] dac_config_4
+ row_on_detect_bot[50] dac_config_0 dac_config_1 row_off_detect_bot[51] x4_net55
+ dac_config_2 vdda1 vssa1 vssc1 col_event_rst_bot_right[8] x4_net56 row_on_detect_bot[51]
+ row_off_detect_bot[50] openDVS_pixel2x2_bot
x4_x1884 dac_config_3 dac_config_5 col_event_rst_bot_right[7] dac_config_4
+ row_on_detect_bot[50] dac_config_0 dac_config_1 row_off_detect_bot[51] x4_net57
+ dac_config_2 vdda1 vssa1 vssc1 col_event_rst_bot_right[6] x4_net58 row_on_detect_bot[51]
+ row_off_detect_bot[50] openDVS_pixel2x2_bot
x4_x1885 dac_config_3 dac_config_5 col_event_rst_bot_right[5] dac_config_4
+ row_on_detect_bot[50] dac_config_0 dac_config_1 row_off_detect_bot[51] x4_net59
+ dac_config_2 vdda1 vssa1 vssc1 col_event_rst_bot_right[4] x4_net60 row_on_detect_bot[51]
+ row_off_detect_bot[50] openDVS_pixel2x2_bot
x4_x1886 dac_config_3 dac_config_5 col_event_rst_bot_right[3] dac_config_4
+ row_on_detect_bot[50] dac_config_0 dac_config_1 row_off_detect_bot[51] x4_net61
+ dac_config_2 vdda1 vssa1 vssc1 col_event_rst_bot_right[2] x4_net62 row_on_detect_bot[51]
+ row_off_detect_bot[50] openDVS_pixel2x2_bot
x4_x1887 dac_config_3 dac_config_5 col_event_rst_bot_right[1] dac_config_4
+ row_on_detect_bot[50] dac_config_0 dac_config_1 row_off_detect_bot[51] x4_net63
+ dac_config_2 vdda1 vssa1 vssc1 col_event_rst_bot_right[0] x4_net64 row_on_detect_bot[51]
+ row_off_detect_bot[50] openDVS_pixel2x2_bot
x4_x1888 dac_config_3 dac_config_5 col_event_rst_bot_right[63] dac_config_4
+ row_on_detect_bot[52] dac_config_0 dac_config_1 row_off_detect_bot[53] x4_net1
+ dac_config_2 vdda1 vssa1 vssc1 col_event_rst_bot_right[62] x4_net2 row_on_detect_bot[53]
+ row_off_detect_bot[52] openDVS_pixel2x2_bot
x4_x1889 dac_config_3 dac_config_5 col_event_rst_bot_right[61] dac_config_4
+ row_on_detect_bot[52] dac_config_0 dac_config_1 row_off_detect_bot[53] x4_net3
+ dac_config_2 vdda1 vssa1 vssc1 col_event_rst_bot_right[60] x4_net4 row_on_detect_bot[53]
+ row_off_detect_bot[52] openDVS_pixel2x2_bot
x4_x1890 dac_config_3 dac_config_5 col_event_rst_bot_right[59] dac_config_4
+ row_on_detect_bot[52] dac_config_0 dac_config_1 row_off_detect_bot[53] x4_net5
+ dac_config_2 vdda1 vssa1 vssc1 col_event_rst_bot_right[58] x4_net6 row_on_detect_bot[53]
+ row_off_detect_bot[52] openDVS_pixel2x2_bot
x4_x1891 dac_config_3 dac_config_5 col_event_rst_bot_right[57] dac_config_4
+ row_on_detect_bot[52] dac_config_0 dac_config_1 row_off_detect_bot[53] x4_net7
+ dac_config_2 vdda1 vssa1 vssc1 col_event_rst_bot_right[56] x4_net8 row_on_detect_bot[53]
+ row_off_detect_bot[52] openDVS_pixel2x2_bot
x4_x1892 dac_config_3 dac_config_5 col_event_rst_bot_right[55] dac_config_4
+ row_on_detect_bot[52] dac_config_0 dac_config_1 row_off_detect_bot[53] x4_net9
+ dac_config_2 vdda1 vssa1 vssc1 col_event_rst_bot_right[54] x4_net10
+ row_on_detect_bot[53] row_off_detect_bot[52] openDVS_pixel2x2_bot
x4_x1893 dac_config_3 dac_config_5 col_event_rst_bot_right[53] dac_config_4
+ row_on_detect_bot[52] dac_config_0 dac_config_1 row_off_detect_bot[53] x4_net11
+ dac_config_2 vdda1 vssa1 vssc1 col_event_rst_bot_right[52] x4_net12
+ row_on_detect_bot[53] row_off_detect_bot[52] openDVS_pixel2x2_bot
x4_x1894 dac_config_3 dac_config_5 col_event_rst_bot_right[51] dac_config_4
+ row_on_detect_bot[52] dac_config_0 dac_config_1 row_off_detect_bot[53] x4_net13
+ dac_config_2 vdda1 vssa1 vssc1 col_event_rst_bot_right[50] x4_net14
+ row_on_detect_bot[53] row_off_detect_bot[52] openDVS_pixel2x2_bot
x4_x1895 dac_config_3 dac_config_5 col_event_rst_bot_right[49] dac_config_4
+ row_on_detect_bot[52] dac_config_0 dac_config_1 row_off_detect_bot[53] x4_net15
+ dac_config_2 vdda1 vssa1 vssc1 col_event_rst_bot_right[48] x4_net16
+ row_on_detect_bot[53] row_off_detect_bot[52] openDVS_pixel2x2_bot
x4_x1896 dac_config_3 dac_config_5 col_event_rst_bot_right[47] dac_config_4
+ row_on_detect_bot[52] dac_config_0 dac_config_1 row_off_detect_bot[53] x4_net17
+ dac_config_2 vdda1 vssa1 vssc1 col_event_rst_bot_right[46] x4_net18
+ row_on_detect_bot[53] row_off_detect_bot[52] openDVS_pixel2x2_bot
x4_x1897 dac_config_3 dac_config_5 col_event_rst_bot_right[45] dac_config_4
+ row_on_detect_bot[52] dac_config_0 dac_config_1 row_off_detect_bot[53] x4_net19
+ dac_config_2 vdda1 vssa1 vssc1 col_event_rst_bot_right[44] x4_net20
+ row_on_detect_bot[53] row_off_detect_bot[52] openDVS_pixel2x2_bot
x4_x1898 dac_config_3 dac_config_5 col_event_rst_bot_right[43] dac_config_4
+ row_on_detect_bot[52] dac_config_0 dac_config_1 row_off_detect_bot[53] x4_net21
+ dac_config_2 vdda1 vssa1 vssc1 col_event_rst_bot_right[42] x4_net22
+ row_on_detect_bot[53] row_off_detect_bot[52] openDVS_pixel2x2_bot
x4_x1899 dac_config_3 dac_config_5 col_event_rst_bot_right[41] dac_config_4
+ row_on_detect_bot[52] dac_config_0 dac_config_1 row_off_detect_bot[53] x4_net23
+ dac_config_2 vdda1 vssa1 vssc1 col_event_rst_bot_right[40] x4_net24
+ row_on_detect_bot[53] row_off_detect_bot[52] openDVS_pixel2x2_bot
x4_x1900 dac_config_3 dac_config_5 col_event_rst_bot_right[39] dac_config_4
+ row_on_detect_bot[52] dac_config_0 dac_config_1 row_off_detect_bot[53] x4_net25
+ dac_config_2 vdda1 vssa1 vssc1 col_event_rst_bot_right[38] x4_net26
+ row_on_detect_bot[53] row_off_detect_bot[52] openDVS_pixel2x2_bot
x4_x1901 dac_config_3 dac_config_5 col_event_rst_bot_right[37] dac_config_4
+ row_on_detect_bot[52] dac_config_0 dac_config_1 row_off_detect_bot[53] x4_net27
+ dac_config_2 vdda1 vssa1 vssc1 col_event_rst_bot_right[36] x4_net28
+ row_on_detect_bot[53] row_off_detect_bot[52] openDVS_pixel2x2_bot
x4_x1902 dac_config_3 dac_config_5 col_event_rst_bot_right[35] dac_config_4
+ row_on_detect_bot[52] dac_config_0 dac_config_1 row_off_detect_bot[53] x4_net29
+ dac_config_2 vdda1 vssa1 vssc1 col_event_rst_bot_right[34] x4_net30
+ row_on_detect_bot[53] row_off_detect_bot[52] openDVS_pixel2x2_bot
x4_x1903 dac_config_3 dac_config_5 col_event_rst_bot_right[33] dac_config_4
+ row_on_detect_bot[52] dac_config_0 dac_config_1 row_off_detect_bot[53] x4_net31
+ dac_config_2 vdda1 vssa1 vssc1 col_event_rst_bot_right[32] x4_net32
+ row_on_detect_bot[53] row_off_detect_bot[52] openDVS_pixel2x2_bot
x4_x1904 dac_config_3 dac_config_5 col_event_rst_bot_right[31] dac_config_4
+ row_on_detect_bot[52] dac_config_0 dac_config_1 row_off_detect_bot[53] x4_net33
+ dac_config_2 vdda1 vssa1 vssc1 col_event_rst_bot_right[30] x4_net34
+ row_on_detect_bot[53] row_off_detect_bot[52] openDVS_pixel2x2_bot
x4_x1905 dac_config_3 dac_config_5 col_event_rst_bot_right[29] dac_config_4
+ row_on_detect_bot[52] dac_config_0 dac_config_1 row_off_detect_bot[53] x4_net35
+ dac_config_2 vdda1 vssa1 vssc1 col_event_rst_bot_right[28] x4_net36
+ row_on_detect_bot[53] row_off_detect_bot[52] openDVS_pixel2x2_bot
x4_x1906 dac_config_3 dac_config_5 col_event_rst_bot_right[27] dac_config_4
+ row_on_detect_bot[52] dac_config_0 dac_config_1 row_off_detect_bot[53] x4_net37
+ dac_config_2 vdda1 vssa1 vssc1 col_event_rst_bot_right[26] x4_net38
+ row_on_detect_bot[53] row_off_detect_bot[52] openDVS_pixel2x2_bot
x4_x1907 dac_config_3 dac_config_5 col_event_rst_bot_right[25] dac_config_4
+ row_on_detect_bot[52] dac_config_0 dac_config_1 row_off_detect_bot[53] x4_net39
+ dac_config_2 vdda1 vssa1 vssc1 col_event_rst_bot_right[24] x4_net40
+ row_on_detect_bot[53] row_off_detect_bot[52] openDVS_pixel2x2_bot
x4_x1908 dac_config_3 dac_config_5 col_event_rst_bot_right[23] dac_config_4
+ row_on_detect_bot[52] dac_config_0 dac_config_1 row_off_detect_bot[53] x4_net41
+ dac_config_2 vdda1 vssa1 vssc1 col_event_rst_bot_right[22] x4_net42
+ row_on_detect_bot[53] row_off_detect_bot[52] openDVS_pixel2x2_bot
x4_x1909 dac_config_3 dac_config_5 col_event_rst_bot_right[21] dac_config_4
+ row_on_detect_bot[52] dac_config_0 dac_config_1 row_off_detect_bot[53] x4_net43
+ dac_config_2 vdda1 vssa1 vssc1 col_event_rst_bot_right[20] x4_net44
+ row_on_detect_bot[53] row_off_detect_bot[52] openDVS_pixel2x2_bot
x4_x1910 dac_config_3 dac_config_5 col_event_rst_bot_right[19] dac_config_4
+ row_on_detect_bot[52] dac_config_0 dac_config_1 row_off_detect_bot[53] x4_net45
+ dac_config_2 vdda1 vssa1 vssc1 col_event_rst_bot_right[18] x4_net46
+ row_on_detect_bot[53] row_off_detect_bot[52] openDVS_pixel2x2_bot
x4_x1911 dac_config_3 dac_config_5 col_event_rst_bot_right[17] dac_config_4
+ row_on_detect_bot[52] dac_config_0 dac_config_1 row_off_detect_bot[53] x4_net47
+ dac_config_2 vdda1 vssa1 vssc1 col_event_rst_bot_right[16] x4_net48
+ row_on_detect_bot[53] row_off_detect_bot[52] openDVS_pixel2x2_bot
x4_x1912 dac_config_3 dac_config_5 col_event_rst_bot_right[15] dac_config_4
+ row_on_detect_bot[52] dac_config_0 dac_config_1 row_off_detect_bot[53] x4_net49
+ dac_config_2 vdda1 vssa1 vssc1 col_event_rst_bot_right[14] x4_net50
+ row_on_detect_bot[53] row_off_detect_bot[52] openDVS_pixel2x2_bot
x4_x1913 dac_config_3 dac_config_5 col_event_rst_bot_right[13] dac_config_4
+ row_on_detect_bot[52] dac_config_0 dac_config_1 row_off_detect_bot[53] x4_net51
+ dac_config_2 vdda1 vssa1 vssc1 col_event_rst_bot_right[12] x4_net52
+ row_on_detect_bot[53] row_off_detect_bot[52] openDVS_pixel2x2_bot
x4_x1914 dac_config_3 dac_config_5 col_event_rst_bot_right[11] dac_config_4
+ row_on_detect_bot[52] dac_config_0 dac_config_1 row_off_detect_bot[53] x4_net53
+ dac_config_2 vdda1 vssa1 vssc1 col_event_rst_bot_right[10] x4_net54
+ row_on_detect_bot[53] row_off_detect_bot[52] openDVS_pixel2x2_bot
x4_x1915 dac_config_3 dac_config_5 col_event_rst_bot_right[9] dac_config_4
+ row_on_detect_bot[52] dac_config_0 dac_config_1 row_off_detect_bot[53] x4_net55
+ dac_config_2 vdda1 vssa1 vssc1 col_event_rst_bot_right[8] x4_net56 row_on_detect_bot[53]
+ row_off_detect_bot[52] openDVS_pixel2x2_bot
x4_x1916 dac_config_3 dac_config_5 col_event_rst_bot_right[7] dac_config_4
+ row_on_detect_bot[52] dac_config_0 dac_config_1 row_off_detect_bot[53] x4_net57
+ dac_config_2 vdda1 vssa1 vssc1 col_event_rst_bot_right[6] x4_net58 row_on_detect_bot[53]
+ row_off_detect_bot[52] openDVS_pixel2x2_bot
x4_x1917 dac_config_3 dac_config_5 col_event_rst_bot_right[5] dac_config_4
+ row_on_detect_bot[52] dac_config_0 dac_config_1 row_off_detect_bot[53] x4_net59
+ dac_config_2 vdda1 vssa1 vssc1 col_event_rst_bot_right[4] x4_net60 row_on_detect_bot[53]
+ row_off_detect_bot[52] openDVS_pixel2x2_bot
x4_x1918 dac_config_3 dac_config_5 col_event_rst_bot_right[3] dac_config_4
+ row_on_detect_bot[52] dac_config_0 dac_config_1 row_off_detect_bot[53] x4_net61
+ dac_config_2 vdda1 vssa1 vssc1 col_event_rst_bot_right[2] x4_net62 row_on_detect_bot[53]
+ row_off_detect_bot[52] openDVS_pixel2x2_bot
x4_x1919 dac_config_3 dac_config_5 col_event_rst_bot_right[1] dac_config_4
+ row_on_detect_bot[52] dac_config_0 dac_config_1 row_off_detect_bot[53] x4_net63
+ dac_config_2 vdda1 vssa1 vssc1 col_event_rst_bot_right[0] x4_net64 row_on_detect_bot[53]
+ row_off_detect_bot[52] openDVS_pixel2x2_bot
x4_x1920 dac_config_3 dac_config_5 col_event_rst_bot_right[63] dac_config_4
+ row_on_detect_bot[54] dac_config_0 dac_config_1 row_off_detect_bot[55] x4_net1
+ dac_config_2 vdda1 vssa1 vssc1 col_event_rst_bot_right[62] x4_net2 row_on_detect_bot[55]
+ row_off_detect_bot[54] openDVS_pixel2x2_bot
x4_x1921 dac_config_3 dac_config_5 col_event_rst_bot_right[61] dac_config_4
+ row_on_detect_bot[54] dac_config_0 dac_config_1 row_off_detect_bot[55] x4_net3
+ dac_config_2 vdda1 vssa1 vssc1 col_event_rst_bot_right[60] x4_net4 row_on_detect_bot[55]
+ row_off_detect_bot[54] openDVS_pixel2x2_bot
x4_x1922 dac_config_3 dac_config_5 col_event_rst_bot_right[59] dac_config_4
+ row_on_detect_bot[54] dac_config_0 dac_config_1 row_off_detect_bot[55] x4_net5
+ dac_config_2 vdda1 vssa1 vssc1 col_event_rst_bot_right[58] x4_net6 row_on_detect_bot[55]
+ row_off_detect_bot[54] openDVS_pixel2x2_bot
x4_x1923 dac_config_3 dac_config_5 col_event_rst_bot_right[57] dac_config_4
+ row_on_detect_bot[54] dac_config_0 dac_config_1 row_off_detect_bot[55] x4_net7
+ dac_config_2 vdda1 vssa1 vssc1 col_event_rst_bot_right[56] x4_net8 row_on_detect_bot[55]
+ row_off_detect_bot[54] openDVS_pixel2x2_bot
x4_x1924 dac_config_3 dac_config_5 col_event_rst_bot_right[55] dac_config_4
+ row_on_detect_bot[54] dac_config_0 dac_config_1 row_off_detect_bot[55] x4_net9
+ dac_config_2 vdda1 vssa1 vssc1 col_event_rst_bot_right[54] x4_net10
+ row_on_detect_bot[55] row_off_detect_bot[54] openDVS_pixel2x2_bot
x4_x1925 dac_config_3 dac_config_5 col_event_rst_bot_right[53] dac_config_4
+ row_on_detect_bot[54] dac_config_0 dac_config_1 row_off_detect_bot[55] x4_net11
+ dac_config_2 vdda1 vssa1 vssc1 col_event_rst_bot_right[52] x4_net12
+ row_on_detect_bot[55] row_off_detect_bot[54] openDVS_pixel2x2_bot
x4_x1926 dac_config_3 dac_config_5 col_event_rst_bot_right[51] dac_config_4
+ row_on_detect_bot[54] dac_config_0 dac_config_1 row_off_detect_bot[55] x4_net13
+ dac_config_2 vdda1 vssa1 vssc1 col_event_rst_bot_right[50] x4_net14
+ row_on_detect_bot[55] row_off_detect_bot[54] openDVS_pixel2x2_bot
x4_x1927 dac_config_3 dac_config_5 col_event_rst_bot_right[49] dac_config_4
+ row_on_detect_bot[54] dac_config_0 dac_config_1 row_off_detect_bot[55] x4_net15
+ dac_config_2 vdda1 vssa1 vssc1 col_event_rst_bot_right[48] x4_net16
+ row_on_detect_bot[55] row_off_detect_bot[54] openDVS_pixel2x2_bot
x4_x1928 dac_config_3 dac_config_5 col_event_rst_bot_right[47] dac_config_4
+ row_on_detect_bot[54] dac_config_0 dac_config_1 row_off_detect_bot[55] x4_net17
+ dac_config_2 vdda1 vssa1 vssc1 col_event_rst_bot_right[46] x4_net18
+ row_on_detect_bot[55] row_off_detect_bot[54] openDVS_pixel2x2_bot
x4_x1929 dac_config_3 dac_config_5 col_event_rst_bot_right[45] dac_config_4
+ row_on_detect_bot[54] dac_config_0 dac_config_1 row_off_detect_bot[55] x4_net19
+ dac_config_2 vdda1 vssa1 vssc1 col_event_rst_bot_right[44] x4_net20
+ row_on_detect_bot[55] row_off_detect_bot[54] openDVS_pixel2x2_bot
x4_x1930 dac_config_3 dac_config_5 col_event_rst_bot_right[43] dac_config_4
+ row_on_detect_bot[54] dac_config_0 dac_config_1 row_off_detect_bot[55] x4_net21
+ dac_config_2 vdda1 vssa1 vssc1 col_event_rst_bot_right[42] x4_net22
+ row_on_detect_bot[55] row_off_detect_bot[54] openDVS_pixel2x2_bot
x4_x1931 dac_config_3 dac_config_5 col_event_rst_bot_right[41] dac_config_4
+ row_on_detect_bot[54] dac_config_0 dac_config_1 row_off_detect_bot[55] x4_net23
+ dac_config_2 vdda1 vssa1 vssc1 col_event_rst_bot_right[40] x4_net24
+ row_on_detect_bot[55] row_off_detect_bot[54] openDVS_pixel2x2_bot
x4_x1932 dac_config_3 dac_config_5 col_event_rst_bot_right[39] dac_config_4
+ row_on_detect_bot[54] dac_config_0 dac_config_1 row_off_detect_bot[55] x4_net25
+ dac_config_2 vdda1 vssa1 vssc1 col_event_rst_bot_right[38] x4_net26
+ row_on_detect_bot[55] row_off_detect_bot[54] openDVS_pixel2x2_bot
x4_x1933 dac_config_3 dac_config_5 col_event_rst_bot_right[37] dac_config_4
+ row_on_detect_bot[54] dac_config_0 dac_config_1 row_off_detect_bot[55] x4_net27
+ dac_config_2 vdda1 vssa1 vssc1 col_event_rst_bot_right[36] x4_net28
+ row_on_detect_bot[55] row_off_detect_bot[54] openDVS_pixel2x2_bot
x4_x1934 dac_config_3 dac_config_5 col_event_rst_bot_right[35] dac_config_4
+ row_on_detect_bot[54] dac_config_0 dac_config_1 row_off_detect_bot[55] x4_net29
+ dac_config_2 vdda1 vssa1 vssc1 col_event_rst_bot_right[34] x4_net30
+ row_on_detect_bot[55] row_off_detect_bot[54] openDVS_pixel2x2_bot
x4_x1935 dac_config_3 dac_config_5 col_event_rst_bot_right[33] dac_config_4
+ row_on_detect_bot[54] dac_config_0 dac_config_1 row_off_detect_bot[55] x4_net31
+ dac_config_2 vdda1 vssa1 vssc1 col_event_rst_bot_right[32] x4_net32
+ row_on_detect_bot[55] row_off_detect_bot[54] openDVS_pixel2x2_bot
x4_x1936 dac_config_3 dac_config_5 col_event_rst_bot_right[31] dac_config_4
+ row_on_detect_bot[54] dac_config_0 dac_config_1 row_off_detect_bot[55] x4_net33
+ dac_config_2 vdda1 vssa1 vssc1 col_event_rst_bot_right[30] x4_net34
+ row_on_detect_bot[55] row_off_detect_bot[54] openDVS_pixel2x2_bot
x4_x1937 dac_config_3 dac_config_5 col_event_rst_bot_right[29] dac_config_4
+ row_on_detect_bot[54] dac_config_0 dac_config_1 row_off_detect_bot[55] x4_net35
+ dac_config_2 vdda1 vssa1 vssc1 col_event_rst_bot_right[28] x4_net36
+ row_on_detect_bot[55] row_off_detect_bot[54] openDVS_pixel2x2_bot
x4_x1938 dac_config_3 dac_config_5 col_event_rst_bot_right[27] dac_config_4
+ row_on_detect_bot[54] dac_config_0 dac_config_1 row_off_detect_bot[55] x4_net37
+ dac_config_2 vdda1 vssa1 vssc1 col_event_rst_bot_right[26] x4_net38
+ row_on_detect_bot[55] row_off_detect_bot[54] openDVS_pixel2x2_bot
x4_x1939 dac_config_3 dac_config_5 col_event_rst_bot_right[25] dac_config_4
+ row_on_detect_bot[54] dac_config_0 dac_config_1 row_off_detect_bot[55] x4_net39
+ dac_config_2 vdda1 vssa1 vssc1 col_event_rst_bot_right[24] x4_net40
+ row_on_detect_bot[55] row_off_detect_bot[54] openDVS_pixel2x2_bot
x4_x1940 dac_config_3 dac_config_5 col_event_rst_bot_right[23] dac_config_4
+ row_on_detect_bot[54] dac_config_0 dac_config_1 row_off_detect_bot[55] x4_net41
+ dac_config_2 vdda1 vssa1 vssc1 col_event_rst_bot_right[22] x4_net42
+ row_on_detect_bot[55] row_off_detect_bot[54] openDVS_pixel2x2_bot
x4_x1941 dac_config_3 dac_config_5 col_event_rst_bot_right[21] dac_config_4
+ row_on_detect_bot[54] dac_config_0 dac_config_1 row_off_detect_bot[55] x4_net43
+ dac_config_2 vdda1 vssa1 vssc1 col_event_rst_bot_right[20] x4_net44
+ row_on_detect_bot[55] row_off_detect_bot[54] openDVS_pixel2x2_bot
x4_x1942 dac_config_3 dac_config_5 col_event_rst_bot_right[19] dac_config_4
+ row_on_detect_bot[54] dac_config_0 dac_config_1 row_off_detect_bot[55] x4_net45
+ dac_config_2 vdda1 vssa1 vssc1 col_event_rst_bot_right[18] x4_net46
+ row_on_detect_bot[55] row_off_detect_bot[54] openDVS_pixel2x2_bot
x4_x1943 dac_config_3 dac_config_5 col_event_rst_bot_right[17] dac_config_4
+ row_on_detect_bot[54] dac_config_0 dac_config_1 row_off_detect_bot[55] x4_net47
+ dac_config_2 vdda1 vssa1 vssc1 col_event_rst_bot_right[16] x4_net48
+ row_on_detect_bot[55] row_off_detect_bot[54] openDVS_pixel2x2_bot
x4_x1944 dac_config_3 dac_config_5 col_event_rst_bot_right[15] dac_config_4
+ row_on_detect_bot[54] dac_config_0 dac_config_1 row_off_detect_bot[55] x4_net49
+ dac_config_2 vdda1 vssa1 vssc1 col_event_rst_bot_right[14] x4_net50
+ row_on_detect_bot[55] row_off_detect_bot[54] openDVS_pixel2x2_bot
x4_x1945 dac_config_3 dac_config_5 col_event_rst_bot_right[13] dac_config_4
+ row_on_detect_bot[54] dac_config_0 dac_config_1 row_off_detect_bot[55] x4_net51
+ dac_config_2 vdda1 vssa1 vssc1 col_event_rst_bot_right[12] x4_net52
+ row_on_detect_bot[55] row_off_detect_bot[54] openDVS_pixel2x2_bot
x4_x1946 dac_config_3 dac_config_5 col_event_rst_bot_right[11] dac_config_4
+ row_on_detect_bot[54] dac_config_0 dac_config_1 row_off_detect_bot[55] x4_net53
+ dac_config_2 vdda1 vssa1 vssc1 col_event_rst_bot_right[10] x4_net54
+ row_on_detect_bot[55] row_off_detect_bot[54] openDVS_pixel2x2_bot
x4_x1947 dac_config_3 dac_config_5 col_event_rst_bot_right[9] dac_config_4
+ row_on_detect_bot[54] dac_config_0 dac_config_1 row_off_detect_bot[55] x4_net55
+ dac_config_2 vdda1 vssa1 vssc1 col_event_rst_bot_right[8] x4_net56 row_on_detect_bot[55]
+ row_off_detect_bot[54] openDVS_pixel2x2_bot
x4_x1948 dac_config_3 dac_config_5 col_event_rst_bot_right[7] dac_config_4
+ row_on_detect_bot[54] dac_config_0 dac_config_1 row_off_detect_bot[55] x4_net57
+ dac_config_2 vdda1 vssa1 vssc1 col_event_rst_bot_right[6] x4_net58 row_on_detect_bot[55]
+ row_off_detect_bot[54] openDVS_pixel2x2_bot
x4_x1949 dac_config_3 dac_config_5 col_event_rst_bot_right[5] dac_config_4
+ row_on_detect_bot[54] dac_config_0 dac_config_1 row_off_detect_bot[55] x4_net59
+ dac_config_2 vdda1 vssa1 vssc1 col_event_rst_bot_right[4] x4_net60 row_on_detect_bot[55]
+ row_off_detect_bot[54] openDVS_pixel2x2_bot
x4_x1950 dac_config_3 dac_config_5 col_event_rst_bot_right[3] dac_config_4
+ row_on_detect_bot[54] dac_config_0 dac_config_1 row_off_detect_bot[55] x4_net61
+ dac_config_2 vdda1 vssa1 vssc1 col_event_rst_bot_right[2] x4_net62 row_on_detect_bot[55]
+ row_off_detect_bot[54] openDVS_pixel2x2_bot
x4_x1951 dac_config_3 dac_config_5 col_event_rst_bot_right[1] dac_config_4
+ row_on_detect_bot[54] dac_config_0 dac_config_1 row_off_detect_bot[55] x4_net63
+ dac_config_2 vdda1 vssa1 vssc1 col_event_rst_bot_right[0] x4_net64 row_on_detect_bot[55]
+ row_off_detect_bot[54] openDVS_pixel2x2_bot
x4_x1952 dac_config_3 dac_config_5 col_event_rst_bot_right[63] dac_config_4
+ row_on_detect_bot[56] dac_config_0 dac_config_1 row_off_detect_bot[57] x4_net1
+ dac_config_2 vdda1 vssa1 vssc1 col_event_rst_bot_right[62] x4_net2 row_on_detect_bot[57]
+ row_off_detect_bot[56] openDVS_pixel2x2_bot
x4_x1953 dac_config_3 dac_config_5 col_event_rst_bot_right[61] dac_config_4
+ row_on_detect_bot[56] dac_config_0 dac_config_1 row_off_detect_bot[57] x4_net3
+ dac_config_2 vdda1 vssa1 vssc1 col_event_rst_bot_right[60] x4_net4 row_on_detect_bot[57]
+ row_off_detect_bot[56] openDVS_pixel2x2_bot
x4_x1954 dac_config_3 dac_config_5 col_event_rst_bot_right[59] dac_config_4
+ row_on_detect_bot[56] dac_config_0 dac_config_1 row_off_detect_bot[57] x4_net5
+ dac_config_2 vdda1 vssa1 vssc1 col_event_rst_bot_right[58] x4_net6 row_on_detect_bot[57]
+ row_off_detect_bot[56] openDVS_pixel2x2_bot
x4_x1955 dac_config_3 dac_config_5 col_event_rst_bot_right[57] dac_config_4
+ row_on_detect_bot[56] dac_config_0 dac_config_1 row_off_detect_bot[57] x4_net7
+ dac_config_2 vdda1 vssa1 vssc1 col_event_rst_bot_right[56] x4_net8 row_on_detect_bot[57]
+ row_off_detect_bot[56] openDVS_pixel2x2_bot
x4_x1956 dac_config_3 dac_config_5 col_event_rst_bot_right[55] dac_config_4
+ row_on_detect_bot[56] dac_config_0 dac_config_1 row_off_detect_bot[57] x4_net9
+ dac_config_2 vdda1 vssa1 vssc1 col_event_rst_bot_right[54] x4_net10
+ row_on_detect_bot[57] row_off_detect_bot[56] openDVS_pixel2x2_bot
x4_x1957 dac_config_3 dac_config_5 col_event_rst_bot_right[53] dac_config_4
+ row_on_detect_bot[56] dac_config_0 dac_config_1 row_off_detect_bot[57] x4_net11
+ dac_config_2 vdda1 vssa1 vssc1 col_event_rst_bot_right[52] x4_net12
+ row_on_detect_bot[57] row_off_detect_bot[56] openDVS_pixel2x2_bot
x4_x1958 dac_config_3 dac_config_5 col_event_rst_bot_right[51] dac_config_4
+ row_on_detect_bot[56] dac_config_0 dac_config_1 row_off_detect_bot[57] x4_net13
+ dac_config_2 vdda1 vssa1 vssc1 col_event_rst_bot_right[50] x4_net14
+ row_on_detect_bot[57] row_off_detect_bot[56] openDVS_pixel2x2_bot
x4_x1959 dac_config_3 dac_config_5 col_event_rst_bot_right[49] dac_config_4
+ row_on_detect_bot[56] dac_config_0 dac_config_1 row_off_detect_bot[57] x4_net15
+ dac_config_2 vdda1 vssa1 vssc1 col_event_rst_bot_right[48] x4_net16
+ row_on_detect_bot[57] row_off_detect_bot[56] openDVS_pixel2x2_bot
x4_x1960 dac_config_3 dac_config_5 col_event_rst_bot_right[47] dac_config_4
+ row_on_detect_bot[56] dac_config_0 dac_config_1 row_off_detect_bot[57] x4_net17
+ dac_config_2 vdda1 vssa1 vssc1 col_event_rst_bot_right[46] x4_net18
+ row_on_detect_bot[57] row_off_detect_bot[56] openDVS_pixel2x2_bot
x4_x1961 dac_config_3 dac_config_5 col_event_rst_bot_right[45] dac_config_4
+ row_on_detect_bot[56] dac_config_0 dac_config_1 row_off_detect_bot[57] x4_net19
+ dac_config_2 vdda1 vssa1 vssc1 col_event_rst_bot_right[44] x4_net20
+ row_on_detect_bot[57] row_off_detect_bot[56] openDVS_pixel2x2_bot
x4_x1962 dac_config_3 dac_config_5 col_event_rst_bot_right[43] dac_config_4
+ row_on_detect_bot[56] dac_config_0 dac_config_1 row_off_detect_bot[57] x4_net21
+ dac_config_2 vdda1 vssa1 vssc1 col_event_rst_bot_right[42] x4_net22
+ row_on_detect_bot[57] row_off_detect_bot[56] openDVS_pixel2x2_bot
x4_x1963 dac_config_3 dac_config_5 col_event_rst_bot_right[41] dac_config_4
+ row_on_detect_bot[56] dac_config_0 dac_config_1 row_off_detect_bot[57] x4_net23
+ dac_config_2 vdda1 vssa1 vssc1 col_event_rst_bot_right[40] x4_net24
+ row_on_detect_bot[57] row_off_detect_bot[56] openDVS_pixel2x2_bot
x4_x1964 dac_config_3 dac_config_5 col_event_rst_bot_right[39] dac_config_4
+ row_on_detect_bot[56] dac_config_0 dac_config_1 row_off_detect_bot[57] x4_net25
+ dac_config_2 vdda1 vssa1 vssc1 col_event_rst_bot_right[38] x4_net26
+ row_on_detect_bot[57] row_off_detect_bot[56] openDVS_pixel2x2_bot
x4_x1965 dac_config_3 dac_config_5 col_event_rst_bot_right[37] dac_config_4
+ row_on_detect_bot[56] dac_config_0 dac_config_1 row_off_detect_bot[57] x4_net27
+ dac_config_2 vdda1 vssa1 vssc1 col_event_rst_bot_right[36] x4_net28
+ row_on_detect_bot[57] row_off_detect_bot[56] openDVS_pixel2x2_bot
x4_x1966 dac_config_3 dac_config_5 col_event_rst_bot_right[35] dac_config_4
+ row_on_detect_bot[56] dac_config_0 dac_config_1 row_off_detect_bot[57] x4_net29
+ dac_config_2 vdda1 vssa1 vssc1 col_event_rst_bot_right[34] x4_net30
+ row_on_detect_bot[57] row_off_detect_bot[56] openDVS_pixel2x2_bot
x4_x1967 dac_config_3 dac_config_5 col_event_rst_bot_right[33] dac_config_4
+ row_on_detect_bot[56] dac_config_0 dac_config_1 row_off_detect_bot[57] x4_net31
+ dac_config_2 vdda1 vssa1 vssc1 col_event_rst_bot_right[32] x4_net32
+ row_on_detect_bot[57] row_off_detect_bot[56] openDVS_pixel2x2_bot
x4_x1968 dac_config_3 dac_config_5 col_event_rst_bot_right[31] dac_config_4
+ row_on_detect_bot[56] dac_config_0 dac_config_1 row_off_detect_bot[57] x4_net33
+ dac_config_2 vdda1 vssa1 vssc1 col_event_rst_bot_right[30] x4_net34
+ row_on_detect_bot[57] row_off_detect_bot[56] openDVS_pixel2x2_bot
x4_x1969 dac_config_3 dac_config_5 col_event_rst_bot_right[29] dac_config_4
+ row_on_detect_bot[56] dac_config_0 dac_config_1 row_off_detect_bot[57] x4_net35
+ dac_config_2 vdda1 vssa1 vssc1 col_event_rst_bot_right[28] x4_net36
+ row_on_detect_bot[57] row_off_detect_bot[56] openDVS_pixel2x2_bot
x4_x1970 dac_config_3 dac_config_5 col_event_rst_bot_right[27] dac_config_4
+ row_on_detect_bot[56] dac_config_0 dac_config_1 row_off_detect_bot[57] x4_net37
+ dac_config_2 vdda1 vssa1 vssc1 col_event_rst_bot_right[26] x4_net38
+ row_on_detect_bot[57] row_off_detect_bot[56] openDVS_pixel2x2_bot
x4_x1971 dac_config_3 dac_config_5 col_event_rst_bot_right[25] dac_config_4
+ row_on_detect_bot[56] dac_config_0 dac_config_1 row_off_detect_bot[57] x4_net39
+ dac_config_2 vdda1 vssa1 vssc1 col_event_rst_bot_right[24] x4_net40
+ row_on_detect_bot[57] row_off_detect_bot[56] openDVS_pixel2x2_bot
x4_x1972 dac_config_3 dac_config_5 col_event_rst_bot_right[23] dac_config_4
+ row_on_detect_bot[56] dac_config_0 dac_config_1 row_off_detect_bot[57] x4_net41
+ dac_config_2 vdda1 vssa1 vssc1 col_event_rst_bot_right[22] x4_net42
+ row_on_detect_bot[57] row_off_detect_bot[56] openDVS_pixel2x2_bot
x4_x1973 dac_config_3 dac_config_5 col_event_rst_bot_right[21] dac_config_4
+ row_on_detect_bot[56] dac_config_0 dac_config_1 row_off_detect_bot[57] x4_net43
+ dac_config_2 vdda1 vssa1 vssc1 col_event_rst_bot_right[20] x4_net44
+ row_on_detect_bot[57] row_off_detect_bot[56] openDVS_pixel2x2_bot
x4_x1974 dac_config_3 dac_config_5 col_event_rst_bot_right[19] dac_config_4
+ row_on_detect_bot[56] dac_config_0 dac_config_1 row_off_detect_bot[57] x4_net45
+ dac_config_2 vdda1 vssa1 vssc1 col_event_rst_bot_right[18] x4_net46
+ row_on_detect_bot[57] row_off_detect_bot[56] openDVS_pixel2x2_bot
x4_x1975 dac_config_3 dac_config_5 col_event_rst_bot_right[17] dac_config_4
+ row_on_detect_bot[56] dac_config_0 dac_config_1 row_off_detect_bot[57] x4_net47
+ dac_config_2 vdda1 vssa1 vssc1 col_event_rst_bot_right[16] x4_net48
+ row_on_detect_bot[57] row_off_detect_bot[56] openDVS_pixel2x2_bot
x4_x1976 dac_config_3 dac_config_5 col_event_rst_bot_right[15] dac_config_4
+ row_on_detect_bot[56] dac_config_0 dac_config_1 row_off_detect_bot[57] x4_net49
+ dac_config_2 vdda1 vssa1 vssc1 col_event_rst_bot_right[14] x4_net50
+ row_on_detect_bot[57] row_off_detect_bot[56] openDVS_pixel2x2_bot
x4_x1977 dac_config_3 dac_config_5 col_event_rst_bot_right[13] dac_config_4
+ row_on_detect_bot[56] dac_config_0 dac_config_1 row_off_detect_bot[57] x4_net51
+ dac_config_2 vdda1 vssa1 vssc1 col_event_rst_bot_right[12] x4_net52
+ row_on_detect_bot[57] row_off_detect_bot[56] openDVS_pixel2x2_bot
x4_x1978 dac_config_3 dac_config_5 col_event_rst_bot_right[11] dac_config_4
+ row_on_detect_bot[56] dac_config_0 dac_config_1 row_off_detect_bot[57] x4_net53
+ dac_config_2 vdda1 vssa1 vssc1 col_event_rst_bot_right[10] x4_net54
+ row_on_detect_bot[57] row_off_detect_bot[56] openDVS_pixel2x2_bot
x4_x1979 dac_config_3 dac_config_5 col_event_rst_bot_right[9] dac_config_4
+ row_on_detect_bot[56] dac_config_0 dac_config_1 row_off_detect_bot[57] x4_net55
+ dac_config_2 vdda1 vssa1 vssc1 col_event_rst_bot_right[8] x4_net56 row_on_detect_bot[57]
+ row_off_detect_bot[56] openDVS_pixel2x2_bot
x4_x1980 dac_config_3 dac_config_5 col_event_rst_bot_right[7] dac_config_4
+ row_on_detect_bot[56] dac_config_0 dac_config_1 row_off_detect_bot[57] x4_net57
+ dac_config_2 vdda1 vssa1 vssc1 col_event_rst_bot_right[6] x4_net58 row_on_detect_bot[57]
+ row_off_detect_bot[56] openDVS_pixel2x2_bot
x4_x1981 dac_config_3 dac_config_5 col_event_rst_bot_right[5] dac_config_4
+ row_on_detect_bot[56] dac_config_0 dac_config_1 row_off_detect_bot[57] x4_net59
+ dac_config_2 vdda1 vssa1 vssc1 col_event_rst_bot_right[4] x4_net60 row_on_detect_bot[57]
+ row_off_detect_bot[56] openDVS_pixel2x2_bot
x4_x1982 dac_config_3 dac_config_5 col_event_rst_bot_right[3] dac_config_4
+ row_on_detect_bot[56] dac_config_0 dac_config_1 row_off_detect_bot[57] x4_net61
+ dac_config_2 vdda1 vssa1 vssc1 col_event_rst_bot_right[2] x4_net62 row_on_detect_bot[57]
+ row_off_detect_bot[56] openDVS_pixel2x2_bot
x4_x1983 dac_config_3 dac_config_5 col_event_rst_bot_right[1] dac_config_4
+ row_on_detect_bot[56] dac_config_0 dac_config_1 row_off_detect_bot[57] x4_net63
+ dac_config_2 vdda1 vssa1 vssc1 col_event_rst_bot_right[0] x4_net64 row_on_detect_bot[57]
+ row_off_detect_bot[56] openDVS_pixel2x2_bot
x4_x1984 dac_config_3 dac_config_5 col_event_rst_bot_right[63] dac_config_4
+ row_on_detect_bot[58] dac_config_0 dac_config_1 row_off_detect_bot[59] x4_net1
+ dac_config_2 vdda1 vssa1 vssc1 col_event_rst_bot_right[62] x4_net2 row_on_detect_bot[59]
+ row_off_detect_bot[58] openDVS_pixel2x2_bot
x4_x1985 dac_config_3 dac_config_5 col_event_rst_bot_right[61] dac_config_4
+ row_on_detect_bot[58] dac_config_0 dac_config_1 row_off_detect_bot[59] x4_net3
+ dac_config_2 vdda1 vssa1 vssc1 col_event_rst_bot_right[60] x4_net4 row_on_detect_bot[59]
+ row_off_detect_bot[58] openDVS_pixel2x2_bot
x4_x1986 dac_config_3 dac_config_5 col_event_rst_bot_right[59] dac_config_4
+ row_on_detect_bot[58] dac_config_0 dac_config_1 row_off_detect_bot[59] x4_net5
+ dac_config_2 vdda1 vssa1 vssc1 col_event_rst_bot_right[58] x4_net6 row_on_detect_bot[59]
+ row_off_detect_bot[58] openDVS_pixel2x2_bot
x4_x1987 dac_config_3 dac_config_5 col_event_rst_bot_right[57] dac_config_4
+ row_on_detect_bot[58] dac_config_0 dac_config_1 row_off_detect_bot[59] x4_net7
+ dac_config_2 vdda1 vssa1 vssc1 col_event_rst_bot_right[56] x4_net8 row_on_detect_bot[59]
+ row_off_detect_bot[58] openDVS_pixel2x2_bot
x4_x1988 dac_config_3 dac_config_5 col_event_rst_bot_right[55] dac_config_4
+ row_on_detect_bot[58] dac_config_0 dac_config_1 row_off_detect_bot[59] x4_net9
+ dac_config_2 vdda1 vssa1 vssc1 col_event_rst_bot_right[54] x4_net10
+ row_on_detect_bot[59] row_off_detect_bot[58] openDVS_pixel2x2_bot
x4_x1989 dac_config_3 dac_config_5 col_event_rst_bot_right[53] dac_config_4
+ row_on_detect_bot[58] dac_config_0 dac_config_1 row_off_detect_bot[59] x4_net11
+ dac_config_2 vdda1 vssa1 vssc1 col_event_rst_bot_right[52] x4_net12
+ row_on_detect_bot[59] row_off_detect_bot[58] openDVS_pixel2x2_bot
x4_x1990 dac_config_3 dac_config_5 col_event_rst_bot_right[51] dac_config_4
+ row_on_detect_bot[58] dac_config_0 dac_config_1 row_off_detect_bot[59] x4_net13
+ dac_config_2 vdda1 vssa1 vssc1 col_event_rst_bot_right[50] x4_net14
+ row_on_detect_bot[59] row_off_detect_bot[58] openDVS_pixel2x2_bot
x4_x1991 dac_config_3 dac_config_5 col_event_rst_bot_right[49] dac_config_4
+ row_on_detect_bot[58] dac_config_0 dac_config_1 row_off_detect_bot[59] x4_net15
+ dac_config_2 vdda1 vssa1 vssc1 col_event_rst_bot_right[48] x4_net16
+ row_on_detect_bot[59] row_off_detect_bot[58] openDVS_pixel2x2_bot
x4_x1992 dac_config_3 dac_config_5 col_event_rst_bot_right[47] dac_config_4
+ row_on_detect_bot[58] dac_config_0 dac_config_1 row_off_detect_bot[59] x4_net17
+ dac_config_2 vdda1 vssa1 vssc1 col_event_rst_bot_right[46] x4_net18
+ row_on_detect_bot[59] row_off_detect_bot[58] openDVS_pixel2x2_bot
x4_x1993 dac_config_3 dac_config_5 col_event_rst_bot_right[45] dac_config_4
+ row_on_detect_bot[58] dac_config_0 dac_config_1 row_off_detect_bot[59] x4_net19
+ dac_config_2 vdda1 vssa1 vssc1 col_event_rst_bot_right[44] x4_net20
+ row_on_detect_bot[59] row_off_detect_bot[58] openDVS_pixel2x2_bot
x4_x1994 dac_config_3 dac_config_5 col_event_rst_bot_right[43] dac_config_4
+ row_on_detect_bot[58] dac_config_0 dac_config_1 row_off_detect_bot[59] x4_net21
+ dac_config_2 vdda1 vssa1 vssc1 col_event_rst_bot_right[42] x4_net22
+ row_on_detect_bot[59] row_off_detect_bot[58] openDVS_pixel2x2_bot
x4_x1995 dac_config_3 dac_config_5 col_event_rst_bot_right[41] dac_config_4
+ row_on_detect_bot[58] dac_config_0 dac_config_1 row_off_detect_bot[59] x4_net23
+ dac_config_2 vdda1 vssa1 vssc1 col_event_rst_bot_right[40] x4_net24
+ row_on_detect_bot[59] row_off_detect_bot[58] openDVS_pixel2x2_bot
x4_x1996 dac_config_3 dac_config_5 col_event_rst_bot_right[39] dac_config_4
+ row_on_detect_bot[58] dac_config_0 dac_config_1 row_off_detect_bot[59] x4_net25
+ dac_config_2 vdda1 vssa1 vssc1 col_event_rst_bot_right[38] x4_net26
+ row_on_detect_bot[59] row_off_detect_bot[58] openDVS_pixel2x2_bot
x4_x1997 dac_config_3 dac_config_5 col_event_rst_bot_right[37] dac_config_4
+ row_on_detect_bot[58] dac_config_0 dac_config_1 row_off_detect_bot[59] x4_net27
+ dac_config_2 vdda1 vssa1 vssc1 col_event_rst_bot_right[36] x4_net28
+ row_on_detect_bot[59] row_off_detect_bot[58] openDVS_pixel2x2_bot
x4_x1998 dac_config_3 dac_config_5 col_event_rst_bot_right[35] dac_config_4
+ row_on_detect_bot[58] dac_config_0 dac_config_1 row_off_detect_bot[59] x4_net29
+ dac_config_2 vdda1 vssa1 vssc1 col_event_rst_bot_right[34] x4_net30
+ row_on_detect_bot[59] row_off_detect_bot[58] openDVS_pixel2x2_bot
x4_x1999 dac_config_3 dac_config_5 col_event_rst_bot_right[33] dac_config_4
+ row_on_detect_bot[58] dac_config_0 dac_config_1 row_off_detect_bot[59] x4_net31
+ dac_config_2 vdda1 vssa1 vssc1 col_event_rst_bot_right[32] x4_net32
+ row_on_detect_bot[59] row_off_detect_bot[58] openDVS_pixel2x2_bot
x4_x2000 dac_config_3 dac_config_5 col_event_rst_bot_right[31] dac_config_4
+ row_on_detect_bot[58] dac_config_0 dac_config_1 row_off_detect_bot[59] x4_net33
+ dac_config_2 vdda1 vssa1 vssc1 col_event_rst_bot_right[30] x4_net34
+ row_on_detect_bot[59] row_off_detect_bot[58] openDVS_pixel2x2_bot
x4_x2001 dac_config_3 dac_config_5 col_event_rst_bot_right[29] dac_config_4
+ row_on_detect_bot[58] dac_config_0 dac_config_1 row_off_detect_bot[59] x4_net35
+ dac_config_2 vdda1 vssa1 vssc1 col_event_rst_bot_right[28] x4_net36
+ row_on_detect_bot[59] row_off_detect_bot[58] openDVS_pixel2x2_bot
x4_x2002 dac_config_3 dac_config_5 col_event_rst_bot_right[27] dac_config_4
+ row_on_detect_bot[58] dac_config_0 dac_config_1 row_off_detect_bot[59] x4_net37
+ dac_config_2 vdda1 vssa1 vssc1 col_event_rst_bot_right[26] x4_net38
+ row_on_detect_bot[59] row_off_detect_bot[58] openDVS_pixel2x2_bot
x4_x2003 dac_config_3 dac_config_5 col_event_rst_bot_right[25] dac_config_4
+ row_on_detect_bot[58] dac_config_0 dac_config_1 row_off_detect_bot[59] x4_net39
+ dac_config_2 vdda1 vssa1 vssc1 col_event_rst_bot_right[24] x4_net40
+ row_on_detect_bot[59] row_off_detect_bot[58] openDVS_pixel2x2_bot
x4_x2004 dac_config_3 dac_config_5 col_event_rst_bot_right[23] dac_config_4
+ row_on_detect_bot[58] dac_config_0 dac_config_1 row_off_detect_bot[59] x4_net41
+ dac_config_2 vdda1 vssa1 vssc1 col_event_rst_bot_right[22] x4_net42
+ row_on_detect_bot[59] row_off_detect_bot[58] openDVS_pixel2x2_bot
x4_x2005 dac_config_3 dac_config_5 col_event_rst_bot_right[21] dac_config_4
+ row_on_detect_bot[58] dac_config_0 dac_config_1 row_off_detect_bot[59] x4_net43
+ dac_config_2 vdda1 vssa1 vssc1 col_event_rst_bot_right[20] x4_net44
+ row_on_detect_bot[59] row_off_detect_bot[58] openDVS_pixel2x2_bot
x4_x2006 dac_config_3 dac_config_5 col_event_rst_bot_right[19] dac_config_4
+ row_on_detect_bot[58] dac_config_0 dac_config_1 row_off_detect_bot[59] x4_net45
+ dac_config_2 vdda1 vssa1 vssc1 col_event_rst_bot_right[18] x4_net46
+ row_on_detect_bot[59] row_off_detect_bot[58] openDVS_pixel2x2_bot
x4_x2007 dac_config_3 dac_config_5 col_event_rst_bot_right[17] dac_config_4
+ row_on_detect_bot[58] dac_config_0 dac_config_1 row_off_detect_bot[59] x4_net47
+ dac_config_2 vdda1 vssa1 vssc1 col_event_rst_bot_right[16] x4_net48
+ row_on_detect_bot[59] row_off_detect_bot[58] openDVS_pixel2x2_bot
x4_x2008 dac_config_3 dac_config_5 col_event_rst_bot_right[15] dac_config_4
+ row_on_detect_bot[58] dac_config_0 dac_config_1 row_off_detect_bot[59] x4_net49
+ dac_config_2 vdda1 vssa1 vssc1 col_event_rst_bot_right[14] x4_net50
+ row_on_detect_bot[59] row_off_detect_bot[58] openDVS_pixel2x2_bot
x4_x2009 dac_config_3 dac_config_5 col_event_rst_bot_right[13] dac_config_4
+ row_on_detect_bot[58] dac_config_0 dac_config_1 row_off_detect_bot[59] x4_net51
+ dac_config_2 vdda1 vssa1 vssc1 col_event_rst_bot_right[12] x4_net52
+ row_on_detect_bot[59] row_off_detect_bot[58] openDVS_pixel2x2_bot
x4_x2010 dac_config_3 dac_config_5 col_event_rst_bot_right[11] dac_config_4
+ row_on_detect_bot[58] dac_config_0 dac_config_1 row_off_detect_bot[59] x4_net53
+ dac_config_2 vdda1 vssa1 vssc1 col_event_rst_bot_right[10] x4_net54
+ row_on_detect_bot[59] row_off_detect_bot[58] openDVS_pixel2x2_bot
x4_x2011 dac_config_3 dac_config_5 col_event_rst_bot_right[9] dac_config_4
+ row_on_detect_bot[58] dac_config_0 dac_config_1 row_off_detect_bot[59] x4_net55
+ dac_config_2 vdda1 vssa1 vssc1 col_event_rst_bot_right[8] x4_net56 row_on_detect_bot[59]
+ row_off_detect_bot[58] openDVS_pixel2x2_bot
x4_x2012 dac_config_3 dac_config_5 col_event_rst_bot_right[7] dac_config_4
+ row_on_detect_bot[58] dac_config_0 dac_config_1 row_off_detect_bot[59] x4_net57
+ dac_config_2 vdda1 vssa1 vssc1 col_event_rst_bot_right[6] x4_net58 row_on_detect_bot[59]
+ row_off_detect_bot[58] openDVS_pixel2x2_bot
x4_x2013 dac_config_3 dac_config_5 col_event_rst_bot_right[5] dac_config_4
+ row_on_detect_bot[58] dac_config_0 dac_config_1 row_off_detect_bot[59] x4_net59
+ dac_config_2 vdda1 vssa1 vssc1 col_event_rst_bot_right[4] x4_net60 row_on_detect_bot[59]
+ row_off_detect_bot[58] openDVS_pixel2x2_bot
x4_x2014 dac_config_3 dac_config_5 col_event_rst_bot_right[3] dac_config_4
+ row_on_detect_bot[58] dac_config_0 dac_config_1 row_off_detect_bot[59] x4_net61
+ dac_config_2 vdda1 vssa1 vssc1 col_event_rst_bot_right[2] x4_net62 row_on_detect_bot[59]
+ row_off_detect_bot[58] openDVS_pixel2x2_bot
x4_x2015 dac_config_3 dac_config_5 col_event_rst_bot_right[1] dac_config_4
+ row_on_detect_bot[58] dac_config_0 dac_config_1 row_off_detect_bot[59] x4_net63
+ dac_config_2 vdda1 vssa1 vssc1 col_event_rst_bot_right[0] x4_net64 row_on_detect_bot[59]
+ row_off_detect_bot[58] openDVS_pixel2x2_bot
x4_x2016 dac_config_3 dac_config_5 col_event_rst_bot_right[63] dac_config_4
+ row_on_detect_bot[60] dac_config_0 dac_config_1 row_off_detect_bot[61] x4_net1
+ dac_config_2 vdda1 vssa1 vssc1 col_event_rst_bot_right[62] x4_net2 row_on_detect_bot[61]
+ row_off_detect_bot[60] openDVS_pixel2x2_bot
x4_x2017 dac_config_3 dac_config_5 col_event_rst_bot_right[61] dac_config_4
+ row_on_detect_bot[60] dac_config_0 dac_config_1 row_off_detect_bot[61] x4_net3
+ dac_config_2 vdda1 vssa1 vssc1 col_event_rst_bot_right[60] x4_net4 row_on_detect_bot[61]
+ row_off_detect_bot[60] openDVS_pixel2x2_bot
x4_x2018 dac_config_3 dac_config_5 col_event_rst_bot_right[59] dac_config_4
+ row_on_detect_bot[60] dac_config_0 dac_config_1 row_off_detect_bot[61] x4_net5
+ dac_config_2 vdda1 vssa1 vssc1 col_event_rst_bot_right[58] x4_net6 row_on_detect_bot[61]
+ row_off_detect_bot[60] openDVS_pixel2x2_bot
x4_x2019 dac_config_3 dac_config_5 col_event_rst_bot_right[57] dac_config_4
+ row_on_detect_bot[60] dac_config_0 dac_config_1 row_off_detect_bot[61] x4_net7
+ dac_config_2 vdda1 vssa1 vssc1 col_event_rst_bot_right[56] x4_net8 row_on_detect_bot[61]
+ row_off_detect_bot[60] openDVS_pixel2x2_bot
x4_x2020 dac_config_3 dac_config_5 col_event_rst_bot_right[55] dac_config_4
+ row_on_detect_bot[60] dac_config_0 dac_config_1 row_off_detect_bot[61] x4_net9
+ dac_config_2 vdda1 vssa1 vssc1 col_event_rst_bot_right[54] x4_net10
+ row_on_detect_bot[61] row_off_detect_bot[60] openDVS_pixel2x2_bot
x4_x2021 dac_config_3 dac_config_5 col_event_rst_bot_right[53] dac_config_4
+ row_on_detect_bot[60] dac_config_0 dac_config_1 row_off_detect_bot[61] x4_net11
+ dac_config_2 vdda1 vssa1 vssc1 col_event_rst_bot_right[52] x4_net12
+ row_on_detect_bot[61] row_off_detect_bot[60] openDVS_pixel2x2_bot
x4_x2022 dac_config_3 dac_config_5 col_event_rst_bot_right[51] dac_config_4
+ row_on_detect_bot[60] dac_config_0 dac_config_1 row_off_detect_bot[61] x4_net13
+ dac_config_2 vdda1 vssa1 vssc1 col_event_rst_bot_right[50] x4_net14
+ row_on_detect_bot[61] row_off_detect_bot[60] openDVS_pixel2x2_bot
x4_x2023 dac_config_3 dac_config_5 col_event_rst_bot_right[49] dac_config_4
+ row_on_detect_bot[60] dac_config_0 dac_config_1 row_off_detect_bot[61] x4_net15
+ dac_config_2 vdda1 vssa1 vssc1 col_event_rst_bot_right[48] x4_net16
+ row_on_detect_bot[61] row_off_detect_bot[60] openDVS_pixel2x2_bot
x4_x2024 dac_config_3 dac_config_5 col_event_rst_bot_right[47] dac_config_4
+ row_on_detect_bot[60] dac_config_0 dac_config_1 row_off_detect_bot[61] x4_net17
+ dac_config_2 vdda1 vssa1 vssc1 col_event_rst_bot_right[46] x4_net18
+ row_on_detect_bot[61] row_off_detect_bot[60] openDVS_pixel2x2_bot
x4_x2025 dac_config_3 dac_config_5 col_event_rst_bot_right[45] dac_config_4
+ row_on_detect_bot[60] dac_config_0 dac_config_1 row_off_detect_bot[61] x4_net19
+ dac_config_2 vdda1 vssa1 vssc1 col_event_rst_bot_right[44] x4_net20
+ row_on_detect_bot[61] row_off_detect_bot[60] openDVS_pixel2x2_bot
x4_x2026 dac_config_3 dac_config_5 col_event_rst_bot_right[43] dac_config_4
+ row_on_detect_bot[60] dac_config_0 dac_config_1 row_off_detect_bot[61] x4_net21
+ dac_config_2 vdda1 vssa1 vssc1 col_event_rst_bot_right[42] x4_net22
+ row_on_detect_bot[61] row_off_detect_bot[60] openDVS_pixel2x2_bot
x4_x2027 dac_config_3 dac_config_5 col_event_rst_bot_right[41] dac_config_4
+ row_on_detect_bot[60] dac_config_0 dac_config_1 row_off_detect_bot[61] x4_net23
+ dac_config_2 vdda1 vssa1 vssc1 col_event_rst_bot_right[40] x4_net24
+ row_on_detect_bot[61] row_off_detect_bot[60] openDVS_pixel2x2_bot
x4_x2028 dac_config_3 dac_config_5 col_event_rst_bot_right[39] dac_config_4
+ row_on_detect_bot[60] dac_config_0 dac_config_1 row_off_detect_bot[61] x4_net25
+ dac_config_2 vdda1 vssa1 vssc1 col_event_rst_bot_right[38] x4_net26
+ row_on_detect_bot[61] row_off_detect_bot[60] openDVS_pixel2x2_bot
x4_x2029 dac_config_3 dac_config_5 col_event_rst_bot_right[37] dac_config_4
+ row_on_detect_bot[60] dac_config_0 dac_config_1 row_off_detect_bot[61] x4_net27
+ dac_config_2 vdda1 vssa1 vssc1 col_event_rst_bot_right[36] x4_net28
+ row_on_detect_bot[61] row_off_detect_bot[60] openDVS_pixel2x2_bot
x4_x2030 dac_config_3 dac_config_5 col_event_rst_bot_right[35] dac_config_4
+ row_on_detect_bot[60] dac_config_0 dac_config_1 row_off_detect_bot[61] x4_net29
+ dac_config_2 vdda1 vssa1 vssc1 col_event_rst_bot_right[34] x4_net30
+ row_on_detect_bot[61] row_off_detect_bot[60] openDVS_pixel2x2_bot
x4_x2031 dac_config_3 dac_config_5 col_event_rst_bot_right[33] dac_config_4
+ row_on_detect_bot[60] dac_config_0 dac_config_1 row_off_detect_bot[61] x4_net31
+ dac_config_2 vdda1 vssa1 vssc1 col_event_rst_bot_right[32] x4_net32
+ row_on_detect_bot[61] row_off_detect_bot[60] openDVS_pixel2x2_bot
x4_x2032 dac_config_3 dac_config_5 col_event_rst_bot_right[31] dac_config_4
+ row_on_detect_bot[60] dac_config_0 dac_config_1 row_off_detect_bot[61] x4_net33
+ dac_config_2 vdda1 vssa1 vssc1 col_event_rst_bot_right[30] x4_net34
+ row_on_detect_bot[61] row_off_detect_bot[60] openDVS_pixel2x2_bot
x4_x2033 dac_config_3 dac_config_5 col_event_rst_bot_right[29] dac_config_4
+ row_on_detect_bot[60] dac_config_0 dac_config_1 row_off_detect_bot[61] x4_net35
+ dac_config_2 vdda1 vssa1 vssc1 col_event_rst_bot_right[28] x4_net36
+ row_on_detect_bot[61] row_off_detect_bot[60] openDVS_pixel2x2_bot
x4_x2034 dac_config_3 dac_config_5 col_event_rst_bot_right[27] dac_config_4
+ row_on_detect_bot[60] dac_config_0 dac_config_1 row_off_detect_bot[61] x4_net37
+ dac_config_2 vdda1 vssa1 vssc1 col_event_rst_bot_right[26] x4_net38
+ row_on_detect_bot[61] row_off_detect_bot[60] openDVS_pixel2x2_bot
x4_x2035 dac_config_3 dac_config_5 col_event_rst_bot_right[25] dac_config_4
+ row_on_detect_bot[60] dac_config_0 dac_config_1 row_off_detect_bot[61] x4_net39
+ dac_config_2 vdda1 vssa1 vssc1 col_event_rst_bot_right[24] x4_net40
+ row_on_detect_bot[61] row_off_detect_bot[60] openDVS_pixel2x2_bot
x4_x2036 dac_config_3 dac_config_5 col_event_rst_bot_right[23] dac_config_4
+ row_on_detect_bot[60] dac_config_0 dac_config_1 row_off_detect_bot[61] x4_net41
+ dac_config_2 vdda1 vssa1 vssc1 col_event_rst_bot_right[22] x4_net42
+ row_on_detect_bot[61] row_off_detect_bot[60] openDVS_pixel2x2_bot
x4_x2037 dac_config_3 dac_config_5 col_event_rst_bot_right[21] dac_config_4
+ row_on_detect_bot[60] dac_config_0 dac_config_1 row_off_detect_bot[61] x4_net43
+ dac_config_2 vdda1 vssa1 vssc1 col_event_rst_bot_right[20] x4_net44
+ row_on_detect_bot[61] row_off_detect_bot[60] openDVS_pixel2x2_bot
x4_x2038 dac_config_3 dac_config_5 col_event_rst_bot_right[19] dac_config_4
+ row_on_detect_bot[60] dac_config_0 dac_config_1 row_off_detect_bot[61] x4_net45
+ dac_config_2 vdda1 vssa1 vssc1 col_event_rst_bot_right[18] x4_net46
+ row_on_detect_bot[61] row_off_detect_bot[60] openDVS_pixel2x2_bot
x4_x2039 dac_config_3 dac_config_5 col_event_rst_bot_right[17] dac_config_4
+ row_on_detect_bot[60] dac_config_0 dac_config_1 row_off_detect_bot[61] x4_net47
+ dac_config_2 vdda1 vssa1 vssc1 col_event_rst_bot_right[16] x4_net48
+ row_on_detect_bot[61] row_off_detect_bot[60] openDVS_pixel2x2_bot
x4_x2040 dac_config_3 dac_config_5 col_event_rst_bot_right[15] dac_config_4
+ row_on_detect_bot[60] dac_config_0 dac_config_1 row_off_detect_bot[61] x4_net49
+ dac_config_2 vdda1 vssa1 vssc1 col_event_rst_bot_right[14] x4_net50
+ row_on_detect_bot[61] row_off_detect_bot[60] openDVS_pixel2x2_bot
x4_x2041 dac_config_3 dac_config_5 col_event_rst_bot_right[13] dac_config_4
+ row_on_detect_bot[60] dac_config_0 dac_config_1 row_off_detect_bot[61] x4_net51
+ dac_config_2 vdda1 vssa1 vssc1 col_event_rst_bot_right[12] x4_net52
+ row_on_detect_bot[61] row_off_detect_bot[60] openDVS_pixel2x2_bot
x4_x2042 dac_config_3 dac_config_5 col_event_rst_bot_right[11] dac_config_4
+ row_on_detect_bot[60] dac_config_0 dac_config_1 row_off_detect_bot[61] x4_net53
+ dac_config_2 vdda1 vssa1 vssc1 col_event_rst_bot_right[10] x4_net54
+ row_on_detect_bot[61] row_off_detect_bot[60] openDVS_pixel2x2_bot
x4_x2043 dac_config_3 dac_config_5 col_event_rst_bot_right[9] dac_config_4
+ row_on_detect_bot[60] dac_config_0 dac_config_1 row_off_detect_bot[61] x4_net55
+ dac_config_2 vdda1 vssa1 vssc1 col_event_rst_bot_right[8] x4_net56 row_on_detect_bot[61]
+ row_off_detect_bot[60] openDVS_pixel2x2_bot
x4_x2044 dac_config_3 dac_config_5 col_event_rst_bot_right[7] dac_config_4
+ row_on_detect_bot[60] dac_config_0 dac_config_1 row_off_detect_bot[61] x4_net57
+ dac_config_2 vdda1 vssa1 vssc1 col_event_rst_bot_right[6] x4_net58 row_on_detect_bot[61]
+ row_off_detect_bot[60] openDVS_pixel2x2_bot
x4_x2045 dac_config_3 dac_config_5 col_event_rst_bot_right[5] dac_config_4
+ row_on_detect_bot[60] dac_config_0 dac_config_1 row_off_detect_bot[61] x4_net59
+ dac_config_2 vdda1 vssa1 vssc1 col_event_rst_bot_right[4] x4_net60 row_on_detect_bot[61]
+ row_off_detect_bot[60] openDVS_pixel2x2_bot
x4_x2046 dac_config_3 dac_config_5 col_event_rst_bot_right[3] dac_config_4
+ row_on_detect_bot[60] dac_config_0 dac_config_1 row_off_detect_bot[61] x4_net61
+ dac_config_2 vdda1 vssa1 vssc1 col_event_rst_bot_right[2] x4_net62 row_on_detect_bot[61]
+ row_off_detect_bot[60] openDVS_pixel2x2_bot
x4_x2047 dac_config_3 dac_config_5 col_event_rst_bot_right[1] dac_config_4
+ row_on_detect_bot[60] dac_config_0 dac_config_1 row_off_detect_bot[61] x4_net63
+ dac_config_2 vdda1 vssa1 vssc1 col_event_rst_bot_right[0] x4_net64 row_on_detect_bot[61]
+ row_off_detect_bot[60] openDVS_pixel2x2_bot
x4_x2048 dac_config_3 dac_config_5 col_event_rst_bot_right[63] dac_config_4
+ row_on_detect_bot[62] dac_config_0 dac_config_1 row_off_detect_bot[63] x4_net1
+ dac_config_2 vdda1 vssa1 vssc1 col_event_rst_bot_right[62] x4_net2 row_on_detect_bot[63]
+ row_off_detect_bot[62] openDVS_pixel2x2_bot
x4_x2049 dac_config_3 dac_config_5 col_event_rst_bot_right[61] dac_config_4
+ row_on_detect_bot[62] dac_config_0 dac_config_1 row_off_detect_bot[63] x4_net3
+ dac_config_2 vdda1 vssa1 vssc1 col_event_rst_bot_right[60] x4_net4 row_on_detect_bot[63]
+ row_off_detect_bot[62] openDVS_pixel2x2_bot
x4_x2050 dac_config_3 dac_config_5 col_event_rst_bot_right[59] dac_config_4
+ row_on_detect_bot[62] dac_config_0 dac_config_1 row_off_detect_bot[63] x4_net5
+ dac_config_2 vdda1 vssa1 vssc1 col_event_rst_bot_right[58] x4_net6 row_on_detect_bot[63]
+ row_off_detect_bot[62] openDVS_pixel2x2_bot
x4_x2051 dac_config_3 dac_config_5 col_event_rst_bot_right[57] dac_config_4
+ row_on_detect_bot[62] dac_config_0 dac_config_1 row_off_detect_bot[63] x4_net7
+ dac_config_2 vdda1 vssa1 vssc1 col_event_rst_bot_right[56] x4_net8 row_on_detect_bot[63]
+ row_off_detect_bot[62] openDVS_pixel2x2_bot
x4_x2052 dac_config_3 dac_config_5 col_event_rst_bot_right[55] dac_config_4
+ row_on_detect_bot[62] dac_config_0 dac_config_1 row_off_detect_bot[63] x4_net9
+ dac_config_2 vdda1 vssa1 vssc1 col_event_rst_bot_right[54] x4_net10
+ row_on_detect_bot[63] row_off_detect_bot[62] openDVS_pixel2x2_bot
x4_x2053 dac_config_3 dac_config_5 col_event_rst_bot_right[53] dac_config_4
+ row_on_detect_bot[62] dac_config_0 dac_config_1 row_off_detect_bot[63] x4_net11
+ dac_config_2 vdda1 vssa1 vssc1 col_event_rst_bot_right[52] x4_net12
+ row_on_detect_bot[63] row_off_detect_bot[62] openDVS_pixel2x2_bot
x4_x2054 dac_config_3 dac_config_5 col_event_rst_bot_right[51] dac_config_4
+ row_on_detect_bot[62] dac_config_0 dac_config_1 row_off_detect_bot[63] x4_net13
+ dac_config_2 vdda1 vssa1 vssc1 col_event_rst_bot_right[50] x4_net14
+ row_on_detect_bot[63] row_off_detect_bot[62] openDVS_pixel2x2_bot
x4_x2055 dac_config_3 dac_config_5 col_event_rst_bot_right[49] dac_config_4
+ row_on_detect_bot[62] dac_config_0 dac_config_1 row_off_detect_bot[63] x4_net15
+ dac_config_2 vdda1 vssa1 vssc1 col_event_rst_bot_right[48] x4_net16
+ row_on_detect_bot[63] row_off_detect_bot[62] openDVS_pixel2x2_bot
x4_x2056 dac_config_3 dac_config_5 col_event_rst_bot_right[47] dac_config_4
+ row_on_detect_bot[62] dac_config_0 dac_config_1 row_off_detect_bot[63] x4_net17
+ dac_config_2 vdda1 vssa1 vssc1 col_event_rst_bot_right[46] x4_net18
+ row_on_detect_bot[63] row_off_detect_bot[62] openDVS_pixel2x2_bot
x4_x2057 dac_config_3 dac_config_5 col_event_rst_bot_right[45] dac_config_4
+ row_on_detect_bot[62] dac_config_0 dac_config_1 row_off_detect_bot[63] x4_net19
+ dac_config_2 vdda1 vssa1 vssc1 col_event_rst_bot_right[44] x4_net20
+ row_on_detect_bot[63] row_off_detect_bot[62] openDVS_pixel2x2_bot
x4_x2058 dac_config_3 dac_config_5 col_event_rst_bot_right[43] dac_config_4
+ row_on_detect_bot[62] dac_config_0 dac_config_1 row_off_detect_bot[63] x4_net21
+ dac_config_2 vdda1 vssa1 vssc1 col_event_rst_bot_right[42] x4_net22
+ row_on_detect_bot[63] row_off_detect_bot[62] openDVS_pixel2x2_bot
x4_x2059 dac_config_3 dac_config_5 col_event_rst_bot_right[41] dac_config_4
+ row_on_detect_bot[62] dac_config_0 dac_config_1 row_off_detect_bot[63] x4_net23
+ dac_config_2 vdda1 vssa1 vssc1 col_event_rst_bot_right[40] x4_net24
+ row_on_detect_bot[63] row_off_detect_bot[62] openDVS_pixel2x2_bot
x4_x2060 dac_config_3 dac_config_5 col_event_rst_bot_right[39] dac_config_4
+ row_on_detect_bot[62] dac_config_0 dac_config_1 row_off_detect_bot[63] x4_net25
+ dac_config_2 vdda1 vssa1 vssc1 col_event_rst_bot_right[38] x4_net26
+ row_on_detect_bot[63] row_off_detect_bot[62] openDVS_pixel2x2_bot
x4_x2061 dac_config_3 dac_config_5 col_event_rst_bot_right[37] dac_config_4
+ row_on_detect_bot[62] dac_config_0 dac_config_1 row_off_detect_bot[63] x4_net27
+ dac_config_2 vdda1 vssa1 vssc1 col_event_rst_bot_right[36] x4_net28
+ row_on_detect_bot[63] row_off_detect_bot[62] openDVS_pixel2x2_bot
x4_x2062 dac_config_3 dac_config_5 col_event_rst_bot_right[35] dac_config_4
+ row_on_detect_bot[62] dac_config_0 dac_config_1 row_off_detect_bot[63] x4_net29
+ dac_config_2 vdda1 vssa1 vssc1 col_event_rst_bot_right[34] x4_net30
+ row_on_detect_bot[63] row_off_detect_bot[62] openDVS_pixel2x2_bot
x4_x2063 dac_config_3 dac_config_5 col_event_rst_bot_right[33] dac_config_4
+ row_on_detect_bot[62] dac_config_0 dac_config_1 row_off_detect_bot[63] x4_net31
+ dac_config_2 vdda1 vssa1 vssc1 col_event_rst_bot_right[32] x4_net32
+ row_on_detect_bot[63] row_off_detect_bot[62] openDVS_pixel2x2_bot
x4_x2064 dac_config_3 dac_config_5 col_event_rst_bot_right[31] dac_config_4
+ row_on_detect_bot[62] dac_config_0 dac_config_1 row_off_detect_bot[63] x4_net33
+ dac_config_2 vdda1 vssa1 vssc1 col_event_rst_bot_right[30] x4_net34
+ row_on_detect_bot[63] row_off_detect_bot[62] openDVS_pixel2x2_bot
x4_x2065 dac_config_3 dac_config_5 col_event_rst_bot_right[29] dac_config_4
+ row_on_detect_bot[62] dac_config_0 dac_config_1 row_off_detect_bot[63] x4_net35
+ dac_config_2 vdda1 vssa1 vssc1 col_event_rst_bot_right[28] x4_net36
+ row_on_detect_bot[63] row_off_detect_bot[62] openDVS_pixel2x2_bot
x4_x2066 dac_config_3 dac_config_5 col_event_rst_bot_right[27] dac_config_4
+ row_on_detect_bot[62] dac_config_0 dac_config_1 row_off_detect_bot[63] x4_net37
+ dac_config_2 vdda1 vssa1 vssc1 col_event_rst_bot_right[26] x4_net38
+ row_on_detect_bot[63] row_off_detect_bot[62] openDVS_pixel2x2_bot
x4_x2067 dac_config_3 dac_config_5 col_event_rst_bot_right[25] dac_config_4
+ row_on_detect_bot[62] dac_config_0 dac_config_1 row_off_detect_bot[63] x4_net39
+ dac_config_2 vdda1 vssa1 vssc1 col_event_rst_bot_right[24] x4_net40
+ row_on_detect_bot[63] row_off_detect_bot[62] openDVS_pixel2x2_bot
x4_x2068 dac_config_3 dac_config_5 col_event_rst_bot_right[23] dac_config_4
+ row_on_detect_bot[62] dac_config_0 dac_config_1 row_off_detect_bot[63] x4_net41
+ dac_config_2 vdda1 vssa1 vssc1 col_event_rst_bot_right[22] x4_net42
+ row_on_detect_bot[63] row_off_detect_bot[62] openDVS_pixel2x2_bot
x4_x2069 dac_config_3 dac_config_5 col_event_rst_bot_right[21] dac_config_4
+ row_on_detect_bot[62] dac_config_0 dac_config_1 row_off_detect_bot[63] x4_net43
+ dac_config_2 vdda1 vssa1 vssc1 col_event_rst_bot_right[20] x4_net44
+ row_on_detect_bot[63] row_off_detect_bot[62] openDVS_pixel2x2_bot
x4_x2070 dac_config_3 dac_config_5 col_event_rst_bot_right[19] dac_config_4
+ row_on_detect_bot[62] dac_config_0 dac_config_1 row_off_detect_bot[63] x4_net45
+ dac_config_2 vdda1 vssa1 vssc1 col_event_rst_bot_right[18] x4_net46
+ row_on_detect_bot[63] row_off_detect_bot[62] openDVS_pixel2x2_bot
x4_x2071 dac_config_3 dac_config_5 col_event_rst_bot_right[17] dac_config_4
+ row_on_detect_bot[62] dac_config_0 dac_config_1 row_off_detect_bot[63] x4_net47
+ dac_config_2 vdda1 vssa1 vssc1 col_event_rst_bot_right[16] x4_net48
+ row_on_detect_bot[63] row_off_detect_bot[62] openDVS_pixel2x2_bot
x4_x2072 dac_config_3 dac_config_5 col_event_rst_bot_right[15] dac_config_4
+ row_on_detect_bot[62] dac_config_0 dac_config_1 row_off_detect_bot[63] x4_net49
+ dac_config_2 vdda1 vssa1 vssc1 col_event_rst_bot_right[14] x4_net50
+ row_on_detect_bot[63] row_off_detect_bot[62] openDVS_pixel2x2_bot
x4_x2073 dac_config_3 dac_config_5 col_event_rst_bot_right[13] dac_config_4
+ row_on_detect_bot[62] dac_config_0 dac_config_1 row_off_detect_bot[63] x4_net51
+ dac_config_2 vdda1 vssa1 vssc1 col_event_rst_bot_right[12] x4_net52
+ row_on_detect_bot[63] row_off_detect_bot[62] openDVS_pixel2x2_bot
x4_x2074 dac_config_3 dac_config_5 col_event_rst_bot_right[11] dac_config_4
+ row_on_detect_bot[62] dac_config_0 dac_config_1 row_off_detect_bot[63] x4_net53
+ dac_config_2 vdda1 vssa1 vssc1 col_event_rst_bot_right[10] x4_net54
+ row_on_detect_bot[63] row_off_detect_bot[62] openDVS_pixel2x2_bot
x4_x2075 dac_config_3 dac_config_5 col_event_rst_bot_right[9] dac_config_4
+ row_on_detect_bot[62] dac_config_0 dac_config_1 row_off_detect_bot[63] x4_net55
+ dac_config_2 vdda1 vssa1 vssc1 col_event_rst_bot_right[8] x4_net56 row_on_detect_bot[63]
+ row_off_detect_bot[62] openDVS_pixel2x2_bot
x4_x2076 dac_config_3 dac_config_5 col_event_rst_bot_right[7] dac_config_4
+ row_on_detect_bot[62] dac_config_0 dac_config_1 row_off_detect_bot[63] x4_net57
+ dac_config_2 vdda1 vssa1 vssc1 col_event_rst_bot_right[6] x4_net58 row_on_detect_bot[63]
+ row_off_detect_bot[62] openDVS_pixel2x2_bot
x4_x2077 dac_config_3 dac_config_5 col_event_rst_bot_right[5] dac_config_4
+ row_on_detect_bot[62] dac_config_0 dac_config_1 row_off_detect_bot[63] x4_net59
+ dac_config_2 vdda1 vssa1 vssc1 col_event_rst_bot_right[4] x4_net60 row_on_detect_bot[63]
+ row_off_detect_bot[62] openDVS_pixel2x2_bot
x4_x2078 dac_config_3 dac_config_5 col_event_rst_bot_right[3] dac_config_4
+ row_on_detect_bot[62] dac_config_0 dac_config_1 row_off_detect_bot[63] x4_net61
+ dac_config_2 vdda1 vssa1 vssc1 col_event_rst_bot_right[2] x4_net62 row_on_detect_bot[63]
+ row_off_detect_bot[62] openDVS_pixel2x2_bot
x4_x2079 dac_config_3 dac_config_5 col_event_rst_bot_right[1] dac_config_4
+ row_on_detect_bot[62] dac_config_0 dac_config_1 row_off_detect_bot[63] x4_net63
+ dac_config_2 vdda1 vssa1 vssc1 col_event_rst_bot_right[0] x4_net64 row_on_detect_bot[63]
+ row_off_detect_bot[62] openDVS_pixel2x2_bot
.ends

* expanding   symbol:  pixel_layout_tile.sym # of pins=32
** sym_path: /home/alienfalcon/Projects/skywater/open_dvs_py312/open_dvs/git_dvs/nic2025_openDVS/analog/xschem/pixel_layout_tile.sym
** sch_path: /home/alienfalcon/Projects/skywater/open_dvs_py312/open_dvs/git_dvs/nic2025_openDVS/analog/xschem/pixel_layout_tile.sch
* Removed (flattened into top): pixel_layout_tile

* expanding   symbol:  pixel_layout_tile_bot.sym # of pins=29
** sym_path: /home/alienfalcon/Projects/skywater/open_dvs_py312/open_dvs/git_dvs/nic2025_openDVS/analog/xschem/pixel_layout_tile_bot.sym
** sch_path: /home/alienfalcon/Projects/skywater/open_dvs_py312/open_dvs/git_dvs/nic2025_openDVS/analog/xschem/pixel_layout_tile_bot.sch
* Removed (flattened into top): pixel_layout_tile_bot

* expanding   symbol:  openDVS_pixel2x2_top.sym # of pins=52
** sym_path: /home/alienfalcon/Projects/skywater/open_dvs_py312/open_dvs/git_dvs/nic2025_openDVS/analog/xschem/openDVS_pixel2x2_top.sym
** sch_path: /home/alienfalcon/Projects/skywater/open_dvs_py312/open_dvs/git_dvs/nic2025_openDVS/analog/xschem/openDVS_pixel2x2_top.sch
.subckt openDVS_pixel2x2_top PrBp RefrBp pixRst[0] PrSFBp rowReadON[1] DiffBn OffBn rowReadOFF[0] readLine[0] OnBn VddA18 GndA
+ GndD pixRst[1] readLine[1] rowReadON[0] rowReadOFF[1]
*.PININFO PrBp:B RefrBp:B DiffBn:B OffBn:B OnBn:B PrSFBp:B GndA:B VddA18:B GndD:B readLine[1:0]:B pixRst[1:0]:B rowReadON[1:0]:B
*+ rowReadOFF[1:0]:B
x1 pixRst[1] pixRst[0] rowReadON[1] rowReadON[0] rowReadOFF[1] rowReadOFF[0] readLine[1] readLine[0] net1_3 net1_2 net1_1 net1_0
+ VddA18 GndA GndD OnBn OffBn DiffBn PrSFBp RefrBp PrBp openDVS_pixel2x2
* noconn #net1
.ends

* expanding   symbol:  col_amp_2x1.sym # of pins=20
** sym_path: /home/alienfalcon/Projects/skywater/open_dvs_py312/open_dvs/git_dvs/nic2025_openDVS/analog/xschem/col_amp_2x1.sym
** sch_path: /home/alienfalcon/Projects/skywater/open_dvs_py312/open_dvs/git_dvs/nic2025_openDVS/analog/xschem/col_amp_2x1.sch
.subckt col_amp_2x1 DETECT nDETECT VTHRESH nCHARGE VDD GND COL_LINE0 COL_LINE1 voutn0 voutn1 pixRst1 pixRst0
*.PININFO nCHARGE:B VDD:B GND:B COL_LINE0:B COL_LINE1:B VTHRESH:B voutn0:B voutn1:B nDETECT:B DETECT:B pixRst0:B pixRst1:B
x5 DETECT nDETECT VTHRESH nCHARGE VDD GND COL_LINE0 voutn0 pixRst0 col_periphery
x6 DETECT nDETECT VTHRESH nCHARGE VDD GND COL_LINE1 voutn1 pixRst1 col_periphery
.ends

* expanding   symbol:  openDVS_pixel2x2_bot.sym # of pins=52
** sym_path: /home/alienfalcon/Projects/skywater/open_dvs_py312/open_dvs/git_dvs/nic2025_openDVS/analog/xschem/openDVS_pixel2x2_bot.sym
** sch_path: /home/alienfalcon/Projects/skywater/open_dvs_py312/open_dvs/git_dvs/nic2025_openDVS/analog/xschem/openDVS_pixel2x2_bot.sch
.subckt openDVS_pixel2x2_bot PrBp RefrBp pixRst[0] PrSFBp rowReadON[0] DiffBn OffBn rowReadOFF[1] readLine[0] OnBn VddA18 GndA
+ GndD pixRst[1] readLine[1] rowReadON[1] rowReadOFF[0]
*.PININFO PrBp:B RefrBp:B DiffBn:B OffBn:B OnBn:B PrSFBp:B GndA:B VddA18:B GndD:B readLine[1:0]:B pixRst[1:0]:B rowReadON[1:0]:B
*+ rowReadOFF[1:0]:B
x1 pixRst[1] pixRst[0] rowReadON[1] rowReadON[0] rowReadOFF[1] rowReadOFF[0] readLine[1] readLine[0] net1_3 net1_2 net1_1 net1_0
+ VddA18 GndA GndD OnBn OffBn DiffBn PrSFBp RefrBp PrBp openDVS_pixel2x2
* noconn #net1
.ends

* expanding   symbol:  openDVS_pixel2x2.sym # of pins=14
** sym_path: /home/alienfalcon/Projects/skywater/open_dvs_py312/open_dvs/git_dvs/nic2025_openDVS/analog/xschem/openDVS_pixel2x2.sym
** sch_path: /home/alienfalcon/Projects/skywater/open_dvs_py312/open_dvs/git_dvs/nic2025_openDVS/analog/xschem/openDVS_pixel2x2.sch
.subckt openDVS_pixel2x2 pixRst[1] pixRst[0] rowReadON[1] rowReadON[0] rowReadOFF[1] rowReadOFF[0] readLine[1] readLine[0] vpd[3]
+ vpd[2] vpd[1] vpd[0] VddA18 GndA GndD OffBn OnBn DiffBn RefrBp PrSFBp PrBp
*.PININFO PrBp:B GndA:B VddA18:B RefrBp:B DiffBn:B OffBn:B OnBn:B PrSFBp:B GndD:B vpd[3],vpd[2],vpd[1],vpd[0]:B pixRst[1:0]:I
*+ rowReadON[1:0]:I rowReadOFF[1:0]:I readLine[1:0]:B
xPix[3] rowReadON[1] VddA18 PrBp GndA vpd[3] rowReadOFF[1] pixRst[1] RefrBp DiffBn OffBn OnBn PrSFBp readLine[1] GndD
+ openDVS_pixel
xPix[2] rowReadON[0] VddA18 PrBp GndA vpd[2] rowReadOFF[0] pixRst[1] RefrBp DiffBn OffBn OnBn PrSFBp readLine[1] GndD
+ openDVS_pixel
xPix[1] rowReadON[1] VddA18 PrBp GndA vpd[1] rowReadOFF[1] pixRst[0] RefrBp DiffBn OffBn OnBn PrSFBp readLine[0] GndD
+ openDVS_pixel
xPix[0] rowReadON[0] VddA18 PrBp GndA vpd[0] rowReadOFF[0] pixRst[0] RefrBp DiffBn OffBn OnBn PrSFBp readLine[0] GndD
+ openDVS_pixel
.ends

* expanding   symbol:  col_periphery.sym # of pins=15
** sym_path: /home/alienfalcon/Projects/skywater/open_dvs_py312/open_dvs/git_dvs/nic2025_openDVS/analog/xschem/col_periphery.sym
** sch_path: /home/alienfalcon/Projects/skywater/open_dvs_py312/open_dvs/git_dvs/nic2025_openDVS/analog/xschem/col_periphery.sch
.subckt col_periphery DETECT nDETECT VTHRESH nCHARGE VDD GND readLine voutn pixRst
*.PININFO nCHARGE:B VDD:B GND:B readLine:B VTHRESH:B voutn:B nDETECT:B DETECT:B pixRst:B
x1 VDD net1 VTHRESH GND nDETECT DETECT net2 voutn dyn_comp
x2 VDD nCHARGE net1 GND readLine col_amp
* noconn pixRst
.ends

* expanding   symbol:  openDVS_pixel.sym # of pins=14
** sym_path: /home/alienfalcon/Projects/skywater/open_dvs_py312/open_dvs/git_dvs/nic2025_openDVS/analog/xschem/openDVS_pixel.sym
** sch_path: /home/alienfalcon/Projects/skywater/open_dvs_py312/open_dvs/git_dvs/nic2025_openDVS/analog/xschem/openDVS_pixel.sch
.subckt openDVS_pixel rowReadON VddA18 PrBp GndA vpd rowReadOFF pixRst RefrBp DiffBn OffBn OnBn PrSFBp readLine GndD
*.PININFO vpd:B PrBp:B GndA:B VddA18:B RefrBp:B DiffBn:B OffBn:B OnBn:B PrSFBp:B pixRst:I rowReadON:I rowReadOFF:I readLine:B
*+ GndD:B
xpr VddA18 PrBp GndA vpd vpr PixelPhotoreceptor
xsf VddA18 RefrBp GndA vpr vsf PixelSourceFollower
xchAmp VddA18 DiffBn GndA vsf vdiff nRst PixelChangeAmplifier
xcomp VddA18 OffBn GndA vdiff ON OnBn nOFF PixelComparators
xhandshake rowReadOFF GndA rowReadON readLine ON nOFF GndD PixelHandshake
xrst rowReadON GndA pixRst nRst PrSFBp VddA18 PixelResetGen
.ends

* expanding   symbol:  col_amp_v2_std_dvs/xschem/dyn_comp.sym # of pins=8
** sym_path: /home/alienfalcon/Projects/skywater/open_dvs_py312/open_dvs/git_dvs/nic2025_openDVS/analog/xschem/col_amp_v2_std_dvs/xschem/dyn_comp.sym
** sch_path: /home/alienfalcon/Projects/skywater/open_dvs_py312/open_dvs/git_dvs/nic2025_openDVS/analog/xschem/col_amp_v2_std_dvs/xschem/dyn_comp.sch
.subckt dyn_comp vdd vp vm gnd nDETECT DETECT voutp voutn
*.PININFO vdd:B gnd:B vp:I vm:I nDETECT:I voutn:O voutp:O DETECT:I
XMmirr3 int_outn DETECT vdd vdd sky130_fd_pr__pfet_01v8 L=0.5 W=1 nf=1
XMdio2 int_outp DETECT vdd vdd sky130_fd_pr__pfet_01v8 L=0.5 W=1 nf=1
XMinm3 int_outp vp vsource gnd sky130_fd_pr__nfet_01v8 L=0.15 W=1 nf=1
XMinp3 int_outn vm vsource gnd sky130_fd_pr__nfet_01v8 L=0.15 W=1 nf=1
XMbias1 vsource DETECT gnd gnd sky130_fd_pr__nfet_01v8 L=0.15 W=1 nf=1
XMmirr4 net3 nDETECT vdd vdd sky130_fd_pr__pfet_01v8 L=0.5 W=1 nf=1
XMmirr5 net2 net1 net3 vdd sky130_fd_pr__pfet_01v8 L=0.5 W=1 nf=1
XMdio3 net1 net2 net3 vdd sky130_fd_pr__pfet_01v8 L=0.5 W=1 nf=1
XMinp4 net1 net2 gnd gnd sky130_fd_pr__nfet_01v8 L=0.15 W=1 nf=1
XMinm4 net2 net1 gnd gnd sky130_fd_pr__nfet_01v8 L=0.15 W=1 nf=1
XMinm5 net1 int_outp gnd gnd sky130_fd_pr__nfet_01v8 L=0.15 W=1 nf=1 m=4
XMinp5 net2 int_outn gnd gnd sky130_fd_pr__nfet_01v8 L=0.15 W=1 nf=1 m=4
XMmirr1 voutp net2 vdd vdd sky130_fd_pr__pfet_01v8 L=1 W=2 nf=1
XMinm1 voutp net2 gnd gnd sky130_fd_pr__nfet_01v8 L=1 W=1 nf=1
XMmirr2 voutn net1 vdd vdd sky130_fd_pr__pfet_01v8 L=1 W=2 nf=1
XMinm2 voutn net1 gnd gnd sky130_fd_pr__nfet_01v8 L=1 W=1 nf=1
.ends

* expanding   symbol:  col_amp_v2_std_dvs/xschem/col_amp.sym # of pins=5
** sym_path: /home/alienfalcon/Projects/skywater/open_dvs_py312/open_dvs/git_dvs/nic2025_openDVS/analog/xschem/col_amp_v2_std_dvs/xschem/col_amp.sym
** sch_path: /home/alienfalcon/Projects/skywater/open_dvs_py312/open_dvs/git_dvs/nic2025_openDVS/analog/xschem/col_amp_v2_std_dvs/xschem/col_amp.sch
.subckt col_amp VDD nCHARGE COL_OUT GND COL_LINE
*.PININFO nCHARGE:I COL_OUT:O VDD:B GND:B COL_LINE:B
XM1 COL_OUT COL_OUT COL_LINE GND sky130_fd_pr__nfet_01v8 L=1 W=1 nf=1 m=16
XM2 COL_OUT nCHARGE VDD VDD sky130_fd_pr__pfet_01v8 L=1 W=1 nf=1 m=8
.ends

* expanding   symbol:  PixelPhotoreceptor.sym # of pins=5
** sym_path: /home/alienfalcon/Projects/skywater/open_dvs_py312/open_dvs/git_dvs/nic2025_openDVS/analog/xschem/PixelPhotoreceptor.sym
** sch_path: /home/alienfalcon/Projects/skywater/open_dvs_py312/open_dvs/git_dvs/nic2025_openDVS/analog/xschem/PixelPhotoreceptor.sch
.subckt PixelPhotoreceptor VddA18 PrBp GndA vpd vpr
*.PININFO PrBp:B VddA18:B vpd:B GndA:B vpr:B
XMpd VddA18 vpr vpd GndA sky130_fd_pr__nfet_01v8 L=0.3 W=0.5 nf=1
XMpr_amp vpr vpd GndA GndA sky130_fd_pr__nfet_01v8 L=0.3 W=0.42 nf=1
XMprBias vpr PrBp VddA18 VddA18 sky130_fd_pr__pfet_01v8 L=0.15 W=0.5 nf=1
XD1 GndA vpd sky130_fd_pr__model__parasitic__diode_ps2dn area=32.49
.ends

* expanding   symbol:  PixelSourceFollower.sym # of pins=5
** sym_path: /home/alienfalcon/Projects/skywater/open_dvs_py312/open_dvs/git_dvs/nic2025_openDVS/analog/xschem/PixelSourceFollower.sym
** sch_path: /home/alienfalcon/Projects/skywater/open_dvs_py312/open_dvs/git_dvs/nic2025_openDVS/analog/xschem/PixelSourceFollower.sch
.subckt PixelSourceFollower VddA18 PrSFBp GndA vpr vsf
*.PININFO GndA:B PrSFBp:B vpr:B vsf:B VddA18:B
XMsfBias vsf PrSFBp VddA18 VddA18 sky130_fd_pr__pfet_01v8_hvt L=1.5 W=0.42 nf=1
XMsf GndA vpr vsf VddA18 sky130_fd_pr__pfet_01v8 L=0.25 W=0.42 nf=1
.ends

* expanding   symbol:  PixelChangeAmplifier.sym # of pins=6
** sym_path: /home/alienfalcon/Projects/skywater/open_dvs_py312/open_dvs/git_dvs/nic2025_openDVS/analog/xschem/PixelChangeAmplifier.sym
** sch_path: /home/alienfalcon/Projects/skywater/open_dvs_py312/open_dvs/git_dvs/nic2025_openDVS/analog/xschem/PixelChangeAmplifier.sch
.subckt PixelChangeAmplifier VddA18 DiffBn GndA vsf vdiff nRst
*.PININFO DiffBn:B vsf:B VddA18:B GndA:B vdiff:B nRst:B
XC1b vd vsf sky130_fd_pr__cap_mim_m3_1 W=6.47 L=1.05
XC2 vd vdiff sky130_fd_pr__cap_mim_m3_1 W=1 L=1
XMchAmpBias vdiff DiffBn GndA GndA sky130_fd_pr__nfet_01v8 L=1.5 W=1.5 nf=1
XMrst vdiff nRst vd VddA18 sky130_fd_pr__pfet_01v8_hvt L=0.42 W=0.42 nf=1
XMchAmp vdiff vd VddA18 VddA18 sky130_fd_pr__pfet_01v8 L=1.5 W=1.5 nf=1
XC1a vd vsf sky130_fd_pr__cap_mim_m3_1 W=2.27 L=3.985
.ends

* expanding   symbol:  PixelComparators.sym # of pins=7
** sym_path: /home/alienfalcon/Projects/skywater/open_dvs_py312/open_dvs/git_dvs/nic2025_openDVS/analog/xschem/PixelComparators.sym
** sch_path: /home/alienfalcon/Projects/skywater/open_dvs_py312/open_dvs/git_dvs/nic2025_openDVS/analog/xschem/PixelComparators.sch
.subckt PixelComparators VddA18 OnBn GndA vdiff ON OffBn nOFF
*.PININFO OnBn:B OffBn:B VddA18:B vdiff:B GndA:B ON:B nOFF:B
XMonBias ON OnBn GndA GndA sky130_fd_pr__nfet_01v8 L=1.5 W=1.5 nf=1
XMoffBias nOFF OffBn GndA GndA sky130_fd_pr__nfet_01v8 L=1.5 W=1.5 nf=1
XMon ON vdiff VddA18 VddA18 sky130_fd_pr__pfet_01v8 L=1.5 W=1.5 nf=1
XMoff nOFF vdiff VddA18 VddA18 sky130_fd_pr__pfet_01v8 L=1.5 W=1.5 nf=1
.ends

* expanding   symbol:  PixelHandshake.sym # of pins=7
** sym_path: /home/alienfalcon/Projects/skywater/open_dvs_py312/open_dvs/git_dvs/nic2025_openDVS/analog/xschem/PixelHandshake.sym
** sch_path: /home/alienfalcon/Projects/skywater/open_dvs_py312/open_dvs/git_dvs/nic2025_openDVS/analog/xschem/PixelHandshake.sch
.subckt PixelHandshake rowReadOFF GndA rowReadON readLine ON nOFF GndD
*.PININFO rowReadON:I rowReadOFF:I readLine:B ON:B nOFF:B GndD:B GndA:B
XMswON readLine rowReadON readLineONpd GndA sky130_fd_pr__nfet_01v8 L=0.15 W=0.42 nf=1
XMoutON readLineONpd ON GndD GndA sky130_fd_pr__nfet_01v8 L=0.15 W=0.42 nf=1
XMswOFF readLine rowReadOFF readLineOFFpd GndA sky130_fd_pr__nfet_01v8 L=0.15 W=0.42 nf=1
XMoutOFF readLineOFFpd nOFF GndD GndA sky130_fd_pr__nfet_01v8 L=0.15 W=0.42 nf=1
.ends

* expanding   symbol:  PixelResetGen.sym # of pins=6
** sym_path: /home/alienfalcon/Projects/skywater/open_dvs_py312/open_dvs/git_dvs/nic2025_openDVS/analog/xschem/PixelResetGen.sym
** sch_path: /home/alienfalcon/Projects/skywater/open_dvs_py312/open_dvs/git_dvs/nic2025_openDVS/analog/xschem/PixelResetGen.sch
.subckt PixelResetGen rowRst GndA colRst nRst RefrBp VddA18
*.PININFO rowRst:I colRst:I RefrBp:B GndA:B VddA18:B nRst:B
XMPDrefrCol nRst colRst net1 GndA sky130_fd_pr__nfet_01v8 L=0.15 W=0.42 nf=1
XMrefrBias nRst RefrBp VddA18 VddA18 sky130_fd_pr__pfet_01v8 L=1.5 W=0.42 nf=1
XMcapRefr VddA18 nRst VddA18 VddA18 sky130_fd_pr__pfet_01v8 L=1.5 W=1.5 nf=1
XMPDRefrRow net1 rowRst GndA GndA sky130_fd_pr__nfet_01v8 L=0.15 W=0.42 nf=1
.ends
