** sch_path: /home/alienfalcon/Projects/skywater/open_dvs_py312/open_dvs/git_dvs/nic2025_openDVS/analog/xschem/BiasBranchnMasterx11.sch
**.subckt BiasBranchnMasterx11 VddA18 GndA BufferN BufferP rx VMasterBiasN VMasterBiasP
*+ BiasCB[7],BiasCB[6],BiasCB[5],BiasCB[4],BiasCB[3],BiasCB[2],BiasCB[1],BiasCB[0] Bias
*+ FineCodeBuffer[7],FineCodeBuffer[6],FineCodeBuffer[5],FineCodeBuffer[4],FineCodeBuffer[3],FineCodeBuffer[2],FineCodeBuffer[1],FineCodeBuffer[0]
*+ CoarseOneHot_bit7[10],CoarseOneHot_bit7[9],CoarseOneHot_bit7[8],CoarseOneHot_bit7[7],CoarseOneHot_bit7[6],CoarseOneHot_bit7[5],CoarseOneHot_bit7[4],CoarseOneHot_bit7[3],CoarseOneHot_bit7[2],CoarseOneHot_bit7[1],CoarseOneHot_bit7[0]
*+ nFineCodeBuffer[7],nFineCodeBuffer[6],nFineCodeBuffer[5],nFineCodeBuffer[4],nFineCodeBuffer[3],nFineCodeBuffer[2],nFineCodeBuffer[1],nFineCodeBuffer[0]
*+ CoarseOneHotBuffer[7],CoarseOneHotBuffer[6],CoarseOneHotBuffer[5],CoarseOneHotBuffer[4],CoarseOneHotBuffer[3],CoarseOneHotBuffer[2],CoarseOneHotBuffer[1],CoarseOneHotBuffer[0]
*+ LowBiasInterfaceEn[10],LowBiasInterfaceEn[9],LowBiasInterfaceEn[8],LowBiasInterfaceEn[7],LowBiasInterfaceEn[6],LowBiasInterfaceEn[5],LowBiasInterfaceEn[4],LowBiasInterfaceEn[3],LowBiasInterfaceEn[2],LowBiasInterfaceEn[1],LowBiasInterfaceEn[0]
*+ nLowBiasInterfaceEn[10],nLowBiasInterfaceEn[9],nLowBiasInterfaceEn[8],nLowBiasInterfaceEn[7],nLowBiasInterfaceEn[6],nLowBiasInterfaceEn[5],nLowBiasInterfaceEn[4],nLowBiasInterfaceEn[3],nLowBiasInterfaceEn[2],nLowBiasInterfaceEn[1],nLowBiasInterfaceEn[0]
*+ CoarseOneHotLowBiasEn[10],CoarseOneHotLowBiasEn[9],CoarseOneHotLowBiasEn[8],CoarseOneHotLowBiasEn[7],CoarseOneHotLowBiasEn[6],CoarseOneHotLowBiasEn[5],CoarseOneHotLowBiasEn[4],CoarseOneHotLowBiasEn[3],CoarseOneHotLowBiasEn[2],CoarseOneHotLowBiasEn[1],CoarseOneHotLowBiasEn[0] BIT0[10],BIT0[9],BIT0[8],BIT0[7],BIT0[6],BIT0[5],BIT0[4],BIT0[3],BIT0[2],BIT0[1],BIT0[0]
*+ PowerDown[10],PowerDown[9],PowerDown[8],PowerDown[7],PowerDown[6],PowerDown[5],PowerDown[4],PowerDown[3],PowerDown[2],PowerDown[1],PowerDown[0] LowBiasInterfaceEnBuffer nLowBiasInterfaceEnBuffer CoarseOneHotLowBiasEnBuffer PowerDown
*+ NBiasEn[10],NBiasEn[9],NBiasEn[8],NBiasEn[7],NBiasEn[6],NBiasEn[5],NBiasEn[4],NBiasEn[3],NBiasEn[2],NBiasEn[1],NBiasEn[0] PBiasEn[10],PBiasEn[9],PBiasEn[8],PBiasEn[7],PBiasEn[6],PBiasEn[5],PBiasEn[4],PBiasEn[3],PBiasEn[2],PBiasEn[1],PBiasEn[0]
*+ BiasDisable[10],BiasDisable[9],BiasDisable[8],BiasDisable[7],BiasDisable[6],BiasDisable[5],BiasDisable[4],BiasDisable[3],BiasDisable[2],BiasDisable[1],BiasDisable[0]
*+ FineCode_bit0[10],FineCode_bit0[9],FineCode_bit0[8],FineCode_bit0[7],FineCode_bit0[6],FineCode_bit0[5],FineCode_bit0[4],FineCode_bit0[3],FineCode_bit0[2],FineCode_bit0[1],FineCode_bit0[0]
*+ FineCode_bit1[10],FineCode_bit1[9],FineCode_bit1[8],FineCode_bit1[7],FineCode_bit1[6],FineCode_bit1[5],FineCode_bit1[4],FineCode_bit1[3],FineCode_bit1[2],FineCode_bit1[1],FineCode_bit1[0]
*+ FineCode_bit2[10],FineCode_bit2[9],FineCode_bit2[8],FineCode_bit2[7],FineCode_bit2[6],FineCode_bit2[5],FineCode_bit2[4],FineCode_bit2[3],FineCode_bit2[2],FineCode_bit2[1],FineCode_bit2[0]
*+ FineCode_bit3[10],FineCode_bit3[9],FineCode_bit3[8],FineCode_bit3[7],FineCode_bit3[6],FineCode_bit3[5],FineCode_bit3[4],FineCode_bit3[3],FineCode_bit3[2],FineCode_bit3[1],FineCode_bit3[0]
*+ FineCode_bit4[10],FineCode_bit4[9],FineCode_bit4[8],FineCode_bit4[7],FineCode_bit4[6],FineCode_bit4[5],FineCode_bit4[4],FineCode_bit4[3],FineCode_bit4[2],FineCode_bit4[1],FineCode_bit4[0]
*+ FineCode_bit5[10],FineCode_bit5[9],FineCode_bit5[8],FineCode_bit5[7],FineCode_bit5[6],FineCode_bit5[5],FineCode_bit5[4],FineCode_bit5[3],FineCode_bit5[2],FineCode_bit5[1],FineCode_bit5[0]
*+ FineCode_bit6[10],FineCode_bit6[9],FineCode_bit6[8],FineCode_bit6[7],FineCode_bit6[6],FineCode_bit6[5],FineCode_bit6[4],FineCode_bit6[3],FineCode_bit6[2],FineCode_bit6[1],FineCode_bit6[0]
*+ FineCode_bit7[10],FineCode_bit7[9],FineCode_bit7[8],FineCode_bit7[7],FineCode_bit7[6],FineCode_bit7[5],FineCode_bit7[4],FineCode_bit7[3],FineCode_bit7[2],FineCode_bit7[1],FineCode_bit7[0]
*+ nFineCode_bit0[10],nFineCode_bit0[9],nFineCode_bit0[8],nFineCode_bit0[7],nFineCode_bit0[6],nFineCode_bit0[5],nFineCode_bit0[4],nFineCode_bit0[3],nFineCode_bit0[2],nFineCode_bit0[1],nFineCode_bit0[0]
*+ nFineCode_bit1[10],nFineCode_bit1[9],nFineCode_bit1[8],nFineCode_bit1[7],nFineCode_bit1[6],nFineCode_bit1[5],nFineCode_bit1[4],nFineCode_bit1[3],nFineCode_bit1[2],nFineCode_bit1[1],nFineCode_bit1[0]
*+ nFineCode_bit2[10],nFineCode_bit2[9],nFineCode_bit2[8],nFineCode_bit2[7],nFineCode_bit2[6],nFineCode_bit2[5],nFineCode_bit2[4],nFineCode_bit2[3],nFineCode_bit2[2],nFineCode_bit2[1],nFineCode_bit2[0]
*+ nFineCode_bit3[10],nFineCode_bit3[9],nFineCode_bit3[8],nFineCode_bit3[7],nFineCode_bit3[6],nFineCode_bit3[5],nFineCode_bit3[4],nFineCode_bit3[3],nFineCode_bit3[2],nFineCode_bit3[1],nFineCode_bit3[0]
*+ nFineCode_bit4[10],nFineCode_bit4[9],nFineCode_bit4[8],nFineCode_bit4[7],nFineCode_bit4[6],nFineCode_bit4[5],nFineCode_bit4[4],nFineCode_bit4[3],nFineCode_bit4[2],nFineCode_bit4[1],nFineCode_bit4[0]
*+ nFineCode_bit5[10],nFineCode_bit5[9],nFineCode_bit5[8],nFineCode_bit5[7],nFineCode_bit5[6],nFineCode_bit5[5],nFineCode_bit5[4],nFineCode_bit5[3],nFineCode_bit5[2],nFineCode_bit5[1],nFineCode_bit5[0]
*+ nFineCode_bit6[10],nFineCode_bit6[9],nFineCode_bit6[8],nFineCode_bit6[7],nFineCode_bit6[6],nFineCode_bit6[5],nFineCode_bit6[4],nFineCode_bit6[3],nFineCode_bit6[2],nFineCode_bit6[1],nFineCode_bit6[0]
*+ nFineCode_bit7[10],nFineCode_bit7[9],nFineCode_bit7[8],nFineCode_bit7[7],nFineCode_bit7[6],nFineCode_bit7[5],nFineCode_bit7[4],nFineCode_bit7[3],nFineCode_bit7[2],nFineCode_bit7[1],nFineCode_bit7[0]
*+ CoarseOneHot_bit0[10],CoarseOneHot_bit0[9],CoarseOneHot_bit0[8],CoarseOneHot_bit0[7],CoarseOneHot_bit0[6],CoarseOneHot_bit0[5],CoarseOneHot_bit0[4],CoarseOneHot_bit0[3],CoarseOneHot_bit0[2],CoarseOneHot_bit0[1],CoarseOneHot_bit0[0]
*+ CoarseOneHot_bit1[10],CoarseOneHot_bit1[9],CoarseOneHot_bit1[8],CoarseOneHot_bit1[7],CoarseOneHot_bit1[6],CoarseOneHot_bit1[5],CoarseOneHot_bit1[4],CoarseOneHot_bit1[3],CoarseOneHot_bit1[2],CoarseOneHot_bit1[1],CoarseOneHot_bit1[0]
*+ CoarseOneHot_bit2[10],CoarseOneHot_bit2[9],CoarseOneHot_bit2[8],CoarseOneHot_bit2[7],CoarseOneHot_bit2[6],CoarseOneHot_bit2[5],CoarseOneHot_bit2[4],CoarseOneHot_bit2[3],CoarseOneHot_bit2[2],CoarseOneHot_bit2[1],CoarseOneHot_bit2[0]
*+ CoarseOneHot_bit3[10],CoarseOneHot_bit3[9],CoarseOneHot_bit3[8],CoarseOneHot_bit3[7],CoarseOneHot_bit3[6],CoarseOneHot_bit3[5],CoarseOneHot_bit3[4],CoarseOneHot_bit3[3],CoarseOneHot_bit3[2],CoarseOneHot_bit3[1],CoarseOneHot_bit3[0]
*+ CoarseOneHot_bit4[10],CoarseOneHot_bit4[9],CoarseOneHot_bit4[8],CoarseOneHot_bit4[7],CoarseOneHot_bit4[6],CoarseOneHot_bit4[5],CoarseOneHot_bit4[4],CoarseOneHot_bit4[3],CoarseOneHot_bit4[2],CoarseOneHot_bit4[1],CoarseOneHot_bit4[0]
*+ CoarseOneHot_bit5[10],CoarseOneHot_bit5[9],CoarseOneHot_bit5[8],CoarseOneHot_bit5[7],CoarseOneHot_bit5[6],CoarseOneHot_bit5[5],CoarseOneHot_bit5[4],CoarseOneHot_bit5[3],CoarseOneHot_bit5[2],CoarseOneHot_bit5[1],CoarseOneHot_bit5[0]
*+ CoarseOneHot_bit6[10],CoarseOneHot_bit6[9],CoarseOneHot_bit6[8],CoarseOneHot_bit6[7],CoarseOneHot_bit6[6],CoarseOneHot_bit6[5],CoarseOneHot_bit6[4],CoarseOneHot_bit6[3],CoarseOneHot_bit6[2],CoarseOneHot_bit6[1],CoarseOneHot_bit6[0] PadBias[10],PadBias[9],PadBias[8],PadBias[7],PadBias[6],PadBias[5],PadBias[4],PadBias[3],PadBias[2],PadBias[1],PadBias[0]
*+ PadBias[10],PadBias[9],PadBias[8],PadBias[7],PadBias[6],PadBias[5],PadBias[4],PadBias[3],PadBias[2],PadBias[1],PadBias[0]
*.iopin VddA18
*.iopin GndA
*.opin BufferN
*.opin BufferP
*.iopin rx
*.opin VMasterBiasN
*.opin VMasterBiasP
*.opin BiasCB[7],BiasCB[6],BiasCB[5],BiasCB[4],BiasCB[3],BiasCB[2],BiasCB[1],BiasCB[0]
*.opin Bias
*.ipin
*+ FineCodeBuffer[7],FineCodeBuffer[6],FineCodeBuffer[5],FineCodeBuffer[4],FineCodeBuffer[3],FineCodeBuffer[2],FineCodeBuffer[1],FineCodeBuffer[0]
*.ipin
*+ CoarseOneHot_bit7[10],CoarseOneHot_bit7[9],CoarseOneHot_bit7[8],CoarseOneHot_bit7[7],CoarseOneHot_bit7[6],CoarseOneHot_bit7[5],CoarseOneHot_bit7[4],CoarseOneHot_bit7[3],CoarseOneHot_bit7[2],CoarseOneHot_bit7[1],CoarseOneHot_bit7[0]
*.ipin
*+ nFineCodeBuffer[7],nFineCodeBuffer[6],nFineCodeBuffer[5],nFineCodeBuffer[4],nFineCodeBuffer[3],nFineCodeBuffer[2],nFineCodeBuffer[1],nFineCodeBuffer[0]
*.ipin
*+ CoarseOneHotBuffer[7],CoarseOneHotBuffer[6],CoarseOneHotBuffer[5],CoarseOneHotBuffer[4],CoarseOneHotBuffer[3],CoarseOneHotBuffer[2],CoarseOneHotBuffer[1],CoarseOneHotBuffer[0]
*.ipin
*+ LowBiasInterfaceEn[10],LowBiasInterfaceEn[9],LowBiasInterfaceEn[8],LowBiasInterfaceEn[7],LowBiasInterfaceEn[6],LowBiasInterfaceEn[5],LowBiasInterfaceEn[4],LowBiasInterfaceEn[3],LowBiasInterfaceEn[2],LowBiasInterfaceEn[1],LowBiasInterfaceEn[0]
*.ipin
*+ nLowBiasInterfaceEn[10],nLowBiasInterfaceEn[9],nLowBiasInterfaceEn[8],nLowBiasInterfaceEn[7],nLowBiasInterfaceEn[6],nLowBiasInterfaceEn[5],nLowBiasInterfaceEn[4],nLowBiasInterfaceEn[3],nLowBiasInterfaceEn[2],nLowBiasInterfaceEn[1],nLowBiasInterfaceEn[0]
*.ipin
*+ CoarseOneHotLowBiasEn[10],CoarseOneHotLowBiasEn[9],CoarseOneHotLowBiasEn[8],CoarseOneHotLowBiasEn[7],CoarseOneHotLowBiasEn[6],CoarseOneHotLowBiasEn[5],CoarseOneHotLowBiasEn[4],CoarseOneHotLowBiasEn[3],CoarseOneHotLowBiasEn[2],CoarseOneHotLowBiasEn[1],CoarseOneHotLowBiasEn[0]
*.ipin BIT0[10],BIT0[9],BIT0[8],BIT0[7],BIT0[6],BIT0[5],BIT0[4],BIT0[3],BIT0[2],BIT0[1],BIT0[0]
*.ipin
*+ PowerDown[10],PowerDown[9],PowerDown[8],PowerDown[7],PowerDown[6],PowerDown[5],PowerDown[4],PowerDown[3],PowerDown[2],PowerDown[1],PowerDown[0]
*.ipin LowBiasInterfaceEnBuffer
*.ipin nLowBiasInterfaceEnBuffer
*.ipin CoarseOneHotLowBiasEnBuffer
*.ipin PowerDown
*.ipin NBiasEn[10],NBiasEn[9],NBiasEn[8],NBiasEn[7],NBiasEn[6],NBiasEn[5],NBiasEn[4],NBiasEn[3],NBiasEn[2],NBiasEn[1],NBiasEn[0]
*.ipin PBiasEn[10],PBiasEn[9],PBiasEn[8],PBiasEn[7],PBiasEn[6],PBiasEn[5],PBiasEn[4],PBiasEn[3],PBiasEn[2],PBiasEn[1],PBiasEn[0]
*.ipin
*+ BiasDisable[10],BiasDisable[9],BiasDisable[8],BiasDisable[7],BiasDisable[6],BiasDisable[5],BiasDisable[4],BiasDisable[3],BiasDisable[2],BiasDisable[1],BiasDisable[0]
*.ipin
*+ FineCode_bit0[10],FineCode_bit0[9],FineCode_bit0[8],FineCode_bit0[7],FineCode_bit0[6],FineCode_bit0[5],FineCode_bit0[4],FineCode_bit0[3],FineCode_bit0[2],FineCode_bit0[1],FineCode_bit0[0]
*.ipin
*+ FineCode_bit1[10],FineCode_bit1[9],FineCode_bit1[8],FineCode_bit1[7],FineCode_bit1[6],FineCode_bit1[5],FineCode_bit1[4],FineCode_bit1[3],FineCode_bit1[2],FineCode_bit1[1],FineCode_bit1[0]
*.ipin
*+ FineCode_bit2[10],FineCode_bit2[9],FineCode_bit2[8],FineCode_bit2[7],FineCode_bit2[6],FineCode_bit2[5],FineCode_bit2[4],FineCode_bit2[3],FineCode_bit2[2],FineCode_bit2[1],FineCode_bit2[0]
*.ipin
*+ FineCode_bit3[10],FineCode_bit3[9],FineCode_bit3[8],FineCode_bit3[7],FineCode_bit3[6],FineCode_bit3[5],FineCode_bit3[4],FineCode_bit3[3],FineCode_bit3[2],FineCode_bit3[1],FineCode_bit3[0]
*.ipin
*+ FineCode_bit4[10],FineCode_bit4[9],FineCode_bit4[8],FineCode_bit4[7],FineCode_bit4[6],FineCode_bit4[5],FineCode_bit4[4],FineCode_bit4[3],FineCode_bit4[2],FineCode_bit4[1],FineCode_bit4[0]
*.ipin
*+ FineCode_bit5[10],FineCode_bit5[9],FineCode_bit5[8],FineCode_bit5[7],FineCode_bit5[6],FineCode_bit5[5],FineCode_bit5[4],FineCode_bit5[3],FineCode_bit5[2],FineCode_bit5[1],FineCode_bit5[0]
*.ipin
*+ FineCode_bit6[10],FineCode_bit6[9],FineCode_bit6[8],FineCode_bit6[7],FineCode_bit6[6],FineCode_bit6[5],FineCode_bit6[4],FineCode_bit6[3],FineCode_bit6[2],FineCode_bit6[1],FineCode_bit6[0]
*.ipin
*+ FineCode_bit7[10],FineCode_bit7[9],FineCode_bit7[8],FineCode_bit7[7],FineCode_bit7[6],FineCode_bit7[5],FineCode_bit7[4],FineCode_bit7[3],FineCode_bit7[2],FineCode_bit7[1],FineCode_bit7[0]
*.ipin
*+ nFineCode_bit0[10],nFineCode_bit0[9],nFineCode_bit0[8],nFineCode_bit0[7],nFineCode_bit0[6],nFineCode_bit0[5],nFineCode_bit0[4],nFineCode_bit0[3],nFineCode_bit0[2],nFineCode_bit0[1],nFineCode_bit0[0]
*.ipin
*+ nFineCode_bit1[10],nFineCode_bit1[9],nFineCode_bit1[8],nFineCode_bit1[7],nFineCode_bit1[6],nFineCode_bit1[5],nFineCode_bit1[4],nFineCode_bit1[3],nFineCode_bit1[2],nFineCode_bit1[1],nFineCode_bit1[0]
*.ipin
*+ nFineCode_bit2[10],nFineCode_bit2[9],nFineCode_bit2[8],nFineCode_bit2[7],nFineCode_bit2[6],nFineCode_bit2[5],nFineCode_bit2[4],nFineCode_bit2[3],nFineCode_bit2[2],nFineCode_bit2[1],nFineCode_bit2[0]
*.ipin
*+ nFineCode_bit3[10],nFineCode_bit3[9],nFineCode_bit3[8],nFineCode_bit3[7],nFineCode_bit3[6],nFineCode_bit3[5],nFineCode_bit3[4],nFineCode_bit3[3],nFineCode_bit3[2],nFineCode_bit3[1],nFineCode_bit3[0]
*.ipin
*+ nFineCode_bit4[10],nFineCode_bit4[9],nFineCode_bit4[8],nFineCode_bit4[7],nFineCode_bit4[6],nFineCode_bit4[5],nFineCode_bit4[4],nFineCode_bit4[3],nFineCode_bit4[2],nFineCode_bit4[1],nFineCode_bit4[0]
*.ipin
*+ nFineCode_bit5[10],nFineCode_bit5[9],nFineCode_bit5[8],nFineCode_bit5[7],nFineCode_bit5[6],nFineCode_bit5[5],nFineCode_bit5[4],nFineCode_bit5[3],nFineCode_bit5[2],nFineCode_bit5[1],nFineCode_bit5[0]
*.ipin
*+ nFineCode_bit6[10],nFineCode_bit6[9],nFineCode_bit6[8],nFineCode_bit6[7],nFineCode_bit6[6],nFineCode_bit6[5],nFineCode_bit6[4],nFineCode_bit6[3],nFineCode_bit6[2],nFineCode_bit6[1],nFineCode_bit6[0]
*.ipin
*+ nFineCode_bit7[10],nFineCode_bit7[9],nFineCode_bit7[8],nFineCode_bit7[7],nFineCode_bit7[6],nFineCode_bit7[5],nFineCode_bit7[4],nFineCode_bit7[3],nFineCode_bit7[2],nFineCode_bit7[1],nFineCode_bit7[0]
*.ipin
*+ CoarseOneHot_bit0[10],CoarseOneHot_bit0[9],CoarseOneHot_bit0[8],CoarseOneHot_bit0[7],CoarseOneHot_bit0[6],CoarseOneHot_bit0[5],CoarseOneHot_bit0[4],CoarseOneHot_bit0[3],CoarseOneHot_bit0[2],CoarseOneHot_bit0[1],CoarseOneHot_bit0[0]
*.ipin
*+ CoarseOneHot_bit1[10],CoarseOneHot_bit1[9],CoarseOneHot_bit1[8],CoarseOneHot_bit1[7],CoarseOneHot_bit1[6],CoarseOneHot_bit1[5],CoarseOneHot_bit1[4],CoarseOneHot_bit1[3],CoarseOneHot_bit1[2],CoarseOneHot_bit1[1],CoarseOneHot_bit1[0]
*.ipin
*+ CoarseOneHot_bit2[10],CoarseOneHot_bit2[9],CoarseOneHot_bit2[8],CoarseOneHot_bit2[7],CoarseOneHot_bit2[6],CoarseOneHot_bit2[5],CoarseOneHot_bit2[4],CoarseOneHot_bit2[3],CoarseOneHot_bit2[2],CoarseOneHot_bit2[1],CoarseOneHot_bit2[0]
*.ipin
*+ CoarseOneHot_bit3[10],CoarseOneHot_bit3[9],CoarseOneHot_bit3[8],CoarseOneHot_bit3[7],CoarseOneHot_bit3[6],CoarseOneHot_bit3[5],CoarseOneHot_bit3[4],CoarseOneHot_bit3[3],CoarseOneHot_bit3[2],CoarseOneHot_bit3[1],CoarseOneHot_bit3[0]
*.ipin
*+ CoarseOneHot_bit4[10],CoarseOneHot_bit4[9],CoarseOneHot_bit4[8],CoarseOneHot_bit4[7],CoarseOneHot_bit4[6],CoarseOneHot_bit4[5],CoarseOneHot_bit4[4],CoarseOneHot_bit4[3],CoarseOneHot_bit4[2],CoarseOneHot_bit4[1],CoarseOneHot_bit4[0]
*.ipin
*+ CoarseOneHot_bit5[10],CoarseOneHot_bit5[9],CoarseOneHot_bit5[8],CoarseOneHot_bit5[7],CoarseOneHot_bit5[6],CoarseOneHot_bit5[5],CoarseOneHot_bit5[4],CoarseOneHot_bit5[3],CoarseOneHot_bit5[2],CoarseOneHot_bit5[1],CoarseOneHot_bit5[0]
*.ipin
*+ CoarseOneHot_bit6[10],CoarseOneHot_bit6[9],CoarseOneHot_bit6[8],CoarseOneHot_bit6[7],CoarseOneHot_bit6[6],CoarseOneHot_bit6[5],CoarseOneHot_bit6[4],CoarseOneHot_bit6[3],CoarseOneHot_bit6[2],CoarseOneHot_bit6[1],CoarseOneHot_bit6[0]
*.iopin PadBias[10],PadBias[9],PadBias[8],PadBias[7],PadBias[6],PadBias[5],PadBias[4],PadBias[3],PadBias[2],PadBias[1],PadBias[0]
*.iopin PadBias[10],PadBias[9],PadBias[8],PadBias[7],PadBias[6],PadBias[5],PadBias[4],PadBias[3],PadBias[2],PadBias[1],PadBias[0]
xBiasBranch[10] VddA18 GndA BiasCB[7] BiasCB[6] BiasCB[5] BiasCB[4] BiasCB[3] BiasCB[2] BiasCB[1] BiasCB[0] BufferN BufferP Bias
+ LowBiasInterfaceEn[10] nLowBiasInterfaceEn[10] FineCode_bit7[10] CoarseOneHotLowBiasEn[10] BIT0[10] NBiasEn[10] PBiasEn[10] BiasDisable[10]
+ FineCode_bit6[10] FineCode_bit5[10] FineCode_bit4[10] FineCode_bit3[10] FineCode_bit2[10] FineCode_bit1[10] FineCode_bit0[10] nFineCode_bit7[10]
+ nFineCode_bit6[10] nFineCode_bit5[10] nFineCode_bit4[10] nFineCode_bit3[10] nFineCode_bit2[10] nFineCode_bit1[10] nFineCode_bit0[10]
+ CoarseOneHot_bit7[10] CoarseOneHot_bit6[10] CoarseOneHot_bit5[10] CoarseOneHot_bit4[10] CoarseOneHot_bit3[10] CoarseOneHot_bit2[10]
+ CoarseOneHot_bit1[10] CoarseOneHot_bit0[10] PadBias[10] PowerDown[10] BiasBranch
xBiasBranch[9] VddA18 GndA BiasCB[7] BiasCB[6] BiasCB[5] BiasCB[4] BiasCB[3] BiasCB[2] BiasCB[1] BiasCB[0] BufferN BufferP Bias
+ LowBiasInterfaceEn[9] nLowBiasInterfaceEn[9] FineCode_bit7[9] CoarseOneHotLowBiasEn[9] BIT0[9] NBiasEn[9] PBiasEn[9] BiasDisable[9] FineCode_bit6[9]
+ FineCode_bit5[9] FineCode_bit4[9] FineCode_bit3[9] FineCode_bit2[9] FineCode_bit1[9] FineCode_bit0[9] nFineCode_bit7[9] nFineCode_bit6[9]
+ nFineCode_bit5[9] nFineCode_bit4[9] nFineCode_bit3[9] nFineCode_bit2[9] nFineCode_bit1[9] nFineCode_bit0[9] CoarseOneHot_bit7[9]
+ CoarseOneHot_bit6[9] CoarseOneHot_bit5[9] CoarseOneHot_bit4[9] CoarseOneHot_bit3[9] CoarseOneHot_bit2[9] CoarseOneHot_bit1[9] CoarseOneHot_bit0[9]
+ PadBias[9] PowerDown[9] BiasBranch
xBiasBranch[8] VddA18 GndA BiasCB[7] BiasCB[6] BiasCB[5] BiasCB[4] BiasCB[3] BiasCB[2] BiasCB[1] BiasCB[0] BufferN BufferP Bias
+ LowBiasInterfaceEn[8] nLowBiasInterfaceEn[8] FineCode_bit7[8] CoarseOneHotLowBiasEn[8] BIT0[8] NBiasEn[8] PBiasEn[8] BiasDisable[8] FineCode_bit6[8]
+ FineCode_bit5[8] FineCode_bit4[8] FineCode_bit3[8] FineCode_bit2[8] FineCode_bit1[8] FineCode_bit0[8] nFineCode_bit7[8] nFineCode_bit6[8]
+ nFineCode_bit5[8] nFineCode_bit4[8] nFineCode_bit3[8] nFineCode_bit2[8] nFineCode_bit1[8] nFineCode_bit0[8] CoarseOneHot_bit7[8]
+ CoarseOneHot_bit6[8] CoarseOneHot_bit5[8] CoarseOneHot_bit4[8] CoarseOneHot_bit3[8] CoarseOneHot_bit2[8] CoarseOneHot_bit1[8] CoarseOneHot_bit0[8]
+ PadBias[8] PowerDown[8] BiasBranch
xBiasBranch[7] VddA18 GndA BiasCB[7] BiasCB[6] BiasCB[5] BiasCB[4] BiasCB[3] BiasCB[2] BiasCB[1] BiasCB[0] BufferN BufferP Bias
+ LowBiasInterfaceEn[7] nLowBiasInterfaceEn[7] FineCode_bit7[7] CoarseOneHotLowBiasEn[7] BIT0[7] NBiasEn[7] PBiasEn[7] BiasDisable[7] FineCode_bit6[7]
+ FineCode_bit5[7] FineCode_bit4[7] FineCode_bit3[7] FineCode_bit2[7] FineCode_bit1[7] FineCode_bit0[7] nFineCode_bit7[7] nFineCode_bit6[7]
+ nFineCode_bit5[7] nFineCode_bit4[7] nFineCode_bit3[7] nFineCode_bit2[7] nFineCode_bit1[7] nFineCode_bit0[7] CoarseOneHot_bit7[7]
+ CoarseOneHot_bit6[7] CoarseOneHot_bit5[7] CoarseOneHot_bit4[7] CoarseOneHot_bit3[7] CoarseOneHot_bit2[7] CoarseOneHot_bit1[7] CoarseOneHot_bit0[7]
+ PadBias[7] PowerDown[7] BiasBranch
xBiasBranch[6] VddA18 GndA BiasCB[7] BiasCB[6] BiasCB[5] BiasCB[4] BiasCB[3] BiasCB[2] BiasCB[1] BiasCB[0] BufferN BufferP Bias
+ LowBiasInterfaceEn[6] nLowBiasInterfaceEn[6] FineCode_bit7[6] CoarseOneHotLowBiasEn[6] BIT0[6] NBiasEn[6] PBiasEn[6] BiasDisable[6] FineCode_bit6[6]
+ FineCode_bit5[6] FineCode_bit4[6] FineCode_bit3[6] FineCode_bit2[6] FineCode_bit1[6] FineCode_bit0[6] nFineCode_bit7[6] nFineCode_bit6[6]
+ nFineCode_bit5[6] nFineCode_bit4[6] nFineCode_bit3[6] nFineCode_bit2[6] nFineCode_bit1[6] nFineCode_bit0[6] CoarseOneHot_bit7[6]
+ CoarseOneHot_bit6[6] CoarseOneHot_bit5[6] CoarseOneHot_bit4[6] CoarseOneHot_bit3[6] CoarseOneHot_bit2[6] CoarseOneHot_bit1[6] CoarseOneHot_bit0[6]
+ PadBias[6] PowerDown[6] BiasBranch
xBiasBranch[5] VddA18 GndA BiasCB[7] BiasCB[6] BiasCB[5] BiasCB[4] BiasCB[3] BiasCB[2] BiasCB[1] BiasCB[0] BufferN BufferP Bias
+ LowBiasInterfaceEn[5] nLowBiasInterfaceEn[5] FineCode_bit7[5] CoarseOneHotLowBiasEn[5] BIT0[5] NBiasEn[5] PBiasEn[5] BiasDisable[5] FineCode_bit6[5]
+ FineCode_bit5[5] FineCode_bit4[5] FineCode_bit3[5] FineCode_bit2[5] FineCode_bit1[5] FineCode_bit0[5] nFineCode_bit7[5] nFineCode_bit6[5]
+ nFineCode_bit5[5] nFineCode_bit4[5] nFineCode_bit3[5] nFineCode_bit2[5] nFineCode_bit1[5] nFineCode_bit0[5] CoarseOneHot_bit7[5]
+ CoarseOneHot_bit6[5] CoarseOneHot_bit5[5] CoarseOneHot_bit4[5] CoarseOneHot_bit3[5] CoarseOneHot_bit2[5] CoarseOneHot_bit1[5] CoarseOneHot_bit0[5]
+ PadBias[5] PowerDown[5] BiasBranch
xBiasBranch[4] VddA18 GndA BiasCB[7] BiasCB[6] BiasCB[5] BiasCB[4] BiasCB[3] BiasCB[2] BiasCB[1] BiasCB[0] BufferN BufferP Bias
+ LowBiasInterfaceEn[4] nLowBiasInterfaceEn[4] FineCode_bit7[4] CoarseOneHotLowBiasEn[4] BIT0[4] NBiasEn[4] PBiasEn[4] BiasDisable[4] FineCode_bit6[4]
+ FineCode_bit5[4] FineCode_bit4[4] FineCode_bit3[4] FineCode_bit2[4] FineCode_bit1[4] FineCode_bit0[4] nFineCode_bit7[4] nFineCode_bit6[4]
+ nFineCode_bit5[4] nFineCode_bit4[4] nFineCode_bit3[4] nFineCode_bit2[4] nFineCode_bit1[4] nFineCode_bit0[4] CoarseOneHot_bit7[4]
+ CoarseOneHot_bit6[4] CoarseOneHot_bit5[4] CoarseOneHot_bit4[4] CoarseOneHot_bit3[4] CoarseOneHot_bit2[4] CoarseOneHot_bit1[4] CoarseOneHot_bit0[4]
+ PadBias[4] PowerDown[4] BiasBranch
xBiasBranch[3] VddA18 GndA BiasCB[7] BiasCB[6] BiasCB[5] BiasCB[4] BiasCB[3] BiasCB[2] BiasCB[1] BiasCB[0] BufferN BufferP Bias
+ LowBiasInterfaceEn[3] nLowBiasInterfaceEn[3] FineCode_bit7[3] CoarseOneHotLowBiasEn[3] BIT0[3] NBiasEn[3] PBiasEn[3] BiasDisable[3] FineCode_bit6[3]
+ FineCode_bit5[3] FineCode_bit4[3] FineCode_bit3[3] FineCode_bit2[3] FineCode_bit1[3] FineCode_bit0[3] nFineCode_bit7[3] nFineCode_bit6[3]
+ nFineCode_bit5[3] nFineCode_bit4[3] nFineCode_bit3[3] nFineCode_bit2[3] nFineCode_bit1[3] nFineCode_bit0[3] CoarseOneHot_bit7[3]
+ CoarseOneHot_bit6[3] CoarseOneHot_bit5[3] CoarseOneHot_bit4[3] CoarseOneHot_bit3[3] CoarseOneHot_bit2[3] CoarseOneHot_bit1[3] CoarseOneHot_bit0[3]
+ PadBias[3] PowerDown[3] BiasBranch
xBiasBranch[2] VddA18 GndA BiasCB[7] BiasCB[6] BiasCB[5] BiasCB[4] BiasCB[3] BiasCB[2] BiasCB[1] BiasCB[0] BufferN BufferP Bias
+ LowBiasInterfaceEn[2] nLowBiasInterfaceEn[2] FineCode_bit7[2] CoarseOneHotLowBiasEn[2] BIT0[2] NBiasEn[2] PBiasEn[2] BiasDisable[2] FineCode_bit6[2]
+ FineCode_bit5[2] FineCode_bit4[2] FineCode_bit3[2] FineCode_bit2[2] FineCode_bit1[2] FineCode_bit0[2] nFineCode_bit7[2] nFineCode_bit6[2]
+ nFineCode_bit5[2] nFineCode_bit4[2] nFineCode_bit3[2] nFineCode_bit2[2] nFineCode_bit1[2] nFineCode_bit0[2] CoarseOneHot_bit7[2]
+ CoarseOneHot_bit6[2] CoarseOneHot_bit5[2] CoarseOneHot_bit4[2] CoarseOneHot_bit3[2] CoarseOneHot_bit2[2] CoarseOneHot_bit1[2] CoarseOneHot_bit0[2]
+ PadBias[2] PowerDown[2] BiasBranch
xBiasBranch[1] VddA18 GndA BiasCB[7] BiasCB[6] BiasCB[5] BiasCB[4] BiasCB[3] BiasCB[2] BiasCB[1] BiasCB[0] BufferN BufferP Bias
+ LowBiasInterfaceEn[1] nLowBiasInterfaceEn[1] FineCode_bit7[1] CoarseOneHotLowBiasEn[1] BIT0[1] NBiasEn[1] PBiasEn[1] BiasDisable[1] FineCode_bit6[1]
+ FineCode_bit5[1] FineCode_bit4[1] FineCode_bit3[1] FineCode_bit2[1] FineCode_bit1[1] FineCode_bit0[1] nFineCode_bit7[1] nFineCode_bit6[1]
+ nFineCode_bit5[1] nFineCode_bit4[1] nFineCode_bit3[1] nFineCode_bit2[1] nFineCode_bit1[1] nFineCode_bit0[1] CoarseOneHot_bit7[1]
+ CoarseOneHot_bit6[1] CoarseOneHot_bit5[1] CoarseOneHot_bit4[1] CoarseOneHot_bit3[1] CoarseOneHot_bit2[1] CoarseOneHot_bit1[1] CoarseOneHot_bit0[1]
+ PadBias[1] PowerDown[1] BiasBranch
xBiasBranch[0] VddA18 GndA BiasCB[7] BiasCB[6] BiasCB[5] BiasCB[4] BiasCB[3] BiasCB[2] BiasCB[1] BiasCB[0] BufferN BufferP Bias
+ LowBiasInterfaceEn[0] nLowBiasInterfaceEn[0] FineCode_bit7[0] CoarseOneHotLowBiasEn[0] BIT0[0] NBiasEn[0] PBiasEn[0] BiasDisable[0] FineCode_bit6[0]
+ FineCode_bit5[0] FineCode_bit4[0] FineCode_bit3[0] FineCode_bit2[0] FineCode_bit1[0] FineCode_bit0[0] nFineCode_bit7[0] nFineCode_bit6[0]
+ nFineCode_bit5[0] nFineCode_bit4[0] nFineCode_bit3[0] nFineCode_bit2[0] nFineCode_bit1[0] nFineCode_bit0[0] CoarseOneHot_bit7[0]
+ CoarseOneHot_bit6[0] CoarseOneHot_bit5[0] CoarseOneHot_bit4[0] CoarseOneHot_bit3[0] CoarseOneHot_bit2[0] CoarseOneHot_bit1[0] CoarseOneHot_bit0[0]
+ PadBias[0] PowerDown[0] BiasBranch
xBiasMasternCoarse VddA18 GndA BiasCB[0] BiasCB[1] BiasCB[3] BiasCB[4] BiasCB[5] BiasCB[6] BiasCB[7] BiasCB[2] PowerDown
+ VMasterBiasN VMasterBiasP rx BiasMasternCoarse
xBiasBuffer VddA18 GndA BiasCB[7] BiasCB[6] BiasCB[5] BiasCB[4] BiasCB[3] BiasCB[2] BiasCB[1] BiasCB[0] CoarseOneHotBuffer[7]
+ CoarseOneHotBuffer[6] CoarseOneHotBuffer[5] CoarseOneHotBuffer[4] CoarseOneHotBuffer[3] CoarseOneHotBuffer[2] CoarseOneHotBuffer[1]
+ CoarseOneHotBuffer[0] BufferN BufferP LowBiasInterfaceEnBuffer nLowBiasInterfaceEnBuffer FineCodeBuffer[7] FineCodeBuffer[6] FineCodeBuffer[5]
+ FineCodeBuffer[4] FineCodeBuffer[3] FineCodeBuffer[2] FineCodeBuffer[1] FineCodeBuffer[0] nFineCodeBuffer[7] nFineCodeBuffer[6] nFineCodeBuffer[5]
+ nFineCodeBuffer[4] nFineCodeBuffer[3] nFineCodeBuffer[2] nFineCodeBuffer[1] nFineCodeBuffer[0] CoarseOneHotLowBiasEnBuffer BiasBranchBuffer
**.ends

* expanding   symbol:  BiasBranch.sym # of pins=39
** sym_path: /home/alienfalcon/Projects/skywater/open_dvs_py312/open_dvs/git_dvs/nic2025_openDVS/analog/xschem/BiasBranch.sym
** sch_path: /home/alienfalcon/Projects/skywater/open_dvs_py312/open_dvs/git_dvs/nic2025_openDVS/analog/xschem/BiasBranch.sch
.subckt BiasBranch VddA18 GndA BiasCB[7] BiasCB[6] BiasCB[5] BiasCB[4] BiasCB[3] BiasCB[2] BiasCB[1] BiasCB[0] BufferN BufferP
+ VBiasOut LowBiasInterfaceEn nLowBiasInterfaceEn FineCode[7] CoarseOneHotLowBiasEn BIT0 NBiasEn PBiasEn BiasDisabled FineCode[6]
+ FineCode[5] FineCode[4] FineCode[3] FineCode[2] FineCode[1] FineCode[0] nFineCode[7] nFineCode[6] nFineCode[5] nFineCode[4] nFineCode[3]
+ nFineCode[2] nFineCode[1] nFineCode[0] CoarseOneHot[7] CoarseOneHot[6] CoarseOneHot[5] CoarseOneHot[4] CoarseOneHot[3] CoarseOneHot[2]
+ CoarseOneHot[1] CoarseOneHot[0] PadBias PowerDown
*.iopin VddA18
*.iopin GndA
*.opin VBiasOut
*.ipin BiasCB[7],BiasCB[6],BiasCB[5],BiasCB[4],BiasCB[3],BiasCB[2],BiasCB[1],BiasCB[0]
*.ipin BufferN
*.ipin BufferP
*.ipin LowBiasInterfaceEn
*.ipin nLowBiasInterfaceEn
*.ipin CoarseOneHotLowBiasEn
*.ipin BIT0
*.ipin BiasDisabled
*.ipin NBiasEn
*.ipin PBiasEn
*.ipin FineCode[0]
*.ipin FineCode[1]
*.ipin FineCode[2]
*.ipin FineCode[3]
*.ipin FineCode[4]
*.ipin FineCode[5]
*.ipin FineCode[6]
*.ipin FineCode[7]
*.ipin nFineCode[0]
*.ipin nFineCode[1]
*.ipin nFineCode[2]
*.ipin nFineCode[3]
*.ipin nFineCode[4]
*.ipin nFineCode[5]
*.ipin nFineCode[6]
*.ipin nFineCode[7]
*.ipin CoarseOneHot[0]
*.ipin CoarseOneHot[1]
*.ipin CoarseOneHot[2]
*.ipin CoarseOneHot[3]
*.ipin CoarseOneHot[4]
*.ipin CoarseOneHot[5]
*.ipin CoarseOneHot[6]
*.ipin CoarseOneHot[7]
*.iopin PadBias
*.ipin PowerDown
xCoarse2Fine VddA18 GndA LowBiasInterfaceEn nLowBiasInterfaceEn BiasVGate IInDiv BiasCoarseFineInterface
xDivFine VddA18 GndA FineCode[7] FineCode[6] FineCode[5] FineCode[4] FineCode[3] FineCode[2] FineCode[1] FineCode[0] nFineCode[7]
+ nFineCode[6] nFineCode[5] nFineCode[4] nFineCode[3] nFineCode[2] nFineCode[1] nFineCode[0] IInDiv IOutDiv BiasVGate BiasDividerFine
xBuffs VddA18 GndA NBiasEn PBiasEn BiasDisabled BIT0 BufferN BufferP IOutDiv VBiasOut PadBias PowerDown BiasBuffers
xCoarseSel8to1 VddA18 GndA CoarseOneHot[7] CoarseOneHot[6] CoarseOneHot[5] CoarseOneHot[4] CoarseOneHot[3] CoarseOneHot[2]
+ CoarseOneHot[1] CoarseOneHot[0] CoarseOneHotLowBiasEn BiasCB[7] BiasCB[6] BiasCB[5] BiasCB[4] BiasCB[3] BiasCB[2] BiasCB[1] BiasCB[0] BiasVGate
+ BiasCoarseSel8to1
.ends

* expanding   symbol:  BiasMasternCoarse.sym # of pins=14
** sym_path: /home/alienfalcon/Projects/skywater/open_dvs_py312/open_dvs/git_dvs/nic2025_openDVS/analog/xschem/BiasMasternCoarse.sym
** sch_path: /home/alienfalcon/Projects/skywater/open_dvs_py312/open_dvs/git_dvs/nic2025_openDVS/analog/xschem/BiasMasternCoarse.sch
.subckt BiasMasternCoarse VddA18 GndA BiasCB0 BiasCB1 BiasCB3 BiasCB4 BiasCB5 BiasCB6 BiasCB7 BiasCB2 PowerDown VMasterBiasN
+ VMasterBiasP IR
*.ipin PowerDown
*.opin VMasterBiasN
*.iopin VddA18
*.iopin GndA
*.iopin IR
*.opin VMasterBiasP
*.iopin BiasCB0
*.iopin BiasCB1
*.iopin BiasCB2
*.iopin BiasCB3
*.iopin BiasCB4
*.iopin BiasCB5
*.iopin BiasCB6
*.iopin BiasCB7
xBiasMasterBias VMasterBiasP Coarse2 Coarse1 VMasterBiasN PowerDown VddA18 GndA IR BiasMasterBias
xMBDiv VddA18 GndA Coarse2 Coarse1 BiasCB0 BiasCB1 BiasCB3 BiasCB4 BiasCB5 BiasCB6 BiasCB7 BiasCB2 BiasCoarseMBDivider
XC1 VMasterBiasN GndA sky130_fd_pr__cap_mim_m3_1 W=17.42 L=363.855 MF=1
XC2 VMasterBiasN GndA sky130_fd_pr__cap_mim_m3_1 W=30 L=145 MF=1
XC3 VMasterBiasN GndA sky130_fd_pr__cap_mim_m3_1 W=30 L=145 MF=1
XC4 VMasterBiasN GndA sky130_fd_pr__cap_mim_m3_1 W=30 L=145 MF=1
.ends

* expanding   symbol:  BiasBranchBuffer.sym # of pins=13
** sym_path: /home/alienfalcon/Projects/skywater/open_dvs_py312/open_dvs/git_dvs/nic2025_openDVS/analog/xschem/BiasBranchBuffer.sym
** sch_path: /home/alienfalcon/Projects/skywater/open_dvs_py312/open_dvs/git_dvs/nic2025_openDVS/analog/xschem/BiasBranchBuffer.sch
.subckt BiasBranchBuffer VddA18 GndA BiasCB[7] BiasCB[6] BiasCB[5] BiasCB[4] BiasCB[3] BiasCB[2] BiasCB[1] BiasCB[0]
+ CoarseOneHot[7] CoarseOneHot[6] CoarseOneHot[5] CoarseOneHot[4] CoarseOneHot[3] CoarseOneHot[2] CoarseOneHot[1] CoarseOneHot[0] BufferN BufferP
+ LowBiasInterfaceEn nLowBiasInterfaceEn FineCode[7] FineCode[6] FineCode[5] FineCode[4] FineCode[3] FineCode[2] FineCode[1] FineCode[0] nFineCode[7]
+ nFineCode[6] nFineCode[5] nFineCode[4] nFineCode[3] nFineCode[2] nFineCode[1] nFineCode[0] CoarseOneHotLowBiasEn
*.iopin VddA18
*.iopin GndA
*.opin BufferN
*.ipin BiasCB[7],BiasCB[6],BiasCB[5],BiasCB[4],BiasCB[3],BiasCB[2],BiasCB[1],BiasCB[0]
*.ipin BufferN
*.ipin BufferP
*.opin BufferP
*.ipin LowBiasInterfaceEn
*.ipin nLowBiasInterfaceEn
*.ipin FineCode[7],FineCode[6],FineCode[5],FineCode[4],FineCode[3],FineCode[2],FineCode[1],FineCode[0]
*.ipin nFineCode[7],nFineCode[6],nFineCode[5],nFineCode[4],nFineCode[3],nFineCode[2],nFineCode[1],nFineCode[0]
*.ipin
*+ CoarseOneHot[7],CoarseOneHot[6],CoarseOneHot[5],CoarseOneHot[4],CoarseOneHot[3],CoarseOneHot[2],CoarseOneHot[1],CoarseOneHot[0]
*.ipin CoarseOneHotLowBiasEn
xCoarse2Fine VddA18 GndA LowBiasInterfaceEn nLowBiasInterfaceEn BiasVGate IInDiv BiasCoarseFineInterface
xDivFine VddA18 GndA FineCode[7] FineCode[6] FineCode[5] FineCode[4] FineCode[3] FineCode[2] FineCode[1] FineCode[0] nFineCode[7]
+ nFineCode[6] nFineCode[5] nFineCode[4] nFineCode[3] nFineCode[2] nFineCode[1] nFineCode[0] IInDiv BufferN BiasVGate BiasDividerFine
XMpDio BufferP BufferP VddA18 VddA18 sky130_fd_pr__pfet_01v8_lvt L=3 W=6 nf=1 ad=1.74 as=1.74 pd=12.58 ps=12.58
+ nrd=0.0483333333333333 nrs=0.0483333333333333 sa=0 sb=0 sd=0 mult=2 m=2
XMnDio BufferN BufferN GndA GndA sky130_fd_pr__nfet_01v8_lvt L=6 W=6 nf=1 ad=1.74 as=1.74 pd=12.58 ps=12.58 nrd=0.0483333333333333
+ nrs=0.0483333333333333 sa=0 sb=0 sd=0 mult=16 m=16
XMnMirr BufferP BufferN GndA GndA sky130_fd_pr__nfet_01v8_lvt L=6 W=6 nf=1 ad=1.74 as=1.74 pd=12.58 ps=12.58
+ nrd=0.0483333333333333 nrs=0.0483333333333333 sa=0 sb=0 sd=0 mult=16 m=16
xCoarseSel8to1 VddA18 GndA CoarseOneHot[7] CoarseOneHot[6] CoarseOneHot[5] CoarseOneHot[4] CoarseOneHot[3] CoarseOneHot[2]
+ CoarseOneHot[1] CoarseOneHot[0] CoarseOneHotLowBiasEn BiasCB[7] BiasCB[6] BiasCB[5] BiasCB[4] BiasCB[3] BiasCB[2] BiasCB[1] BiasCB[0] BiasVGate
+ BiasCoarseSel8to1
.ends

* expanding   symbol:  BiasCoarseFineInterface.sym # of pins=6
** sym_path: /home/alienfalcon/Projects/skywater/open_dvs_py312/open_dvs/git_dvs/nic2025_openDVS/analog/xschem/BiasCoarseFineInterface.sym
** sch_path: /home/alienfalcon/Projects/skywater/open_dvs_py312/open_dvs/git_dvs/nic2025_openDVS/analog/xschem/BiasCoarseFineInterface.sch
.subckt BiasCoarseFineInterface VddA18 GndA LowBiasEn nLowBiasEn IIn IOut
*.iopin GndA
*.iopin VddA18
*.iopin IIn
*.iopin IOut
*.ipin nLowBiasEn
*.ipin LowBiasEn
XMpDisableHighBias HighBiasDioGate nLowBiasEn VddA18 VddA18 sky130_fd_pr__pfet_01v8 L=0.15 W=0.42 nf=1 ad=0.1218 as=0.1218 pd=1.42
+ ps=1.42 nrd=0.69047619047619 nrs=0.69047619047619 sa=0 sb=0 sd=0 mult=1
XMpDioHighBias HighBiasDioDrain HighBiasDioGate VddA18 VddA18 sky130_fd_pr__pfet_01v8 L=1 W=32 nf=2 ad=4.64 as=9.28 pd=32.58
+ ps=65.16 nrd=0.0090625 nrs=0.0090625 sa=0 sb=0 sd=0 mult=8 m=8
XMpMirrHighBias HighBiasMirr HighBiasDioGate VddA18 VddA18 sky130_fd_pr__pfet_01v8 L=1 W=32 nf=2 ad=4.64 as=9.28 pd=32.58 ps=65.16
+ nrd=0.0090625 nrs=0.0090625 sa=0 sb=0 sd=0 mult=8 m=8
XMpswDioHighBias HighBiasDioGate LowBiasEn HighBiasDioDrain VddA18 sky130_fd_pr__pfet_01v8 L=0.5 W=0.42 nf=1 ad=0.1218 as=0.1218
+ pd=1.42 ps=1.42 nrd=0.69047619047619 nrs=0.69047619047619 sa=0 sb=0 sd=0 mult=1
XMnDisableDioHighBias HighBiasDioDrain LowBiasEn GndA GndA sky130_fd_pr__nfet_01v8 L=0.15 W=0.42 nf=1 ad=0.1218 as=0.1218 pd=1.42
+ ps=1.42 nrd=0.69047619047619 nrs=0.69047619047619 sa=0 sb=0 sd=0 mult=1
XMpSelDioHighBias net1 LowBiasEn HighBiasDioDrain VddA18 sky130_fd_pr__pfet_01v8_hvt L=0.5 W=32 nf=2 ad=4.64 as=9.28 pd=32.58
+ ps=65.16 nrd=0.0090625 nrs=0.0090625 sa=0 sb=0 sd=0 mult=8 m=8
XMpSelMirrHighBias IOut LowBiasEn HighBiasMirr VddA18 sky130_fd_pr__pfet_01v8_hvt L=0.5 W=32 nf=2 ad=4.64 as=9.28 pd=32.58
+ ps=65.16 nrd=0.0090625 nrs=0.0090625 sa=0 sb=0 sd=0 mult=8 m=8
XMnDisableOutMirr HighBiasMirr LowBiasEn GndA GndA sky130_fd_pr__nfet_01v8 L=0.15 W=0.42 nf=1 ad=0.1218 as=0.1218 pd=1.42 ps=1.42
+ nrd=0.69047619047619 nrs=0.69047619047619 sa=0 sb=0 sd=0 mult=1
XMpInDio IIn IIn net1 VddA18 sky130_fd_pr__pfet_01v8_lvt L=1 W=9 nf=1 ad=2.61 as=2.61 pd=18.58 ps=18.58 nrd=0.0322222222222222
+ nrs=0.0322222222222222 sa=0 sb=0 sd=0 mult=2 m=2
XMpDioLowBias1 LowBiasDioInt LowBiasDioGate VddA18 VddA18 sky130_fd_pr__pfet_01v8 L=2 W=4 nf=1 ad=1.16 as=1.16 pd=8.58 ps=8.58
+ nrd=0.0725 nrs=0.0725 sa=0 sb=0 sd=0 mult=2 m=2
XMpMirrLowBias1 LowBiasMirrInt LowBiasDioGate VddA18 VddA18 sky130_fd_pr__pfet_01v8 L=2 W=4 nf=1 ad=1.16 as=1.16 pd=8.58 ps=8.58
+ nrd=0.0725 nrs=0.0725 sa=0 sb=0 sd=0 mult=2 m=2
XMpDioLowBias2 LowBiasDioGate LowBiasDioGate LowBiasDioInt VddA18 sky130_fd_pr__pfet_01v8 L=2 W=4 nf=1 ad=1.16 as=1.16 pd=8.58
+ ps=8.58 nrd=0.0725 nrs=0.0725 sa=0 sb=0 sd=0 mult=2 m=2
XMpMirrLowBias2 LowBiasMirr LowBiasDioGate LowBiasMirrInt VddA18 sky130_fd_pr__pfet_01v8 L=2 W=4 nf=1 ad=1.16 as=1.16 pd=8.58
+ ps=8.58 nrd=0.0725 nrs=0.0725 sa=0 sb=0 sd=0 mult=2 m=2
XMpSelDioLowBias net1 nLowBiasEn LowBiasDioGate VddA18 sky130_fd_pr__pfet_01v8_lvt L=2 W=4 nf=1 ad=1.16 as=1.16 pd=8.58 ps=8.58
+ nrd=0.0725 nrs=0.0725 sa=0 sb=0 sd=0 mult=2 m=2
XMpSelMirrLowBias IOut nLowBiasEn LowBiasMirr VddA18 sky130_fd_pr__pfet_01v8_lvt L=2 W=4 nf=1 ad=1.16 as=1.16 pd=8.58 ps=8.58
+ nrd=0.0725 nrs=0.0725 sa=0 sb=0 sd=0 mult=2 m=2
XMpDum1 net2 VddA18 VddA18 VddA18 sky130_fd_pr__pfet_01v8 L=0.5 W=16 nf=1 ad=4.64 as=4.64 pd=32.58 ps=32.58 nrd=0.018125
+ nrs=0.018125 sa=0 sb=0 sd=0 mult=1
XMpDum2 net3 VddA18 VddA18 VddA18 sky130_fd_pr__pfet_01v8 L=0.5 W=16 nf=1 ad=4.64 as=4.64 pd=32.58 ps=32.58 nrd=0.018125
+ nrs=0.018125 sa=0 sb=0 sd=0 mult=1
XMpDum3 net4 VddA18 VddA18 VddA18 sky130_fd_pr__pfet_01v8 L=0.2 W=4 nf=1 ad=1.16 as=1.16 pd=8.58 ps=8.58 nrd=0.0725 nrs=0.0725
+ sa=0 sb=0 sd=0 mult=1
XMpDum4 net5 VddA18 VddA18 VddA18 sky130_fd_pr__pfet_01v8 L=0.2 W=4 nf=1 ad=1.16 as=1.16 pd=8.58 ps=8.58 nrd=0.0725 nrs=0.0725
+ sa=0 sb=0 sd=0 mult=1
XMpDum5 net6 VddA18 VddA18 VddA18 sky130_fd_pr__pfet_01v8 L=0.2 W=4 nf=1 ad=1.16 as=1.16 pd=8.58 ps=8.58 nrd=0.0725 nrs=0.0725
+ sa=0 sb=0 sd=0 mult=1
XMpDum6 net7 VddA18 VddA18 VddA18 sky130_fd_pr__pfet_01v8 L=0.2 W=4 nf=1 ad=1.16 as=1.16 pd=8.58 ps=8.58 nrd=0.0725 nrs=0.0725
+ sa=0 sb=0 sd=0 mult=1
XMpDum7 net8 VddA18 VddA18 VddA18 sky130_fd_pr__pfet_01v8 L=0.2 W=4 nf=1 ad=1.16 as=1.16 pd=8.58 ps=8.58 nrd=0.0725 nrs=0.0725
+ sa=0 sb=0 sd=0 mult=1
* noconn #net2
* noconn #net3
* noconn #net4
* noconn #net5
* noconn #net6
* noconn #net7
* noconn #net8
.ends

* expanding   symbol:  BiasDividerFine.sym # of pins=7
** sym_path: /home/alienfalcon/Projects/skywater/open_dvs_py312/open_dvs/git_dvs/nic2025_openDVS/analog/xschem/BiasDividerFine.sym
** sch_path: /home/alienfalcon/Projects/skywater/open_dvs_py312/open_dvs/git_dvs/nic2025_openDVS/analog/xschem/BiasDividerFine.sch
.subckt BiasDividerFine VddA18 GndA FineCode[7] FineCode[6] FineCode[5] FineCode[4] FineCode[3] FineCode[2] FineCode[1]
+ FineCode[0] nFineCode[7] nFineCode[6] nFineCode[5] nFineCode[4] nFineCode[3] nFineCode[2] nFineCode[1] nFineCode[0] IIn IOut VGate
*.iopin VddA18
*.iopin GndA
*.iopin IOut
*.ipin FineCode[7],FineCode[6],FineCode[5],FineCode[4],FineCode[3],FineCode[2],FineCode[1],FineCode[0]
*.ipin VGate
*.iopin IIn
*.ipin nFineCode[7],nFineCode[6],nFineCode[5],nFineCode[4],nFineCode[3],nFineCode[2],nFineCode[1],nFineCode[0]
xdiv0 Idiv1 Idiv0 VGate IOut VddA18 termDio nFineCode[0] FineCode[0] BiasDividerFineCell
xdiv1 Idiv2 Idiv1 VGate IOut VddA18 termDio nFineCode[1] FineCode[1] BiasDividerFineCell
xdiv2 Idiv3 Idiv2 VGate IOut VddA18 termDio nFineCode[2] FineCode[2] BiasDividerFineCell
xdiv3 Idiv4 Idiv3 VGate IOut VddA18 termDio nFineCode[3] FineCode[3] BiasDividerFineCell
xdiv4 Idiv5 Idiv4 VGate IOut VddA18 termDio nFineCode[4] FineCode[4] BiasDividerFineCell
xdiv5 Idiv6 Idiv5 VGate IOut VddA18 termDio nFineCode[5] FineCode[5] BiasDividerFineCell
xdiv6 Idiv7 Idiv6 VGate IOut VddA18 termDio nFineCode[6] FineCode[6] BiasDividerFineCell
xdiv7 IIn Idiv7 VGate IOut VddA18 termDio nFineCode[7] FineCode[7] BiasDividerFineCell
XMrTerm termDio VGate Idiv0 VddA18 sky130_fd_pr__pfet_01v8_lvt L=1 W=9 nf=1 ad=2.61 as=2.61 pd=18.58 ps=18.58
+ nrd=0.0322222222222222 nrs=0.0322222222222222 sa=0 sb=0 sd=0 mult=2 m=2
XMnterm termDio termDio GndA GndA sky130_fd_pr__nfet_01v8_lvt L=0.8 W=8 nf=1 ad=2.32 as=2.32 pd=16.58 ps=16.58 nrd=0.03625
+ nrs=0.03625 sa=0 sb=0 sd=0 mult=1
.ends

* expanding   symbol:  BiasBuffers.sym # of pins=12
** sym_path: /home/alienfalcon/Projects/skywater/open_dvs_py312/open_dvs/git_dvs/nic2025_openDVS/analog/xschem/BiasBuffers.sym
** sch_path: /home/alienfalcon/Projects/skywater/open_dvs_py312/open_dvs/git_dvs/nic2025_openDVS/analog/xschem/BiasBuffers.sch
.subckt BiasBuffers VddA18 GndA NBiasEnabled PBiasEnabled BiasDisabled BIT0 BufferNBias BufferPBias SplitterOutput VBiasOut
+ PadBias PowerDown
*.iopin GndA
*.iopin VddA18
*.opin VBiasOut
*.ipin NBiasEnabled
*.ipin PBiasEnabled
*.ipin BiasDisabled
*.ipin BufferNBias
*.ipin BufferPBias
*.iopin SplitterOutput
*.ipin BIT0
*.iopin PadBias
*.ipin PowerDown
XMnDio SplitterOutput NBias GndA GndA sky130_fd_pr__nfet_01v8 L=6 W=6 nf=1 ad=1.74 as=1.74 pd=12.58 ps=12.58
+ nrd=0.0483333333333333 nrs=0.0483333333333333 sa=0 sb=0 sd=0 mult=1
XMnswnMirrnB0 net1 nB0 NBias GndA sky130_fd_pr__nfet_01v8 L=0.15 W=1 nf=1 ad=0.29 as=0.29 pd=2.58 ps=2.58 nrd=0.29 nrs=0.29 sa=0
+ sb=0 sd=0 mult=1
XMpswnMirrnB0 NBias B0 net1 VddA18 sky130_fd_pr__pfet_01v8 L=0.38 W=1 nf=1 ad=0.29 as=0.29 pd=2.58 ps=2.58 nrd=0.29 nrs=0.29 sa=0
+ sb=0 sd=0 mult=1
XMnMirrBuffB0 nMirrBuffDrain SplitterOutput net2 GndA sky130_fd_pr__nfet_01v8_lvt L=2.4 W=0.5 nf=1 ad=0.145 as=0.145 pd=1.58
+ ps=1.58 nrd=0.58 nrs=0.58 sa=0 sb=0 sd=0 mult=1
XMpnMirrEnable nMirrBuffDrain disable VddA18 VddA18 sky130_fd_pr__pfet_01v8 L=0.15 W=1 nf=1 ad=0.29 as=0.29 pd=2.58 ps=2.58
+ nrd=0.29 nrs=0.29 sa=0 sb=0 sd=0 mult=1
XMnswnMirrB0 net2 B0 NBias GndA sky130_fd_pr__nfet_01v8 L=0.15 W=1 nf=1 ad=0.29 as=0.29 pd=2.58 ps=2.58 nrd=0.29 nrs=0.29 sa=0
+ sb=0 sd=0 mult=1
XMpswnMirrB0 NBias nB0 net2 VddA18 sky130_fd_pr__pfet_01v8 L=0.38 W=1 nf=1 ad=0.29 as=0.29 pd=2.58 ps=2.58 nrd=0.29 nrs=0.29 sa=0
+ sb=0 sd=0 mult=1
XMnMirr nCopy NBias GndA GndA sky130_fd_pr__nfet_01v8 L=6 W=6 nf=1 ad=1.74 as=1.74 pd=12.58 ps=12.58 nrd=0.0483333333333333
+ nrs=0.0483333333333333 sa=0 sb=0 sd=0 mult=1
XMnMirrBuffBias NBias BufferNBias GndA GndA sky130_fd_pr__nfet_01v8_lvt L=6 W=6 nf=1 ad=1.74 as=1.74 pd=12.58 ps=12.58
+ nrd=0.0483333333333333 nrs=0.0483333333333333 sa=0 sb=0 sd=0 mult=16 m=16
XMpDio nCopy PBias VddA18 VddA18 sky130_fd_pr__pfet_01v8 L=3 W=6 nf=1 ad=1.74 as=1.74 pd=12.58 ps=12.58 nrd=0.0483333333333333
+ nrs=0.0483333333333333 sa=0 sb=0 sd=0 mult=2 m=2
XMnswpMirrnB0 PBias nB0 net3 GndA sky130_fd_pr__nfet_01v8 L=0.15 W=1 nf=1 ad=0.29 as=0.29 pd=2.58 ps=2.58 nrd=0.29 nrs=0.29 sa=0
+ sb=0 sd=0 mult=1
XMpswpMirrnB0 net3 B0 PBias VddA18 sky130_fd_pr__pfet_01v8 L=0.38 W=1 nf=1 ad=0.29 as=0.29 pd=2.58 ps=2.58 nrd=0.29 nrs=0.29 sa=0
+ sb=0 sd=0 mult=1
XMnswpMirrB0 PBias B0 net4 GndA sky130_fd_pr__nfet_01v8 L=0.15 W=1 nf=1 ad=0.29 as=0.29 pd=2.58 ps=2.58 nrd=0.29 nrs=0.29 sa=0
+ sb=0 sd=0 mult=1
XMpswpMirrB0 net4 nB0 PBias VddA18 sky130_fd_pr__pfet_01v8 L=0.38 W=1 nf=1 ad=0.29 as=0.29 pd=2.58 ps=2.58 nrd=0.29 nrs=0.29 sa=0
+ sb=0 sd=0 mult=1
XMpMirrBuffnB0 net3 nCopy pMirrBuffDrain VddA18 sky130_fd_pr__pfet_01v8_lvt L=0.38 W=2.4 nf=1 ad=0.696 as=0.696 pd=5.38 ps=5.38
+ nrd=0.120833333333333 nrs=0.120833333333333 sa=0 sb=0 sd=0 mult=6 m=6
XMpMirrBuffB0 net4 nCopy pMirrBuffDrain VddA18 sky130_fd_pr__pfet_01v8_lvt L=2.4 W=0.5 nf=1 ad=0.145 as=0.145 pd=1.58 ps=1.58
+ nrd=0.58 nrs=0.58 sa=0 sb=0 sd=0 mult=1
XMnpMirrEnable pMirrBuffDrain net6 GndA GndA sky130_fd_pr__nfet_01v8 L=0.15 W=1 nf=1 ad=0.29 as=0.29 pd=2.58 ps=2.58 nrd=0.29
+ nrs=0.29 sa=0 sb=0 sd=0 mult=1
XMpMirrBuffBias PBias BufferPBias VddA18 VddA18 sky130_fd_pr__pfet_01v8_lvt L=3 W=6 nf=1 ad=1.74 as=1.74 pd=12.58 ps=12.58
+ nrd=0.0483333333333333 nrs=0.0483333333333333 sa=0 sb=0 sd=0 mult=2 m=2
XMnswNBias NBias NBiasEnabled net5 GndA sky130_fd_pr__nfet_01v8 L=0.15 W=4 nf=1 ad=1.16 as=1.16 pd=8.58 ps=8.58 nrd=0.0725
+ nrs=0.0725 sa=0 sb=0 sd=0 mult=1
XMpswNBias net5 PBiasEnabled NBias VddA18 sky130_fd_pr__pfet_01v8 L=0.38 W=4 nf=1 ad=1.16 as=1.16 pd=8.58 ps=8.58 nrd=0.0725
+ nrs=0.0725 sa=0 sb=0 sd=0 mult=1
XMnswPBias net5 PBiasEnabled PBias GndA sky130_fd_pr__nfet_01v8 L=0.15 W=4 nf=1 ad=1.16 as=1.16 pd=8.58 ps=8.58 nrd=0.0725
+ nrs=0.0725 sa=0 sb=0 sd=0 mult=1
XMpswPBias PBias NBiasEnabled net5 VddA18 sky130_fd_pr__pfet_01v8 L=0.38 W=4 nf=1 ad=1.16 as=1.16 pd=8.58 ps=8.58 nrd=0.0725
+ nrs=0.0725 sa=0 sb=0 sd=0 mult=1
XMnswBias net5 nPowerDown VBiasOut GndA sky130_fd_pr__nfet_01v8 L=0.15 W=4 nf=1 ad=1.16 as=1.16 pd=8.58 ps=8.58 nrd=0.0725
+ nrs=0.0725 sa=0 sb=0 sd=0 mult=1
XMpswBias VBiasOut PowerDown net5 VddA18 sky130_fd_pr__pfet_01v8 L=0.38 W=4 nf=1 ad=1.16 as=1.16 pd=8.58 ps=8.58 nrd=0.0725
+ nrs=0.0725 sa=0 sb=0 sd=0 mult=1
XMnswRail VBiasOut PowerDown PadBias GndA sky130_fd_pr__nfet_01v8 L=0.15 W=4 nf=1 ad=1.16 as=1.16 pd=8.58 ps=8.58 nrd=0.0725
+ nrs=0.0725 sa=0 sb=0 sd=0 mult=1
XMpswRail PadBias nPowerDown VBiasOut VddA18 sky130_fd_pr__pfet_01v8 L=0.38 W=4 nf=1 ad=1.16 as=1.16 pd=8.58 ps=8.58 nrd=0.0725
+ nrs=0.0725 sa=0 sb=0 sd=0 mult=1
XMnMirrBuffnB0 nMirrBuffDrain SplitterOutput net1 GndA sky130_fd_pr__nfet_01v8_lvt L=0.24 W=2.4 nf=1 ad=0.696 as=0.696 pd=5.38
+ ps=5.38 nrd=0.120833333333333 nrs=0.120833333333333 sa=0 sb=0 sd=0 mult=10 m=10
x1 ndisable PBiasEnabled VddA18 VddA18 GndA GndA net6 sky130_fd_sc_hd__and2_1
x2 PowerDown BiasDisabled ndisable VddA18 VddA18 GndA GndA sky130_fd_sc_hd__nor2_1
x3 BIT0 nB0 VddA18 VddA18 GndA GndA sky130_fd_sc_hd__inv_1
x4 nB0 B0 VddA18 VddA18 GndA GndA sky130_fd_sc_hd__inv_1
x5 ndisable disable VddA18 VddA18 GndA GndA sky130_fd_sc_hd__inv_1
x6 PowerDown nPowerDown VddA18 VddA18 GndA GndA sky130_fd_sc_hd__inv_1
.ends

* expanding   symbol:  BiasCoarseSel8to1.sym # of pins=6
** sym_path: /home/alienfalcon/Projects/skywater/open_dvs_py312/open_dvs/git_dvs/nic2025_openDVS/analog/xschem/BiasCoarseSel8to1.sym
** sch_path: /home/alienfalcon/Projects/skywater/open_dvs_py312/open_dvs/git_dvs/nic2025_openDVS/analog/xschem/BiasCoarseSel8to1.sch
.subckt BiasCoarseSel8to1 VddA18 GndA CoarseOneHot[7] CoarseOneHot[6] CoarseOneHot[5] CoarseOneHot[4] CoarseOneHot[3]
+ CoarseOneHot[2] CoarseOneHot[1] CoarseOneHot[0] CoarseOneHotLowBiasEn BiasCB[7] BiasCB[6] BiasCB[5] BiasCB[4] BiasCB[3] BiasCB[2] BiasCB[1]
+ BiasCB[0] CoarseBias
*.ipin BiasCB[7],BiasCB[6],BiasCB[5],BiasCB[4],BiasCB[3],BiasCB[2],BiasCB[1],BiasCB[0]
*.ipin
*+ CoarseOneHot[7],CoarseOneHot[6],CoarseOneHot[5],CoarseOneHot[4],CoarseOneHot[3],CoarseOneHot[2],CoarseOneHot[1],CoarseOneHot[0]
*.iopin CoarseBias
*.iopin VddA18
*.iopin GndA
*.ipin CoarseOneHotLowBiasEn
XMpswB0 net1 CoarseOneHot[0] VddA18 VddA18 sky130_fd_pr__pfet_01v8 L=0.15 W=0.45 nf=1 ad=0.1305 as=0.1305 pd=1.48 ps=1.48
+ nrd=0.644444444444444 nrs=0.644444444444444 sa=0 sb=0 sd=0 mult=1
XMnswuB0 CoarseBias CoarseOneHot[0] net1 GndA sky130_fd_pr__nfet_01v8 L=0.15 W=1 nf=1 ad=0.29 as=0.29 pd=2.58 ps=2.58 nrd=0.29
+ nrs=0.29 sa=0 sb=0 sd=0 mult=1
XMnswlB0 net1 CoarseOneHot[0] MirrB0_drain GndA sky130_fd_pr__nfet_01v8_lvt L=0.15 W=1 nf=1 ad=0.29 as=0.29 pd=2.58 ps=2.58
+ nrd=0.29 nrs=0.29 sa=0 sb=0 sd=0 mult=1
XMmirrB0 MirrB0_drain BiasCB[0] GndA GndA sky130_fd_pr__nfet_01v8_lvt L=5 W=1.8 nf=1 ad=0.522 as=0.522 pd=4.18 ps=4.18
+ nrd=0.161111111111111 nrs=0.161111111111111 sa=0 sb=0 sd=0 mult=8 m=8
XMpswB1 net2 CoarseOneHot[1] VddA18 VddA18 sky130_fd_pr__pfet_01v8 L=0.15 W=0.45 nf=1 ad=0.1305 as=0.1305 pd=1.48 ps=1.48
+ nrd=0.644444444444444 nrs=0.644444444444444 sa=0 sb=0 sd=0 mult=1
XMnswuB1 CoarseBias CoarseOneHot[1] net2 GndA sky130_fd_pr__nfet_01v8 L=1 W=1 nf=1 ad=0.29 as=0.29 pd=2.58 ps=2.58 nrd=0.29
+ nrs=0.29 sa=0 sb=0 sd=0 mult=1
XMnswlB1 net2 CoarseOneHot[1] MirrB1_drain GndA sky130_fd_pr__nfet_01v8 L=1 W=1 nf=1 ad=0.29 as=0.29 pd=2.58 ps=2.58 nrd=0.29
+ nrs=0.29 sa=0 sb=0 sd=0 mult=1
XMmirrB1 MirrB1_drain BiasCB[1] GndA GndA sky130_fd_pr__nfet_01v8_lvt L=9.98 W=0.98 nf=1 ad=0.2842 as=0.2842 pd=2.54 ps=2.54
+ nrd=0.295918367346939 nrs=0.295918367346939 sa=0 sb=0 sd=0 mult=8 m=8
XMpswB2 net3 CoarseOneHot[2] VddA18 VddA18 sky130_fd_pr__pfet_01v8 L=0.15 W=0.45 nf=1 ad=0.1305 as=0.1305 pd=1.48 ps=1.48
+ nrd=0.644444444444444 nrs=0.644444444444444 sa=0 sb=0 sd=0 mult=1
XMnswuB2 CoarseBias CoarseOneHot[2] net3 GndA sky130_fd_pr__nfet_01v8 L=1 W=1 nf=1 ad=0.29 as=0.29 pd=2.58 ps=2.58 nrd=0.29
+ nrs=0.29 sa=0 sb=0 sd=0 mult=1
XMnswlB2 net3 CoarseOneHot[2] MirrB2_drain GndA sky130_fd_pr__nfet_01v8 L=1 W=1 nf=1 ad=0.29 as=0.29 pd=2.58 ps=2.58 nrd=0.29
+ nrs=0.29 sa=0 sb=0 sd=0 mult=1
XMmirrhB2 MirrB2_drain BiasCB[2] net4 GndA sky130_fd_pr__nfet_01v8_lvt L=5 W=1.98 nf=1 ad=0.5742 as=0.5742 pd=4.54 ps=4.54
+ nrd=0.146464646464646 nrs=0.146464646464646 sa=0 sb=0 sd=0 mult=1
XMmirrgB2 net4 BiasCB[2] net5 GndA sky130_fd_pr__nfet_01v8_lvt L=5 W=1.98 nf=1 ad=0.5742 as=0.5742 pd=4.54 ps=4.54
+ nrd=0.146464646464646 nrs=0.146464646464646 sa=0 sb=0 sd=0 mult=1
XMmirrfB2 net5 BiasCB[2] net6 GndA sky130_fd_pr__nfet_01v8_lvt L=5 W=1.98 nf=1 ad=0.5742 as=0.5742 pd=4.54 ps=4.54
+ nrd=0.146464646464646 nrs=0.146464646464646 sa=0 sb=0 sd=0 mult=1
XMmirrfB1 net6 BiasCB[2] net7 GndA sky130_fd_pr__nfet_01v8_lvt L=5 W=1.98 nf=1 ad=0.5742 as=0.5742 pd=4.54 ps=4.54
+ nrd=0.146464646464646 nrs=0.146464646464646 sa=0 sb=0 sd=0 mult=1
XMmirreB2 net7 BiasCB[2] net8 GndA sky130_fd_pr__nfet_01v8_lvt L=5 W=1.98 nf=1 ad=0.5742 as=0.5742 pd=4.54 ps=4.54
+ nrd=0.146464646464646 nrs=0.146464646464646 sa=0 sb=0 sd=0 mult=1
XMmirrcB2 net8 BiasCB[2] net9 GndA sky130_fd_pr__nfet_01v8_lvt L=5 W=1.98 nf=1 ad=0.5742 as=0.5742 pd=4.54 ps=4.54
+ nrd=0.146464646464646 nrs=0.146464646464646 sa=0 sb=0 sd=0 mult=1
XMmirrbB2 net9 BiasCB[2] net10 GndA sky130_fd_pr__nfet_01v8_lvt L=5 W=1.98 nf=1 ad=0.5742 as=0.5742 pd=4.54 ps=4.54
+ nrd=0.146464646464646 nrs=0.146464646464646 sa=0 sb=0 sd=0 mult=1
XMmirraB2 net10 BiasCB[2] GndA GndA sky130_fd_pr__nfet_01v8_lvt L=5 W=1.98 nf=1 ad=0.5742 as=0.5742 pd=4.54 ps=4.54
+ nrd=0.146464646464646 nrs=0.146464646464646 sa=0 sb=0 sd=0 mult=1
XMpswB3 net11 CoarseOneHot[3] VddA18 VddA18 sky130_fd_pr__pfet_01v8 L=0.15 W=0.45 nf=1 ad=0.1305 as=0.1305 pd=1.48 ps=1.48
+ nrd=0.644444444444444 nrs=0.644444444444444 sa=0 sb=0 sd=0 mult=1
XMnswuB3 CoarseBias CoarseOneHot[3] net11 GndA sky130_fd_pr__nfet_01v8 L=1 W=1 nf=1 ad=0.29 as=0.29 pd=2.58 ps=2.58 nrd=0.29
+ nrs=0.29 sa=0 sb=0 sd=0 mult=1
XMnswlB3 net11 CoarseOneHot[3] MirrB3_drain GndA sky130_fd_pr__nfet_01v8 L=1 W=1 nf=1 ad=0.29 as=0.29 pd=2.58 ps=2.58 nrd=0.29
+ nrs=0.29 sa=0 sb=0 sd=0 mult=1
XMmirrhB3 MirrB3_drain BiasCB[3] net12 GndA sky130_fd_pr__nfet_01v8_lvt L=9.98 W=0.98 nf=1 ad=0.2842 as=0.2842 pd=2.54 ps=2.54
+ nrd=0.295918367346939 nrs=0.295918367346939 sa=0 sb=0 sd=0 mult=1
XMmirrgB3 net12 BiasCB[3] net13 GndA sky130_fd_pr__nfet_01v8_lvt L=9.98 W=0.98 nf=1 ad=0.2842 as=0.2842 pd=2.54 ps=2.54
+ nrd=0.295918367346939 nrs=0.295918367346939 sa=0 sb=0 sd=0 mult=1
XMmirrfB3 net13 BiasCB[3] net14 GndA sky130_fd_pr__nfet_01v8_lvt L=9.98 W=0.98 nf=1 ad=0.2842 as=0.2842 pd=2.54 ps=2.54
+ nrd=0.295918367346939 nrs=0.295918367346939 sa=0 sb=0 sd=0 mult=1
XMmirreB3 net14 BiasCB[3] net15 GndA sky130_fd_pr__nfet_01v8_lvt L=9.98 W=0.98 nf=1 ad=0.2842 as=0.2842 pd=2.54 ps=2.54
+ nrd=0.295918367346939 nrs=0.295918367346939 sa=0 sb=0 sd=0 mult=1
XMmirrdB3 net15 BiasCB[3] net16 GndA sky130_fd_pr__nfet_01v8_lvt L=9.98 W=0.98 nf=1 ad=0.2842 as=0.2842 pd=2.54 ps=2.54
+ nrd=0.295918367346939 nrs=0.295918367346939 sa=0 sb=0 sd=0 mult=1
XMmirrcB3 net16 BiasCB[3] net17 GndA sky130_fd_pr__nfet_01v8_lvt L=9.98 W=0.98 nf=1 ad=0.2842 as=0.2842 pd=2.54 ps=2.54
+ nrd=0.295918367346939 nrs=0.295918367346939 sa=0 sb=0 sd=0 mult=1
XMmirrbB3 net17 BiasCB[3] net18 GndA sky130_fd_pr__nfet_01v8_lvt L=9.98 W=0.98 nf=1 ad=0.2842 as=0.2842 pd=2.54 ps=2.54
+ nrd=0.295918367346939 nrs=0.295918367346939 sa=0 sb=0 sd=0 mult=1
XMmirraB3 net18 BiasCB[3] GndA GndA sky130_fd_pr__nfet_01v8_lvt L=9.98 W=0.98 nf=1 ad=0.2842 as=0.2842 pd=2.54 ps=2.54
+ nrd=0.295918367346939 nrs=0.295918367346939 sa=0 sb=0 sd=0 mult=1
XMnswuB4to7 CoarseBias CoarseOneHotLowBiasEn MirrB4o5o6o7_drain GndA sky130_fd_pr__nfet_01v8 L=1 W=1 nf=1 ad=0.29 as=0.29 pd=2.58
+ ps=2.58 nrd=0.29 nrs=0.29 sa=0 sb=0 sd=0 mult=1
XMmirrhB4to7 MirrB4o5o6o7_drain MirrB4o5o6o7_gate net19 GndA sky130_fd_pr__nfet_01v8_lvt L=20 W=0.5 nf=1 ad=0.145 as=0.145 pd=1.58
+ ps=1.58 nrd=0.58 nrs=0.58 sa=0 sb=0 sd=0 mult=1
XMmirraB4to7 net25 MirrB4o5o6o7_gate GndA GndA sky130_fd_pr__nfet_01v8_lvt L=20 W=0.5 nf=1 ad=0.145 as=0.145 pd=1.58 ps=1.58
+ nrd=0.58 nrs=0.58 sa=0 sb=0 sd=0 mult=1
XMmirrbB4to7 net24 MirrB4o5o6o7_gate net25 GndA sky130_fd_pr__nfet_01v8_lvt L=20 W=0.5 nf=1 ad=0.145 as=0.145 pd=1.58 ps=1.58
+ nrd=0.58 nrs=0.58 sa=0 sb=0 sd=0 mult=1
XMmirrcB4to7 net23 MirrB4o5o6o7_gate net24 GndA sky130_fd_pr__nfet_01v8_lvt L=20 W=0.5 nf=1 ad=0.145 as=0.145 pd=1.58 ps=1.58
+ nrd=0.58 nrs=0.58 sa=0 sb=0 sd=0 mult=1
XMmirrdB4to7 net22 MirrB4o5o6o7_gate net23 GndA sky130_fd_pr__nfet_01v8_lvt L=20 W=0.5 nf=1 ad=0.145 as=0.145 pd=1.58 ps=1.58
+ nrd=0.58 nrs=0.58 sa=0 sb=0 sd=0 mult=1
XMmirreB4to7 net21 MirrB4o5o6o7_gate net22 GndA sky130_fd_pr__nfet_01v8_lvt L=20 W=0.5 nf=1 ad=0.145 as=0.145 pd=1.58 ps=1.58
+ nrd=0.58 nrs=0.58 sa=0 sb=0 sd=0 mult=1
XMmirrfB4to7 net20 MirrB4o5o6o7_gate net21 GndA sky130_fd_pr__nfet_01v8_lvt L=20 W=0.5 nf=1 ad=0.145 as=0.145 pd=1.58 ps=1.58
+ nrd=0.58 nrs=0.58 sa=0 sb=0 sd=0 mult=1
XMmirrgB4to7 net19 MirrB4o5o6o7_gate net20 GndA sky130_fd_pr__nfet_01v8_lvt L=20 W=0.5 nf=1 ad=0.145 as=0.145 pd=1.58 ps=1.58
+ nrd=0.58 nrs=0.58 sa=0 sb=0 sd=0 mult=1
XMnswl7 MirrB4o5o6o7_gate CoarseOneHot[7] BiasCB[7] GndA sky130_fd_pr__nfet_01v8 L=1 W=1 nf=1 ad=0.29 as=0.29 pd=2.58 ps=2.58
+ nrd=0.29 nrs=0.29 sa=0 sb=0 sd=0 mult=1
XMnswlB6 MirrB4o5o6o7_gate CoarseOneHot[6] BiasCB[6] GndA sky130_fd_pr__nfet_01v8 L=1 W=1 nf=1 ad=0.29 as=0.29 pd=2.58 ps=2.58
+ nrd=0.29 nrs=0.29 sa=0 sb=0 sd=0 mult=1
XMnswlB5 MirrB4o5o6o7_gate CoarseOneHot[5] BiasCB[5] GndA sky130_fd_pr__nfet_01v8 L=1 W=1 nf=1 ad=0.29 as=0.29 pd=2.58 ps=2.58
+ nrd=0.29 nrs=0.29 sa=0 sb=0 sd=0 mult=1
XMnswlB4 MirrB4o5o6o7_gate CoarseOneHot[4] BiasCB[4] GndA sky130_fd_pr__nfet_01v8 L=1 W=1 nf=1 ad=0.29 as=0.29 pd=2.58 ps=2.58
+ nrd=0.29 nrs=0.29 sa=0 sb=0 sd=0 mult=1
.ends

* expanding   symbol:  BiasMasterBias.sym # of pins=8
** sym_path: /home/alienfalcon/Projects/skywater/open_dvs_py312/open_dvs/git_dvs/nic2025_openDVS/analog/xschem/BiasMasterBias.sym
** sch_path: /home/alienfalcon/Projects/skywater/open_dvs_py312/open_dvs/git_dvs/nic2025_openDVS/analog/xschem/BiasMasterBias.sch
.subckt BiasMasterBias VMasterBiasP ICoarse2 ICoarse1 VMasterBiasN BiasPowerDown VddA18 GndA IR
*.opin VMasterBiasP
*.iopin IR
*.iopin VddA18
*.iopin GndA
*.opin VMasterBiasN
*.iopin ICoarse1
*.iopin ICoarse2
*.ipin BiasPowerDown
XMNBiasDio VMasterBiasN VMasterBiasN GndA GndA sky130_fd_pr__nfet_01v8_lvt L=5 W=20 nf=1 ad=5.8 as=5.8 pd=40.58 ps=40.58
+ nrd=0.0145 nrs=0.0145 sa=0 sb=0 sd=0 mult=12 m=12
XMPBias VCasc VMasterBiasP VddA18 VddA18 sky130_fd_pr__pfet_01v8 L=20 W=2 nf=1 ad=0.58 as=0.58 pd=4.58 ps=4.58 nrd=0.145 nrs=0.145
+ sa=0 sb=0 sd=0 mult=8 m=8
XMNBias net1 VMasterBiasN IR GndA sky130_fd_pr__nfet_01v8_lvt L=5 W=20 nf=1 ad=5.8 as=5.8 pd=40.58 ps=40.58 nrd=0.0145 nrs=0.0145
+ sa=0 sb=0 sd=0 mult=16 m=16
XMnBiasCascDio VCasc VCasc VMasterBiasN GndA sky130_fd_pr__nfet_01v8_lvt L=20 W=1 nf=1 ad=0.29 as=0.29 pd=2.58 ps=2.58 nrd=0.29
+ nrs=0.29 sa=0 sb=0 sd=0 mult=12 m=12
XMnBiasCasc VMasterBiasP VCasc net1 GndA sky130_fd_pr__nfet_01v8_lvt L=20 W=1 nf=1 ad=0.29 as=0.29 pd=2.58 ps=2.58 nrd=0.29
+ nrs=0.29 sa=0 sb=0 sd=0 mult=16 m=16
XMPBiasDio VMasterBiasP VMasterBiasP VddA18 VddA18 sky130_fd_pr__pfet_01v8 L=20 W=2 nf=1 ad=0.58 as=0.58 pd=4.58 ps=4.58 nrd=0.145
+ nrs=0.145 sa=0 sb=0 sd=0 mult=8 m=8
XMNMirr1 net2 VMasterBiasN GndA GndA sky130_fd_pr__nfet_01v8_lvt L=5 W=20 nf=1 ad=5.8 as=5.8 pd=40.58 ps=40.58 nrd=0.0145
+ nrs=0.0145 sa=0 sb=0 sd=0 mult=1
XMNMirrCasc1 ICoarse1 VCasc net2 GndA sky130_fd_pr__nfet_01v8_lvt L=20 W=1 nf=1 ad=0.29 as=0.29 pd=2.58 ps=2.58 nrd=0.29 nrs=0.29
+ sa=0 sb=0 sd=0 mult=1
XMNMirr2 net3 VMasterBiasN GndA GndA sky130_fd_pr__nfet_01v8_lvt L=5 W=20 nf=1 ad=5.8 as=5.8 pd=40.58 ps=40.58 nrd=0.0145
+ nrs=0.0145 sa=0 sb=0 sd=0 mult=1
XMNMirrCasc2 ICoarse2 VCasc net3 GndA sky130_fd_pr__nfet_01v8_lvt L=20 W=1 nf=1 ad=0.29 as=0.29 pd=2.58 ps=2.58 nrd=0.29 nrs=0.29
+ sa=0 sb=0 sd=0 mult=1
XMNBSPD VCasc BiasPowerDown GndA GndA sky130_fd_pr__nfet_01v8_lvt L=0.2 W=2 nf=1 ad=0.58 as=0.58 pd=4.58 ps=4.58 nrd=0.145
+ nrs=0.145 sa=0 sb=0 sd=0 mult=1
XMNBSCapBias VddA18 VMasterBiasP VddA18 GndA sky130_fd_pr__nfet_01v8 L=16 W=16 nf=1 ad=4.64 as=4.64 pd=32.58 ps=32.58 nrd=0.018125
+ nrs=0.018125 sa=0 sb=0 sd=0 mult=1
XMPBS bootstrap VMasterBiasP VddA18 VddA18 sky130_fd_pr__pfet_01v8 L=0.2 W=2 nf=1 ad=0.58 as=0.58 pd=4.58 ps=4.58 nrd=0.145
+ nrs=0.145 sa=0 sb=0 sd=0 mult=1
XMNBSCapBS BiasPowerDown bootstrap BiasPowerDown GndA sky130_fd_pr__nfet_01v8 L=16 W=16 nf=1 ad=4.64 as=4.64 pd=32.58 ps=32.58
+ nrd=0.018125 nrs=0.018125 sa=0 sb=0 sd=0 mult=1
XMPBSPU VCasc bootstrap VddA18 VddA18 sky130_fd_pr__pfet_01v8 L=0.2 W=2 nf=1 ad=0.58 as=0.58 pd=4.58 ps=4.58 nrd=0.145 nrs=0.145
+ sa=0 sb=0 sd=0 mult=1
.ends

* expanding   symbol:  BiasCoarseMBDivider.sym # of pins=12
** sym_path: /home/alienfalcon/Projects/skywater/open_dvs_py312/open_dvs/git_dvs/nic2025_openDVS/analog/xschem/BiasCoarseMBDivider.sym
** sch_path: /home/alienfalcon/Projects/skywater/open_dvs_py312/open_dvs/git_dvs/nic2025_openDVS/analog/xschem/BiasCoarseMBDivider.sch
.subckt BiasCoarseMBDivider VddA18 GndA ICoarse2 ICoarse1 BiasCB0 BiasCB1 BiasCB3 BiasCB4 BiasCB5 BiasCB6 BiasCB7 BiasCB2
*.iopin VddA18
*.iopin GndA
*.iopin ICoarse1
*.iopin BiasCB0
*.iopin BiasCB1
*.iopin BiasCB2
*.iopin BiasCB3
*.iopin BiasCB4
*.iopin BiasCB5
*.iopin BiasCB6
*.iopin BiasCB7
*.iopin ICoarse2
x1 GndA VddA18 ICoarse2 BiasCB2 BiasCB3 BiasCB4 BiasCB5 BiasCB6 BiasCB7 BiasDivider
xMult GndA VddA18 ICoarse1 BiasCB0 BiasCB1 BiasMultiplier
XMNDioCB0 BiasCB0 BiasCB0 GndA GndA sky130_fd_pr__nfet_01v8_lvt L=5 W=1.98 nf=1 ad=0.5742 as=0.5742 pd=4.54 ps=4.54
+ nrd=0.146464646464646 nrs=0.146464646464646 sa=0 sb=0 sd=0 mult=8 m=8
XMNDioCB1 BiasCB1 BiasCB1 GndA GndA sky130_fd_pr__nfet_01v8_lvt L=10 W=1 nf=1 ad=0.29 as=0.29 pd=2.58 ps=2.58 nrd=0.29 nrs=0.29
+ sa=0 sb=0 sd=0 mult=8 m=8
XMNDioCB2 BiasCB2 BiasCB2 s17 GndA sky130_fd_pr__nfet_01v8_lvt L=5 W=1.98 nf=1 ad=0.5742 as=0.5742 pd=4.54 ps=4.54
+ nrd=0.146464646464646 nrs=0.146464646464646 sa=0 sb=0 sd=0 mult=1
XMNDioCB3 BiasCB3 BiasCB3 s27 GndA sky130_fd_pr__nfet_01v8_lvt L=10 W=1 nf=1 ad=0.29 as=0.29 pd=2.58 ps=2.58 nrd=0.29 nrs=0.29
+ sa=0 sb=0 sd=0 mult=1
XMNDioCB4 BiasCB4 BiasCB4 s37 GndA sky130_fd_pr__nfet_01v8_lvt L=20 W=0.5 nf=1 ad=0.145 as=0.145 pd=1.58 ps=1.58 nrd=0.58 nrs=0.58
+ sa=0 sb=0 sd=0 mult=1
XM10 s17 BiasCB2 s16 GndA sky130_fd_pr__nfet_01v8_lvt L=5 W=1.98 nf=1 ad=0.5742 as=0.5742 pd=4.54 ps=4.54 nrd=0.146464646464646
+ nrs=0.146464646464646 sa=0 sb=0 sd=0 mult=1
XM11 s16 BiasCB2 s15 GndA sky130_fd_pr__nfet_01v8_lvt L=5 W=1.98 nf=1 ad=0.5742 as=0.5742 pd=4.54 ps=4.54 nrd=0.146464646464646
+ nrs=0.146464646464646 sa=0 sb=0 sd=0 mult=1
XM12 s15 BiasCB2 s14 GndA sky130_fd_pr__nfet_01v8_lvt L=5 W=1.98 nf=1 ad=0.5742 as=0.5742 pd=4.54 ps=4.54 nrd=0.146464646464646
+ nrs=0.146464646464646 sa=0 sb=0 sd=0 mult=1
XM13 s14 BiasCB2 s13 GndA sky130_fd_pr__nfet_01v8_lvt L=5 W=1.98 nf=1 ad=0.5742 as=0.5742 pd=4.54 ps=4.54 nrd=0.146464646464646
+ nrs=0.146464646464646 sa=0 sb=0 sd=0 mult=1
XM14 s13 BiasCB2 s12 GndA sky130_fd_pr__nfet_01v8_lvt L=5 W=1.98 nf=1 ad=0.5742 as=0.5742 pd=4.54 ps=4.54 nrd=0.146464646464646
+ nrs=0.146464646464646 sa=0 sb=0 sd=0 mult=1
XM15 s12 BiasCB2 s11 GndA sky130_fd_pr__nfet_01v8_lvt L=5 W=1.98 nf=1 ad=0.5742 as=0.5742 pd=4.54 ps=4.54 nrd=0.146464646464646
+ nrs=0.146464646464646 sa=0 sb=0 sd=0 mult=1
XM16 s11 BiasCB2 GndA GndA sky130_fd_pr__nfet_01v8_lvt L=5 W=1.98 nf=1 ad=0.5742 as=0.5742 pd=4.54 ps=4.54 nrd=0.146464646464646
+ nrs=0.146464646464646 sa=0 sb=0 sd=0 mult=1
XM17 s27 BiasCB3 s26 GndA sky130_fd_pr__nfet_01v8_lvt L=10 W=1 nf=1 ad=0.29 as=0.29 pd=2.58 ps=2.58 nrd=0.29 nrs=0.29 sa=0 sb=0
+ sd=0 mult=1
XM18 s26 BiasCB3 s25 GndA sky130_fd_pr__nfet_01v8_lvt L=10 W=1 nf=1 ad=0.29 as=0.29 pd=2.58 ps=2.58 nrd=0.29 nrs=0.29 sa=0 sb=0
+ sd=0 mult=1
XM19 s25 BiasCB3 s24 GndA sky130_fd_pr__nfet_01v8_lvt L=10 W=1 nf=1 ad=0.29 as=0.29 pd=2.58 ps=2.58 nrd=0.29 nrs=0.29 sa=0 sb=0
+ sd=0 mult=1
XM20 s24 BiasCB3 s23 GndA sky130_fd_pr__nfet_01v8_lvt L=10 W=1 nf=1 ad=0.29 as=0.29 pd=2.58 ps=2.58 nrd=0.29 nrs=0.29 sa=0 sb=0
+ sd=0 mult=1
XM21 s23 BiasCB3 s22 GndA sky130_fd_pr__nfet_01v8_lvt L=10 W=1 nf=1 ad=0.29 as=0.29 pd=2.58 ps=2.58 nrd=0.29 nrs=0.29 sa=0 sb=0
+ sd=0 mult=1
XM22 s22 BiasCB3 s21 GndA sky130_fd_pr__nfet_01v8_lvt L=10 W=1 nf=1 ad=0.29 as=0.29 pd=2.58 ps=2.58 nrd=0.29 nrs=0.29 sa=0 sb=0
+ sd=0 mult=1
XM23 s21 BiasCB3 GndA GndA sky130_fd_pr__nfet_01v8_lvt L=10 W=1 nf=1 ad=0.29 as=0.29 pd=2.58 ps=2.58 nrd=0.29 nrs=0.29 sa=0 sb=0
+ sd=0 mult=1
XM24 s37 BiasCB4 s36 GndA sky130_fd_pr__nfet_01v8_lvt L=20 W=0.5 nf=1 ad=0.145 as=0.145 pd=1.58 ps=1.58 nrd=0.58 nrs=0.58 sa=0
+ sb=0 sd=0 mult=1
XM25 s36 BiasCB4 s35 GndA sky130_fd_pr__nfet_01v8_lvt L=20 W=0.5 nf=1 ad=0.145 as=0.145 pd=1.58 ps=1.58 nrd=0.58 nrs=0.58 sa=0
+ sb=0 sd=0 mult=1
XM26 s35 BiasCB4 s34 GndA sky130_fd_pr__nfet_01v8_lvt L=20 W=0.5 nf=1 ad=0.145 as=0.145 pd=1.58 ps=1.58 nrd=0.58 nrs=0.58 sa=0
+ sb=0 sd=0 mult=1
XM27 s34 BiasCB4 s33 GndA sky130_fd_pr__nfet_01v8_lvt L=20 W=0.5 nf=1 ad=0.145 as=0.145 pd=1.58 ps=1.58 nrd=0.58 nrs=0.58 sa=0
+ sb=0 sd=0 mult=1
XM28 s33 BiasCB4 s32 GndA sky130_fd_pr__nfet_01v8_lvt L=20 W=0.5 nf=1 ad=0.145 as=0.145 pd=1.58 ps=1.58 nrd=0.58 nrs=0.58 sa=0
+ sb=0 sd=0 mult=1
XM29 s32 BiasCB4 s31 GndA sky130_fd_pr__nfet_01v8_lvt L=20 W=0.5 nf=1 ad=0.145 as=0.145 pd=1.58 ps=1.58 nrd=0.58 nrs=0.58 sa=0
+ sb=0 sd=0 mult=1
XM30 s31 BiasCB4 GndA GndA sky130_fd_pr__nfet_01v8_lvt L=20 W=0.5 nf=1 ad=0.145 as=0.145 pd=1.58 ps=1.58 nrd=0.58 nrs=0.58 sa=0
+ sb=0 sd=0 mult=1
XMNDioCB5 BiasCB5 BiasCB5 s47 GndA sky130_fd_pr__nfet_01v8_lvt L=20 W=0.5 nf=1 ad=0.145 as=0.145 pd=1.58 ps=1.58 nrd=0.58 nrs=0.58
+ sa=0 sb=0 sd=0 mult=1
XM7 s47 BiasCB5 s46 GndA sky130_fd_pr__nfet_01v8_lvt L=20 W=0.5 nf=1 ad=0.145 as=0.145 pd=1.58 ps=1.58 nrd=0.58 nrs=0.58 sa=0 sb=0
+ sd=0 mult=1
XM8 s46 BiasCB5 s45 GndA sky130_fd_pr__nfet_01v8_lvt L=20 W=0.5 nf=1 ad=0.145 as=0.145 pd=1.58 ps=1.58 nrd=0.58 nrs=0.58 sa=0 sb=0
+ sd=0 mult=1
XM9 s45 BiasCB5 s44 GndA sky130_fd_pr__nfet_01v8_lvt L=20 W=0.5 nf=1 ad=0.145 as=0.145 pd=1.58 ps=1.58 nrd=0.58 nrs=0.58 sa=0 sb=0
+ sd=0 mult=1
XM31 s44 BiasCB5 s43 GndA sky130_fd_pr__nfet_01v8_lvt L=20 W=0.5 nf=1 ad=0.145 as=0.145 pd=1.58 ps=1.58 nrd=0.58 nrs=0.58 sa=0
+ sb=0 sd=0 mult=1
XM32 s43 BiasCB5 s42 GndA sky130_fd_pr__nfet_01v8_lvt L=20 W=0.5 nf=1 ad=0.145 as=0.145 pd=1.58 ps=1.58 nrd=0.58 nrs=0.58 sa=0
+ sb=0 sd=0 mult=1
XM33 s42 BiasCB5 s41 GndA sky130_fd_pr__nfet_01v8_lvt L=20 W=0.5 nf=1 ad=0.145 as=0.145 pd=1.58 ps=1.58 nrd=0.58 nrs=0.58 sa=0
+ sb=0 sd=0 mult=1
XM34 s41 BiasCB5 GndA GndA sky130_fd_pr__nfet_01v8_lvt L=20 W=0.5 nf=1 ad=0.145 as=0.145 pd=1.58 ps=1.58 nrd=0.58 nrs=0.58 sa=0
+ sb=0 sd=0 mult=1
XMNDioCB6 BiasCB6 BiasCB6 s57 GndA sky130_fd_pr__nfet_01v8_lvt L=20 W=0.5 nf=1 ad=0.145 as=0.145 pd=1.58 ps=1.58 nrd=0.58 nrs=0.58
+ sa=0 sb=0 sd=0 mult=1
XM36 s57 BiasCB6 s56 GndA sky130_fd_pr__nfet_01v8_lvt L=20 W=0.5 nf=1 ad=0.145 as=0.145 pd=1.58 ps=1.58 nrd=0.58 nrs=0.58 sa=0
+ sb=0 sd=0 mult=1
XM37 s56 BiasCB6 s55 GndA sky130_fd_pr__nfet_01v8_lvt L=20 W=0.5 nf=1 ad=0.145 as=0.145 pd=1.58 ps=1.58 nrd=0.58 nrs=0.58 sa=0
+ sb=0 sd=0 mult=1
XM38 s55 BiasCB6 s54 GndA sky130_fd_pr__nfet_01v8_lvt L=20 W=0.5 nf=1 ad=0.145 as=0.145 pd=1.58 ps=1.58 nrd=0.58 nrs=0.58 sa=0
+ sb=0 sd=0 mult=1
XM39 s54 BiasCB6 s53 GndA sky130_fd_pr__nfet_01v8_lvt L=20 W=0.5 nf=1 ad=0.145 as=0.145 pd=1.58 ps=1.58 nrd=0.58 nrs=0.58 sa=0
+ sb=0 sd=0 mult=1
XM40 s53 BiasCB6 s52 GndA sky130_fd_pr__nfet_01v8_lvt L=20 W=0.5 nf=1 ad=0.145 as=0.145 pd=1.58 ps=1.58 nrd=0.58 nrs=0.58 sa=0
+ sb=0 sd=0 mult=1
XM41 s52 BiasCB6 s51 GndA sky130_fd_pr__nfet_01v8_lvt L=20 W=0.5 nf=1 ad=0.145 as=0.145 pd=1.58 ps=1.58 nrd=0.58 nrs=0.58 sa=0
+ sb=0 sd=0 mult=1
XM42 s51 BiasCB6 GndA GndA sky130_fd_pr__nfet_01v8_lvt L=20 W=0.5 nf=1 ad=0.145 as=0.145 pd=1.58 ps=1.58 nrd=0.58 nrs=0.58 sa=0
+ sb=0 sd=0 mult=1
XMNDioCB7 BiasCB7 BiasCB7 s67 GndA sky130_fd_pr__nfet_01v8_lvt L=20 W=0.5 nf=1 ad=0.145 as=0.145 pd=1.58 ps=1.58 nrd=0.58 nrs=0.58
+ sa=0 sb=0 sd=0 mult=1
XM44 s67 BiasCB7 s66 GndA sky130_fd_pr__nfet_01v8_lvt L=20 W=0.5 nf=1 ad=0.145 as=0.145 pd=1.58 ps=1.58 nrd=0.58 nrs=0.58 sa=0
+ sb=0 sd=0 mult=1
XM45 s66 BiasCB7 s65 GndA sky130_fd_pr__nfet_01v8_lvt L=20 W=0.5 nf=1 ad=0.145 as=0.145 pd=1.58 ps=1.58 nrd=0.58 nrs=0.58 sa=0
+ sb=0 sd=0 mult=1
XM46 s65 BiasCB7 s64 GndA sky130_fd_pr__nfet_01v8_lvt L=20 W=0.5 nf=1 ad=0.145 as=0.145 pd=1.58 ps=1.58 nrd=0.58 nrs=0.58 sa=0
+ sb=0 sd=0 mult=1
XM47 s64 BiasCB7 s63 GndA sky130_fd_pr__nfet_01v8_lvt L=20 W=0.5 nf=1 ad=0.145 as=0.145 pd=1.58 ps=1.58 nrd=0.58 nrs=0.58 sa=0
+ sb=0 sd=0 mult=1
XM48 s63 BiasCB7 s62 GndA sky130_fd_pr__nfet_01v8_lvt L=20 W=0.5 nf=1 ad=0.145 as=0.145 pd=1.58 ps=1.58 nrd=0.58 nrs=0.58 sa=0
+ sb=0 sd=0 mult=1
XM49 s62 BiasCB7 s61 GndA sky130_fd_pr__nfet_01v8_lvt L=20 W=0.5 nf=1 ad=0.145 as=0.145 pd=1.58 ps=1.58 nrd=0.58 nrs=0.58 sa=0
+ sb=0 sd=0 mult=1
XM50 s61 BiasCB7 GndA GndA sky130_fd_pr__nfet_01v8_lvt L=20 W=0.5 nf=1 ad=0.145 as=0.145 pd=1.58 ps=1.58 nrd=0.58 nrs=0.58 sa=0
+ sb=0 sd=0 mult=1
.ends

* expanding   symbol:  BiasDividerFineCell.sym # of pins=8
** sym_path: /home/alienfalcon/Projects/skywater/open_dvs_py312/open_dvs/git_dvs/nic2025_openDVS/analog/xschem/BiasDividerFineCell.sym
** sch_path: /home/alienfalcon/Projects/skywater/open_dvs_py312/open_dvs/git_dvs/nic2025_openDVS/analog/xschem/BiasDividerFineCell.sch
.subckt BiasDividerFineCell IPrev INext VGate IOut VddA18 INOut nSel Sel
*.iopin INext
*.iopin IOut
*.iopin IPrev
*.ipin VGate
*.iopin VddA18
*.ipin nSel
*.ipin Sel
*.iopin INOut
XMr INext VGate IPrev VddA18 sky130_fd_pr__pfet_01v8_lvt L=1 W=9 nf=1 ad=2.61 as=2.61 pd=18.58 ps=18.58 nrd=0.0322222222222222
+ nrs=0.0322222222222222 sa=0 sb=0 sd=0 mult=2 m=2
XM2ru net1 VGate IPrev VddA18 sky130_fd_pr__pfet_01v8_lvt L=1 W=9 nf=1 ad=2.61 as=2.61 pd=18.58 ps=18.58 nrd=0.0322222222222222
+ nrs=0.0322222222222222 sa=0 sb=0 sd=0 mult=2 m=2
XM2rl net2 VGate net1 VddA18 sky130_fd_pr__pfet_01v8_lvt L=1 W=9 nf=1 ad=2.61 as=2.61 pd=18.58 ps=18.58 nrd=0.0322222222222222
+ nrs=0.0322222222222222 sa=0 sb=0 sd=0 mult=2 m=2
XMswNOut INOut Sel net2 VddA18 sky130_fd_pr__pfet_01v8_hvt L=0.5 W=2 nf=1 ad=0.58 as=0.58 pd=4.58 ps=4.58 nrd=0.145 nrs=0.145 sa=0
+ sb=0 sd=0 mult=1
XMswOut IOut nSel net2 VddA18 sky130_fd_pr__pfet_01v8_hvt L=0.5 W=2 nf=1 ad=0.58 as=0.58 pd=4.58 ps=4.58 nrd=0.145 nrs=0.145 sa=0
+ sb=0 sd=0 mult=1
.ends

* expanding   symbol:  sky130_fd_sc_hd__and2_1.sym # of pins=7
** sym_path: /home/alienfalcon/Projects/skywater/open_dvs_py312/open_dvs/git_dvs/nic2025_openDVS/analog/xschem/sky130_fd_sc_hd__and2_1.sym
** sch_path: /home/alienfalcon/Projects/skywater/open_dvs_py312/open_dvs/git_dvs/nic2025_openDVS/analog/xschem/sky130_fd_sc_hd__and2_1.sch
.subckt sky130_fd_sc_hd__and2_1 A B VPWR VPB VGND VNB X
*.ipin A
*.opin X
*.iopin VNB
*.iopin VPB
*.iopin VPWR
*.ipin B
*.iopin VGND
XX0 X a_59_75# VGND VNB sky130_fd_pr__nfet_01v8 L=0.15 W=0.65 nf=1 ad=0.1885 as=0.1885 pd=1.88 ps=1.88 nrd=0.446153846153846
+ nrs=0.446153846153846 sa=0 sb=0 sd=0 mult=1
XX4 a_59_75# B VPWR VPB sky130_fd_pr__pfet_01v8_hvt L=0.15 W=0.42 nf=1 ad=0.1218 as=0.1218 pd=1.42 ps=1.42 nrd=0.69047619047619
+ nrs=0.69047619047619 sa=0 sb=0 sd=0 mult=1
XX1 a_59_75# A VPWR VPB sky130_fd_pr__pfet_01v8_hvt L=0.15 W=0.42 nf=1 ad=0.1218 as=0.1218 pd=1.42 ps=1.42 nrd=0.69047619047619
+ nrs=0.69047619047619 sa=0 sb=0 sd=0 mult=1
XX5 X a_59_75# VPWR VPB sky130_fd_pr__pfet_01v8_hvt L=0.15 W=1 nf=1 ad=0.29 as=0.29 pd=2.58 ps=2.58 nrd=0.29 nrs=0.29 sa=0 sb=0
+ sd=0 mult=1
XX2 a_59_75# A a_145_75# VNB sky130_fd_pr__nfet_01v8 L=0.15 W=0.42 nf=1 ad=0.1218 as=0.1218 pd=1.42 ps=1.42 nrd=0.69047619047619
+ nrs=0.69047619047619 sa=0 sb=0 sd=0 mult=1
XX3 a_145_75# B VGND VNB sky130_fd_pr__nfet_01v8 L=0.15 W=0.42 nf=1 ad=0.1218 as=0.1218 pd=1.42 ps=1.42 nrd=0.69047619047619
+ nrs=0.69047619047619 sa=0 sb=0 sd=0 mult=1
.ends

* expanding   symbol:  sky130_fd_sc_hd__nor2_1.sym # of pins=7
** sym_path: /home/alienfalcon/Projects/skywater/open_dvs_py312/open_dvs/git_dvs/nic2025_openDVS/analog/xschem/sky130_fd_sc_hd__nor2_1.sym
** sch_path: /home/alienfalcon/Projects/skywater/open_dvs_py312/open_dvs/git_dvs/nic2025_openDVS/analog/xschem/sky130_fd_sc_hd__nor2_1.sch
.subckt sky130_fd_sc_hd__nor2_1 A B Y VPWR VPB VGND VNB
*.ipin A
*.opin Y
*.iopin VNB
*.iopin VPB
*.iopin VPWR
*.ipin B
*.iopin VGND
XX1 Y A VGND VNB sky130_fd_pr__nfet_01v8 L=0.15 W=0.64 nf=1 ad=0.1856 as=0.1856 pd=1.86 ps=1.86 nrd=0.453125 nrs=0.453125 sa=0
+ sb=0 sd=0 mult=1
XX2 Y B VGND VNB sky130_fd_pr__nfet_01v8 L=0.15 W=0.65 nf=1 ad=0.1885 as=0.1885 pd=1.88 ps=1.88 nrd=0.446153846153846
+ nrs=0.446153846153846 sa=0 sb=0 sd=0 mult=1
XX3 Y B a_109_297# VPB sky130_fd_pr__pfet_01v8_hvt L=0.15 W=1 nf=1 ad=0.29 as=0.29 pd=2.58 ps=2.58 nrd=0.29 nrs=0.29 sa=0 sb=0
+ sd=0 mult=1
XX0 a_109_297# A VPWR VPB sky130_fd_pr__pfet_01v8_hvt L=0.15 W=1 nf=1 ad=0.29 as=0.29 pd=2.58 ps=2.58 nrd=0.29 nrs=0.29 sa=0 sb=0
+ sd=0 mult=1
.ends

* expanding   symbol:  sky130_fd_sc_hd__inv_1.sym # of pins=6
** sym_path: /home/alienfalcon/Projects/skywater/open_dvs_py312/open_dvs/git_dvs/nic2025_openDVS/analog/xschem/sky130_fd_sc_hd__inv_1.sym
** sch_path: /home/alienfalcon/Projects/skywater/open_dvs_py312/open_dvs/git_dvs/nic2025_openDVS/analog/xschem/sky130_fd_sc_hd__inv_1.sch
.subckt sky130_fd_sc_hd__inv_1 A Y VPWR VPB VGND VNB
*.ipin A
*.opin Y
*.iopin VNB
*.iopin VPB
*.iopin VPWR
*.iopin VGND
XX0 Y A VGND VNB sky130_fd_pr__nfet_01v8 L=0.15 W=0.65 nf=1 ad=0.1885 as=0.1885 pd=1.88 ps=1.88 nrd=0.446153846153846
+ nrs=0.446153846153846 sa=0 sb=0 sd=0 mult=1
XX1 Y A VPWR VPB sky130_fd_pr__pfet_01v8_hvt L=0.15 W=1 nf=1 ad=0.29 as=0.29 pd=2.58 ps=2.58 nrd=0.29 nrs=0.29 sa=0 sb=0 sd=0
+ mult=1
.ends

* expanding   symbol:  BiasDivider.sym # of pins=9
** sym_path: /home/alienfalcon/Projects/skywater/open_dvs_py312/open_dvs/git_dvs/nic2025_openDVS/analog/xschem/BiasDivider.sym
** sch_path: /home/alienfalcon/Projects/skywater/open_dvs_py312/open_dvs/git_dvs/nic2025_openDVS/analog/xschem/BiasDivider.sch
.subckt BiasDivider GndA VddA18 IIn IOut0 IOut1 IOut2 IOut3 IOut4 IOut5
*.iopin GndA
*.iopin VddA18
*.iopin IIn
*.iopin IOut0
*.iopin IOut1
*.iopin IOut2
*.iopin IOut3
*.iopin IOut4
*.iopin IOut5
xDivCell0 VddA18 VOut0 IIn IOut0 BiasDividerCell
XM1 VddA18 VddA18 VddA18 VddA18 sky130_fd_pr__pfet_01v8 L=8 W=4 nf=1 ad=1.16 as=1.16 pd=8.58 ps=8.58 nrd=0.0725 nrs=0.0725 sa=0
+ sb=0 sd=0 mult=2 m=2
XM2 IIn IIn VddA18 VddA18 sky130_fd_pr__pfet_01v8 L=8 W=4 nf=1 ad=1.16 as=1.16 pd=8.58 ps=8.58 nrd=0.0725 nrs=0.0725 sa=0 sb=0
+ sd=0 mult=13 m=13
xDivCell5 VOut4 GndA IIn IOut5 BiasDividerCell
xDivCell1 VOut0 VOut1 IIn IOut1 BiasDividerCell
xDivCell2 VOut1 VOut2 IIn IOut2 BiasDividerCell
xDivCell3 VOut2 VOut3 IIn IOut3 BiasDividerCell
xDivCell4 VOut3 VOut4 IIn IOut4 BiasDividerCell
.ends

* expanding   symbol:  BiasMultiplier.sym # of pins=5
** sym_path: /home/alienfalcon/Projects/skywater/open_dvs_py312/open_dvs/git_dvs/nic2025_openDVS/analog/xschem/BiasMultiplier.sym
** sch_path: /home/alienfalcon/Projects/skywater/open_dvs_py312/open_dvs/git_dvs/nic2025_openDVS/analog/xschem/BiasMultiplier.sch
.subckt BiasMultiplier GndA VddA18 IIn IOut1 IOut0
*.iopin GndA
*.iopin VddA18
*.iopin IIn
*.iopin IOut0
*.iopin IOut1
xMultCell0 VIn VOut0 IIn IOut0 BiasMultiplierCell
xMultCell1 VOut0 VddA18 IIn IOut1 BiasMultiplierCell
XM1 GndA IIn VIn VIn sky130_fd_pr__pfet_01v8 L=8 W=4 nf=1 ad=1.16 as=1.16 pd=8.58 ps=8.58 nrd=0.0725 nrs=0.0725 sa=0 sb=0 sd=0
+ mult=2 m=2
XM2 IIn IIn VIn VIn sky130_fd_pr__pfet_01v8 L=8 W=4 nf=1 ad=1.16 as=1.16 pd=8.58 ps=8.58 nrd=0.0725 nrs=0.0725 sa=0 sb=0 sd=0
+ mult=13 m=13
.ends

* expanding   symbol:  BiasDividerCell.sym # of pins=4
** sym_path: /home/alienfalcon/Projects/skywater/open_dvs_py312/open_dvs/git_dvs/nic2025_openDVS/analog/xschem/BiasDividerCell.sym
** sch_path: /home/alienfalcon/Projects/skywater/open_dvs_py312/open_dvs/git_dvs/nic2025_openDVS/analog/xschem/BiasDividerCell.sch
.subckt BiasDividerCell IPrev INext VGate IOut
*.iopin INext
*.iopin IOut
*.iopin IPrev
*.ipin VGate
XM1 INext VGate IPrev IPrev sky130_fd_pr__pfet_01v8 L=8 W=4 nf=1 ad=1.16 as=1.16 pd=8.58 ps=8.58 nrd=0.0725 nrs=0.0725 sa=0 sb=0
+ sd=0 mult=2 m=2
XM2 IOut VGate IPrev IPrev sky130_fd_pr__pfet_01v8 L=8 W=4 nf=1 ad=1.16 as=1.16 pd=8.58 ps=8.58 nrd=0.0725 nrs=0.0725 sa=0 sb=0
+ sd=0 mult=13 m=13
.ends

* expanding   symbol:  BiasMultiplierCell.sym # of pins=4
** sym_path: /home/alienfalcon/Projects/skywater/open_dvs_py312/open_dvs/git_dvs/nic2025_openDVS/analog/xschem/BiasMultiplierCell.sym
** sch_path: /home/alienfalcon/Projects/skywater/open_dvs_py312/open_dvs/git_dvs/nic2025_openDVS/analog/xschem/BiasMultiplierCell.sch
.subckt BiasMultiplierCell IPrev INext VGate IOut
*.iopin IPrev
*.iopin IOut
*.iopin INext
*.ipin VGate
XM1 IPrev VGate INext INext sky130_fd_pr__pfet_01v8 L=8 W=4 nf=1 ad=1.16 as=1.16 pd=8.58 ps=8.58 nrd=0.0725 nrs=0.0725 sa=0 sb=0
+ sd=0 mult=2 m=2
XM2 IOut VGate INext INext sky130_fd_pr__pfet_01v8 L=8 W=4 nf=1 ad=1.16 as=1.16 pd=8.58 ps=8.58 nrd=0.0725 nrs=0.0725 sa=0 sb=0
+ sd=0 mult=13 m=13
.ends

.end
