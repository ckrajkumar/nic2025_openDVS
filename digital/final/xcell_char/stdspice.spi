*
* SPICE model include for sky130A characterization.
*
* PDK installed via ciel (commit 026824c7969ce6f4fc9678e6ca04b0a06a596c4b).
* The section name below is lowercase "tt" because that's the literal
* section name inside sky130.lib.spice (`.lib tt`, not `.lib TT`) - checked
* directly. This is independent of xcell.conf's `corner "TT"` string, which
* is just metadata xcell writes into the output liberty file's
* operating_conditions/process_label fields - it doesn't select a .lib
* section, so it doesn't need to match this file's case.
*
.lib '/Users/kamerongano/.ciel/sky130A/libs.tech/ngspice/sky130.lib.spice' tt
